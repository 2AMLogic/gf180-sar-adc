* ==================================================================
* adc_top.spice -- the SAR ADC analog core: CDAC array, its four-leg
* bottom-plate switch network and the local drivers, and the
* top-plate V_cm switch DR-0014's sampling phase turns on.
*
* GENERATED by design/adc-top/gen_adc_top.py -- do not edit.
*
* This library holds ONLY what is not already owned by another
* canonical file. The comparator lives in design/comparator/
* comparator.spice and the SAR controller in design/sar-logic/
* sar_ctrl.spice; the testbenches under sim/adc-*/ inline all three.
*
* Fidelity (DR-0010): everything here is transistor level. The
* sequencer and the output register stay at rung 1 (ideal XSPICE
* primitives) because the open gf180mcu PDK ships no 3.3 V standard-
* cell library -- the gap DR-0010 names as an open precondition of
* rung 3. The T-gate DRIVERS are transistor level even so: they are
* custom cells placed with the CDAC (design/sar-logic/README.md), not
* standard cells, so the library gap does not apply to them, and they
* are the dominant digital load in a SAR ADC.
* ==================================================================

* --- ADC-TOP-NETLIST-BEGIN (verbatim-copied into every testbench) ---
* ---- switches ----------------------------------------------------
* CDAC bottom-plate T-gate, unfolded form. The CONVERTER's decode
* banks no longer instantiate this subckt -- DR-0050 folds their
* T-gate PMOS into a shared-source/drain pair (`adc_tgate_f` below)
* -- but it stays the library's parametrised T-gate: `adc_tp_sw`
* (whose fold is out of DR-0050's scope: its row is not
* height-critical) and the testbench replicas that must match
* sim/device-switch-ron/ and sim/cdac-bit-settling/'s characterised
* geometry still call it, so R_on carries the corner sensitivity
* those records already characterised.
.subckt adc_tgate vin vout gn gp vdd wn=10u wp=20u
XN vin gn vout 0   nfet_03v3 w='wn' l=0.28u
XP vin gp vout vdd pfet_03v3 w='wp' l=0.28u
.ends adc_tgate

* The RATIFIED decode-bank T-gate (DR-0050): electrically the same
* device as adc_tgate wn=10u wp=20u -- the PMOS is two parallel
* wp=10u fingers, i.e. unchanged parallel W -- and the netlist side
* of the layout's shared-source/drain fold (issue #936 measured the
* candidate, -13,434.100 um^2 / -10.26 % on ADC_BLOCK; DR-0050
* adopts it). Stating the fingers HERE is what keeps the schematic
* and the extracted deck one netlist: the layout draws each pair as
* one abutting mirrored island whose shared diffusion carries the
* same net on both sides, so the extracted stream states exactly
* these two devices. Literal widths -- the fold is one specific
* ratio, not a parameterised sweep, so nothing downstream depends
* on expression evaluation.
.subckt adc_tgate_f vin vout gn gp vdd
XN  vin gn vout 0   nfet_03v3 w=10u l=0.28u
XP1 vin gp vout vdd pfet_03v3 w=10u l=0.28u
XP2 vin gp vout vdd pfet_03v3 w=10u l=0.28u
.ends adc_tgate_f

* Dedicated top-plate input sampling switch: dummy-compensated T-gate,
* DR-0007 (track switch) / DR-0013. NO LONGER IN THE CONVERTER --
* DR-0014 samples on the bottom plates, so the input reaches the array
* through the nine cell T-gates of each side's fourth leg and this
* switch is gone from adc_cdac_side and from every adc-* deck. It is
* kept in the library because sim/top-plate-cpar/ instantiates it to
* measure the SUPERSEDED topology's top-plate load set -- the measured
* evidence DR-0014's Context rests on -- and because #61 re-takes that
* measurement on the new topology from this same library. Identical
* device text to the `tgate_dum` subckt sim/track-switch-sampling/
* measured the ratified gain-error number with, at the same default
* rd = 7/16.
.subckt adc_tgate_dum vin vout clk clkb vdd wn=40u wp=80u rd=0.4375
XN  vin  clk  vout 0   nfet_03v3 w='wn' l=0.28u
XP  vin  clkb vout vdd pfet_03v3 w='wp' l=0.28u
XDN vout clkb vout 0   nfet_03v3 w='wn*rd' l=0.28u
XDP vout clk  vout vdd pfet_03v3 w='wp*rd' l=0.28u
.ends adc_tgate_dum

* Local T-gate driver -- one per leg, placed with the CDAC cell. This
* is design/sar-logic/sar_ctrl.spice's `sar_tgate_drv` promoted from
* its rung-1 ideal inverter to real devices: the controller routes
* only the active-high (NMOS gate) half of each leg, and the
* complementary PMOS gate is made here.
.subckt adc_drv a y vdd vss
Xp y a vdd vdd pfet_03v3 w=8u l=0.35u
Xn y a vss vss nfet_03v3 w=4u l=0.35u
.ends adc_drv

* ---- top-plate V_cm switch (DR-0014) ------------------------------
* One per array side. Closed for ph0..ph2 and OPENED ON THE EDGE INTO
* ph3 -- that edge is the sampling instant, and it is the reason the
* whole record exists: with the top plate released before the bottom
* plates move, the sampled input and every subsequent DAC step land in
* the same numerator over the same denominator, so C_arr/(C_arr+C_par)
* cancels from the comparator's decision instead of dividing the DAC
* step alone.
*
* Plain T-gate at the CDAC bottom-plate geometry -- deliberately NOT
* dummy-compensated, and this is a choice, not an omission. DR-0013's
* dummies exist because the OLD sampling switch opened with an
* input-dependent voltage on its channel. This switch always opens
* with its node at V_cm, so its injection is signal-independent: a
* fixed offset, common to both sides, which differential operation
* removes and which DR-0007's Offset row already covers. Adding
* dummies would instead re-hang two permanently-connected MOS
* capacitors on the top plate -- the 194 fF sim/top-plate-cpar/
* measured as 66 % of C_par -- which no longer costs gain under this
* record but does cost bit-trial settling. The residual side-to-side
* MISMATCH of this injection is one of the four things DR-0014's
* Consequences require #61 to measure; it is not claimed here.
*
* Sizing, from the acquisition it has to support: it holds the top
* node at V_cm while the bottom plates slew, so its own time constant
* is R_on * (C_arr + C_par) = 570 ohm * 9.1 pF = 5.2 ns worst case,
* i.e. 36 tau inside the 187.5 ns acquisition window and 0.21 of the
* input network's own 25 ns tau. The lag it leaves at the sampling
* instant is (tau_sw/tau_in)*exp(-7.5) = 1.1e-4 of the input step --
* 0.12 LSB at full scale, and LINEAR in the input, so it is a gain
* term and not a linearity term. Widening it would buy that back at
* the price of more injection to mismatch, which is the term this
* topology cannot cancel.
.subckt adc_tp_sw top vcm gn vdd vss
Xd gn gp vdd vss adc_drv
Xs vcm top gn gp vdd adc_tgate wn=10u wp=20u
.ends adc_tp_sw

* ---- one CDAC cell ------------------------------------------------
* A weight-w block of unit capacitors and its FOUR-way bottom-plate
* switch: driven to V_in while sampling (DR-0014's fourth leg),
* released to V_cm, or engaged to V_REF or GND (DR-0011, unchanged).
* Exactly one leg conducts at a time -- the four-leg one-hot invariant
* sim/sar-logic-functional/ checks on the control side.
*
* All four legs are the same T-gate -- DR-0050's folded `adc_tgate_f`,
* PMOS stated as two parallel wp=10u fingers. That is what makes the
* cell one repeated device rather than four different ones, and it is
* why the Input-structure row's series R_on has to be re-measured
* rather than carried over (DR-0014, and #61 owns it): the input now
* reaches the array through nine of these in parallel, instead of
* through one dedicated 40u/80u switch. Under DR-0050 the re-take
* moves only through junction parasitics -- parallel W per T-gate is
* unchanged (20u = 2 x 10u), exactly as issue #940's campaign
* re-runs measure.
.subckt adc_cdac_cell top vin vref vcm vss vdd gn_in gn_rel gn_hi gn_lo
+ cw=10u cl=10u
Xc  top bp mim_cap_2f0 c_width='cw' c_length='cl'
Xdi gn_in  gp_in  vdd vss adc_drv
Xdr gn_rel gp_rel vdd vss adc_drv
Xdh gn_hi  gp_hi  vdd vss adc_drv
Xdl gn_lo  gp_lo  vdd vss adc_drv
Xsi vin  bp gn_in  gp_in  vdd adc_tgate_f
Xsr vcm  bp gn_rel gp_rel vdd adc_tgate_f
Xsh vref bp gn_hi  gp_hi  vdd adc_tgate_f
Xsl vss  bp gn_lo  gp_lo  vdd adc_tgate_f
.ends adc_cdac_cell

* ---- one array side -----------------------------------------------
* DR-0011: 2^(N-1) = 512 unit positions per side -- nine binary
* weighted blocks (256..1, 511 units) plus one terminating unit fixed
* to V_cm. C_u = 35.6528 fF (spec/cdac-sizing-memo.md Sec 4), so the
* per-side track-mode capacitance is 512 * C_u = 18.254 pF, which is
* the C_in the ratified Input-structure row publishes.
*
* Each block is drawn as ONE capacitor of the block's total area, not
* as w separate unit cells. That is exact for this campaign and it is
* deliberate: these records verify the NOMINAL design over PVT, where
* unit-to-unit mismatch is zero by construction, and the statistical
* spread of the same array is sim/mc-cdac-mismatch/'s claim, taken at
* nominal PVT with a behavioural model because the open PDK ships no
* local capacitor mismatch model at all. Drawing 1022 unit cells here
* would multiply simulation cost by ~50x and change no number.
*
* Areas from the measured MiM density law (devchar Sec 1.2),
* C(s) = 1.99*s^2 + 0.9532*s fF for a square of side s um:
*   w=256  C =   9127.12 fF  ->  s = 67.4846 um
*   w=128  C =   4563.56 fF  ->  s = 47.6489 um
*   w= 64  C =   2281.78 fF  ->  s = 33.6232 um
*   w= 32  C =   1140.89 fF  ->  s = 23.7056 um
*   w= 16  C =    570.44 fF  ->  s = 16.6931 um
*   w=  8  C =    285.22 fF  ->  s = 11.7349 um
*   w=  4  C =    142.61 fF  ->  s = 8.2293 um
*   w=  2  C =     71.31 fF  ->  s = 5.7513 um
*   w=  1  C =     35.65 fF  ->  s = 4.0000 um
*
* `sel_in` is ONE port, not nine: every cell's fourth leg is driven by
* the same broadcast control, because all bottom plates sample
* together by construction (design/sar-logic/README.md states the same
* bus-width argument from the controller side). The per-cell decode is
* still four one-hot legs; one of the four is shared.
.subckt adc_cdac_side top vin vref vcm vss vdd sel_in rel_256 hi_256
+ lo_256 rel_128 hi_128 lo_128 rel_64 hi_64 lo_64 rel_32 hi_32 lo_32
+ rel_16 hi_16 lo_16 rel_8 hi_8 lo_8 rel_4 hi_4 lo_4 rel_2 hi_2 lo_2 rel_1
+ hi_1 lo_1
X256 top vin vref vcm vss vdd sel_in rel_256 hi_256 lo_256 adc_cdac_cell cw=67.4846u cl=67.4846u
X128 top vin vref vcm vss vdd sel_in rel_128 hi_128 lo_128 adc_cdac_cell cw=47.6489u cl=47.6489u
X64 top vin vref vcm vss vdd sel_in rel_64 hi_64 lo_64 adc_cdac_cell cw=33.6232u cl=33.6232u
X32 top vin vref vcm vss vdd sel_in rel_32 hi_32 lo_32 adc_cdac_cell cw=23.7056u cl=23.7056u
X16 top vin vref vcm vss vdd sel_in rel_16 hi_16 lo_16 adc_cdac_cell cw=16.6931u cl=16.6931u
X8 top vin vref vcm vss vdd sel_in rel_8 hi_8 lo_8 adc_cdac_cell cw=11.7349u cl=11.7349u
X4 top vin vref vcm vss vdd sel_in rel_4 hi_4 lo_4 adc_cdac_cell cw=8.2293u cl=8.2293u
X2 top vin vref vcm vss vdd sel_in rel_2 hi_2 lo_2 adc_cdac_cell cw=5.7513u cl=5.7513u
X1 top vin vref vcm vss vdd sel_in rel_1 hi_1 lo_1 adc_cdac_cell cw=4.0000u cl=4.0000u
* terminating unit: DR-0011's 512th position, fixed to V_cm, never
* switched -- it is what makes the weight-1 trial resolve exactly one
* LSB of full scale rather than one part in 511. Under DR-0014 it is
* also the one unit that does NOT track V_in during acquisition, so
* the capacitance the input PIN drives is 511*C_u = 18.219 pF while the
* C_arr the charge balance runs on is still 512*C_u = 18.254 pF. The
* 0.2 % difference sits inside the ratified Input-structure row's own
* rounding and does not change DR-0013's <= 30 ns drive contract.
Xterm top vcm mim_cap_2f0 c_width=4.0000u c_length=4.0000u
.ends adc_cdac_side
* --- ADC-TOP-NETLIST-END ---
