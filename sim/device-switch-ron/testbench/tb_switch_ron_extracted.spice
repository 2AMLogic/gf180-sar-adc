* ==================================================================
* tb_switch_ron_extracted -- the switch-R_on testbench with its
* transmission-gate branch wired against the EXTRACTED, PMOS-body-
* remediated `adc_tgate` leaf cell (sim/extracted-delta-summary.md
* SS6.3's Input-structure R_on re-take). GENERATED by
* layout/adc-top/parasitics/gen_extracted_switch_ron_tb.py -- do not
* edit.
*
* Runs sim/device-switch-ron/testbench/tb.json UNMODIFIED, via
* `run_corners.py device-switch-ron --netlist <this file>`. Everything
* above the transmission-gate section below -- the supply, the seven
* supply-tracking input points, and the whole NMOS-only and PMOS-only
* branches -- is copied VERBATIM from tb_switch_ron.spice, so ron_n_*
* and ron_p_* are a built-in control (they must come back bit-
* identical) and ron_t_* is the only measurement that can move.
* ==================================================================
* tb_switch_ron -- sampling-switch on-resistance vs input voltage
*
* Netlist FRAGMENT. The harness supplies the models, the corner .lib
* sections, .temp, the .control block and .end. Parameters provided by the
* harness: vdd_val, vdd_nom, temp_c.
*
* Question this answers (feeds #10, switch topology): how flat is R_on across
* the input range for an NMOS-only, a PMOS-only and a transmission-gate
* sampling switch, and which PVT corner is worst?
*
* Method. Each branch holds the switch source at a fixed input voltage and
* forces V_ds = 10 mV across the channel -- deep triode, small enough that
* R_on = 10 mV / |I| is the small-signal channel resistance rather than a
* large-signal average. One 10 mV source per branch means its current IS the
* channel current, with no divider or probe to correct for.
*
* WHY THE INPUT POINTS TRACK THE SUPPLY. The input is swept as a fraction of
* vdd_val, not as a fixed 0-3.3 V ladder. At the low-supply corner (2.97 V) a
* 3.3 V input would sit 330 mV above the rail: the PMOS source-body junction
* forward-biases and the "R_on" measured there is a forward-biased diode, not
* a switch. Sweeping f * vdd_val characterises each supply corner across its
* own rail-to-rail range, which is the physically meaningful comparison.
* (That a 0-3.3 V input range is NOT samplable at a drooped 2.97 V supply is
* itself a finding for #1/#10; see the characterization report.)
*
* Body connections are the single-well reality: NMOS body to ground, PMOS
* body to vdd. R_on therefore carries the body effect, which is most of the
* reason the NMOS degrades toward the top of the range.
*
* Device sizing. W is a free variable for #10 -- R_on scales as 1/W to first
* order -- so this testbench pins one geometry and reports the resistance for
* it: NMOS W = 10 um, PMOS W = 20 um (2:1 for the mobility ratio), both at
* L = 0.28 um (the 3.3 V minimum). The transmission gate is exactly those two
* devices in parallel. Scale by 10 um / W_actual to re-use these numbers.

vsup vdd 0 dc {vdd_val}

* ---- input ladder: 7 points from rail to rail ----------------------------
vin_f00  nf00  0 dc 0
vin_f17  nf17  0 dc {vdd_val/6}
vin_f33  nf33  0 dc {vdd_val/3}
vin_f50  nf50  0 dc {vdd_val/2}
vin_f67  nf67  0 dc {2*vdd_val/3}
vin_f83  nf83  0 dc {5*vdd_val/6}
vin_f100 nf100 0 dc {vdd_val}

* ===========================================================================
* NMOS-only switch, gate hard on at vdd
vdn_f00  ndn_f00  nf00  dc 10m
XN_f00   ndn_f00  vdd nf00  0 nfet_03v3 w=10u l=0.28u
vdn_f17  ndn_f17  nf17  dc 10m
XN_f17   ndn_f17  vdd nf17  0 nfet_03v3 w=10u l=0.28u
vdn_f33  ndn_f33  nf33  dc 10m
XN_f33   ndn_f33  vdd nf33  0 nfet_03v3 w=10u l=0.28u
vdn_f50  ndn_f50  nf50  dc 10m
XN_f50   ndn_f50  vdd nf50  0 nfet_03v3 w=10u l=0.28u
vdn_f67  ndn_f67  nf67  dc 10m
XN_f67   ndn_f67  vdd nf67  0 nfet_03v3 w=10u l=0.28u
vdn_f83  ndn_f83  nf83  dc 10m
XN_f83   ndn_f83  vdd nf83  0 nfet_03v3 w=10u l=0.28u
vdn_f100 ndn_f100 nf100 dc 10m
XN_f100  ndn_f100 vdd nf100 0 nfet_03v3 w=10u l=0.28u

* ===========================================================================
* PMOS-only switch, gate hard on at 0
vdp_f00  ndp_f00  nf00  dc 10m
XP_f00   ndp_f00  0 nf00  vdd pfet_03v3 w=20u l=0.28u
vdp_f17  ndp_f17  nf17  dc 10m
XP_f17   ndp_f17  0 nf17  vdd pfet_03v3 w=20u l=0.28u
vdp_f33  ndp_f33  nf33  dc 10m
XP_f33   ndp_f33  0 nf33  vdd pfet_03v3 w=20u l=0.28u
vdp_f50  ndp_f50  nf50  dc 10m
XP_f50   ndp_f50  0 nf50  vdd pfet_03v3 w=20u l=0.28u
vdp_f67  ndp_f67  nf67  dc 10m
XP_f67   ndp_f67  0 nf67  vdd pfet_03v3 w=20u l=0.28u
vdp_f83  ndp_f83  nf83  dc 10m
XP_f83   ndp_f83  0 nf83  vdd pfet_03v3 w=20u l=0.28u
vdp_f100 ndp_f100 nf100 dc 10m
XP_f100  ndp_f100 0 nf100 vdd pfet_03v3 w=20u l=0.28u

* ===========================================================================
* The DRAWN transmission gate, extracted with its parasitics.
*
* Source: layout/adc-top/parasitics/reports/20261116-195623-2a77538/adc_tgate.para.spice
* (`klt extract --deck gf180mcu --parasitics --pdk`, asserted against
* layout/adc-top/parasitics/cells.json by run_extract_parasitics.py),
* passed through remediate_extracted.py --leaf, which made NO body
* rewrite: all 1 PMOS body terminal(s) already extract on `vdd`,
* the cell's own declared pin, because DR-0035 draws an n+ tap inside
* the cell's Nwell and routes it to vdd. This deck wires that pin to
* vdd below -- the single-well convention tb_switch_ron.spice's own
* header states.
*
* Device geometry is asserted equal on both sides before this file is
* written: nfet_03v3 W=10.0u L=0.28u, pfet_03v3 W=20.0u L=0.28u.
* ===========================================================================
* REMEDIATED extracted leaf cell -- NOT raw `klt extract` output.
* Produced by layout/adc-top/parasitics/remediate_extracted.py
* (remediate_leaf):
*   - body-tie step NOT APPLIED: all 1 PMOS body terminal(s) already
*     extract on `vdd`, a declared .SUBCKT pin, because DR-0035 draws an n+ tap
*     inside the cell's Nwell and routes it there -- closing the klayout-tools#555
*     body gap in the LAYOUT, with no anonymous Nwell net left to promote.
*     Asserted, not assumed: see remediate_extracted._assert_no_unreachable_bodies()
*     (issue #381).
*   - device geometry, connectivity and the parasitic RC ladder are untouched.
* See remediate_extracted.py's remediate_leaf() for provenance.
* parasitic model (--parasitics):
* - capacitance: net-to-ground for every net's own (non-coupled) area/perimeter, plus net-to-net for the vertical-overlap coupling `coupling` describes below -- a coupled net pair gets a direct capacitor between their two hub nodes, not just capacitors to the deck's ground/substrate net
* - coupling: vertical overlap (crossover) unconditionally -- where one net's conductor on an adjacent metal level sits directly over another *distinct* net's conductor, that overlap area is charged between the two nets instead of to ground (issue #760) -- plus lateral (same-layer, sidewall) coupling, but only for a net pair naming one of the caller's declared `--critical-net` nets (issue #976): facing-edge length within that layer's own minimum-spacing lookback is charged between the two nets, *additively* (not deducted from either net's substrate fringe term, unlike the vertical case -- a known simplification). Any same-layer pair with neither side named `--critical-net`, and fringe shielding in general, are still not modelled
* - resistance: single lumped series resistance per net, distributed as a star across that net's device terminals (issue #592) -- not a per-segment, distributed RC ladder, *unless* `--distributed-rc` names this net via `--critical-net` (issue #977, Epic #709 Phase 2b): then the net's terminals are ordered along their approximate physical spread and its total R/C is broken into a chain of per-segment resistors (segment length proportional to inter-terminal distance) with a ground capacitor at each terminal node (proportional to its adjacent segment length/2), instead of one star hub -- still an approximation (terminal position is a device-placement proxy, not true per-segment routing geometry), but a strictly finer-grained one than the single-hub star
* - frequency: quasi-static -- one frequency-independent R and C per net; no skin effect, no distributed transmission-line behavior
* cell ADC_TGATE
* pin gn
* pin gp
* pin vdd
* pin vin
* pin vout
* pin vsubs
.SUBCKT ADC_TGATE gn gp vdd vin vout vsubs
* device instance $1 r0 *1 1.24,5 nfet
X$1 vin__t0 gn__t0 vout__t0 vsubs nfet_03v3 L=0.28U W=10U AS=11P AD=11P PS=22.2U PD=22.2U
* device instance $2 r0 *1 5.02,10 pfet
X$2 vin__t1 gp__t0 vout__t1 vdd__t0 pfet_03v3 L=0.28U W=20U AS=22P AD=22P PS=42.2U PD=42.2U
* device instance gn_t0 r0 *1 0,0
Rgn_t0 gn__t0 gn 52.9302
* device instance gn r0 *1 0,0
Cgn gn vsubs 5.86084e-16
* device instance gp_t0 r0 *1 0,0
Rgp_t0 gp__t0 gp 75.8294
* device instance gp r0 *1 0,0
Cgp gp vsubs 7.64977e-16
* device instance vdd_t0 r0 *1 0,0
Rvdd_t0 vdd__t0 vdd 433.8957
* device instance vdd r0 *1 0,0
Cvdd vdd vsubs 4.208107e-15
* device instance vin_t0 r0 *1 0,0
Rvin_t0 vin__t0 vin 59.6585
* device instance vin_t1 r0 *1 0,0
Rvin_t1 vin__t1 vin 59.6585
* device instance vin r0 *1 0,0
Cvin vin vsubs 4.203056e-15
* device instance vout_t0 r0 *1 0,0
Rvout_t0 vout__t0 vout 37.93035
* device instance vout_t1 r0 *1 0,0
Rvout_t1 vout__t1 vout 37.93035
* device instance vout r0 *1 0,0
Cvout vout vsubs 3.845272e-15
* device instance vsubs_dctie r0 *1 0,0
Rvsubs_dctie vsubs 0 1e+12
.ENDS ADC_TGATE

* ===========================================================================
* Transmission gate: one extracted-cell instance per input point.
* Same forcing method as the schematic branch it replaces -- a 10 mV
* source from the forced node to the input point, so its current IS the
* channel current and R_on = 10 mV / |I| at that input.
* Pin order: gn gp vdd vin vout vsubs  (gn = vdd, gp = 0: both devices hard on;
* vin = the forced node, vout = the input point, vsubs = 0, and the
* well terminal -- the cell's own `vdd` pin since DR-0035 drew the tap,
* or the promoted `vnw` pin on an untapped extraction -- = vdd. Either
* way the PMOS body is biased at vdd, the single-well convention
* tb_switch_ron.spice's own header states.)
vdt_f00  ndt_f00  nf00  dc 10m
Xtg_f00  vdd 0 vdd ndt_f00 nf00 0 ADC_TGATE
vdt_f17  ndt_f17  nf17  dc 10m
Xtg_f17  vdd 0 vdd ndt_f17 nf17 0 ADC_TGATE
vdt_f33  ndt_f33  nf33  dc 10m
Xtg_f33  vdd 0 vdd ndt_f33 nf33 0 ADC_TGATE
vdt_f50  ndt_f50  nf50  dc 10m
Xtg_f50  vdd 0 vdd ndt_f50 nf50 0 ADC_TGATE
vdt_f67  ndt_f67  nf67  dc 10m
Xtg_f67  vdd 0 vdd ndt_f67 nf67 0 ADC_TGATE
vdt_f83  ndt_f83  nf83  dc 10m
Xtg_f83  vdd 0 vdd ndt_f83 nf83 0 ADC_TGATE
vdt_f100  ndt_f100  nf100  dc 10m
Xtg_f100  vdd 0 vdd ndt_f100 nf100 0 ADC_TGATE
