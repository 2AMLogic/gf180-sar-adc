* Flat LVS reference for ADC_TP_SW.
*
* GENERATED by layout/adc-top/cells/gen_adc_cells.py from
* design/adc-top/adc_top.spice's `.subckt adc_tp_sw` -- do not
* edit. See layout/adc-top/lib/netlist.py for why the layout and this
* reference are derived from the same parsed design netlist, and what
* that does and does not let LVS prove.
*
* Deliberate, documented differences from the schematic, each forced by
* `klt extract`'s gf180mcu ExtractionDeck and restated in
* layout/adc-top/README.md:
*   - every NMOS body is on the deck's `vsubs` global, not on the
*     schematic's `0`/`vss`: the curated deck has no tap layer, so a
*     drawn substrate tie cannot name that net;
*   - every PMOS body is on the Nwell island's own (unnamed) net, not
*     on `vdd`: the deck never connects `nwell` to `contact`;
*   - the MiM capacitor is absent: the deck reads none of the MiM
*     layers and has no capacitor device class at all.
*
* Runnable by hand:  klt lvs layout/adc-top/cells/adc_tp_sw.lvs.json --format json
.SUBCKT ADC_TP_SW gn top vcm vdd vss vsubs
MXd_Xp gp gn vdd nw pfet L=0.35U W=8U
MXd_Xn gp gn vss vsubs nfet L=0.35U W=4U
MXs_XN vcm gn top vsubs nfet L=0.28U W=10U
MXs_XP vcm gp top nw pfet L=0.28U W=20U
.ENDS ADC_TP_SW
