* extracted by klt extract --deck gf180mcu
* parasitic model (--parasitics):
* - capacitance: net-to-ground for every net's own (non-coupled) area/perimeter, plus net-to-net for the vertical-overlap coupling `coupling` describes below -- a coupled net pair gets a direct capacitor between their two hub nodes, not just capacitors to the deck's ground/substrate net
* - coupling: vertical overlap (crossover) unconditionally -- where one net's conductor on an adjacent metal level sits directly over another *distinct* net's conductor, that overlap area is charged between the two nets instead of to ground (issue #760) -- plus lateral (same-layer, sidewall) coupling, but only for a net pair naming one of the caller's declared `--critical-net` nets (issue #976): facing-edge length within that layer's own minimum-spacing lookback is charged between the two nets, *additively* (not deducted from either net's substrate fringe term, unlike the vertical case -- a known simplification). Any same-layer pair with neither side named `--critical-net`, and fringe shielding in general, are still not modelled
* - resistance: single lumped series resistance per net, distributed as a star across that net's device terminals (issue #592) -- not a per-segment, distributed RC ladder, *unless* `--distributed-rc` names this net via `--critical-net` (issue #977, Epic #709 Phase 2b): then the net's terminals are ordered along their approximate physical spread and its total R/C is broken into a chain of per-segment resistors (segment length proportional to inter-terminal distance) with a ground capacitor at each terminal node (proportional to its adjacent segment length/2), instead of one star hub -- still an approximation (terminal position is a device-placement proxy, not true per-segment routing geometry), but a strictly finer-grained one than the single-hub star
* - frequency: quasi-static -- one frequency-independent R and C per net; no skin effect, no distributed transmission-line behavior
.GLOBAL vsubs

* cell ADC_BLOCK
* pin XCMP_pon
* pin XCMP_pop
* pin cmpclk
* pin dout
* pin doutb
* pin hi_128_n
* pin hi_128_p
* pin hi_16_n
* pin hi_16_p
* pin hi_1_n
* pin hi_1_p
* pin hi_256_n
* pin hi_256_p
* pin hi_2_n
* pin hi_2_p
* pin hi_32_n
* pin hi_32_p
* pin hi_4_n
* pin hi_4_p
* pin hi_64_n
* pin hi_64_p
* pin hi_8_n
* pin hi_8_p
* pin ibias
* pin lo_128_n
* pin lo_128_p
* pin lo_16_n
* pin lo_16_p
* pin lo_1_n
* pin lo_1_p
* pin lo_256_n
* pin lo_256_p
* pin lo_2_n
* pin lo_2_p
* pin lo_32_n
* pin lo_32_p
* pin lo_4_n
* pin lo_4_p
* pin lo_64_n
* pin lo_64_p
* pin lo_8_n
* pin lo_8_p
* pin pinn
* pin pinp
* pin rel_128_n
* pin rel_128_p
* pin rel_16_n
* pin rel_16_p
* pin rel_1_n
* pin rel_1_p
* pin rel_256_n
* pin rel_256_p
* pin rel_2_n
* pin rel_2_p
* pin rel_32_n
* pin rel_32_p
* pin rel_4_n
* pin rel_4_p
* pin rel_64_n
* pin rel_64_p
* pin rel_8_n
* pin rel_8_p
* pin sel_in
* pin topn
* pin topp
* pin tp_gn
* pin vcm
* pin vdd
* pin vref
* pin vss
.SUBCKT ADC_BLOCK XCMP_pon XCMP_pop cmpclk dout doutb hi_128_n hi_128_p hi_16_n
+ hi_16_p hi_1_n hi_1_p hi_256_n hi_256_p hi_2_n hi_2_p hi_32_n hi_32_p hi_4_n
+ hi_4_p hi_64_n hi_64_p hi_8_n hi_8_p ibias lo_128_n lo_128_p lo_16_n lo_16_p
+ lo_1_n lo_1_p lo_256_n lo_256_p lo_2_n lo_2_p lo_32_n lo_32_p lo_4_n lo_4_p
+ lo_64_n lo_64_p lo_8_n lo_8_p pinn pinp rel_128_n rel_128_p rel_16_n rel_16_p
+ rel_1_n rel_1_p rel_256_n rel_256_p rel_2_n rel_2_p rel_32_n rel_32_p rel_4_n
+ rel_4_p rel_64_n rel_64_p rel_8_n rel_8_p sel_in topn topp tp_gn vcm vdd vref
+ vss
* device instance $1 r0 *1 1.275,2 nfet
X$1 \$5__t0 sel_in__t0 vss__t0 vss__t121 nfet_03v3 L=0.35U W=4U AS=4.4P AD=4.4P
+ PS=10.2U PD=10.2U
* device instance $2 r0 *1 4.225,2 nfet
X$2 \$7__t2 rel_256_p__t2 vss__t115 vss__t122 nfet_03v3 L=0.35U W=4U AS=4.4P
+ AD=4.4P PS=10.2U PD=10.2U
* device instance $3 r0 *1 7.175,2 nfet
X$3 \$9__t2 hi_256_p__t2 vss__t117 vss__t123 nfet_03v3 L=0.35U W=4U AS=4.4P
+ AD=4.4P PS=10.2U PD=10.2U
* device instance $4 r0 *1 10.125,2 nfet
X$4 \$11__t2 lo_256_p__t2 vss__t104 vss__t124 nfet_03v3 L=0.35U W=4U AS=4.4P
+ AD=4.4P PS=10.2U PD=10.2U
* device instance $5 r0 *1 13.04,5 nfet
X$5 pinp__t0 sel_in__t1 \$12__t0 vss__t199 nfet_03v3 L=0.28U W=10U AS=11P
+ AD=11P PS=22.2U PD=22.2U
* device instance $6 r0 *1 15.92,5 nfet
X$6 vcm__t35 rel_256_p__t1 \$12__t261 vss__t200 nfet_03v3 L=0.28U W=10U AS=11P
+ AD=11P PS=22.2U PD=22.2U
* device instance $7 r0 *1 18.8,5 nfet
X$7 vref__t30 hi_256_p__t1 \$12__t262 vss__t201 nfet_03v3 L=0.28U W=10U AS=11P
+ AD=11P PS=22.2U PD=22.2U
* device instance $8 r0 *1 21.68,5 nfet
X$8 vss__t35 lo_256_p__t1 \$12__t263 vss__t202 nfet_03v3 L=0.28U W=10U AS=11P
+ AD=11P PS=22.2U PD=22.2U
* device instance $9 r0 *1 49.715,2 nfet
X$9 \$17__t2 sel_in__t37 vss__t42 vss__t125 nfet_03v3 L=0.35U W=4U AS=4.4P
+ AD=4.4P PS=10.2U PD=10.2U
* device instance $10 r0 *1 52.665,2 nfet
X$10 \$19__t2 rel_128_p__t2 vss__t98 vss__t126 nfet_03v3 L=0.35U W=4U AS=4.4P
+ AD=4.4P PS=10.2U PD=10.2U
* device instance $11 r0 *1 55.615,2 nfet
X$11 \$21__t2 hi_128_p__t2 vss__t101 vss__t127 nfet_03v3 L=0.35U W=4U AS=4.4P
+ AD=4.4P PS=10.2U PD=10.2U
* device instance $12 r0 *1 58.565,2 nfet
X$12 \$23__t2 lo_128_p__t2 vss__t108 vss__t128 nfet_03v3 L=0.35U W=4U AS=4.4P
+ AD=4.4P PS=10.2U PD=10.2U
* device instance $13 r0 *1 61.48,5 nfet
X$13 pinp__t15 sel_in__t31 \$24__t135 vss__t203 nfet_03v3 L=0.28U W=10U AS=11P
+ AD=11P PS=22.2U PD=22.2U
* device instance $14 r0 *1 64.36,5 nfet
X$14 vcm__t33 rel_128_p__t1 \$24__t134 vss__t204 nfet_03v3 L=0.28U W=10U AS=11P
+ AD=11P PS=22.2U PD=22.2U
* device instance $15 r0 *1 67.24,5 nfet
X$15 vref__t27 hi_128_p__t1 \$24__t133 vss__t205 nfet_03v3 L=0.28U W=10U AS=11P
+ AD=11P PS=22.2U PD=22.2U
* device instance $16 r0 *1 70.12,5 nfet
X$16 vss__t31 lo_128_p__t1 \$24__t132 vss__t206 nfet_03v3 L=0.28U W=10U AS=11P
+ AD=11P PS=22.2U PD=22.2U
* device instance $17 r0 *1 98.155,2 nfet
X$17 \$25__t2 sel_in__t44 vss__t66 vss__t129 nfet_03v3 L=0.35U W=4U AS=4.4P
+ AD=4.4P PS=10.2U PD=10.2U
* device instance $18 r0 *1 101.105,2 nfet
X$18 \$27__t2 rel_64_p__t2 vss__t67 vss__t130 nfet_03v3 L=0.35U W=4U AS=4.4P
+ AD=4.4P PS=10.2U PD=10.2U
* device instance $19 r0 *1 104.055,2 nfet
X$19 \$29__t2 hi_64_p__t2 vss__t68 vss__t131 nfet_03v3 L=0.35U W=4U AS=4.4P
+ AD=4.4P PS=10.2U PD=10.2U
* device instance $20 r0 *1 107.005,2 nfet
X$20 \$31__t2 lo_64_p__t2 vss__t92 vss__t132 nfet_03v3 L=0.35U W=4U AS=4.4P
+ AD=4.4P PS=10.2U PD=10.2U
* device instance $21 r0 *1 109.92,5 nfet
X$21 pinp__t14 sel_in__t30 \$32__t71 vss__t207 nfet_03v3 L=0.28U W=10U AS=11P
+ AD=11P PS=22.2U PD=22.2U
* device instance $22 r0 *1 112.8,5 nfet
X$22 vcm__t36 rel_64_p__t1 \$32__t70 vss__t208 nfet_03v3 L=0.28U W=10U AS=11P
+ AD=11P PS=22.2U PD=22.2U
* device instance $23 r0 *1 115.68,5 nfet
X$23 vref__t31 hi_64_p__t1 \$32__t69 vss__t209 nfet_03v3 L=0.28U W=10U AS=11P
+ AD=11P PS=22.2U PD=22.2U
* device instance $24 r0 *1 118.56,5 nfet
X$24 vss__t36 lo_64_p__t1 \$32__t68 vss__t210 nfet_03v3 L=0.28U W=10U AS=11P
+ AD=11P PS=22.2U PD=22.2U
* device instance $25 r0 *1 146.595,2 nfet
X$25 \$33__t2 sel_in__t38 vss__t50 vss__t133 nfet_03v3 L=0.35U W=4U AS=4.4P
+ AD=4.4P PS=10.2U PD=10.2U
* device instance $26 r0 *1 149.545,2 nfet
X$26 \$35__t2 rel_32_p__t2 vss__t84 vss__t134 nfet_03v3 L=0.35U W=4U AS=4.4P
+ AD=4.4P PS=10.2U PD=10.2U
* device instance $27 r0 *1 152.495,2 nfet
X$27 \$37__t2 hi_32_p__t2 vss__t85 vss__t135 nfet_03v3 L=0.35U W=4U AS=4.4P
+ AD=4.4P PS=10.2U PD=10.2U
* device instance $28 r0 *1 155.445,2 nfet
X$28 \$39__t2 lo_32_p__t2 vss__t86 vss__t136 nfet_03v3 L=0.35U W=4U AS=4.4P
+ AD=4.4P PS=10.2U PD=10.2U
* device instance $29 r0 *1 158.36,5 nfet
X$29 pinp__t16 sel_in__t33 \$40__t39 vss__t211 nfet_03v3 L=0.28U W=10U AS=11P
+ AD=11P PS=22.2U PD=22.2U
* device instance $30 r0 *1 161.24,5 nfet
X$30 vcm__t38 rel_32_p__t1 \$40__t38 vss__t212 nfet_03v3 L=0.28U W=10U AS=11P
+ AD=11P PS=22.2U PD=22.2U
* device instance $31 r0 *1 164.12,5 nfet
X$31 vref__t32 hi_32_p__t1 \$40__t37 vss__t213 nfet_03v3 L=0.28U W=10U AS=11P
+ AD=11P PS=22.2U PD=22.2U
* device instance $32 r0 *1 167,5 nfet
X$32 vss__t38 lo_32_p__t1 \$40__t36 vss__t214 nfet_03v3 L=0.28U W=10U AS=11P
+ AD=11P PS=22.2U PD=22.2U
* device instance $33 r0 *1 195.035,2 nfet
X$33 \$41__t2 sel_in__t48 vss__t87 vss__t137 nfet_03v3 L=0.35U W=4U AS=4.4P
+ AD=4.4P PS=10.2U PD=10.2U
* device instance $34 r0 *1 197.985,2 nfet
X$34 \$43__t2 rel_16_p__t2 vss__t88 vss__t138 nfet_03v3 L=0.35U W=4U AS=4.4P
+ AD=4.4P PS=10.2U PD=10.2U
* device instance $35 r0 *1 200.935,2 nfet
X$35 \$45__t2 hi_16_p__t2 vss__t89 vss__t139 nfet_03v3 L=0.35U W=4U AS=4.4P
+ AD=4.4P PS=10.2U PD=10.2U
* device instance $36 r0 *1 203.885,2 nfet
X$36 \$47__t2 lo_16_p__t2 vss__t90 vss__t140 nfet_03v3 L=0.35U W=4U AS=4.4P
+ AD=4.4P PS=10.2U PD=10.2U
* device instance $37 r0 *1 206.8,5 nfet
X$37 pinp__t13 sel_in__t29 \$48__t22 vss__t215 nfet_03v3 L=0.28U W=10U AS=11P
+ AD=11P PS=22.2U PD=22.2U
* device instance $38 r0 *1 209.68,5 nfet
X$38 vcm__t30 rel_16_p__t1 \$48__t21 vss__t216 nfet_03v3 L=0.28U W=10U AS=11P
+ AD=11P PS=22.2U PD=22.2U
* device instance $39 r0 *1 212.56,5 nfet
X$39 vref__t21 hi_16_p__t1 \$48__t20 vss__t217 nfet_03v3 L=0.28U W=10U AS=11P
+ AD=11P PS=22.2U PD=22.2U
* device instance $40 r0 *1 215.44,5 nfet
X$40 vss__t41 lo_16_p__t1 \$48__t23 vss__t218 nfet_03v3 L=0.28U W=10U AS=11P
+ AD=11P PS=22.2U PD=22.2U
* device instance $41 r0 *1 243.475,2 nfet
X$41 \$49__t2 sel_in__t45 vss__t72 vss__t141 nfet_03v3 L=0.35U W=4U AS=4.4P
+ AD=4.4P PS=10.2U PD=10.2U
* device instance $42 r0 *1 246.425,2 nfet
X$42 \$51__t2 rel_8_p__t2 vss__t73 vss__t142 nfet_03v3 L=0.35U W=4U AS=4.4P
+ AD=4.4P PS=10.2U PD=10.2U
* device instance $43 r0 *1 249.375,2 nfet
X$43 \$53__t2 hi_8_p__t2 vss__t91 vss__t143 nfet_03v3 L=0.35U W=4U AS=4.4P
+ AD=4.4P PS=10.2U PD=10.2U
* device instance $44 r0 *1 252.325,2 nfet
X$44 \$55__t2 lo_8_p__t2 vss__t79 vss__t144 nfet_03v3 L=0.35U W=4U AS=4.4P
+ AD=4.4P PS=10.2U PD=10.2U
* device instance $45 r0 *1 255.24,5 nfet
X$45 pinp__t17 sel_in__t35 \$56__t15 vss__t219 nfet_03v3 L=0.28U W=10U AS=11P
+ AD=11P PS=22.2U PD=22.2U
* device instance $46 r0 *1 258.12,5 nfet
X$46 vcm__t40 rel_8_p__t1 \$56__t14 vss__t220 nfet_03v3 L=0.28U W=10U AS=11P
+ AD=11P PS=22.2U PD=22.2U
* device instance $47 r0 *1 261,5 nfet
X$47 vref__t24 hi_8_p__t1 \$56__t12 vss__t221 nfet_03v3 L=0.28U W=10U AS=11P
+ AD=11P PS=22.2U PD=22.2U
* device instance $48 r0 *1 263.88,5 nfet
X$48 vss__t33 lo_8_p__t1 \$56__t13 vss__t222 nfet_03v3 L=0.28U W=10U AS=11P
+ AD=11P PS=22.2U PD=22.2U
* device instance $49 r0 *1 291.915,2 nfet
X$49 \$57__t2 sel_in__t51 vss__t103 vss__t145 nfet_03v3 L=0.35U W=4U AS=4.4P
+ AD=4.4P PS=10.2U PD=10.2U
* device instance $50 r0 *1 294.865,2 nfet
X$50 \$59__t2 rel_4_p__t2 vss__t93 vss__t146 nfet_03v3 L=0.35U W=4U AS=4.4P
+ AD=4.4P PS=10.2U PD=10.2U
* device instance $51 r0 *1 297.815,2 nfet
X$51 \$61__t2 hi_4_p__t2 vss__t47 vss__t147 nfet_03v3 L=0.35U W=4U AS=4.4P
+ AD=4.4P PS=10.2U PD=10.2U
* device instance $52 r0 *1 300.765,2 nfet
X$52 \$63__t2 lo_4_p__t2 vss__t44 vss__t148 nfet_03v3 L=0.35U W=4U AS=4.4P
+ AD=4.4P PS=10.2U PD=10.2U
* device instance $53 r0 *1 303.68,5 nfet
X$53 pinp__t12 sel_in__t22 \$64__t11 vss__t223 nfet_03v3 L=0.28U W=10U AS=11P
+ AD=11P PS=22.2U PD=22.2U
* device instance $54 r0 *1 306.56,5 nfet
X$54 vcm__t22 rel_4_p__t1 \$64__t8 vss__t224 nfet_03v3 L=0.28U W=10U AS=11P
+ AD=11P PS=22.2U PD=22.2U
* device instance $55 r0 *1 309.44,5 nfet
X$55 vref__t19 hi_4_p__t1 \$64__t9 vss__t225 nfet_03v3 L=0.28U W=10U AS=11P
+ AD=11P PS=22.2U PD=22.2U
* device instance $56 r0 *1 312.32,5 nfet
X$56 vss__t25 lo_4_p__t1 \$64__t10 vss__t226 nfet_03v3 L=0.28U W=10U AS=11P
+ AD=11P PS=22.2U PD=22.2U
* device instance $57 r0 *1 340.355,2 nfet
X$57 \$65__t2 sel_in__t42 vss__t54 vss__t149 nfet_03v3 L=0.35U W=4U AS=4.4P
+ AD=4.4P PS=10.2U PD=10.2U
* device instance $58 r0 *1 343.305,2 nfet
X$58 \$67__t2 rel_2_p__t2 vss__t55 vss__t150 nfet_03v3 L=0.35U W=4U AS=4.4P
+ AD=4.4P PS=10.2U PD=10.2U
* device instance $59 r0 *1 346.255,2 nfet
X$59 \$69__t2 hi_2_p__t2 vss__t56 vss__t151 nfet_03v3 L=0.35U W=4U AS=4.4P
+ AD=4.4P PS=10.2U PD=10.2U
* device instance $60 r0 *1 349.205,2 nfet
X$60 \$71__t2 lo_2_p__t2 vss__t57 vss__t152 nfet_03v3 L=0.35U W=4U AS=4.4P
+ AD=4.4P PS=10.2U PD=10.2U
* device instance $61 r0 *1 352.12,5 nfet
X$61 pinp__t10 sel_in__t20 \$72__t6 vss__t227 nfet_03v3 L=0.28U W=10U AS=11P
+ AD=11P PS=22.2U PD=22.2U
* device instance $62 r0 *1 355,5 nfet
X$62 vcm__t23 rel_2_p__t1 \$72__t7 vss__t228 nfet_03v3 L=0.28U W=10U AS=11P
+ AD=11P PS=22.2U PD=22.2U
* device instance $63 r0 *1 357.88,5 nfet
X$63 vref__t20 hi_2_p__t1 \$72__t8 vss__t229 nfet_03v3 L=0.28U W=10U AS=11P
+ AD=11P PS=22.2U PD=22.2U
* device instance $64 r0 *1 360.76,5 nfet
X$64 vss__t26 lo_2_p__t1 \$72__t9 vss__t230 nfet_03v3 L=0.28U W=10U AS=11P
+ AD=11P PS=22.2U PD=22.2U
* device instance $65 r0 *1 388.795,2 nfet
X$65 \$73__t2 sel_in__t43 vss__t64 vss__t153 nfet_03v3 L=0.35U W=4U AS=4.4P
+ AD=4.4P PS=10.2U PD=10.2U
* device instance $66 r0 *1 391.745,2 nfet
X$66 \$75__t2 rel_1_p__t2 vss__t60 vss__t154 nfet_03v3 L=0.35U W=4U AS=4.4P
+ AD=4.4P PS=10.2U PD=10.2U
* device instance $67 r0 *1 394.695,2 nfet
X$67 \$77__t2 hi_1_p__t2 vss__t59 vss__t155 nfet_03v3 L=0.35U W=4U AS=4.4P
+ AD=4.4P PS=10.2U PD=10.2U
* device instance $68 r0 *1 397.645,2 nfet
X$68 \$79__t2 lo_1_p__t2 vss__t58 vss__t156 nfet_03v3 L=0.35U W=4U AS=4.4P
+ AD=4.4P PS=10.2U PD=10.2U
* device instance $69 r0 *1 400.56,5 nfet
X$69 pinp__t11 sel_in__t21 \$80__t7 vss__t231 nfet_03v3 L=0.28U W=10U AS=11P
+ AD=11P PS=22.2U PD=22.2U
* device instance $70 r0 *1 403.44,5 nfet
X$70 vcm__t24 rel_1_p__t1 \$80__t8 vss__t232 nfet_03v3 L=0.28U W=10U AS=11P
+ AD=11P PS=22.2U PD=22.2U
* device instance $71 r0 *1 406.32,5 nfet
X$71 vref__t18 hi_1_p__t1 \$80__t5 vss__t233 nfet_03v3 L=0.28U W=10U AS=11P
+ AD=11P PS=22.2U PD=22.2U
* device instance $72 r0 *1 409.2,5 nfet
X$72 vss__t24 lo_1_p__t1 \$80__t6 vss__t234 nfet_03v3 L=0.28U W=10U AS=11P
+ AD=11P PS=22.2U PD=22.2U
* device instance $73 r0 *1 1.275,36 nfet
X$73 \$127__t2 sel_in__t49 vss__t94 vss__t157 nfet_03v3 L=0.35U W=4U AS=4.4P
+ AD=4.4P PS=10.2U PD=10.2U
* device instance $74 r0 *1 4.225,36 nfet
X$74 \$129__t2 rel_256_n__t2 vss__t95 vss__t158 nfet_03v3 L=0.35U W=4U AS=4.4P
+ AD=4.4P PS=10.2U PD=10.2U
* device instance $75 r0 *1 7.175,36 nfet
X$75 \$92__t2 hi_256_n__t2 vss__t78 vss__t159 nfet_03v3 L=0.35U W=4U AS=4.4P
+ AD=4.4P PS=10.2U PD=10.2U
* device instance $76 r0 *1 10.125,36 nfet
X$76 \$94__t2 lo_256_n__t2 vss__t96 vss__t160 nfet_03v3 L=0.35U W=4U AS=4.4P
+ AD=4.4P PS=10.2U PD=10.2U
* device instance $77 r0 *1 13.04,39 nfet
X$77 pinn__t12 sel_in__t26 \$81__t260 vss__t235 nfet_03v3 L=0.28U W=10U AS=11P
+ AD=11P PS=22.2U PD=22.2U
* device instance $78 r0 *1 15.92,39 nfet
X$78 vcm__t31 rel_256_n__t1 \$81__t261 vss__t236 nfet_03v3 L=0.28U W=10U AS=11P
+ AD=11P PS=22.2U PD=22.2U
* device instance $79 r0 *1 18.8,39 nfet
X$79 vref__t34 hi_256_n__t1 \$81__t263 vss__t237 nfet_03v3 L=0.28U W=10U AS=11P
+ AD=11P PS=22.2U PD=22.2U
* device instance $80 r0 *1 21.68,39 nfet
X$80 vss__t32 lo_256_n__t1 \$81__t262 vss__t238 nfet_03v3 L=0.28U W=10U AS=11P
+ AD=11P PS=22.2U PD=22.2U
* device instance $81 r0 *1 49.715,36 nfet
X$81 \$130__t2 sel_in__t53 vss__t118 vss__t161 nfet_03v3 L=0.35U W=4U AS=4.4P
+ AD=4.4P PS=10.2U PD=10.2U
* device instance $82 r0 *1 52.665,36 nfet
X$82 \$132__t2 rel_128_n__t2 vss__t105 vss__t162 nfet_03v3 L=0.35U W=4U AS=4.4P
+ AD=4.4P PS=10.2U PD=10.2U
* device instance $83 r0 *1 55.615,36 nfet
X$83 \$96__t2 hi_128_n__t2 vss__t106 vss__t163 nfet_03v3 L=0.35U W=4U AS=4.4P
+ AD=4.4P PS=10.2U PD=10.2U
* device instance $84 r0 *1 58.565,36 nfet
X$84 \$98__t2 lo_128_n__t2 vss__t107 vss__t164 nfet_03v3 L=0.35U W=4U AS=4.4P
+ AD=4.4P PS=10.2U PD=10.2U
* device instance $85 r0 *1 61.48,39 nfet
X$85 pinn__t13 sel_in__t27 \$83__t132 vss__t239 nfet_03v3 L=0.28U W=10U AS=11P
+ AD=11P PS=22.2U PD=22.2U
* device instance $86 r0 *1 64.36,39 nfet
X$86 vcm__t32 rel_128_n__t1 \$83__t133 vss__t240 nfet_03v3 L=0.28U W=10U AS=11P
+ AD=11P PS=22.2U PD=22.2U
* device instance $87 r0 *1 67.24,39 nfet
X$87 vref__t28 hi_128_n__t1 \$83__t134 vss__t241 nfet_03v3 L=0.28U W=10U AS=11P
+ AD=11P PS=22.2U PD=22.2U
* device instance $88 r0 *1 70.12,39 nfet
X$88 vss__t34 lo_128_n__t1 \$83__t135 vss__t242 nfet_03v3 L=0.28U W=10U AS=11P
+ AD=11P PS=22.2U PD=22.2U
* device instance $89 r0 *1 98.155,36 nfet
X$89 \$133__t2 sel_in__t52 vss__t111 vss__t165 nfet_03v3 L=0.35U W=4U AS=4.4P
+ AD=4.4P PS=10.2U PD=10.2U
* device instance $90 r0 *1 101.105,36 nfet
X$90 \$135__t2 rel_64_n__t2 vss__t112 vss__t166 nfet_03v3 L=0.35U W=4U AS=4.4P
+ AD=4.4P PS=10.2U PD=10.2U
* device instance $91 r0 *1 104.055,36 nfet
X$91 \$100__t2 hi_64_n__t2 vss__t113 vss__t167 nfet_03v3 L=0.35U W=4U AS=4.4P
+ AD=4.4P PS=10.2U PD=10.2U
* device instance $92 r0 *1 107.005,36 nfet
X$92 \$102__t2 lo_64_n__t2 vss__t114 vss__t168 nfet_03v3 L=0.35U W=4U AS=4.4P
+ AD=4.4P PS=10.2U PD=10.2U
* device instance $93 r0 *1 109.92,39 nfet
X$93 pinn__t14 sel_in__t28 \$84__t68 vss__t243 nfet_03v3 L=0.28U W=10U AS=11P
+ AD=11P PS=22.2U PD=22.2U
* device instance $94 r0 *1 112.8,39 nfet
X$94 vcm__t34 rel_64_n__t1 \$84__t69 vss__t244 nfet_03v3 L=0.28U W=10U AS=11P
+ AD=11P PS=22.2U PD=22.2U
* device instance $95 r0 *1 115.68,39 nfet
X$95 vref__t29 hi_64_n__t1 \$84__t70 vss__t245 nfet_03v3 L=0.28U W=10U AS=11P
+ AD=11P PS=22.2U PD=22.2U
* device instance $96 r0 *1 118.56,39 nfet
X$96 vss__t37 lo_64_n__t1 \$84__t71 vss__t246 nfet_03v3 L=0.28U W=10U AS=11P
+ AD=11P PS=22.2U PD=22.2U
* device instance $97 r0 *1 146.595,36 nfet
X$97 \$136__t2 sel_in__t39 vss__t51 vss__t169 nfet_03v3 L=0.35U W=4U AS=4.4P
+ AD=4.4P PS=10.2U PD=10.2U
* device instance $98 r0 *1 149.545,36 nfet
X$98 \$138__t2 rel_32_n__t2 vss__t69 vss__t170 nfet_03v3 L=0.35U W=4U AS=4.4P
+ AD=4.4P PS=10.2U PD=10.2U
* device instance $99 r0 *1 152.495,36 nfet
X$99 \$104__t2 hi_32_n__t2 vss__t70 vss__t171 nfet_03v3 L=0.35U W=4U AS=4.4P
+ AD=4.4P PS=10.2U PD=10.2U
* device instance $100 r0 *1 155.445,36 nfet
X$100 \$106__t2 lo_32_n__t2 vss__t71 vss__t172 nfet_03v3 L=0.35U W=4U AS=4.4P
+ AD=4.4P PS=10.2U PD=10.2U
* device instance $101 r0 *1 158.36,39 nfet
X$101 pinn__t15 sel_in__t32 \$85__t36 vss__t247 nfet_03v3 L=0.28U W=10U AS=11P
+ AD=11P PS=22.2U PD=22.2U
* device instance $102 r0 *1 161.24,39 nfet
X$102 vcm__t37 rel_32_n__t1 \$85__t37 vss__t248 nfet_03v3 L=0.28U W=10U AS=11P
+ AD=11P PS=22.2U PD=22.2U
* device instance $103 r0 *1 164.12,39 nfet
X$103 vref__t33 hi_32_n__t1 \$85__t38 vss__t249 nfet_03v3 L=0.28U W=10U AS=11P
+ AD=11P PS=22.2U PD=22.2U
* device instance $104 r0 *1 167,39 nfet
X$104 vss__t39 lo_32_n__t1 \$85__t39 vss__t250 nfet_03v3 L=0.28U W=10U AS=11P
+ AD=11P PS=22.2U PD=22.2U
* device instance $105 r0 *1 195.035,36 nfet
X$105 \$139__t2 sel_in__t46 vss__t74 vss__t173 nfet_03v3 L=0.35U W=4U AS=4.4P
+ AD=4.4P PS=10.2U PD=10.2U
* device instance $106 r0 *1 197.985,36 nfet
X$106 \$141__t2 rel_16_n__t2 vss__t75 vss__t174 nfet_03v3 L=0.35U W=4U AS=4.4P
+ AD=4.4P PS=10.2U PD=10.2U
* device instance $107 r0 *1 200.935,36 nfet
X$107 \$108__t2 hi_16_n__t2 vss__t76 vss__t175 nfet_03v3 L=0.35U W=4U AS=4.4P
+ AD=4.4P PS=10.2U PD=10.2U
* device instance $108 r0 *1 203.885,36 nfet
X$108 \$110__t2 lo_16_n__t2 vss__t77 vss__t176 nfet_03v3 L=0.35U W=4U AS=4.4P
+ AD=4.4P PS=10.2U PD=10.2U
* device instance $109 r0 *1 206.8,39 nfet
X$109 pinn__t16 sel_in__t34 \$86__t20 vss__t251 nfet_03v3 L=0.28U W=10U AS=11P
+ AD=11P PS=22.2U PD=22.2U
* device instance $110 r0 *1 209.68,39 nfet
X$110 vcm__t39 rel_16_n__t1 \$86__t21 vss__t252 nfet_03v3 L=0.28U W=10U AS=11P
+ AD=11P PS=22.2U PD=22.2U
* device instance $111 r0 *1 212.56,39 nfet
X$111 vref__t35 hi_16_n__t1 \$86__t23 vss__t253 nfet_03v3 L=0.28U W=10U AS=11P
+ AD=11P PS=22.2U PD=22.2U
* device instance $112 r0 *1 215.44,39 nfet
X$112 vss__t40 lo_16_n__t1 \$86__t22 vss__t254 nfet_03v3 L=0.28U W=10U AS=11P
+ AD=11P PS=22.2U PD=22.2U
* device instance $113 r0 *1 243.475,36 nfet
X$113 \$142__t2 sel_in__t47 vss__t80 vss__t177 nfet_03v3 L=0.35U W=4U AS=4.4P
+ AD=4.4P PS=10.2U PD=10.2U
* device instance $114 r0 *1 246.425,36 nfet
X$114 \$144__t2 rel_8_n__t2 vss__t81 vss__t178 nfet_03v3 L=0.35U W=4U AS=4.4P
+ AD=4.4P PS=10.2U PD=10.2U
* device instance $115 r0 *1 249.375,36 nfet
X$115 \$112__t2 hi_8_n__t2 vss__t82 vss__t179 nfet_03v3 L=0.35U W=4U AS=4.4P
+ AD=4.4P PS=10.2U PD=10.2U
* device instance $116 r0 *1 252.325,36 nfet
X$116 \$114__t2 lo_8_n__t2 vss__t83 vss__t180 nfet_03v3 L=0.35U W=4U AS=4.4P
+ AD=4.4P PS=10.2U PD=10.2U
* device instance $117 r0 *1 255.24,39 nfet
X$117 pinn__t17 sel_in__t36 \$87__t15 vss__t255 nfet_03v3 L=0.28U W=10U AS=11P
+ AD=11P PS=22.2U PD=22.2U
* device instance $118 r0 *1 258.12,39 nfet
X$118 vcm__t41 rel_8_n__t1 \$87__t14 vss__t256 nfet_03v3 L=0.28U W=10U AS=11P
+ AD=11P PS=22.2U PD=22.2U
* device instance $119 r0 *1 261,39 nfet
X$119 vref__t26 hi_8_n__t1 \$87__t12 vss__t257 nfet_03v3 L=0.28U W=10U AS=11P
+ AD=11P PS=22.2U PD=22.2U
* device instance $120 r0 *1 263.88,39 nfet
X$120 vss__t30 lo_8_n__t1 \$87__t13 vss__t258 nfet_03v3 L=0.28U W=10U AS=11P
+ AD=11P PS=22.2U PD=22.2U
* device instance $121 r0 *1 291.915,36 nfet
X$121 \$145__t2 sel_in__t50 vss__t102 vss__t181 nfet_03v3 L=0.35U W=4U AS=4.4P
+ AD=4.4P PS=10.2U PD=10.2U
* device instance $122 r0 *1 294.865,36 nfet
X$122 \$147__t2 rel_4_n__t2 vss__t45 vss__t182 nfet_03v3 L=0.35U W=4U AS=4.4P
+ AD=4.4P PS=10.2U PD=10.2U
* device instance $123 r0 *1 297.815,36 nfet
X$123 \$116__t2 hi_4_n__t2 vss__t46 vss__t183 nfet_03v3 L=0.35U W=4U AS=4.4P
+ AD=4.4P PS=10.2U PD=10.2U
* device instance $124 r0 *1 300.765,36 nfet
X$124 \$118__t2 lo_4_n__t2 vss__t65 vss__t184 nfet_03v3 L=0.35U W=4U AS=4.4P
+ AD=4.4P PS=10.2U PD=10.2U
* device instance $125 r0 *1 303.68,39 nfet
X$125 pinn__t11 sel_in__t25 \$88__t11 vss__t259 nfet_03v3 L=0.28U W=10U AS=11P
+ AD=11P PS=22.2U PD=22.2U
* device instance $126 r0 *1 306.56,39 nfet
X$126 vcm__t28 rel_4_n__t1 \$88__t10 vss__t260 nfet_03v3 L=0.28U W=10U AS=11P
+ AD=11P PS=22.2U PD=22.2U
* device instance $127 r0 *1 309.44,39 nfet
X$127 vref__t23 hi_4_n__t1 \$88__t9 vss__t261 nfet_03v3 L=0.28U W=10U AS=11P
+ AD=11P PS=22.2U PD=22.2U
* device instance $128 r0 *1 312.32,39 nfet
X$128 vss__t28 lo_4_n__t1 \$88__t8 vss__t262 nfet_03v3 L=0.28U W=10U AS=11P
+ AD=11P PS=22.2U PD=22.2U
* device instance $129 r0 *1 340.355,36 nfet
X$129 \$148__t2 sel_in__t41 vss__t53 vss__t185 nfet_03v3 L=0.35U W=4U AS=4.4P
+ AD=4.4P PS=10.2U PD=10.2U
* device instance $130 r0 *1 343.305,36 nfet
X$130 \$150__t2 rel_2_n__t2 vss__t61 vss__t186 nfet_03v3 L=0.35U W=4U AS=4.4P
+ AD=4.4P PS=10.2U PD=10.2U
* device instance $131 r0 *1 346.255,36 nfet
X$131 \$120__t2 hi_2_n__t2 vss__t63 vss__t187 nfet_03v3 L=0.35U W=4U AS=4.4P
+ AD=4.4P PS=10.2U PD=10.2U
* device instance $132 r0 *1 349.205,36 nfet
X$132 \$122__t2 lo_2_n__t2 vss__t62 vss__t188 nfet_03v3 L=0.35U W=4U AS=4.4P
+ AD=4.4P PS=10.2U PD=10.2U
* device instance $133 r0 *1 352.12,39 nfet
X$133 pinn__t9 sel_in__t23 \$89__t9 vss__t263 nfet_03v3 L=0.28U W=10U AS=11P
+ AD=11P PS=22.2U PD=22.2U
* device instance $134 r0 *1 355,39 nfet
X$134 vcm__t27 rel_2_n__t1 \$89__t8 vss__t264 nfet_03v3 L=0.28U W=10U AS=11P
+ AD=11P PS=22.2U PD=22.2U
* device instance $135 r0 *1 357.88,39 nfet
X$135 vref__t22 hi_2_n__t1 \$89__t7 vss__t265 nfet_03v3 L=0.28U W=10U AS=11P
+ AD=11P PS=22.2U PD=22.2U
* device instance $136 r0 *1 360.76,39 nfet
X$136 vss__t27 lo_2_n__t1 \$89__t6 vss__t266 nfet_03v3 L=0.28U W=10U AS=11P
+ AD=11P PS=22.2U PD=22.2U
* device instance $137 r0 *1 388.795,36 nfet
X$137 \$151__t2 sel_in__t40 vss__t52 vss__t189 nfet_03v3 L=0.35U W=4U AS=4.4P
+ AD=4.4P PS=10.2U PD=10.2U
* device instance $138 r0 *1 391.745,36 nfet
X$138 \$153__t2 rel_1_n__t2 vss__t49 vss__t190 nfet_03v3 L=0.35U W=4U AS=4.4P
+ AD=4.4P PS=10.2U PD=10.2U
* device instance $139 r0 *1 394.695,36 nfet
X$139 \$124__t2 hi_1_n__t2 vss__t48 vss__t191 nfet_03v3 L=0.35U W=4U AS=4.4P
+ AD=4.4P PS=10.2U PD=10.2U
* device instance $140 r0 *1 397.645,36 nfet
X$140 \$126__t2 lo_1_n__t2 vss__t43 vss__t192 nfet_03v3 L=0.35U W=4U AS=4.4P
+ AD=4.4P PS=10.2U PD=10.2U
* device instance $141 r0 *1 400.56,39 nfet
X$141 pinn__t10 sel_in__t24 \$90__t5 vss__t267 nfet_03v3 L=0.28U W=10U AS=11P
+ AD=11P PS=22.2U PD=22.2U
* device instance $142 r0 *1 403.44,39 nfet
X$142 vcm__t29 rel_1_n__t1 \$90__t6 vss__t268 nfet_03v3 L=0.28U W=10U AS=11P
+ AD=11P PS=22.2U PD=22.2U
* device instance $143 r0 *1 406.32,39 nfet
X$143 vref__t25 hi_1_n__t1 \$90__t7 vss__t269 nfet_03v3 L=0.28U W=10U AS=11P
+ AD=11P PS=22.2U PD=22.2U
* device instance $144 r0 *1 409.2,39 nfet
X$144 vss__t29 lo_1_n__t1 \$90__t8 vss__t270 nfet_03v3 L=0.28U W=10U AS=11P
+ AD=11P PS=22.2U PD=22.2U
* device instance $145 r0 *1 444.075,70 nfet
X$145 \$171__t2 tp_gn__t5 vss__t99 vss__t197 nfet_03v3 L=0.35U W=4U AS=4.4P
+ AD=4.4P PS=10.2U PD=10.2U
* device instance $146 r0 *1 446.99,73 nfet
X$146 vcm__t26 tp_gn__t3 topp__t514 vss__t271 nfet_03v3 L=0.28U W=10U AS=11P
+ AD=11P PS=22.2U PD=22.2U
* device instance $147 r0 *1 457.535,70 nfet
X$147 \$172__t2 tp_gn__t4 vss__t97 vss__t198 nfet_03v3 L=0.35U W=4U AS=4.4P
+ AD=4.4P PS=10.2U PD=10.2U
* device instance $148 r0 *1 460.45,73 nfet
X$148 vcm__t25 tp_gn__t2 topn__t514 vss__t272 nfet_03v3 L=0.28U W=10U AS=11P
+ AD=11P PS=22.2U PD=22.2U
* device instance $149 r0 *1 480.8,73.66 nfet
X$149 ibias__t0 ibias__t1 vss__t1 vss__t273 nfet_03v3 L=2U W=20U AS=22P AD=22P
+ PS=42.2U PD=42.2U
* device instance $150 r0 *1 484.9,83.66 nfet
X$150 XCMP_pon__t0 topp__t1 \$155__t0 vss__t275 nfet_03v3 L=1U W=40U AS=44P
+ AD=44P PS=82.2U PD=82.2U
* device instance $151 r0 *1 488.5,83.66 nfet
X$151 XCMP_pop__t2 topn__t0 \$155__t1 vss__t276 nfet_03v3 L=1U W=40U AS=44P
+ AD=44P PS=82.2U PD=82.2U
* device instance $152 r0 *1 492.6,73.66 nfet
X$152 \$155__t2 ibias__t2 vss__t5 vss__t274 nfet_03v3 L=2U W=20U AS=22P AD=22P
+ PS=42.2U PD=42.2U
* device instance $153 r0 *1 497.275,71.66 nfet
X$153 \$158__t0 cmpclk__t0 vss__t2 vss__t277 nfet_03v3 L=0.35U W=16U AS=17.6P
+ AD=17.6P PS=34.2U PD=34.2U
* device instance $154 r0 *1 500.3,67.66 nfet
X$154 \$159__t0 XCMP_pop__t1 \$158__t1 vss__t278 nfet_03v3 L=0.5U W=8U AS=8.8P
+ AD=8.8P PS=18.2U PD=18.2U
* device instance $155 r0 *1 503.4,67.66 nfet
X$155 \$160__t2 XCMP_pon__t1 \$158__t2 vss__t279 nfet_03v3 L=0.5U W=8U AS=8.8P
+ AD=8.8P PS=18.2U PD=18.2U
* device instance $156 r0 *1 506.425,66.66 nfet
X$156 \$162__t2 \$161__t0 \$159__t1 vss__t280 nfet_03v3 L=0.35U W=6U AS=6.6P
+ AD=6.6P PS=14.2U PD=14.2U
* device instance $157 r0 *1 509.375,66.66 nfet
X$157 \$161__t1 \$162__t4 \$160__t1 vss__t281 nfet_03v3 L=0.35U W=6U AS=6.6P
+ AD=6.6P PS=14.2U PD=14.2U
* device instance $158 r0 *1 531.825,64.16 nfet
X$158 \$163__t0 \$162__t0 vss__t3 vss__t282 nfet_03v3 L=0.35U W=1U AS=1.1P
+ AD=1.1P PS=4.2U PD=4.2U
* device instance $159 r0 *1 539.525,64.16 nfet
X$159 \$164__t0 \$161__t3 vss__t4 vss__t283 nfet_03v3 L=0.35U W=1U AS=1.1P
+ AD=1.1P PS=4.2U PD=4.2U
* device instance $160 r0 *1 547.225,65.66 nfet
X$160 dout__t3 \$164__t3 vss__t116 vss__t193 nfet_03v3 L=0.35U W=4U AS=4.4P
+ AD=4.4P PS=10.2U PD=10.2U
* device instance $161 r0 *1 550.175,65.66 nfet
X$161 dout__t2 doutb__t4 vss__t110 vss__t194 nfet_03v3 L=0.35U W=4U AS=4.4P
+ AD=4.4P PS=10.2U PD=10.2U
* device instance $162 r0 *1 560.825,65.66 nfet
X$162 doutb__t3 \$163__t3 vss__t109 vss__t195 nfet_03v3 L=0.35U W=4U AS=4.4P
+ AD=4.4P PS=10.2U PD=10.2U
* device instance $163 r0 *1 563.775,65.66 nfet
X$163 doutb__t2 dout__t4 vss__t100 vss__t196 nfet_03v3 L=0.35U W=4U AS=4.4P
+ AD=4.4P PS=10.2U PD=10.2U
* device instance $164 r0 *1 25.495,4 pfet
X$164 \$5__t1 sel_in__t4 vdd__t0 vdd__t1 pfet_03v3 L=0.35U W=8U AS=8.8P AD=8.8P
+ PS=18.2U PD=18.2U
* device instance $165 r0 *1 28.445,4 pfet
X$165 \$7__t1 rel_256_p__t0 vdd__t189 vdd__t112 pfet_03v3 L=0.35U W=8U AS=8.8P
+ AD=8.8P PS=18.2U PD=18.2U
* device instance $166 r0 *1 31.395,4 pfet
X$166 \$9__t1 hi_256_p__t0 vdd__t188 vdd__t111 pfet_03v3 L=0.35U W=8U AS=8.8P
+ AD=8.8P PS=18.2U PD=18.2U
* device instance $167 r0 *1 34.345,4 pfet
X$167 \$11__t1 lo_256_p__t0 vdd__t187 vdd__t110 pfet_03v3 L=0.35U W=8U AS=8.8P
+ AD=8.8P PS=18.2U PD=18.2U
* device instance $168 r0 *1 37.26,10 pfet
X$168 pinp__t1 \$5__t2 \$12__t1 vdd__t2 pfet_03v3 L=0.28U W=20U AS=22P AD=22P
+ PS=42.2U PD=42.2U
* device instance $169 r0 *1 40.14,10 pfet
X$169 vcm__t12 \$7__t0 \$12__t260 vdd__t57 pfet_03v3 L=0.28U W=20U AS=22P
+ AD=22P PS=42.2U PD=42.2U
* device instance $170 r0 *1 43.02,10 pfet
X$170 vref__t10 \$9__t0 \$12__t259 vdd__t56 pfet_03v3 L=0.28U W=20U AS=22P
+ AD=22P PS=42.2U PD=42.2U
* device instance $171 r0 *1 45.9,10 pfet
X$171 vss__t16 \$11__t0 \$12__t258 vdd__t55 pfet_03v3 L=0.28U W=20U AS=22P
+ AD=22P PS=42.2U PD=42.2U
* device instance $172 r0 *1 73.935,4 pfet
X$172 \$17__t1 sel_in__t17 vdd__t231 vdd__t154 pfet_03v3 L=0.35U W=8U AS=8.8P
+ AD=8.8P PS=18.2U PD=18.2U
* device instance $173 r0 *1 76.885,4 pfet
X$173 \$19__t1 rel_128_p__t0 vdd__t230 vdd__t153 pfet_03v3 L=0.35U W=8U AS=8.8P
+ AD=8.8P PS=18.2U PD=18.2U
* device instance $174 r0 *1 79.835,4 pfet
X$174 \$21__t1 hi_128_p__t0 vdd__t229 vdd__t152 pfet_03v3 L=0.35U W=8U AS=8.8P
+ AD=8.8P PS=18.2U PD=18.2U
* device instance $175 r0 *1 82.785,4 pfet
X$175 \$23__t1 lo_128_p__t0 vdd__t228 vdd__t151 pfet_03v3 L=0.35U W=8U AS=8.8P
+ AD=8.8P PS=18.2U PD=18.2U
* device instance $176 r0 *1 85.7,10 pfet
X$176 pinp__t7 \$17__t0 \$24__t131 vdd__t54 pfet_03v3 L=0.28U W=20U AS=22P
+ AD=22P PS=42.2U PD=42.2U
* device instance $177 r0 *1 88.58,10 pfet
X$177 vcm__t11 \$19__t0 \$24__t130 vdd__t53 pfet_03v3 L=0.28U W=20U AS=22P
+ AD=22P PS=42.2U PD=42.2U
* device instance $178 r0 *1 91.46,10 pfet
X$178 vref__t9 \$21__t0 \$24__t129 vdd__t52 pfet_03v3 L=0.28U W=20U AS=22P
+ AD=22P PS=42.2U PD=42.2U
* device instance $179 r0 *1 94.34,10 pfet
X$179 vss__t15 \$23__t0 \$24__t128 vdd__t51 pfet_03v3 L=0.28U W=20U AS=22P
+ AD=22P PS=42.2U PD=42.2U
* device instance $180 r0 *1 122.375,4 pfet
X$180 \$25__t1 sel_in__t16 vdd__t227 vdd__t150 pfet_03v3 L=0.35U W=8U AS=8.8P
+ AD=8.8P PS=18.2U PD=18.2U
* device instance $181 r0 *1 125.325,4 pfet
X$181 \$27__t1 rel_64_p__t0 vdd__t237 vdd__t160 pfet_03v3 L=0.35U W=8U AS=8.8P
+ AD=8.8P PS=18.2U PD=18.2U
* device instance $182 r0 *1 128.275,4 pfet
X$182 \$29__t1 hi_64_p__t0 vdd__t176 vdd__t99 pfet_03v3 L=0.35U W=8U AS=8.8P
+ AD=8.8P PS=18.2U PD=18.2U
* device instance $183 r0 *1 131.225,4 pfet
X$183 \$31__t1 lo_64_p__t0 vdd__t185 vdd__t108 pfet_03v3 L=0.35U W=8U AS=8.8P
+ AD=8.8P PS=18.2U PD=18.2U
* device instance $184 r0 *1 134.14,10 pfet
X$184 pinp__t6 \$25__t0 \$32__t67 vdd__t50 pfet_03v3 L=0.28U W=20U AS=22P
+ AD=22P PS=42.2U PD=42.2U
* device instance $185 r0 *1 137.02,10 pfet
X$185 vcm__t10 \$27__t0 \$32__t66 vdd__t49 pfet_03v3 L=0.28U W=20U AS=22P
+ AD=22P PS=42.2U PD=42.2U
* device instance $186 r0 *1 139.9,10 pfet
X$186 vref__t8 \$29__t0 \$32__t65 vdd__t48 pfet_03v3 L=0.28U W=20U AS=22P
+ AD=22P PS=42.2U PD=42.2U
* device instance $187 r0 *1 142.78,10 pfet
X$187 vss__t14 \$31__t0 \$32__t64 vdd__t47 pfet_03v3 L=0.28U W=20U AS=22P
+ AD=22P PS=42.2U PD=42.2U
* device instance $188 r0 *1 170.815,4 pfet
X$188 \$33__t1 sel_in__t15 vdd__t226 vdd__t149 pfet_03v3 L=0.35U W=8U AS=8.8P
+ AD=8.8P PS=18.2U PD=18.2U
* device instance $189 r0 *1 173.765,4 pfet
X$189 \$35__t1 rel_32_p__t0 vdd__t236 vdd__t159 pfet_03v3 L=0.35U W=8U AS=8.8P
+ AD=8.8P PS=18.2U PD=18.2U
* device instance $190 r0 *1 176.715,4 pfet
X$190 \$37__t1 hi_32_p__t0 vdd__t242 vdd__t165 pfet_03v3 L=0.35U W=8U AS=8.8P
+ AD=8.8P PS=18.2U PD=18.2U
* device instance $191 r0 *1 179.665,4 pfet
X$191 \$39__t1 lo_32_p__t0 vdd__t243 vdd__t166 pfet_03v3 L=0.35U W=8U AS=8.8P
+ AD=8.8P PS=18.2U PD=18.2U
* device instance $192 r0 *1 182.58,10 pfet
X$192 pinp__t5 \$33__t0 \$40__t34 vdd__t44 pfet_03v3 L=0.28U W=20U AS=22P
+ AD=22P PS=42.2U PD=42.2U
* device instance $193 r0 *1 185.46,10 pfet
X$193 vcm__t13 \$35__t0 \$40__t35 vdd__t58 pfet_03v3 L=0.28U W=20U AS=22P
+ AD=22P PS=42.2U PD=42.2U
* device instance $194 r0 *1 188.34,10 pfet
X$194 vref__t6 \$37__t0 \$40__t33 vdd__t42 pfet_03v3 L=0.28U W=20U AS=22P
+ AD=22P PS=42.2U PD=42.2U
* device instance $195 r0 *1 191.22,10 pfet
X$195 vss__t12 \$39__t0 \$40__t32 vdd__t41 pfet_03v3 L=0.28U W=20U AS=22P
+ AD=22P PS=42.2U PD=42.2U
* device instance $196 r0 *1 219.255,4 pfet
X$196 \$41__t1 sel_in__t13 vdd__t223 vdd__t146 pfet_03v3 L=0.35U W=8U AS=8.8P
+ AD=8.8P PS=18.2U PD=18.2U
* device instance $197 r0 *1 222.205,4 pfet
X$197 \$43__t1 rel_16_p__t0 vdd__t222 vdd__t145 pfet_03v3 L=0.35U W=8U AS=8.8P
+ AD=8.8P PS=18.2U PD=18.2U
* device instance $198 r0 *1 225.155,4 pfet
X$198 \$45__t1 hi_16_p__t0 vdd__t215 vdd__t138 pfet_03v3 L=0.35U W=8U AS=8.8P
+ AD=8.8P PS=18.2U PD=18.2U
* device instance $199 r0 *1 228.105,4 pfet
X$199 \$47__t1 lo_16_p__t0 vdd__t181 vdd__t104 pfet_03v3 L=0.35U W=8U AS=8.8P
+ AD=8.8P PS=18.2U PD=18.2U
* device instance $200 r0 *1 231.02,10 pfet
X$200 pinp__t4 \$41__t0 \$48__t19 vdd__t40 pfet_03v3 L=0.28U W=20U AS=22P
+ AD=22P PS=42.2U PD=42.2U
* device instance $201 r0 *1 233.9,10 pfet
X$201 vcm__t8 \$43__t0 \$48__t18 vdd__t39 pfet_03v3 L=0.28U W=20U AS=22P AD=22P
+ PS=42.2U PD=42.2U
* device instance $202 r0 *1 236.78,10 pfet
X$202 vref__t5 \$45__t0 \$48__t17 vdd__t36 pfet_03v3 L=0.28U W=20U AS=22P
+ AD=22P PS=42.2U PD=42.2U
* device instance $203 r0 *1 239.66,10 pfet
X$203 vss__t11 \$47__t0 \$48__t16 vdd__t35 pfet_03v3 L=0.28U W=20U AS=22P
+ AD=22P PS=42.2U PD=42.2U
* device instance $204 r0 *1 267.695,4 pfet
X$204 \$49__t1 sel_in__t6 vdd__t198 vdd__t121 pfet_03v3 L=0.35U W=8U AS=8.8P
+ AD=8.8P PS=18.2U PD=18.2U
* device instance $205 r0 *1 270.645,4 pfet
X$205 \$51__t1 rel_8_p__t0 vdd__t197 vdd__t120 pfet_03v3 L=0.35U W=8U AS=8.8P
+ AD=8.8P PS=18.2U PD=18.2U
* device instance $206 r0 *1 273.595,4 pfet
X$206 \$53__t1 hi_8_p__t0 vdd__t191 vdd__t114 pfet_03v3 L=0.35U W=8U AS=8.8P
+ AD=8.8P PS=18.2U PD=18.2U
* device instance $207 r0 *1 276.545,4 pfet
X$207 \$55__t1 lo_8_p__t0 vdd__t190 vdd__t113 pfet_03v3 L=0.35U W=8U AS=8.8P
+ AD=8.8P PS=18.2U PD=18.2U
* device instance $208 r0 *1 279.46,10 pfet
X$208 pinp__t9 \$49__t0 \$56__t8 vdd__t73 pfet_03v3 L=0.28U W=20U AS=22P AD=22P
+ PS=42.2U PD=42.2U
* device instance $209 r0 *1 282.34,10 pfet
X$209 vcm__t21 \$51__t0 \$56__t10 vdd__t87 pfet_03v3 L=0.28U W=20U AS=22P
+ AD=22P PS=42.2U PD=42.2U
* device instance $210 r0 *1 285.22,10 pfet
X$210 vref__t17 \$53__t0 \$56__t11 vdd__t88 pfet_03v3 L=0.28U W=20U AS=22P
+ AD=22P PS=42.2U PD=42.2U
* device instance $211 r0 *1 288.1,10 pfet
X$211 vss__t23 \$55__t0 \$56__t9 vdd__t86 pfet_03v3 L=0.28U W=20U AS=22P AD=22P
+ PS=42.2U PD=42.2U
* device instance $212 r0 *1 316.135,4 pfet
X$212 \$57__t1 sel_in__t10 vdd__t210 vdd__t133 pfet_03v3 L=0.35U W=8U AS=8.8P
+ AD=8.8P PS=18.2U PD=18.2U
* device instance $213 r0 *1 319.085,4 pfet
X$213 \$59__t1 rel_4_p__t0 vdd__t211 vdd__t134 pfet_03v3 L=0.35U W=8U AS=8.8P
+ AD=8.8P PS=18.2U PD=18.2U
* device instance $214 r0 *1 322.035,4 pfet
X$214 \$61__t1 hi_4_p__t0 vdd__t212 vdd__t135 pfet_03v3 L=0.35U W=8U AS=8.8P
+ AD=8.8P PS=18.2U PD=18.2U
* device instance $215 r0 *1 324.985,4 pfet
X$215 \$63__t1 lo_4_p__t0 vdd__t213 vdd__t136 pfet_03v3 L=0.35U W=8U AS=8.8P
+ AD=8.8P PS=18.2U PD=18.2U
* device instance $216 r0 *1 327.9,10 pfet
X$216 pinp__t2 \$57__t0 \$64__t7 vdd__t26 pfet_03v3 L=0.28U W=20U AS=22P AD=22P
+ PS=42.2U PD=42.2U
* device instance $217 r0 *1 330.78,10 pfet
X$217 vcm__t4 \$59__t0 \$64__t6 vdd__t25 pfet_03v3 L=0.28U W=20U AS=22P AD=22P
+ PS=42.2U PD=42.2U
* device instance $218 r0 *1 333.66,10 pfet
X$218 vref__t2 \$61__t0 \$64__t5 vdd__t24 pfet_03v3 L=0.28U W=20U AS=22P AD=22P
+ PS=42.2U PD=42.2U
* device instance $219 r0 *1 336.54,10 pfet
X$219 vss__t7 \$63__t0 \$64__t4 vdd__t20 pfet_03v3 L=0.28U W=20U AS=22P AD=22P
+ PS=42.2U PD=42.2U
* device instance $220 r0 *1 364.575,4 pfet
X$220 \$65__t1 sel_in__t12 vdd__t218 vdd__t141 pfet_03v3 L=0.35U W=8U AS=8.8P
+ AD=8.8P PS=18.2U PD=18.2U
* device instance $221 r0 *1 367.525,4 pfet
X$221 \$67__t1 rel_2_p__t0 vdd__t219 vdd__t142 pfet_03v3 L=0.35U W=8U AS=8.8P
+ AD=8.8P PS=18.2U PD=18.2U
* device instance $222 r0 *1 370.475,4 pfet
X$222 \$69__t1 hi_2_p__t0 vdd__t220 vdd__t143 pfet_03v3 L=0.35U W=8U AS=8.8P
+ AD=8.8P PS=18.2U PD=18.2U
* device instance $223 r0 *1 373.425,4 pfet
X$223 \$71__t1 lo_2_p__t0 vdd__t221 vdd__t144 pfet_03v3 L=0.35U W=8U AS=8.8P
+ AD=8.8P PS=18.2U PD=18.2U
* device instance $224 r0 *1 376.34,10 pfet
X$224 pinp__t3 \$65__t0 \$72__t5 vdd__t28 pfet_03v3 L=0.28U W=20U AS=22P AD=22P
+ PS=42.2U PD=42.2U
* device instance $225 r0 *1 379.22,10 pfet
X$225 vcm__t3 \$67__t0 \$72__t4 vdd__t23 pfet_03v3 L=0.28U W=20U AS=22P AD=22P
+ PS=42.2U PD=42.2U
* device instance $226 r0 *1 382.1,10 pfet
X$226 vref__t1 \$69__t0 \$72__t3 vdd__t22 pfet_03v3 L=0.28U W=20U AS=22P AD=22P
+ PS=42.2U PD=42.2U
* device instance $227 r0 *1 384.98,10 pfet
X$227 vss__t8 \$71__t0 \$72__t2 vdd__t21 pfet_03v3 L=0.28U W=20U AS=22P AD=22P
+ PS=42.2U PD=42.2U
* device instance $228 r0 *1 413.015,4 pfet
X$228 \$73__t1 sel_in__t14 vdd__t224 vdd__t147 pfet_03v3 L=0.35U W=8U AS=8.8P
+ AD=8.8P PS=18.2U PD=18.2U
* device instance $229 r0 *1 415.965,4 pfet
X$229 \$75__t1 rel_1_p__t0 vdd__t178 vdd__t101 pfet_03v3 L=0.35U W=8U AS=8.8P
+ AD=8.8P PS=18.2U PD=18.2U
* device instance $230 r0 *1 418.915,4 pfet
X$230 \$77__t1 hi_1_p__t0 vdd__t179 vdd__t102 pfet_03v3 L=0.35U W=8U AS=8.8P
+ AD=8.8P PS=18.2U PD=18.2U
* device instance $231 r0 *1 421.865,4 pfet
X$231 \$79__t1 lo_1_p__t0 vdd__t180 vdd__t103 pfet_03v3 L=0.35U W=8U AS=8.8P
+ AD=8.8P PS=18.2U PD=18.2U
* device instance $232 r0 *1 424.78,10 pfet
X$232 pinp__t8 \$73__t0 \$80__t4 vdd__t59 pfet_03v3 L=0.28U W=20U AS=22P AD=22P
+ PS=42.2U PD=42.2U
* device instance $233 r0 *1 427.66,10 pfet
X$233 vcm__t5 \$75__t0 \$80__t3 vdd__t27 pfet_03v3 L=0.28U W=20U AS=22P AD=22P
+ PS=42.2U PD=42.2U
* device instance $234 r0 *1 430.54,10 pfet
X$234 vref__t0 \$77__t0 \$80__t1 vdd__t18 pfet_03v3 L=0.28U W=20U AS=22P AD=22P
+ PS=42.2U PD=42.2U
* device instance $235 r0 *1 433.42,10 pfet
X$235 vss__t6 \$79__t0 \$80__t2 vdd__t19 pfet_03v3 L=0.28U W=20U AS=22P AD=22P
+ PS=42.2U PD=42.2U
* device instance $236 r0 *1 25.495,38 pfet
X$236 \$127__t1 sel_in__t7 vdd__t203 vdd__t126 pfet_03v3 L=0.35U W=8U AS=8.8P
+ AD=8.8P PS=18.2U PD=18.2U
* device instance $237 r0 *1 28.445,38 pfet
X$237 \$129__t1 rel_256_n__t0 vdd__t202 vdd__t125 pfet_03v3 L=0.35U W=8U
+ AS=8.8P AD=8.8P PS=18.2U PD=18.2U
* device instance $238 r0 *1 31.395,38 pfet
X$238 \$92__t1 hi_256_n__t0 vdd__t201 vdd__t124 pfet_03v3 L=0.35U W=8U AS=8.8P
+ AD=8.8P PS=18.2U PD=18.2U
* device instance $239 r0 *1 34.345,38 pfet
X$239 \$94__t1 lo_256_n__t0 vdd__t200 vdd__t123 pfet_03v3 L=0.35U W=8U AS=8.8P
+ AD=8.8P PS=18.2U PD=18.2U
* device instance $240 r0 *1 37.26,44 pfet
X$240 pinn__t2 \$127__t0 \$81__t256 vdd__t60 pfet_03v3 L=0.28U W=20U AS=22P
+ AD=22P PS=42.2U PD=42.2U
* device instance $241 r0 *1 40.14,44 pfet
X$241 vcm__t14 \$129__t0 \$81__t257 vdd__t61 pfet_03v3 L=0.28U W=20U AS=22P
+ AD=22P PS=42.2U PD=42.2U
* device instance $242 r0 *1 43.02,44 pfet
X$242 vref__t11 \$92__t0 \$81__t258 vdd__t62 pfet_03v3 L=0.28U W=20U AS=22P
+ AD=22P PS=42.2U PD=42.2U
* device instance $243 r0 *1 45.9,44 pfet
X$243 vss__t17 \$94__t0 \$81__t259 vdd__t63 pfet_03v3 L=0.28U W=20U AS=22P
+ AD=22P PS=42.2U PD=42.2U
* device instance $244 r0 *1 73.935,38 pfet
X$244 \$130__t1 sel_in__t8 vdd__t205 vdd__t128 pfet_03v3 L=0.35U W=8U AS=8.8P
+ AD=8.8P PS=18.2U PD=18.2U
* device instance $245 r0 *1 76.885,38 pfet
X$245 \$132__t1 rel_128_n__t0 vdd__t194 vdd__t117 pfet_03v3 L=0.35U W=8U
+ AS=8.8P AD=8.8P PS=18.2U PD=18.2U
* device instance $246 r0 *1 79.835,38 pfet
X$246 \$96__t1 hi_128_n__t0 vdd__t193 vdd__t116 pfet_03v3 L=0.35U W=8U AS=8.8P
+ AD=8.8P PS=18.2U PD=18.2U
* device instance $247 r0 *1 82.785,38 pfet
X$247 \$98__t1 lo_128_n__t0 vdd__t238 vdd__t161 pfet_03v3 L=0.35U W=8U AS=8.8P
+ AD=8.8P PS=18.2U PD=18.2U
* device instance $248 r0 *1 85.7,44 pfet
X$248 pinn__t3 \$130__t0 \$83__t128 vdd__t64 pfet_03v3 L=0.28U W=20U AS=22P
+ AD=22P PS=42.2U PD=42.2U
* device instance $249 r0 *1 88.58,44 pfet
X$249 vcm__t15 \$132__t0 \$83__t129 vdd__t65 pfet_03v3 L=0.28U W=20U AS=22P
+ AD=22P PS=42.2U PD=42.2U
* device instance $250 r0 *1 91.46,44 pfet
X$250 vref__t12 \$96__t0 \$83__t130 vdd__t66 pfet_03v3 L=0.28U W=20U AS=22P
+ AD=22P PS=42.2U PD=42.2U
* device instance $251 r0 *1 94.34,44 pfet
X$251 vss__t18 \$98__t0 \$83__t131 vdd__t69 pfet_03v3 L=0.28U W=20U AS=22P
+ AD=22P PS=42.2U PD=42.2U
* device instance $252 r0 *1 122.375,38 pfet
X$252 \$133__t1 sel_in__t18 vdd__t233 vdd__t156 pfet_03v3 L=0.35U W=8U AS=8.8P
+ AD=8.8P PS=18.2U PD=18.2U
* device instance $253 r0 *1 125.325,38 pfet
X$253 \$135__t1 rel_64_n__t0 vdd__t232 vdd__t155 pfet_03v3 L=0.35U W=8U AS=8.8P
+ AD=8.8P PS=18.2U PD=18.2U
* device instance $254 r0 *1 128.275,38 pfet
X$254 \$100__t1 hi_64_n__t0 vdd__t175 vdd__t98 pfet_03v3 L=0.35U W=8U AS=8.8P
+ AD=8.8P PS=18.2U PD=18.2U
* device instance $255 r0 *1 131.225,38 pfet
X$255 \$102__t1 lo_64_n__t0 vdd__t174 vdd__t97 pfet_03v3 L=0.35U W=8U AS=8.8P
+ AD=8.8P PS=18.2U PD=18.2U
* device instance $256 r0 *1 134.14,44 pfet
X$256 pinn__t6 \$133__t0 \$84__t64 vdd__t80 pfet_03v3 L=0.28U W=20U AS=22P
+ AD=22P PS=42.2U PD=42.2U
* device instance $257 r0 *1 137.02,44 pfet
X$257 vcm__t19 \$135__t0 \$84__t65 vdd__t81 pfet_03v3 L=0.28U W=20U AS=22P
+ AD=22P PS=42.2U PD=42.2U
* device instance $258 r0 *1 139.9,44 pfet
X$258 vref__t16 \$100__t0 \$84__t66 vdd__t82 pfet_03v3 L=0.28U W=20U AS=22P
+ AD=22P PS=42.2U PD=42.2U
* device instance $259 r0 *1 142.78,44 pfet
X$259 vss__t22 \$102__t0 \$84__t67 vdd__t83 pfet_03v3 L=0.28U W=20U AS=22P
+ AD=22P PS=42.2U PD=42.2U
* device instance $260 r0 *1 170.815,38 pfet
X$260 \$136__t1 sel_in__t9 vdd__t209 vdd__t132 pfet_03v3 L=0.35U W=8U AS=8.8P
+ AD=8.8P PS=18.2U PD=18.2U
* device instance $261 r0 *1 173.765,38 pfet
X$261 \$138__t1 rel_32_n__t0 vdd__t208 vdd__t131 pfet_03v3 L=0.35U W=8U AS=8.8P
+ AD=8.8P PS=18.2U PD=18.2U
* device instance $262 r0 *1 176.715,38 pfet
X$262 \$104__t1 hi_32_n__t0 vdd__t207 vdd__t130 pfet_03v3 L=0.35U W=8U AS=8.8P
+ AD=8.8P PS=18.2U PD=18.2U
* device instance $263 r0 *1 179.665,38 pfet
X$263 \$106__t1 lo_32_n__t0 vdd__t206 vdd__t129 pfet_03v3 L=0.35U W=8U AS=8.8P
+ AD=8.8P PS=18.2U PD=18.2U
* device instance $264 r0 *1 182.58,44 pfet
X$264 pinn__t7 \$136__t0 \$85__t34 vdd__t84 pfet_03v3 L=0.28U W=20U AS=22P
+ AD=22P PS=42.2U PD=42.2U
* device instance $265 r0 *1 185.46,44 pfet
X$265 vcm__t20 \$138__t0 \$85__t35 vdd__t85 pfet_03v3 L=0.28U W=20U AS=22P
+ AD=22P PS=42.2U PD=42.2U
* device instance $266 r0 *1 188.34,44 pfet
X$266 vref__t3 \$104__t0 \$85__t32 vdd__t29 pfet_03v3 L=0.28U W=20U AS=22P
+ AD=22P PS=42.2U PD=42.2U
* device instance $267 r0 *1 191.22,44 pfet
X$267 vss__t9 \$106__t0 \$85__t33 vdd__t30 pfet_03v3 L=0.28U W=20U AS=22P
+ AD=22P PS=42.2U PD=42.2U
* device instance $268 r0 *1 219.255,38 pfet
X$268 \$139__t1 sel_in__t2 vdd__t177 vdd__t100 pfet_03v3 L=0.35U W=8U AS=8.8P
+ AD=8.8P PS=18.2U PD=18.2U
* device instance $269 r0 *1 222.205,38 pfet
X$269 \$141__t1 rel_16_n__t0 vdd__t186 vdd__t109 pfet_03v3 L=0.35U W=8U AS=8.8P
+ AD=8.8P PS=18.2U PD=18.2U
* device instance $270 r0 *1 225.155,38 pfet
X$270 \$108__t1 hi_16_n__t0 vdd__t173 vdd__t96 pfet_03v3 L=0.35U W=8U AS=8.8P
+ AD=8.8P PS=18.2U PD=18.2U
* device instance $271 r0 *1 228.105,38 pfet
X$271 \$110__t1 lo_16_n__t0 vdd__t199 vdd__t122 pfet_03v3 L=0.35U W=8U AS=8.8P
+ AD=8.8P PS=18.2U PD=18.2U
* device instance $272 r0 *1 231.02,44 pfet
X$272 pinn__t0 \$139__t0 \$86__t16 vdd__t31 pfet_03v3 L=0.28U W=20U AS=22P
+ AD=22P PS=42.2U PD=42.2U
* device instance $273 r0 *1 233.9,44 pfet
X$273 vcm__t6 \$141__t0 \$86__t17 vdd__t32 pfet_03v3 L=0.28U W=20U AS=22P
+ AD=22P PS=42.2U PD=42.2U
* device instance $274 r0 *1 236.78,44 pfet
X$274 vref__t4 \$108__t0 \$86__t18 vdd__t33 pfet_03v3 L=0.28U W=20U AS=22P
+ AD=22P PS=42.2U PD=42.2U
* device instance $275 r0 *1 239.66,44 pfet
X$275 vss__t10 \$110__t0 \$86__t19 vdd__t34 pfet_03v3 L=0.28U W=20U AS=22P
+ AD=22P PS=42.2U PD=42.2U
* device instance $276 r0 *1 267.695,38 pfet
X$276 \$142__t1 sel_in__t5 vdd__t196 vdd__t119 pfet_03v3 L=0.35U W=8U AS=8.8P
+ AD=8.8P PS=18.2U PD=18.2U
* device instance $277 r0 *1 270.645,38 pfet
X$277 \$144__t1 rel_8_n__t0 vdd__t192 vdd__t115 pfet_03v3 L=0.35U W=8U AS=8.8P
+ AD=8.8P PS=18.2U PD=18.2U
* device instance $278 r0 *1 273.595,38 pfet
X$278 \$112__t1 hi_8_n__t0 vdd__t182 vdd__t105 pfet_03v3 L=0.35U W=8U AS=8.8P
+ AD=8.8P PS=18.2U PD=18.2U
* device instance $279 r0 *1 276.545,38 pfet
X$279 \$114__t1 lo_8_n__t0 vdd__t244 vdd__t167 pfet_03v3 L=0.35U W=8U AS=8.8P
+ AD=8.8P PS=18.2U PD=18.2U
* device instance $280 r0 *1 279.46,44 pfet
X$280 pinn__t1 \$142__t0 \$87__t8 vdd__t37 pfet_03v3 L=0.28U W=20U AS=22P
+ AD=22P PS=42.2U PD=42.2U
* device instance $281 r0 *1 282.34,44 pfet
X$281 vcm__t7 \$144__t0 \$87__t9 vdd__t38 pfet_03v3 L=0.28U W=20U AS=22P AD=22P
+ PS=42.2U PD=42.2U
* device instance $282 r0 *1 285.22,44 pfet
X$282 vref__t7 \$112__t0 \$87__t11 vdd__t46 pfet_03v3 L=0.28U W=20U AS=22P
+ AD=22P PS=42.2U PD=42.2U
* device instance $283 r0 *1 288.1,44 pfet
X$283 vss__t13 \$114__t0 \$87__t10 vdd__t45 pfet_03v3 L=0.28U W=20U AS=22P
+ AD=22P PS=42.2U PD=42.2U
* device instance $284 r0 *1 316.135,38 pfet
X$284 \$145__t1 sel_in__t3 vdd__t183 vdd__t106 pfet_03v3 L=0.35U W=8U AS=8.8P
+ AD=8.8P PS=18.2U PD=18.2U
* device instance $285 r0 *1 319.085,38 pfet
X$285 \$147__t1 rel_4_n__t0 vdd__t184 vdd__t107 pfet_03v3 L=0.35U W=8U AS=8.8P
+ AD=8.8P PS=18.2U PD=18.2U
* device instance $286 r0 *1 322.035,38 pfet
X$286 \$116__t1 hi_4_n__t0 vdd__t234 vdd__t157 pfet_03v3 L=0.35U W=8U AS=8.8P
+ AD=8.8P PS=18.2U PD=18.2U
* device instance $287 r0 *1 324.985,38 pfet
X$287 \$118__t1 lo_4_n__t0 vdd__t235 vdd__t158 pfet_03v3 L=0.35U W=8U AS=8.8P
+ AD=8.8P PS=18.2U PD=18.2U
* device instance $288 r0 *1 327.9,44 pfet
X$288 pinn__t4 \$145__t0 \$88__t5 vdd__t68 pfet_03v3 L=0.28U W=20U AS=22P
+ AD=22P PS=42.2U PD=42.2U
* device instance $289 r0 *1 330.78,44 pfet
X$289 vcm__t16 \$147__t0 \$88__t4 vdd__t67 pfet_03v3 L=0.28U W=20U AS=22P
+ AD=22P PS=42.2U PD=42.2U
* device instance $290 r0 *1 333.66,44 pfet
X$290 vref__t15 \$116__t0 \$88__t7 vdd__t79 pfet_03v3 L=0.28U W=20U AS=22P
+ AD=22P PS=42.2U PD=42.2U
* device instance $291 r0 *1 336.54,44 pfet
X$291 vss__t21 \$118__t0 \$88__t6 vdd__t78 pfet_03v3 L=0.28U W=20U AS=22P
+ AD=22P PS=42.2U PD=42.2U
* device instance $292 r0 *1 364.575,38 pfet
X$292 \$148__t1 sel_in__t19 vdd__t245 vdd__t168 pfet_03v3 L=0.35U W=8U AS=8.8P
+ AD=8.8P PS=18.2U PD=18.2U
* device instance $293 r0 *1 367.525,38 pfet
X$293 \$150__t1 rel_2_n__t0 vdd__t239 vdd__t162 pfet_03v3 L=0.35U W=8U AS=8.8P
+ AD=8.8P PS=18.2U PD=18.2U
* device instance $294 r0 *1 370.475,38 pfet
X$294 \$120__t1 hi_2_n__t0 vdd__t240 vdd__t163 pfet_03v3 L=0.35U W=8U AS=8.8P
+ AD=8.8P PS=18.2U PD=18.2U
* device instance $295 r0 *1 373.425,38 pfet
X$295 \$122__t1 lo_2_n__t0 vdd__t241 vdd__t164 pfet_03v3 L=0.35U W=8U AS=8.8P
+ AD=8.8P PS=18.2U PD=18.2U
* device instance $296 r0 *1 376.34,44 pfet
X$296 pinn__t5 \$148__t0 \$89__t5 vdd__t77 pfet_03v3 L=0.28U W=20U AS=22P
+ AD=22P PS=42.2U PD=42.2U
* device instance $297 r0 *1 379.22,44 pfet
X$297 vcm__t18 \$150__t0 \$89__t4 vdd__t76 pfet_03v3 L=0.28U W=20U AS=22P
+ AD=22P PS=42.2U PD=42.2U
* device instance $298 r0 *1 382.1,44 pfet
X$298 vref__t14 \$120__t0 \$89__t3 vdd__t75 pfet_03v3 L=0.28U W=20U AS=22P
+ AD=22P PS=42.2U PD=42.2U
* device instance $299 r0 *1 384.98,44 pfet
X$299 vss__t20 \$122__t0 \$89__t2 vdd__t74 pfet_03v3 L=0.28U W=20U AS=22P
+ AD=22P PS=42.2U PD=42.2U
* device instance $300 r0 *1 413.015,38 pfet
X$300 \$151__t1 sel_in__t11 vdd__t214 vdd__t137 pfet_03v3 L=0.35U W=8U AS=8.8P
+ AD=8.8P PS=18.2U PD=18.2U
* device instance $301 r0 *1 415.965,38 pfet
X$301 \$153__t1 rel_1_n__t0 vdd__t225 vdd__t148 pfet_03v3 L=0.35U W=8U AS=8.8P
+ AD=8.8P PS=18.2U PD=18.2U
* device instance $302 r0 *1 418.915,38 pfet
X$302 \$124__t1 hi_1_n__t0 vdd__t216 vdd__t139 pfet_03v3 L=0.35U W=8U AS=8.8P
+ AD=8.8P PS=18.2U PD=18.2U
* device instance $303 r0 *1 421.865,38 pfet
X$303 \$126__t1 lo_1_n__t0 vdd__t217 vdd__t140 pfet_03v3 L=0.35U W=8U AS=8.8P
+ AD=8.8P PS=18.2U PD=18.2U
* device instance $304 r0 *1 424.78,44 pfet
X$304 pinn__t8 \$151__t0 \$90__t4 vdd__t89 pfet_03v3 L=0.28U W=20U AS=22P
+ AD=22P PS=42.2U PD=42.2U
* device instance $305 r0 *1 427.66,44 pfet
X$305 vcm__t17 \$153__t0 \$90__t3 vdd__t72 pfet_03v3 L=0.28U W=20U AS=22P
+ AD=22P PS=42.2U PD=42.2U
* device instance $306 r0 *1 430.54,44 pfet
X$306 vref__t13 \$124__t0 \$90__t2 vdd__t71 pfet_03v3 L=0.28U W=20U AS=22P
+ AD=22P PS=42.2U PD=42.2U
* device instance $307 r0 *1 433.42,44 pfet
X$307 vss__t19 \$126__t0 \$90__t1 vdd__t70 pfet_03v3 L=0.28U W=20U AS=22P
+ AD=22P PS=42.2U PD=42.2U
* device instance $308 r0 *1 450.805,72 pfet
X$308 \$171__t1 tp_gn__t1 vdd__t204 vdd__t127 pfet_03v3 L=0.35U W=8U AS=8.8P
+ AD=8.8P PS=18.2U PD=18.2U
* device instance $309 r0 *1 453.72,78 pfet
X$309 vcm__t9 \$171__t0 topp__t513 vdd__t43 pfet_03v3 L=0.28U W=20U AS=22P
+ AD=22P PS=42.2U PD=42.2U
* device instance $310 r0 *1 464.265,72 pfet
X$310 \$172__t1 tp_gn__t0 vdd__t195 vdd__t118 pfet_03v3 L=0.35U W=8U AS=8.8P
+ AD=8.8P PS=18.2U PD=18.2U
* device instance $311 r0 *1 467.18,78 pfet
X$311 vcm__t2 \$172__t0 topn__t513 vdd__t17 pfet_03v3 L=0.28U W=20U AS=22P
+ AD=22P PS=42.2U PD=42.2U
* device instance $312 r0 *1 513.225,67.66 pfet
X$312 \$162__t5 \$161__t6 vdd__t169 vdd__t90 pfet_03v3 L=0.35U W=8U AS=8.8P
+ AD=8.8P PS=18.2U PD=18.2U
* device instance $313 r0 *1 516.175,67.66 pfet
X$313 \$161__t5 \$162__t6 vdd__t170 vdd__t91 pfet_03v3 L=0.35U W=8U AS=8.8P
+ AD=8.8P PS=18.2U PD=18.2U
* device instance $314 r0 *1 519.125,65.66 pfet
X$314 \$162__t1 cmpclk__t1 vdd__t3 vdd__t4 pfet_03v3 L=0.35U W=4U AS=4.4P
+ AD=4.4P PS=10.2U PD=10.2U
* device instance $315 r0 *1 522.075,65.66 pfet
X$315 \$161__t2 cmpclk__t4 vdd__t16 vdd__t15 pfet_03v3 L=0.35U W=4U AS=4.4P
+ AD=4.4P PS=10.2U PD=10.2U
* device instance $316 r0 *1 525.025,64.66 pfet
X$316 \$159__t2 cmpclk__t2 vdd__t5 vdd__t6 pfet_03v3 L=0.35U W=2U AS=2.2P
+ AD=2.2P PS=6.2U PD=6.2U
* device instance $317 r0 *1 527.975,64.66 pfet
X$317 \$160__t0 cmpclk__t3 vdd__t14 vdd__t11 pfet_03v3 L=0.35U W=2U AS=2.2P
+ AD=2.2P PS=6.2U PD=6.2U
* device instance $318 r0 *1 535.675,64.66 pfet
X$318 \$163__t1 \$162__t3 vdd__t13 vdd__t10 pfet_03v3 L=0.35U W=2U AS=2.2P
+ AD=2.2P PS=6.2U PD=6.2U
* device instance $319 r0 *1 543.375,64.66 pfet
X$319 \$164__t1 \$161__t4 vdd__t12 vdd__t9 pfet_03v3 L=0.35U W=2U AS=2.2P
+ AD=2.2P PS=6.2U PD=6.2U
* device instance $320 r0 *1 554.025,67.66 pfet
X$320 \$167__t0 \$164__t2 vdd__t171 vdd__t92 pfet_03v3 L=0.35U W=8U AS=8.8P
+ AD=8.8P PS=18.2U PD=18.2U
* device instance $321 r0 *1 556.975,67.66 pfet
X$321 dout__t0 doutb__t1 \$167__t1 vdd__t93 pfet_03v3 L=0.35U W=8U AS=8.8P
+ AD=8.8P PS=18.2U PD=18.2U
* device instance $322 r0 *1 567.625,67.66 pfet
X$322 \$168__t0 \$163__t2 vdd__t172 vdd__t94 pfet_03v3 L=0.35U W=8U AS=8.8P
+ AD=8.8P PS=18.2U PD=18.2U
* device instance $323 r0 *1 570.575,67.66 pfet
X$323 doutb__t0 dout__t1 \$168__t1 vdd__t95 pfet_03v3 L=0.35U W=8U AS=8.8P
+ AD=8.8P PS=18.2U PD=18.2U
* device instance $324 r0 *1 2.6,70.6 cap_mim_2f0_m4m5_noshield
X$324 \$12__t246 topp__t487 cap_mim_2f0_m4m5_noshield c_length=4U c_width=4U
* device instance $325 r0 *1 9,70.6 cap_mim_2f0_m4m5_noshield
X$325 \$72__t1 topp__t486 cap_mim_2f0_m4m5_noshield c_length=4U c_width=4U
* device instance $326 r0 *1 15.4,70.6 cap_mim_2f0_m4m5_noshield
X$326 \$12__t245 topp__t485 cap_mim_2f0_m4m5_noshield c_length=4U c_width=4U
* device instance $327 r0 *1 21.8,70.6 cap_mim_2f0_m4m5_noshield
X$327 \$64__t3 topp__t484 cap_mim_2f0_m4m5_noshield c_length=4U c_width=4U
* device instance $328 r0 *1 28.2,70.6 cap_mim_2f0_m4m5_noshield
X$328 \$12__t244 topp__t483 cap_mim_2f0_m4m5_noshield c_length=4U c_width=4U
* device instance $329 r0 *1 34.6,70.6 cap_mim_2f0_m4m5_noshield
X$329 \$56__t7 topp__t482 cap_mim_2f0_m4m5_noshield c_length=4U c_width=4U
* device instance $330 r0 *1 41,70.6 cap_mim_2f0_m4m5_noshield
X$330 \$12__t240 topp__t478 cap_mim_2f0_m4m5_noshield c_length=4U c_width=4U
* device instance $331 r0 *1 47.4,70.6 cap_mim_2f0_m4m5_noshield
X$331 \$56__t6 topp__t477 cap_mim_2f0_m4m5_noshield c_length=4U c_width=4U
* device instance $332 r0 *1 53.8,70.6 cap_mim_2f0_m4m5_noshield
X$332 \$12__t239 topp__t476 cap_mim_2f0_m4m5_noshield c_length=4U c_width=4U
* device instance $333 r0 *1 60.2,70.6 cap_mim_2f0_m4m5_noshield
X$333 \$48__t15 topp__t475 cap_mim_2f0_m4m5_noshield c_length=4U c_width=4U
* device instance $334 r0 *1 66.6,70.6 cap_mim_2f0_m4m5_noshield
X$334 \$12__t238 topp__t474 cap_mim_2f0_m4m5_noshield c_length=4U c_width=4U
* device instance $335 r0 *1 73,70.6 cap_mim_2f0_m4m5_noshield
X$335 \$48__t14 topp__t473 cap_mim_2f0_m4m5_noshield c_length=4U c_width=4U
* device instance $336 r0 *1 79.4,70.6 cap_mim_2f0_m4m5_noshield
X$336 \$12__t236 topp__t471 cap_mim_2f0_m4m5_noshield c_length=4U c_width=4U
* device instance $337 r0 *1 85.8,70.6 cap_mim_2f0_m4m5_noshield
X$337 \$48__t13 topp__t470 cap_mim_2f0_m4m5_noshield c_length=4U c_width=4U
* device instance $338 r0 *1 92.2,70.6 cap_mim_2f0_m4m5_noshield
X$338 \$12__t235 topp__t469 cap_mim_2f0_m4m5_noshield c_length=4U c_width=4U
* device instance $339 r0 *1 98.6,70.6 cap_mim_2f0_m4m5_noshield
X$339 \$48__t12 topp__t468 cap_mim_2f0_m4m5_noshield c_length=4U c_width=4U
* device instance $340 r0 *1 105,70.6 cap_mim_2f0_m4m5_noshield
X$340 \$12__t234 topp__t467 cap_mim_2f0_m4m5_noshield c_length=4U c_width=4U
* device instance $341 r0 *1 111.4,70.6 cap_mim_2f0_m4m5_noshield
X$341 \$40__t25 topp__t466 cap_mim_2f0_m4m5_noshield c_length=4U c_width=4U
* device instance $342 r0 *1 117.8,70.6 cap_mim_2f0_m4m5_noshield
X$342 \$12__t233 topp__t465 cap_mim_2f0_m4m5_noshield c_length=4U c_width=4U
* device instance $343 r0 *1 124.2,70.6 cap_mim_2f0_m4m5_noshield
X$343 \$40__t24 topp__t464 cap_mim_2f0_m4m5_noshield c_length=4U c_width=4U
* device instance $344 r0 *1 130.6,70.6 cap_mim_2f0_m4m5_noshield
X$344 \$12__t247 topp__t489 cap_mim_2f0_m4m5_noshield c_length=4U c_width=4U
* device instance $345 r0 *1 137,70.6 cap_mim_2f0_m4m5_noshield
X$345 \$40__t26 topp__t488 cap_mim_2f0_m4m5_noshield c_length=4U c_width=4U
* device instance $346 r0 *1 143.4,70.6 cap_mim_2f0_m4m5_noshield
X$346 \$12__t241 topp__t479 cap_mim_2f0_m4m5_noshield c_length=4U c_width=4U
* device instance $347 r0 *1 149.8,70.6 cap_mim_2f0_m4m5_noshield
X$347 \$40__t31 topp__t506 cap_mim_2f0_m4m5_noshield c_length=4U c_width=4U
* device instance $348 r0 *1 156.2,70.6 cap_mim_2f0_m4m5_noshield
X$348 \$12__t253 topp__t502 cap_mim_2f0_m4m5_noshield c_length=4U c_width=4U
* device instance $349 r0 *1 162.6,70.6 cap_mim_2f0_m4m5_noshield
X$349 \$40__t30 topp__t501 cap_mim_2f0_m4m5_noshield c_length=4U c_width=4U
* device instance $350 r0 *1 169,70.6 cap_mim_2f0_m4m5_noshield
X$350 \$12__t252 topp__t500 cap_mim_2f0_m4m5_noshield c_length=4U c_width=4U
* device instance $351 r0 *1 175.4,70.6 cap_mim_2f0_m4m5_noshield
X$351 \$40__t29 topp__t499 cap_mim_2f0_m4m5_noshield c_length=4U c_width=4U
* device instance $352 r0 *1 181.8,70.6 cap_mim_2f0_m4m5_noshield
X$352 \$12__t251 topp__t498 cap_mim_2f0_m4m5_noshield c_length=4U c_width=4U
* device instance $353 r0 *1 188.2,70.6 cap_mim_2f0_m4m5_noshield
X$353 \$40__t28 topp__t497 cap_mim_2f0_m4m5_noshield c_length=4U c_width=4U
* device instance $354 r0 *1 194.6,70.6 cap_mim_2f0_m4m5_noshield
X$354 \$12__t250 topp__t496 cap_mim_2f0_m4m5_noshield c_length=4U c_width=4U
* device instance $355 r0 *1 201,70.6 cap_mim_2f0_m4m5_noshield
X$355 \$40__t27 topp__t495 cap_mim_2f0_m4m5_noshield c_length=4U c_width=4U
* device instance $356 r0 *1 224,70.6 cap_mim_2f0_m4m5_noshield
X$356 \$81__t240 topn__t484 cap_mim_2f0_m4m5_noshield c_length=4U c_width=4U
* device instance $357 r0 *1 230.4,70.6 cap_mim_2f0_m4m5_noshield
X$357 \$89__t1 topn__t512 cap_mim_2f0_m4m5_noshield c_length=4U c_width=4U
* device instance $358 r0 *1 236.8,70.6 cap_mim_2f0_m4m5_noshield
X$358 \$81__t238 topn__t482 cap_mim_2f0_m4m5_noshield c_length=4U c_width=4U
* device instance $359 r0 *1 243.2,70.6 cap_mim_2f0_m4m5_noshield
X$359 \$88__t3 topn__t481 cap_mim_2f0_m4m5_noshield c_length=4U c_width=4U
* device instance $360 r0 *1 249.6,70.6 cap_mim_2f0_m4m5_noshield
X$360 \$81__t237 topn__t480 cap_mim_2f0_m4m5_noshield c_length=4U c_width=4U
* device instance $361 r0 *1 256,70.6 cap_mim_2f0_m4m5_noshield
X$361 \$87__t6 topn__t479 cap_mim_2f0_m4m5_noshield c_length=4U c_width=4U
* device instance $362 r0 *1 262.4,70.6 cap_mim_2f0_m4m5_noshield
X$362 \$81__t241 topn__t485 cap_mim_2f0_m4m5_noshield c_length=4U c_width=4U
* device instance $363 r0 *1 268.8,70.6 cap_mim_2f0_m4m5_noshield
X$363 \$87__t7 topn__t509 cap_mim_2f0_m4m5_noshield c_length=4U c_width=4U
* device instance $364 r0 *1 275.2,70.6 cap_mim_2f0_m4m5_noshield
X$364 \$81__t255 topn__t511 cap_mim_2f0_m4m5_noshield c_length=4U c_width=4U
* device instance $365 r0 *1 281.6,70.6 cap_mim_2f0_m4m5_noshield
X$365 \$86__t15 topn__t510 cap_mim_2f0_m4m5_noshield c_length=4U c_width=4U
* device instance $366 r0 *1 288,70.6 cap_mim_2f0_m4m5_noshield
X$366 \$81__t250 topn__t501 cap_mim_2f0_m4m5_noshield c_length=4U c_width=4U
* device instance $367 r0 *1 294.4,70.6 cap_mim_2f0_m4m5_noshield
X$367 \$86__t10 topn__t385 cap_mim_2f0_m4m5_noshield c_length=4U c_width=4U
* device instance $368 r0 *1 300.8,70.6 cap_mim_2f0_m4m5_noshield
X$368 \$81__t193 topn__t384 cap_mim_2f0_m4m5_noshield c_length=4U c_width=4U
* device instance $369 r0 *1 307.2,70.6 cap_mim_2f0_m4m5_noshield
X$369 \$86__t12 topn__t405 cap_mim_2f0_m4m5_noshield c_length=4U c_width=4U
* device instance $370 r0 *1 313.6,70.6 cap_mim_2f0_m4m5_noshield
X$370 \$81__t201 topn__t404 cap_mim_2f0_m4m5_noshield c_length=4U c_width=4U
* device instance $371 r0 *1 320,70.6 cap_mim_2f0_m4m5_noshield
X$371 \$86__t11 topn__t403 cap_mim_2f0_m4m5_noshield c_length=4U c_width=4U
* device instance $372 r0 *1 326.4,70.6 cap_mim_2f0_m4m5_noshield
X$372 \$81__t200 topn__t402 cap_mim_2f0_m4m5_noshield c_length=4U c_width=4U
* device instance $373 r0 *1 332.8,70.6 cap_mim_2f0_m4m5_noshield
X$373 \$85__t28 topn__t401 cap_mim_2f0_m4m5_noshield c_length=4U c_width=4U
* device instance $374 r0 *1 339.2,70.6 cap_mim_2f0_m4m5_noshield
X$374 \$81__t199 topn__t400 cap_mim_2f0_m4m5_noshield c_length=4U c_width=4U
* device instance $375 r0 *1 345.6,70.6 cap_mim_2f0_m4m5_noshield
X$375 \$85__t27 topn__t399 cap_mim_2f0_m4m5_noshield c_length=4U c_width=4U
* device instance $376 r0 *1 352,70.6 cap_mim_2f0_m4m5_noshield
X$376 \$81__t198 topn__t398 cap_mim_2f0_m4m5_noshield c_length=4U c_width=4U
* device instance $377 r0 *1 358.4,70.6 cap_mim_2f0_m4m5_noshield
X$377 \$85__t26 topn__t397 cap_mim_2f0_m4m5_noshield c_length=4U c_width=4U
* device instance $378 r0 *1 364.8,70.6 cap_mim_2f0_m4m5_noshield
X$378 \$81__t197 topn__t396 cap_mim_2f0_m4m5_noshield c_length=4U c_width=4U
* device instance $379 r0 *1 371.2,70.6 cap_mim_2f0_m4m5_noshield
X$379 \$85__t25 topn__t395 cap_mim_2f0_m4m5_noshield c_length=4U c_width=4U
* device instance $380 r0 *1 377.6,70.6 cap_mim_2f0_m4m5_noshield
X$380 \$81__t196 topn__t394 cap_mim_2f0_m4m5_noshield c_length=4U c_width=4U
* device instance $381 r0 *1 384,70.6 cap_mim_2f0_m4m5_noshield
X$381 \$85__t24 topn__t393 cap_mim_2f0_m4m5_noshield c_length=4U c_width=4U
* device instance $382 r0 *1 390.4,70.6 cap_mim_2f0_m4m5_noshield
X$382 \$81__t195 topn__t392 cap_mim_2f0_m4m5_noshield c_length=4U c_width=4U
* device instance $383 r0 *1 396.8,70.6 cap_mim_2f0_m4m5_noshield
X$383 \$85__t23 topn__t391 cap_mim_2f0_m4m5_noshield c_length=4U c_width=4U
* device instance $384 r0 *1 403.2,70.6 cap_mim_2f0_m4m5_noshield
X$384 \$81__t202 topn__t406 cap_mim_2f0_m4m5_noshield c_length=4U c_width=4U
* device instance $385 r0 *1 409.6,70.6 cap_mim_2f0_m4m5_noshield
X$385 \$85__t22 topn__t389 cap_mim_2f0_m4m5_noshield c_length=4U c_width=4U
* device instance $386 r0 *1 416,70.6 cap_mim_2f0_m4m5_noshield
X$386 \$81__t194 topn__t388 cap_mim_2f0_m4m5_noshield c_length=4U c_width=4U
* device instance $387 r0 *1 422.4,70.6 cap_mim_2f0_m4m5_noshield
X$387 \$85__t21 topn__t387 cap_mim_2f0_m4m5_noshield c_length=4U c_width=4U
* device instance $388 r0 *1 2.6,77 cap_mim_2f0_m4m5_noshield
X$388 \$12__t232 topp__t463 cap_mim_2f0_m4m5_noshield c_length=4U c_width=4U
* device instance $389 r0 *1 9,77 cap_mim_2f0_m4m5_noshield
X$389 \$32__t55 topp__t462 cap_mim_2f0_m4m5_noshield c_length=4U c_width=4U
* device instance $390 r0 *1 15.4,77 cap_mim_2f0_m4m5_noshield
X$390 \$12__t237 topp__t472 cap_mim_2f0_m4m5_noshield c_length=4U c_width=4U
* device instance $391 r0 *1 21.8,77 cap_mim_2f0_m4m5_noshield
X$391 \$32__t54 topp__t461 cap_mim_2f0_m4m5_noshield c_length=4U c_width=4U
* device instance $392 r0 *1 28.2,77 cap_mim_2f0_m4m5_noshield
X$392 \$12__t231 topp__t460 cap_mim_2f0_m4m5_noshield c_length=4U c_width=4U
* device instance $393 r0 *1 34.6,77 cap_mim_2f0_m4m5_noshield
X$393 \$32__t53 topp__t459 cap_mim_2f0_m4m5_noshield c_length=4U c_width=4U
* device instance $394 r0 *1 41,77 cap_mim_2f0_m4m5_noshield
X$394 \$12__t230 topp__t458 cap_mim_2f0_m4m5_noshield c_length=4U c_width=4U
* device instance $395 r0 *1 47.4,77 cap_mim_2f0_m4m5_noshield
X$395 \$32__t52 topp__t457 cap_mim_2f0_m4m5_noshield c_length=4U c_width=4U
* device instance $396 r0 *1 53.8,77 cap_mim_2f0_m4m5_noshield
X$396 \$12__t229 topp__t456 cap_mim_2f0_m4m5_noshield c_length=4U c_width=4U
* device instance $397 r0 *1 60.2,77 cap_mim_2f0_m4m5_noshield
X$397 \$32__t51 topp__t455 cap_mim_2f0_m4m5_noshield c_length=4U c_width=4U
* device instance $398 r0 *1 66.6,77 cap_mim_2f0_m4m5_noshield
X$398 \$12__t228 topp__t454 cap_mim_2f0_m4m5_noshield c_length=4U c_width=4U
* device instance $399 r0 *1 73,77 cap_mim_2f0_m4m5_noshield
X$399 \$32__t50 topp__t453 cap_mim_2f0_m4m5_noshield c_length=4U c_width=4U
* device instance $400 r0 *1 79.4,77 cap_mim_2f0_m4m5_noshield
X$400 \$12__t227 topp__t452 cap_mim_2f0_m4m5_noshield c_length=4U c_width=4U
* device instance $401 r0 *1 85.8,77 cap_mim_2f0_m4m5_noshield
X$401 \$32__t49 topp__t451 cap_mim_2f0_m4m5_noshield c_length=4U c_width=4U
* device instance $402 r0 *1 92.2,77 cap_mim_2f0_m4m5_noshield
X$402 \$12__t226 topp__t450 cap_mim_2f0_m4m5_noshield c_length=4U c_width=4U
* device instance $403 r0 *1 98.6,77 cap_mim_2f0_m4m5_noshield
X$403 \$32__t48 topp__t449 cap_mim_2f0_m4m5_noshield c_length=4U c_width=4U
* device instance $404 r0 *1 105,77 cap_mim_2f0_m4m5_noshield
X$404 \$12__t243 topp__t481 cap_mim_2f0_m4m5_noshield c_length=4U c_width=4U
* device instance $405 r0 *1 111.4,77 cap_mim_2f0_m4m5_noshield
X$405 \$32__t58 topp__t494 cap_mim_2f0_m4m5_noshield c_length=4U c_width=4U
* device instance $406 r0 *1 117.8,77 cap_mim_2f0_m4m5_noshield
X$406 \$12__t249 topp__t493 cap_mim_2f0_m4m5_noshield c_length=4U c_width=4U
* device instance $407 r0 *1 124.2,77 cap_mim_2f0_m4m5_noshield
X$407 \$32__t57 topp__t492 cap_mim_2f0_m4m5_noshield c_length=4U c_width=4U
* device instance $408 r0 *1 130.6,77 cap_mim_2f0_m4m5_noshield
X$408 \$12__t248 topp__t491 cap_mim_2f0_m4m5_noshield c_length=4U c_width=4U
* device instance $409 r0 *1 137,77 cap_mim_2f0_m4m5_noshield
X$409 \$32__t56 topp__t490 cap_mim_2f0_m4m5_noshield c_length=4U c_width=4U
* device instance $410 r0 *1 143.4,77 cap_mim_2f0_m4m5_noshield
X$410 \$12__t242 topp__t480 cap_mim_2f0_m4m5_noshield c_length=4U c_width=4U
* device instance $411 r0 *1 149.8,77 cap_mim_2f0_m4m5_noshield
X$411 \$32__t60 topp__t505 cap_mim_2f0_m4m5_noshield c_length=4U c_width=4U
* device instance $412 r0 *1 156.2,77 cap_mim_2f0_m4m5_noshield
X$412 \$12__t255 topp__t507 cap_mim_2f0_m4m5_noshield c_length=4U c_width=4U
* device instance $413 r0 *1 162.6,77 cap_mim_2f0_m4m5_noshield
X$413 \$32__t61 topp__t508 cap_mim_2f0_m4m5_noshield c_length=4U c_width=4U
* device instance $414 r0 *1 169,77 cap_mim_2f0_m4m5_noshield
X$414 \$12__t256 topp__t509 cap_mim_2f0_m4m5_noshield c_length=4U c_width=4U
* device instance $415 r0 *1 175.4,77 cap_mim_2f0_m4m5_noshield
X$415 \$32__t62 topp__t510 cap_mim_2f0_m4m5_noshield c_length=4U c_width=4U
* device instance $416 r0 *1 181.8,77 cap_mim_2f0_m4m5_noshield
X$416 \$12__t257 topp__t511 cap_mim_2f0_m4m5_noshield c_length=4U c_width=4U
* device instance $417 r0 *1 188.2,77 cap_mim_2f0_m4m5_noshield
X$417 \$32__t63 topp__t512 cap_mim_2f0_m4m5_noshield c_length=4U c_width=4U
* device instance $418 r0 *1 194.6,77 cap_mim_2f0_m4m5_noshield
X$418 \$12__t254 topp__t504 cap_mim_2f0_m4m5_noshield c_length=4U c_width=4U
* device instance $419 r0 *1 201,77 cap_mim_2f0_m4m5_noshield
X$419 \$32__t59 topp__t503 cap_mim_2f0_m4m5_noshield c_length=4U c_width=4U
* device instance $420 r0 *1 224,77 cap_mim_2f0_m4m5_noshield
X$420 \$81__t254 topn__t508 cap_mim_2f0_m4m5_noshield c_length=4U c_width=4U
* device instance $421 r0 *1 230.4,77 cap_mim_2f0_m4m5_noshield
X$421 \$84__t63 topn__t507 cap_mim_2f0_m4m5_noshield c_length=4U c_width=4U
* device instance $422 r0 *1 236.8,77 cap_mim_2f0_m4m5_noshield
X$422 \$81__t253 topn__t506 cap_mim_2f0_m4m5_noshield c_length=4U c_width=4U
* device instance $423 r0 *1 243.2,77 cap_mim_2f0_m4m5_noshield
X$423 \$84__t62 topn__t505 cap_mim_2f0_m4m5_noshield c_length=4U c_width=4U
* device instance $424 r0 *1 249.6,77 cap_mim_2f0_m4m5_noshield
X$424 \$81__t252 topn__t504 cap_mim_2f0_m4m5_noshield c_length=4U c_width=4U
* device instance $425 r0 *1 256,77 cap_mim_2f0_m4m5_noshield
X$425 \$84__t61 topn__t503 cap_mim_2f0_m4m5_noshield c_length=4U c_width=4U
* device instance $426 r0 *1 262.4,77 cap_mim_2f0_m4m5_noshield
X$426 \$81__t251 topn__t502 cap_mim_2f0_m4m5_noshield c_length=4U c_width=4U
* device instance $427 r0 *1 268.8,77 cap_mim_2f0_m4m5_noshield
X$427 \$84__t54 topn__t468 cap_mim_2f0_m4m5_noshield c_length=4U c_width=4U
* device instance $428 r0 *1 275.2,77 cap_mim_2f0_m4m5_noshield
X$428 \$81__t234 topn__t471 cap_mim_2f0_m4m5_noshield c_length=4U c_width=4U
* device instance $429 r0 *1 281.6,77 cap_mim_2f0_m4m5_noshield
X$429 \$84__t56 topn__t470 cap_mim_2f0_m4m5_noshield c_length=4U c_width=4U
* device instance $430 r0 *1 288,77 cap_mim_2f0_m4m5_noshield
X$430 \$81__t249 topn__t500 cap_mim_2f0_m4m5_noshield c_length=4U c_width=4U
* device instance $431 r0 *1 294.4,77 cap_mim_2f0_m4m5_noshield
X$431 \$84__t49 topn__t382 cap_mim_2f0_m4m5_noshield c_length=4U c_width=4U
* device instance $432 r0 *1 300.8,77 cap_mim_2f0_m4m5_noshield
X$432 \$81__t191 topn__t381 cap_mim_2f0_m4m5_noshield c_length=4U c_width=4U
* device instance $433 r0 *1 307.2,77 cap_mim_2f0_m4m5_noshield
X$433 \$84__t48 topn__t380 cap_mim_2f0_m4m5_noshield c_length=4U c_width=4U
* device instance $434 r0 *1 313.6,77 cap_mim_2f0_m4m5_noshield
X$434 \$81__t190 topn__t379 cap_mim_2f0_m4m5_noshield c_length=4U c_width=4U
* device instance $435 r0 *1 320,77 cap_mim_2f0_m4m5_noshield
X$435 \$84__t47 topn__t378 cap_mim_2f0_m4m5_noshield c_length=4U c_width=4U
* device instance $436 r0 *1 326.4,77 cap_mim_2f0_m4m5_noshield
X$436 \$81__t189 topn__t377 cap_mim_2f0_m4m5_noshield c_length=4U c_width=4U
* device instance $437 r0 *1 332.8,77 cap_mim_2f0_m4m5_noshield
X$437 \$84__t46 topn__t376 cap_mim_2f0_m4m5_noshield c_length=4U c_width=4U
* device instance $438 r0 *1 339.2,77 cap_mim_2f0_m4m5_noshield
X$438 \$81__t180 topn__t359 cap_mim_2f0_m4m5_noshield c_length=4U c_width=4U
* device instance $439 r0 *1 345.6,77 cap_mim_2f0_m4m5_noshield
X$439 \$84__t50 topn__t386 cap_mim_2f0_m4m5_noshield c_length=4U c_width=4U
* device instance $440 r0 *1 352,77 cap_mim_2f0_m4m5_noshield
X$440 \$81__t192 topn__t383 cap_mim_2f0_m4m5_noshield c_length=4U c_width=4U
* device instance $441 r0 *1 358.4,77 cap_mim_2f0_m4m5_noshield
X$441 \$84__t34 topn__t343 cap_mim_2f0_m4m5_noshield c_length=4U c_width=4U
* device instance $442 r0 *1 364.8,77 cap_mim_2f0_m4m5_noshield
X$442 \$81__t172 topn__t342 cap_mim_2f0_m4m5_noshield c_length=4U c_width=4U
* device instance $443 r0 *1 371.2,77 cap_mim_2f0_m4m5_noshield
X$443 \$84__t33 topn__t341 cap_mim_2f0_m4m5_noshield c_length=4U c_width=4U
* device instance $444 r0 *1 377.6,77 cap_mim_2f0_m4m5_noshield
X$444 \$81__t171 topn__t340 cap_mim_2f0_m4m5_noshield c_length=4U c_width=4U
* device instance $445 r0 *1 384,77 cap_mim_2f0_m4m5_noshield
X$445 \$84__t32 topn__t339 cap_mim_2f0_m4m5_noshield c_length=4U c_width=4U
* device instance $446 r0 *1 390.4,77 cap_mim_2f0_m4m5_noshield
X$446 \$81__t175 topn__t349 cap_mim_2f0_m4m5_noshield c_length=4U c_width=4U
* device instance $447 r0 *1 396.8,77 cap_mim_2f0_m4m5_noshield
X$447 \$84__t36 topn__t348 cap_mim_2f0_m4m5_noshield c_length=4U c_width=4U
* device instance $448 r0 *1 403.2,77 cap_mim_2f0_m4m5_noshield
X$448 \$81__t174 topn__t347 cap_mim_2f0_m4m5_noshield c_length=4U c_width=4U
* device instance $449 r0 *1 409.6,77 cap_mim_2f0_m4m5_noshield
X$449 \$84__t35 topn__t346 cap_mim_2f0_m4m5_noshield c_length=4U c_width=4U
* device instance $450 r0 *1 416,77 cap_mim_2f0_m4m5_noshield
X$450 \$81__t173 topn__t345 cap_mim_2f0_m4m5_noshield c_length=4U c_width=4U
* device instance $451 r0 *1 422.4,77 cap_mim_2f0_m4m5_noshield
X$451 \$84__t51 topn__t390 cap_mim_2f0_m4m5_noshield c_length=4U c_width=4U
* device instance $452 r0 *1 2.6,83.4 cap_mim_2f0_m4m5_noshield
X$452 \$12__t2 topp__t0 cap_mim_2f0_m4m5_noshield c_length=4U c_width=4U
* device instance $453 r0 *1 9,83.4 cap_mim_2f0_m4m5_noshield
X$453 \$24__t100 topp__t365 cap_mim_2f0_m4m5_noshield c_length=4U c_width=4U
* device instance $454 r0 *1 15.4,83.4 cap_mim_2f0_m4m5_noshield
X$454 \$12__t183 topp__t366 cap_mim_2f0_m4m5_noshield c_length=4U c_width=4U
* device instance $455 r0 *1 21.8,83.4 cap_mim_2f0_m4m5_noshield
X$455 \$24__t101 topp__t367 cap_mim_2f0_m4m5_noshield c_length=4U c_width=4U
* device instance $456 r0 *1 28.2,83.4 cap_mim_2f0_m4m5_noshield
X$456 \$12__t184 topp__t368 cap_mim_2f0_m4m5_noshield c_length=4U c_width=4U
* device instance $457 r0 *1 34.6,83.4 cap_mim_2f0_m4m5_noshield
X$457 \$24__t102 topp__t369 cap_mim_2f0_m4m5_noshield c_length=4U c_width=4U
* device instance $458 r0 *1 41,83.4 cap_mim_2f0_m4m5_noshield
X$458 \$12__t185 topp__t370 cap_mim_2f0_m4m5_noshield c_length=4U c_width=4U
* device instance $459 r0 *1 47.4,83.4 cap_mim_2f0_m4m5_noshield
X$459 \$24__t103 topp__t371 cap_mim_2f0_m4m5_noshield c_length=4U c_width=4U
* device instance $460 r0 *1 53.8,83.4 cap_mim_2f0_m4m5_noshield
X$460 \$12__t186 topp__t372 cap_mim_2f0_m4m5_noshield c_length=4U c_width=4U
* device instance $461 r0 *1 60.2,83.4 cap_mim_2f0_m4m5_noshield
X$461 \$24__t104 topp__t373 cap_mim_2f0_m4m5_noshield c_length=4U c_width=4U
* device instance $462 r0 *1 66.6,83.4 cap_mim_2f0_m4m5_noshield
X$462 \$12__t187 topp__t374 cap_mim_2f0_m4m5_noshield c_length=4U c_width=4U
* device instance $463 r0 *1 73,83.4 cap_mim_2f0_m4m5_noshield
X$463 \$24__t105 topp__t375 cap_mim_2f0_m4m5_noshield c_length=4U c_width=4U
* device instance $464 r0 *1 79.4,83.4 cap_mim_2f0_m4m5_noshield
X$464 \$12__t188 topp__t376 cap_mim_2f0_m4m5_noshield c_length=4U c_width=4U
* device instance $465 r0 *1 85.8,83.4 cap_mim_2f0_m4m5_noshield
X$465 \$24__t106 topp__t377 cap_mim_2f0_m4m5_noshield c_length=4U c_width=4U
* device instance $466 r0 *1 92.2,83.4 cap_mim_2f0_m4m5_noshield
X$466 \$12__t197 topp__t394 cap_mim_2f0_m4m5_noshield c_length=4U c_width=4U
* device instance $467 r0 *1 98.6,83.4 cap_mim_2f0_m4m5_noshield
X$467 \$24__t107 topp__t379 cap_mim_2f0_m4m5_noshield c_length=4U c_width=4U
* device instance $468 r0 *1 105,83.4 cap_mim_2f0_m4m5_noshield
X$468 \$12__t190 topp__t380 cap_mim_2f0_m4m5_noshield c_length=4U c_width=4U
* device instance $469 r0 *1 111.4,83.4 cap_mim_2f0_m4m5_noshield
X$469 \$24__t108 topp__t381 cap_mim_2f0_m4m5_noshield c_length=4U c_width=4U
* device instance $470 r0 *1 117.8,83.4 cap_mim_2f0_m4m5_noshield
X$470 \$12__t191 topp__t382 cap_mim_2f0_m4m5_noshield c_length=4U c_width=4U
* device instance $471 r0 *1 124.2,83.4 cap_mim_2f0_m4m5_noshield
X$471 \$24__t109 topp__t383 cap_mim_2f0_m4m5_noshield c_length=4U c_width=4U
* device instance $472 r0 *1 130.6,83.4 cap_mim_2f0_m4m5_noshield
X$472 \$12__t192 topp__t384 cap_mim_2f0_m4m5_noshield c_length=4U c_width=4U
* device instance $473 r0 *1 137,83.4 cap_mim_2f0_m4m5_noshield
X$473 \$24__t110 topp__t385 cap_mim_2f0_m4m5_noshield c_length=4U c_width=4U
* device instance $474 r0 *1 143.4,83.4 cap_mim_2f0_m4m5_noshield
X$474 \$12__t193 topp__t386 cap_mim_2f0_m4m5_noshield c_length=4U c_width=4U
* device instance $475 r0 *1 149.8,83.4 cap_mim_2f0_m4m5_noshield
X$475 \$24__t111 topp__t387 cap_mim_2f0_m4m5_noshield c_length=4U c_width=4U
* device instance $476 r0 *1 156.2,83.4 cap_mim_2f0_m4m5_noshield
X$476 \$12__t194 topp__t388 cap_mim_2f0_m4m5_noshield c_length=4U c_width=4U
* device instance $477 r0 *1 162.6,83.4 cap_mim_2f0_m4m5_noshield
X$477 \$24__t112 topp__t389 cap_mim_2f0_m4m5_noshield c_length=4U c_width=4U
* device instance $478 r0 *1 169,83.4 cap_mim_2f0_m4m5_noshield
X$478 \$12__t195 topp__t390 cap_mim_2f0_m4m5_noshield c_length=4U c_width=4U
* device instance $479 r0 *1 175.4,83.4 cap_mim_2f0_m4m5_noshield
X$479 \$24__t113 topp__t391 cap_mim_2f0_m4m5_noshield c_length=4U c_width=4U
* device instance $480 r0 *1 181.8,83.4 cap_mim_2f0_m4m5_noshield
X$480 \$12__t196 topp__t392 cap_mim_2f0_m4m5_noshield c_length=4U c_width=4U
* device instance $481 r0 *1 188.2,83.4 cap_mim_2f0_m4m5_noshield
X$481 \$24__t114 topp__t393 cap_mim_2f0_m4m5_noshield c_length=4U c_width=4U
* device instance $482 r0 *1 194.6,83.4 cap_mim_2f0_m4m5_noshield
X$482 \$12__t189 topp__t378 cap_mim_2f0_m4m5_noshield c_length=4U c_width=4U
* device instance $483 r0 *1 201,83.4 cap_mim_2f0_m4m5_noshield
X$483 \$24__t99 topp__t364 cap_mim_2f0_m4m5_noshield c_length=4U c_width=4U
* device instance $484 r0 *1 224,83.4 cap_mim_2f0_m4m5_noshield
X$484 \$81__t159 topn__t315 cap_mim_2f0_m4m5_noshield c_length=4U c_width=4U
* device instance $485 r0 *1 230.4,83.4 cap_mim_2f0_m4m5_noshield
X$485 \$83__t89 topn__t316 cap_mim_2f0_m4m5_noshield c_length=4U c_width=4U
* device instance $486 r0 *1 236.8,83.4 cap_mim_2f0_m4m5_noshield
X$486 \$81__t160 topn__t317 cap_mim_2f0_m4m5_noshield c_length=4U c_width=4U
* device instance $487 r0 *1 243.2,83.4 cap_mim_2f0_m4m5_noshield
X$487 \$83__t90 topn__t318 cap_mim_2f0_m4m5_noshield c_length=4U c_width=4U
* device instance $488 r0 *1 249.6,83.4 cap_mim_2f0_m4m5_noshield
X$488 \$81__t161 topn__t319 cap_mim_2f0_m4m5_noshield c_length=4U c_width=4U
* device instance $489 r0 *1 256,83.4 cap_mim_2f0_m4m5_noshield
X$489 \$83__t91 topn__t320 cap_mim_2f0_m4m5_noshield c_length=4U c_width=4U
* device instance $490 r0 *1 262.4,83.4 cap_mim_2f0_m4m5_noshield
X$490 \$81__t162 topn__t321 cap_mim_2f0_m4m5_noshield c_length=4U c_width=4U
* device instance $491 r0 *1 268.8,83.4 cap_mim_2f0_m4m5_noshield
X$491 \$83__t92 topn__t322 cap_mim_2f0_m4m5_noshield c_length=4U c_width=4U
* device instance $492 r0 *1 275.2,83.4 cap_mim_2f0_m4m5_noshield
X$492 \$81__t163 topn__t323 cap_mim_2f0_m4m5_noshield c_length=4U c_width=4U
* device instance $493 r0 *1 281.6,83.4 cap_mim_2f0_m4m5_noshield
X$493 \$83__t93 topn__t324 cap_mim_2f0_m4m5_noshield c_length=4U c_width=4U
* device instance $494 r0 *1 288,83.4 cap_mim_2f0_m4m5_noshield
X$494 \$81__t164 topn__t325 cap_mim_2f0_m4m5_noshield c_length=4U c_width=4U
* device instance $495 r0 *1 294.4,83.4 cap_mim_2f0_m4m5_noshield
X$495 \$83__t94 topn__t326 cap_mim_2f0_m4m5_noshield c_length=4U c_width=4U
* device instance $496 r0 *1 300.8,83.4 cap_mim_2f0_m4m5_noshield
X$496 \$81__t165 topn__t327 cap_mim_2f0_m4m5_noshield c_length=4U c_width=4U
* device instance $497 r0 *1 307.2,83.4 cap_mim_2f0_m4m5_noshield
X$497 \$83__t100 topn__t344 cap_mim_2f0_m4m5_noshield c_length=4U c_width=4U
* device instance $498 r0 *1 313.6,83.4 cap_mim_2f0_m4m5_noshield
X$498 \$81__t166 topn__t329 cap_mim_2f0_m4m5_noshield c_length=4U c_width=4U
* device instance $499 r0 *1 320,83.4 cap_mim_2f0_m4m5_noshield
X$499 \$83__t95 topn__t330 cap_mim_2f0_m4m5_noshield c_length=4U c_width=4U
* device instance $500 r0 *1 326.4,83.4 cap_mim_2f0_m4m5_noshield
X$500 \$81__t167 topn__t331 cap_mim_2f0_m4m5_noshield c_length=4U c_width=4U
* device instance $501 r0 *1 332.8,83.4 cap_mim_2f0_m4m5_noshield
X$501 \$83__t96 topn__t332 cap_mim_2f0_m4m5_noshield c_length=4U c_width=4U
* device instance $502 r0 *1 339.2,83.4 cap_mim_2f0_m4m5_noshield
X$502 \$81__t168 topn__t333 cap_mim_2f0_m4m5_noshield c_length=4U c_width=4U
* device instance $503 r0 *1 345.6,83.4 cap_mim_2f0_m4m5_noshield
X$503 \$83__t97 topn__t334 cap_mim_2f0_m4m5_noshield c_length=4U c_width=4U
* device instance $504 r0 *1 352,83.4 cap_mim_2f0_m4m5_noshield
X$504 \$81__t169 topn__t335 cap_mim_2f0_m4m5_noshield c_length=4U c_width=4U
* device instance $505 r0 *1 358.4,83.4 cap_mim_2f0_m4m5_noshield
X$505 \$83__t98 topn__t336 cap_mim_2f0_m4m5_noshield c_length=4U c_width=4U
* device instance $506 r0 *1 364.8,83.4 cap_mim_2f0_m4m5_noshield
X$506 \$81__t170 topn__t337 cap_mim_2f0_m4m5_noshield c_length=4U c_width=4U
* device instance $507 r0 *1 371.2,83.4 cap_mim_2f0_m4m5_noshield
X$507 \$83__t99 topn__t338 cap_mim_2f0_m4m5_noshield c_length=4U c_width=4U
* device instance $508 r0 *1 377.6,83.4 cap_mim_2f0_m4m5_noshield
X$508 \$81__t176 topn__t350 cap_mim_2f0_m4m5_noshield c_length=4U c_width=4U
* device instance $509 r0 *1 384,83.4 cap_mim_2f0_m4m5_noshield
X$509 \$83__t101 topn__t351 cap_mim_2f0_m4m5_noshield c_length=4U c_width=4U
* device instance $510 r0 *1 390.4,83.4 cap_mim_2f0_m4m5_noshield
X$510 \$81__t177 topn__t352 cap_mim_2f0_m4m5_noshield c_length=4U c_width=4U
* device instance $511 r0 *1 396.8,83.4 cap_mim_2f0_m4m5_noshield
X$511 \$83__t102 topn__t353 cap_mim_2f0_m4m5_noshield c_length=4U c_width=4U
* device instance $512 r0 *1 403.2,83.4 cap_mim_2f0_m4m5_noshield
X$512 \$81__t178 topn__t354 cap_mim_2f0_m4m5_noshield c_length=4U c_width=4U
* device instance $513 r0 *1 409.6,83.4 cap_mim_2f0_m4m5_noshield
X$513 \$83__t103 topn__t355 cap_mim_2f0_m4m5_noshield c_length=4U c_width=4U
* device instance $514 r0 *1 416,83.4 cap_mim_2f0_m4m5_noshield
X$514 \$81__t179 topn__t356 cap_mim_2f0_m4m5_noshield c_length=4U c_width=4U
* device instance $515 r0 *1 422.4,83.4 cap_mim_2f0_m4m5_noshield
X$515 \$83__t104 topn__t357 cap_mim_2f0_m4m5_noshield c_length=4U c_width=4U
* device instance $516 r0 *1 2.6,89.8 cap_mim_2f0_m4m5_noshield
X$516 \$12__t87 topp__t173 cap_mim_2f0_m4m5_noshield c_length=4U c_width=4U
* device instance $517 r0 *1 9,89.8 cap_mim_2f0_m4m5_noshield
X$517 \$24__t53 topp__t165 cap_mim_2f0_m4m5_noshield c_length=4U c_width=4U
* device instance $518 r0 *1 15.4,89.8 cap_mim_2f0_m4m5_noshield
X$518 \$12__t82 topp__t162 cap_mim_2f0_m4m5_noshield c_length=4U c_width=4U
* device instance $519 r0 *1 21.8,89.8 cap_mim_2f0_m4m5_noshield
X$519 \$24__t52 topp__t163 cap_mim_2f0_m4m5_noshield c_length=4U c_width=4U
* device instance $520 r0 *1 28.2,89.8 cap_mim_2f0_m4m5_noshield
X$520 \$12__t73 topp__t144 cap_mim_2f0_m4m5_noshield c_length=4U c_width=4U
* device instance $521 r0 *1 34.6,89.8 cap_mim_2f0_m4m5_noshield
X$521 \$24__t41 topp__t140 cap_mim_2f0_m4m5_noshield c_length=4U c_width=4U
* device instance $522 r0 *1 41,89.8 cap_mim_2f0_m4m5_noshield
X$522 \$12__t121 topp__t241 cap_mim_2f0_m4m5_noshield c_length=4U c_width=4U
* device instance $523 r0 *1 47.4,89.8 cap_mim_2f0_m4m5_noshield
X$523 \$24__t74 topp__t245 cap_mim_2f0_m4m5_noshield c_length=4U c_width=4U
* device instance $524 r0 *1 53.8,89.8 cap_mim_2f0_m4m5_noshield
X$524 \$12__t122 topp__t242 cap_mim_2f0_m4m5_noshield c_length=4U c_width=4U
* device instance $525 r0 *1 60.2,89.8 cap_mim_2f0_m4m5_noshield
X$525 \$24__t73 topp__t243 cap_mim_2f0_m4m5_noshield c_length=4U c_width=4U
* device instance $526 r0 *1 66.6,89.8 cap_mim_2f0_m4m5_noshield
X$526 \$12__t123 topp__t244 cap_mim_2f0_m4m5_noshield c_length=4U c_width=4U
* device instance $527 r0 *1 73,89.8 cap_mim_2f0_m4m5_noshield
X$527 \$24__t13 topp__t45 cap_mim_2f0_m4m5_noshield c_length=4U c_width=4U
* device instance $528 r0 *1 79.4,89.8 cap_mim_2f0_m4m5_noshield
X$528 \$12__t96 topp__t191 cap_mim_2f0_m4m5_noshield c_length=4U c_width=4U
* device instance $529 r0 *1 85.8,89.8 cap_mim_2f0_m4m5_noshield
X$529 \$24__t67 topp__t192 cap_mim_2f0_m4m5_noshield c_length=4U c_width=4U
* device instance $530 r0 *1 92.2,89.8 cap_mim_2f0_m4m5_noshield
X$530 \$12__t97 topp__t193 cap_mim_2f0_m4m5_noshield c_length=4U c_width=4U
* device instance $531 r0 *1 98.6,89.8 cap_mim_2f0_m4m5_noshield
X$531 \$24__t68 topp__t194 cap_mim_2f0_m4m5_noshield c_length=4U c_width=4U
* device instance $532 r0 *1 105,89.8 cap_mim_2f0_m4m5_noshield
X$532 \$12__t98 topp__t195 cap_mim_2f0_m4m5_noshield c_length=4U c_width=4U
* device instance $533 r0 *1 111.4,89.8 cap_mim_2f0_m4m5_noshield
X$533 \$24__t69 topp__t196 cap_mim_2f0_m4m5_noshield c_length=4U c_width=4U
* device instance $534 r0 *1 117.8,89.8 cap_mim_2f0_m4m5_noshield
X$534 \$12__t94 topp__t188 cap_mim_2f0_m4m5_noshield c_length=4U c_width=4U
* device instance $535 r0 *1 124.2,89.8 cap_mim_2f0_m4m5_noshield
X$535 \$24__t58 topp__t174 cap_mim_2f0_m4m5_noshield c_length=4U c_width=4U
* device instance $536 r0 *1 130.6,89.8 cap_mim_2f0_m4m5_noshield
X$536 \$12__t88 topp__t175 cap_mim_2f0_m4m5_noshield c_length=4U c_width=4U
* device instance $537 r0 *1 137,89.8 cap_mim_2f0_m4m5_noshield
X$537 \$24__t48 topp__t156 cap_mim_2f0_m4m5_noshield c_length=4U c_width=4U
* device instance $538 r0 *1 143.4,89.8 cap_mim_2f0_m4m5_noshield
X$538 \$12__t89 topp__t177 cap_mim_2f0_m4m5_noshield c_length=4U c_width=4U
* device instance $539 r0 *1 149.8,89.8 cap_mim_2f0_m4m5_noshield
X$539 \$24__t116 topp__t422 cap_mim_2f0_m4m5_noshield c_length=4U c_width=4U
* device instance $540 r0 *1 156.2,89.8 cap_mim_2f0_m4m5_noshield
X$540 \$12__t213 topp__t427 cap_mim_2f0_m4m5_noshield c_length=4U c_width=4U
* device instance $541 r0 *1 162.6,89.8 cap_mim_2f0_m4m5_noshield
X$541 \$24__t118 topp__t426 cap_mim_2f0_m4m5_noshield c_length=4U c_width=4U
* device instance $542 r0 *1 169,89.8 cap_mim_2f0_m4m5_noshield
X$542 \$12__t217 topp__t435 cap_mim_2f0_m4m5_noshield c_length=4U c_width=4U
* device instance $543 r0 *1 175.4,89.8 cap_mim_2f0_m4m5_noshield
X$543 \$24__t122 topp__t434 cap_mim_2f0_m4m5_noshield c_length=4U c_width=4U
* device instance $544 r0 *1 181.8,89.8 cap_mim_2f0_m4m5_noshield
X$544 \$12__t225 topp__t448 cap_mim_2f0_m4m5_noshield c_length=4U c_width=4U
* device instance $545 r0 *1 188.2,89.8 cap_mim_2f0_m4m5_noshield
X$545 \$24__t121 topp__t433 cap_mim_2f0_m4m5_noshield c_length=4U c_width=4U
* device instance $546 r0 *1 194.6,89.8 cap_mim_2f0_m4m5_noshield
X$546 \$12__t216 topp__t432 cap_mim_2f0_m4m5_noshield c_length=4U c_width=4U
* device instance $547 r0 *1 201,89.8 cap_mim_2f0_m4m5_noshield
X$547 \$24__t120 topp__t431 cap_mim_2f0_m4m5_noshield c_length=4U c_width=4U
* device instance $548 r0 *1 224,89.8 cap_mim_2f0_m4m5_noshield
X$548 \$81__t224 topn__t448 cap_mim_2f0_m4m5_noshield c_length=4U c_width=4U
* device instance $549 r0 *1 230.4,89.8 cap_mim_2f0_m4m5_noshield
X$549 \$83__t111 topn__t447 cap_mim_2f0_m4m5_noshield c_length=4U c_width=4U
* device instance $550 r0 *1 236.8,89.8 cap_mim_2f0_m4m5_noshield
X$550 \$81__t222 topn__t445 cap_mim_2f0_m4m5_noshield c_length=4U c_width=4U
* device instance $551 r0 *1 243.2,89.8 cap_mim_2f0_m4m5_noshield
X$551 \$83__t110 topn__t444 cap_mim_2f0_m4m5_noshield c_length=4U c_width=4U
* device instance $552 r0 *1 249.6,89.8 cap_mim_2f0_m4m5_noshield
X$552 \$81__t221 topn__t443 cap_mim_2f0_m4m5_noshield c_length=4U c_width=4U
* device instance $553 r0 *1 256,89.8 cap_mim_2f0_m4m5_noshield
X$553 \$83__t119 topn__t462 cap_mim_2f0_m4m5_noshield c_length=4U c_width=4U
* device instance $554 r0 *1 262.4,89.8 cap_mim_2f0_m4m5_noshield
X$554 \$81__t225 topn__t450 cap_mim_2f0_m4m5_noshield c_length=4U c_width=4U
* device instance $555 r0 *1 268.8,89.8 cap_mim_2f0_m4m5_noshield
X$555 \$83__t112 topn__t449 cap_mim_2f0_m4m5_noshield c_length=4U c_width=4U
* device instance $556 r0 *1 275.2,89.8 cap_mim_2f0_m4m5_noshield
X$556 \$81__t223 topn__t446 cap_mim_2f0_m4m5_noshield c_length=4U c_width=4U
* device instance $557 r0 *1 281.6,89.8 cap_mim_2f0_m4m5_noshield
X$557 \$83__t109 topn__t442 cap_mim_2f0_m4m5_noshield c_length=4U c_width=4U
* device instance $558 r0 *1 288,89.8 cap_mim_2f0_m4m5_noshield
X$558 \$81__t219 topn__t438 cap_mim_2f0_m4m5_noshield c_length=4U c_width=4U
* device instance $559 r0 *1 294.4,89.8 cap_mim_2f0_m4m5_noshield
X$559 \$83__t17 topn__t86 cap_mim_2f0_m4m5_noshield c_length=4U c_width=4U
* device instance $560 r0 *1 300.8,89.8 cap_mim_2f0_m4m5_noshield
X$560 \$81__t44 topn__t87 cap_mim_2f0_m4m5_noshield c_length=4U c_width=4U
* device instance $561 r0 *1 307.2,89.8 cap_mim_2f0_m4m5_noshield
X$561 \$83__t18 topn__t88 cap_mim_2f0_m4m5_noshield c_length=4U c_width=4U
* device instance $562 r0 *1 313.6,89.8 cap_mim_2f0_m4m5_noshield
X$562 \$81__t48 topn__t98 cap_mim_2f0_m4m5_noshield c_length=4U c_width=4U
* device instance $563 r0 *1 320,89.8 cap_mim_2f0_m4m5_noshield
X$563 \$83__t19 topn__t90 cap_mim_2f0_m4m5_noshield c_length=4U c_width=4U
* device instance $564 r0 *1 326.4,89.8 cap_mim_2f0_m4m5_noshield
X$564 \$81__t45 topn__t91 cap_mim_2f0_m4m5_noshield c_length=4U c_width=4U
* device instance $565 r0 *1 332.8,89.8 cap_mim_2f0_m4m5_noshield
X$565 \$83__t20 topn__t92 cap_mim_2f0_m4m5_noshield c_length=4U c_width=4U
* device instance $566 r0 *1 339.2,89.8 cap_mim_2f0_m4m5_noshield
X$566 \$81__t46 topn__t93 cap_mim_2f0_m4m5_noshield c_length=4U c_width=4U
* device instance $567 r0 *1 345.6,89.8 cap_mim_2f0_m4m5_noshield
X$567 \$83__t21 topn__t94 cap_mim_2f0_m4m5_noshield c_length=4U c_width=4U
* device instance $568 r0 *1 352,89.8 cap_mim_2f0_m4m5_noshield
X$568 \$81__t47 topn__t95 cap_mim_2f0_m4m5_noshield c_length=4U c_width=4U
* device instance $569 r0 *1 358.4,89.8 cap_mim_2f0_m4m5_noshield
X$569 \$83__t23 topn__t97 cap_mim_2f0_m4m5_noshield c_length=4U c_width=4U
* device instance $570 r0 *1 364.8,89.8 cap_mim_2f0_m4m5_noshield
X$570 \$81__t239 topn__t483 cap_mim_2f0_m4m5_noshield c_length=4U c_width=4U
* device instance $571 r0 *1 371.2,89.8 cap_mim_2f0_m4m5_noshield
X$571 \$83__t1 topn__t14 cap_mim_2f0_m4m5_noshield c_length=4U c_width=4U
* device instance $572 r0 *1 377.6,89.8 cap_mim_2f0_m4m5_noshield
X$572 \$81__t6 topn__t15 cap_mim_2f0_m4m5_noshield c_length=4U c_width=4U
* device instance $573 r0 *1 384,89.8 cap_mim_2f0_m4m5_noshield
X$573 \$83__t2 topn__t16 cap_mim_2f0_m4m5_noshield c_length=4U c_width=4U
* device instance $574 r0 *1 390.4,89.8 cap_mim_2f0_m4m5_noshield
X$574 \$81__t7 topn__t17 cap_mim_2f0_m4m5_noshield c_length=4U c_width=4U
* device instance $575 r0 *1 396.8,89.8 cap_mim_2f0_m4m5_noshield
X$575 \$83__t3 topn__t18 cap_mim_2f0_m4m5_noshield c_length=4U c_width=4U
* device instance $576 r0 *1 403.2,89.8 cap_mim_2f0_m4m5_noshield
X$576 \$81__t12 topn__t27 cap_mim_2f0_m4m5_noshield c_length=4U c_width=4U
* device instance $577 r0 *1 409.6,89.8 cap_mim_2f0_m4m5_noshield
X$577 \$83__t4 topn__t19 cap_mim_2f0_m4m5_noshield c_length=4U c_width=4U
* device instance $578 r0 *1 416,89.8 cap_mim_2f0_m4m5_noshield
X$578 \$81__t8 topn__t20 cap_mim_2f0_m4m5_noshield c_length=4U c_width=4U
* device instance $579 r0 *1 422.4,89.8 cap_mim_2f0_m4m5_noshield
X$579 \$83__t5 topn__t21 cap_mim_2f0_m4m5_noshield c_length=4U c_width=4U
* device instance $580 r0 *1 2.6,96.2 cap_mim_2f0_m4m5_noshield
X$580 \$24__t75 topp__t246 cap_mim_2f0_m4m5_noshield c_length=4U c_width=4U
* device instance $581 r0 *1 9,96.2 cap_mim_2f0_m4m5_noshield
X$581 \$12__t124 topp__t247 cap_mim_2f0_m4m5_noshield c_length=4U c_width=4U
* device instance $582 r0 *1 15.4,96.2 cap_mim_2f0_m4m5_noshield
X$582 \$24__t70 topp__t205 cap_mim_2f0_m4m5_noshield c_length=4U c_width=4U
* device instance $583 r0 *1 21.8,96.2 cap_mim_2f0_m4m5_noshield
X$583 \$12__t80 topp__t157 cap_mim_2f0_m4m5_noshield c_length=4U c_width=4U
* device instance $584 r0 *1 28.2,96.2 cap_mim_2f0_m4m5_noshield
X$584 \$24__t50 topp__t159 cap_mim_2f0_m4m5_noshield c_length=4U c_width=4U
* device instance $585 r0 *1 34.6,96.2 cap_mim_2f0_m4m5_noshield
X$585 \$12__t81 topp__t160 cap_mim_2f0_m4m5_noshield c_length=4U c_width=4U
* device instance $586 r0 *1 41,96.2 cap_mim_2f0_m4m5_noshield
X$586 \$24__t51 topp__t161 cap_mim_2f0_m4m5_noshield c_length=4U c_width=4U
* device instance $587 r0 *1 47.4,96.2 cap_mim_2f0_m4m5_noshield
X$587 \$12__t86 topp__t171 cap_mim_2f0_m4m5_noshield c_length=4U c_width=4U
* device instance $588 r0 *1 53.8,96.2 cap_mim_2f0_m4m5_noshield
X$588 \$24__t57 topp__t172 cap_mim_2f0_m4m5_noshield c_length=4U c_width=4U
* device instance $589 r0 *1 60.2,96.2 cap_mim_2f0_m4m5_noshield
X$589 \$12__t83 topp__t164 cap_mim_2f0_m4m5_noshield c_length=4U c_width=4U
* device instance $590 r0 *1 66.6,96.2 cap_mim_2f0_m4m5_noshield
X$590 \$24__t49 topp__t158 cap_mim_2f0_m4m5_noshield c_length=4U c_width=4U
* device instance $591 r0 *1 73,96.2 cap_mim_2f0_m4m5_noshield
X$591 \$12__t29 topp__t52 cap_mim_2f0_m4m5_noshield c_length=4U c_width=4U
* device instance $592 r0 *1 79.4,96.2 cap_mim_2f0_m4m5_noshield
X$592 \$24__t46 topp__t153 cap_mim_2f0_m4m5_noshield c_length=4U c_width=4U
* device instance $593 r0 *1 85.8,96.2 cap_mim_2f0_m4m5_noshield
X$593 \$12__t79 topp__t154 cap_mim_2f0_m4m5_noshield c_length=4U c_width=4U
* device instance $594 r0 *1 92.2,96.2 cap_mim_2f0_m4m5_noshield
X$594 \$24__t47 topp__t155 cap_mim_2f0_m4m5_noshield c_length=4U c_width=4U
* device instance $595 r0 *1 98.6,96.2 cap_mim_2f0_m4m5_noshield
X$595 \$12__t92 topp__t183 cap_mim_2f0_m4m5_noshield c_length=4U c_width=4U
* device instance $596 r0 *1 105,96.2 cap_mim_2f0_m4m5_noshield
X$596 \$24__t65 topp__t187 cap_mim_2f0_m4m5_noshield c_length=4U c_width=4U
* device instance $597 r0 *1 111.4,96.2 cap_mim_2f0_m4m5_noshield
X$597 \$12__t99 topp__t197 cap_mim_2f0_m4m5_noshield c_length=4U c_width=4U
* device instance $598 r0 *1 117.8,96.2 cap_mim_2f0_m4m5_noshield
X$598 \$24__t66 topp__t189 cap_mim_2f0_m4m5_noshield c_length=4U c_width=4U
* device instance $599 r0 *1 124.2,96.2 cap_mim_2f0_m4m5_noshield
X$599 \$12__t95 topp__t190 cap_mim_2f0_m4m5_noshield c_length=4U c_width=4U
* device instance $600 r0 *1 130.6,96.2 cap_mim_2f0_m4m5_noshield
X$600 \$24__t44 topp__t148 cap_mim_2f0_m4m5_noshield c_length=4U c_width=4U
* device instance $601 r0 *1 137,96.2 cap_mim_2f0_m4m5_noshield
X$601 \$12__t76 topp__t149 cap_mim_2f0_m4m5_noshield c_length=4U c_width=4U
* device instance $602 r0 *1 143.4,96.2 cap_mim_2f0_m4m5_noshield
X$602 \$24__t60 topp__t178 cap_mim_2f0_m4m5_noshield c_length=4U c_width=4U
* device instance $603 r0 *1 149.8,96.2 cap_mim_2f0_m4m5_noshield
X$603 \$12__t218 topp__t437 cap_mim_2f0_m4m5_noshield c_length=4U c_width=4U
* device instance $604 r0 *1 156.2,96.2 cap_mim_2f0_m4m5_noshield
X$604 \$24__t115 topp__t407 cap_mim_2f0_m4m5_noshield c_length=4U c_width=4U
* device instance $605 r0 *1 162.6,96.2 cap_mim_2f0_m4m5_noshield
X$605 \$12__t224 topp__t447 cap_mim_2f0_m4m5_noshield c_length=4U c_width=4U
* device instance $606 r0 *1 169,96.2 cap_mim_2f0_m4m5_noshield
X$606 \$24__t124 topp__t439 cap_mim_2f0_m4m5_noshield c_length=4U c_width=4U
* device instance $607 r0 *1 175.4,96.2 cap_mim_2f0_m4m5_noshield
X$607 \$12__t219 topp__t438 cap_mim_2f0_m4m5_noshield c_length=4U c_width=4U
* device instance $608 r0 *1 181.8,96.2 cap_mim_2f0_m4m5_noshield
X$608 \$24__t123 topp__t436 cap_mim_2f0_m4m5_noshield c_length=4U c_width=4U
* device instance $609 r0 *1 188.2,96.2 cap_mim_2f0_m4m5_noshield
X$609 \$12__t215 topp__t430 cap_mim_2f0_m4m5_noshield c_length=4U c_width=4U
* device instance $610 r0 *1 194.6,96.2 cap_mim_2f0_m4m5_noshield
X$610 \$24__t119 topp__t429 cap_mim_2f0_m4m5_noshield c_length=4U c_width=4U
* device instance $611 r0 *1 201,96.2 cap_mim_2f0_m4m5_noshield
X$611 \$12__t214 topp__t428 cap_mim_2f0_m4m5_noshield c_length=4U c_width=4U
* device instance $612 r0 *1 224,96.2 cap_mim_2f0_m4m5_noshield
X$612 \$83__t114 topn__t454 cap_mim_2f0_m4m5_noshield c_length=4U c_width=4U
* device instance $613 r0 *1 230.4,96.2 cap_mim_2f0_m4m5_noshield
X$613 \$81__t227 topn__t453 cap_mim_2f0_m4m5_noshield c_length=4U c_width=4U
* device instance $614 r0 *1 236.8,96.2 cap_mim_2f0_m4m5_noshield
X$614 \$83__t121 topn__t467 cap_mim_2f0_m4m5_noshield c_length=4U c_width=4U
* device instance $615 r0 *1 243.2,96.2 cap_mim_2f0_m4m5_noshield
X$615 \$81__t226 topn__t451 cap_mim_2f0_m4m5_noshield c_length=4U c_width=4U
* device instance $616 r0 *1 249.6,96.2 cap_mim_2f0_m4m5_noshield
X$616 \$83__t108 topn__t441 cap_mim_2f0_m4m5_noshield c_length=4U c_width=4U
* device instance $617 r0 *1 256,96.2 cap_mim_2f0_m4m5_noshield
X$617 \$81__t220 topn__t440 cap_mim_2f0_m4m5_noshield c_length=4U c_width=4U
* device instance $618 r0 *1 262.4,96.2 cap_mim_2f0_m4m5_noshield
X$618 \$83__t105 topn__t420 cap_mim_2f0_m4m5_noshield c_length=4U c_width=4U
* device instance $619 r0 *1 268.8,96.2 cap_mim_2f0_m4m5_noshield
X$619 \$81__t232 topn__t465 cap_mim_2f0_m4m5_noshield c_length=4U c_width=4U
* device instance $620 r0 *1 275.2,96.2 cap_mim_2f0_m4m5_noshield
X$620 \$83__t120 topn__t464 cap_mim_2f0_m4m5_noshield c_length=4U c_width=4U
* device instance $621 r0 *1 281.6,96.2 cap_mim_2f0_m4m5_noshield
X$621 \$81__t231 topn__t463 cap_mim_2f0_m4m5_noshield c_length=4U c_width=4U
* device instance $622 r0 *1 288,96.2 cap_mim_2f0_m4m5_noshield
X$622 \$83__t107 topn__t439 cap_mim_2f0_m4m5_noshield c_length=4U c_width=4U
* device instance $623 r0 *1 294.4,96.2 cap_mim_2f0_m4m5_noshield
X$623 \$81__t43 topn__t85 cap_mim_2f0_m4m5_noshield c_length=4U c_width=4U
* device instance $624 r0 *1 300.8,96.2 cap_mim_2f0_m4m5_noshield
X$624 \$83__t22 topn__t96 cap_mim_2f0_m4m5_noshield c_length=4U c_width=4U
* device instance $625 r0 *1 307.2,96.2 cap_mim_2f0_m4m5_noshield
X$625 \$81__t29 topn__t55 cap_mim_2f0_m4m5_noshield c_length=4U c_width=4U
* device instance $626 r0 *1 313.6,96.2 cap_mim_2f0_m4m5_noshield
X$626 \$83__t8 topn__t28 cap_mim_2f0_m4m5_noshield c_length=4U c_width=4U
* device instance $627 r0 *1 320,96.2 cap_mim_2f0_m4m5_noshield
X$627 \$81__t15 topn__t31 cap_mim_2f0_m4m5_noshield c_length=4U c_width=4U
* device instance $628 r0 *1 326.4,96.2 cap_mim_2f0_m4m5_noshield
X$628 \$83__t9 topn__t32 cap_mim_2f0_m4m5_noshield c_length=4U c_width=4U
* device instance $629 r0 *1 332.8,96.2 cap_mim_2f0_m4m5_noshield
X$629 \$81__t53 topn__t106 cap_mim_2f0_m4m5_noshield c_length=4U c_width=4U
* device instance $630 r0 *1 339.2,96.2 cap_mim_2f0_m4m5_noshield
X$630 \$83__t28 topn__t116 cap_mim_2f0_m4m5_noshield c_length=4U c_width=4U
* device instance $631 r0 *1 345.6,96.2 cap_mim_2f0_m4m5_noshield
X$631 \$81__t55 topn__t108 cap_mim_2f0_m4m5_noshield c_length=4U c_width=4U
* device instance $632 r0 *1 352,96.2 cap_mim_2f0_m4m5_noshield
X$632 \$83__t24 topn__t109 cap_mim_2f0_m4m5_noshield c_length=4U c_width=4U
* device instance $633 r0 *1 358.4,96.2 cap_mim_2f0_m4m5_noshield
X$633 \$81__t13 topn__t29 cap_mim_2f0_m4m5_noshield c_length=4U c_width=4U
* device instance $634 r0 *1 364.8,96.2 cap_mim_2f0_m4m5_noshield
X$634 \$83__t126 topn__t497 cap_mim_2f0_m4m5_noshield c_length=4U c_width=4U
* device instance $635 r0 *1 371.2,96.2 cap_mim_2f0_m4m5_noshield
X$635 \$81__t17 topn__t37 cap_mim_2f0_m4m5_noshield c_length=4U c_width=4U
* device instance $636 r0 *1 377.6,96.2 cap_mim_2f0_m4m5_noshield
X$636 \$83__t0 topn__t13 cap_mim_2f0_m4m5_noshield c_length=4U c_width=4U
* device instance $637 r0 *1 384,96.2 cap_mim_2f0_m4m5_noshield
X$637 \$81__t9 topn__t22 cap_mim_2f0_m4m5_noshield c_length=4U c_width=4U
* device instance $638 r0 *1 390.4,96.2 cap_mim_2f0_m4m5_noshield
X$638 \$83__t6 topn__t23 cap_mim_2f0_m4m5_noshield c_length=4U c_width=4U
* device instance $639 r0 *1 396.8,96.2 cap_mim_2f0_m4m5_noshield
X$639 \$81__t10 topn__t24 cap_mim_2f0_m4m5_noshield c_length=4U c_width=4U
* device instance $640 r0 *1 403.2,96.2 cap_mim_2f0_m4m5_noshield
X$640 \$83__t7 topn__t25 cap_mim_2f0_m4m5_noshield c_length=4U c_width=4U
* device instance $641 r0 *1 409.6,96.2 cap_mim_2f0_m4m5_noshield
X$641 \$81__t16 topn__t33 cap_mim_2f0_m4m5_noshield c_length=4U c_width=4U
* device instance $642 r0 *1 416,96.2 cap_mim_2f0_m4m5_noshield
X$642 \$83__t10 topn__t34 cap_mim_2f0_m4m5_noshield c_length=4U c_width=4U
* device instance $643 r0 *1 422.4,96.2 cap_mim_2f0_m4m5_noshield
X$643 \$81__t22 topn__t44 cap_mim_2f0_m4m5_noshield c_length=4U c_width=4U
* device instance $644 r0 *1 2.6,102.6 cap_mim_2f0_m4m5_noshield
X$644 \$24__t54 topp__t166 cap_mim_2f0_m4m5_noshield c_length=4U c_width=4U
* device instance $645 r0 *1 9,102.6 cap_mim_2f0_m4m5_noshield
X$645 \$12__t84 topp__t168 cap_mim_2f0_m4m5_noshield c_length=4U c_width=4U
* device instance $646 r0 *1 15.4,102.6 cap_mim_2f0_m4m5_noshield
X$646 \$24__t56 topp__t169 cap_mim_2f0_m4m5_noshield c_length=4U c_width=4U
* device instance $647 r0 *1 21.8,102.6 cap_mim_2f0_m4m5_noshield
X$647 \$12__t85 topp__t170 cap_mim_2f0_m4m5_noshield c_length=4U c_width=4U
* device instance $648 r0 *1 28.2,102.6 cap_mim_2f0_m4m5_noshield
X$648 \$24__t55 topp__t167 cap_mim_2f0_m4m5_noshield c_length=4U c_width=4U
* device instance $649 r0 *1 34.6,102.6 cap_mim_2f0_m4m5_noshield
X$649 \$12__t71 topp__t141 cap_mim_2f0_m4m5_noshield c_length=4U c_width=4U
* device instance $650 r0 *1 41,102.6 cap_mim_2f0_m4m5_noshield
X$650 \$24__t42 topp__t142 cap_mim_2f0_m4m5_noshield c_length=4U c_width=4U
* device instance $651 r0 *1 47.4,102.6 cap_mim_2f0_m4m5_noshield
X$651 \$12__t72 topp__t143 cap_mim_2f0_m4m5_noshield c_length=4U c_width=4U
* device instance $652 r0 *1 53.8,102.6 cap_mim_2f0_m4m5_noshield
X$652 \$24__t43 topp__t145 cap_mim_2f0_m4m5_noshield c_length=4U c_width=4U
* device instance $653 r0 *1 60.2,102.6 cap_mim_2f0_m4m5_noshield
X$653 \$12__t74 topp__t146 cap_mim_2f0_m4m5_noshield c_length=4U c_width=4U
* device instance $654 r0 *1 66.6,102.6 cap_mim_2f0_m4m5_noshield
X$654 \$24__t72 topp__t240 cap_mim_2f0_m4m5_noshield c_length=4U c_width=4U
* device instance $655 r0 *1 73,102.6 cap_mim_2f0_m4m5_noshield
X$655 \$12__t26 topp__t44 cap_mim_2f0_m4m5_noshield c_length=4U c_width=4U
* device instance $656 r0 *1 79.4,102.6 cap_mim_2f0_m4m5_noshield
X$656 \$24__t63 topp__t184 cap_mim_2f0_m4m5_noshield c_length=4U c_width=4U
* device instance $657 r0 *1 85.8,102.6 cap_mim_2f0_m4m5_noshield
X$657 \$12__t93 topp__t185 cap_mim_2f0_m4m5_noshield c_length=4U c_width=4U
* device instance $658 r0 *1 92.2,102.6 cap_mim_2f0_m4m5_noshield
X$658 \$24__t64 topp__t186 cap_mim_2f0_m4m5_noshield c_length=4U c_width=4U
* device instance $659 r0 *1 98.6,102.6 cap_mim_2f0_m4m5_noshield
X$659 \$12__t90 topp__t179 cap_mim_2f0_m4m5_noshield c_length=4U c_width=4U
* device instance $660 r0 *1 105,102.6 cap_mim_2f0_m4m5_noshield
X$660 \$24__t61 topp__t180 cap_mim_2f0_m4m5_noshield c_length=4U c_width=4U
* device instance $661 r0 *1 111.4,102.6 cap_mim_2f0_m4m5_noshield
X$661 \$12__t91 topp__t181 cap_mim_2f0_m4m5_noshield c_length=4U c_width=4U
* device instance $662 r0 *1 117.8,102.6 cap_mim_2f0_m4m5_noshield
X$662 \$24__t62 topp__t182 cap_mim_2f0_m4m5_noshield c_length=4U c_width=4U
* device instance $663 r0 *1 124.2,102.6 cap_mim_2f0_m4m5_noshield
X$663 \$12__t77 topp__t150 cap_mim_2f0_m4m5_noshield c_length=4U c_width=4U
* device instance $664 r0 *1 130.6,102.6 cap_mim_2f0_m4m5_noshield
X$664 \$24__t45 topp__t151 cap_mim_2f0_m4m5_noshield c_length=4U c_width=4U
* device instance $665 r0 *1 137,102.6 cap_mim_2f0_m4m5_noshield
X$665 \$12__t78 topp__t152 cap_mim_2f0_m4m5_noshield c_length=4U c_width=4U
* device instance $666 r0 *1 143.4,102.6 cap_mim_2f0_m4m5_noshield
X$666 \$24__t59 topp__t176 cap_mim_2f0_m4m5_noshield c_length=4U c_width=4U
* device instance $667 r0 *1 149.8,102.6 cap_mim_2f0_m4m5_noshield
X$667 \$12__t211 topp__t423 cap_mim_2f0_m4m5_noshield c_length=4U c_width=4U
* device instance $668 r0 *1 156.2,102.6 cap_mim_2f0_m4m5_noshield
X$668 \$24__t117 topp__t425 cap_mim_2f0_m4m5_noshield c_length=4U c_width=4U
* device instance $669 r0 *1 162.6,102.6 cap_mim_2f0_m4m5_noshield
X$669 \$12__t212 topp__t424 cap_mim_2f0_m4m5_noshield c_length=4U c_width=4U
* device instance $670 r0 *1 169,102.6 cap_mim_2f0_m4m5_noshield
X$670 \$24__t127 topp__t446 cap_mim_2f0_m4m5_noshield c_length=4U c_width=4U
* device instance $671 r0 *1 175.4,102.6 cap_mim_2f0_m4m5_noshield
X$671 \$12__t223 topp__t445 cap_mim_2f0_m4m5_noshield c_length=4U c_width=4U
* device instance $672 r0 *1 181.8,102.6 cap_mim_2f0_m4m5_noshield
X$672 \$24__t126 topp__t444 cap_mim_2f0_m4m5_noshield c_length=4U c_width=4U
* device instance $673 r0 *1 188.2,102.6 cap_mim_2f0_m4m5_noshield
X$673 \$12__t221 topp__t442 cap_mim_2f0_m4m5_noshield c_length=4U c_width=4U
* device instance $674 r0 *1 194.6,102.6 cap_mim_2f0_m4m5_noshield
X$674 \$24__t125 topp__t441 cap_mim_2f0_m4m5_noshield c_length=4U c_width=4U
* device instance $675 r0 *1 201,102.6 cap_mim_2f0_m4m5_noshield
X$675 \$12__t220 topp__t440 cap_mim_2f0_m4m5_noshield c_length=4U c_width=4U
* device instance $676 r0 *1 224,102.6 cap_mim_2f0_m4m5_noshield
X$676 \$83__t118 topn__t461 cap_mim_2f0_m4m5_noshield c_length=4U c_width=4U
* device instance $677 r0 *1 230.4,102.6 cap_mim_2f0_m4m5_noshield
X$677 \$81__t230 topn__t460 cap_mim_2f0_m4m5_noshield c_length=4U c_width=4U
* device instance $678 r0 *1 236.8,102.6 cap_mim_2f0_m4m5_noshield
X$678 \$83__t117 topn__t459 cap_mim_2f0_m4m5_noshield c_length=4U c_width=4U
* device instance $679 r0 *1 243.2,102.6 cap_mim_2f0_m4m5_noshield
X$679 \$81__t229 topn__t458 cap_mim_2f0_m4m5_noshield c_length=4U c_width=4U
* device instance $680 r0 *1 249.6,102.6 cap_mim_2f0_m4m5_noshield
X$680 \$83__t116 topn__t457 cap_mim_2f0_m4m5_noshield c_length=4U c_width=4U
* device instance $681 r0 *1 256,102.6 cap_mim_2f0_m4m5_noshield
X$681 \$81__t228 topn__t456 cap_mim_2f0_m4m5_noshield c_length=4U c_width=4U
* device instance $682 r0 *1 262.4,102.6 cap_mim_2f0_m4m5_noshield
X$682 \$83__t115 topn__t455 cap_mim_2f0_m4m5_noshield c_length=4U c_width=4U
* device instance $683 r0 *1 268.8,102.6 cap_mim_2f0_m4m5_noshield
X$683 \$81__t218 topn__t437 cap_mim_2f0_m4m5_noshield c_length=4U c_width=4U
* device instance $684 r0 *1 275.2,102.6 cap_mim_2f0_m4m5_noshield
X$684 \$83__t113 topn__t452 cap_mim_2f0_m4m5_noshield c_length=4U c_width=4U
* device instance $685 r0 *1 281.6,102.6 cap_mim_2f0_m4m5_noshield
X$685 \$81__t233 topn__t466 cap_mim_2f0_m4m5_noshield c_length=4U c_width=4U
* device instance $686 r0 *1 288,102.6 cap_mim_2f0_m4m5_noshield
X$686 \$83__t106 topn__t421 cap_mim_2f0_m4m5_noshield c_length=4U c_width=4U
* device instance $687 r0 *1 294.4,102.6 cap_mim_2f0_m4m5_noshield
X$687 \$81__t56 topn__t110 cap_mim_2f0_m4m5_noshield c_length=4U c_width=4U
* device instance $688 r0 *1 300.8,102.6 cap_mim_2f0_m4m5_noshield
X$688 \$83__t25 topn__t111 cap_mim_2f0_m4m5_noshield c_length=4U c_width=4U
* device instance $689 r0 *1 307.2,102.6 cap_mim_2f0_m4m5_noshield
X$689 \$81__t57 topn__t112 cap_mim_2f0_m4m5_noshield c_length=4U c_width=4U
* device instance $690 r0 *1 313.6,102.6 cap_mim_2f0_m4m5_noshield
X$690 \$83__t26 topn__t113 cap_mim_2f0_m4m5_noshield c_length=4U c_width=4U
* device instance $691 r0 *1 320,102.6 cap_mim_2f0_m4m5_noshield
X$691 \$81__t58 topn__t114 cap_mim_2f0_m4m5_noshield c_length=4U c_width=4U
* device instance $692 r0 *1 326.4,102.6 cap_mim_2f0_m4m5_noshield
X$692 \$83__t27 topn__t115 cap_mim_2f0_m4m5_noshield c_length=4U c_width=4U
* device instance $693 r0 *1 332.8,102.6 cap_mim_2f0_m4m5_noshield
X$693 \$81__t54 topn__t107 cap_mim_2f0_m4m5_noshield c_length=4U c_width=4U
* device instance $694 r0 *1 339.2,102.6 cap_mim_2f0_m4m5_noshield
X$694 \$83__t15 topn__t82 cap_mim_2f0_m4m5_noshield c_length=4U c_width=4U
* device instance $695 r0 *1 345.6,102.6 cap_mim_2f0_m4m5_noshield
X$695 \$81__t42 topn__t83 cap_mim_2f0_m4m5_noshield c_length=4U c_width=4U
* device instance $696 r0 *1 352,102.6 cap_mim_2f0_m4m5_noshield
X$696 \$83__t16 topn__t84 cap_mim_2f0_m4m5_noshield c_length=4U c_width=4U
* device instance $697 r0 *1 358.4,102.6 cap_mim_2f0_m4m5_noshield
X$697 \$81__t14 topn__t30 cap_mim_2f0_m4m5_noshield c_length=4U c_width=4U
* device instance $698 r0 *1 364.8,102.6 cap_mim_2f0_m4m5_noshield
X$698 \$83__t127 topn__t498 cap_mim_2f0_m4m5_noshield c_length=4U c_width=4U
* device instance $699 r0 *1 371.2,102.6 cap_mim_2f0_m4m5_noshield
X$699 \$81__t19 topn__t39 cap_mim_2f0_m4m5_noshield c_length=4U c_width=4U
* device instance $700 r0 *1 377.6,102.6 cap_mim_2f0_m4m5_noshield
X$700 \$83__t13 topn__t40 cap_mim_2f0_m4m5_noshield c_length=4U c_width=4U
* device instance $701 r0 *1 384,102.6 cap_mim_2f0_m4m5_noshield
X$701 \$81__t20 topn__t41 cap_mim_2f0_m4m5_noshield c_length=4U c_width=4U
* device instance $702 r0 *1 390.4,102.6 cap_mim_2f0_m4m5_noshield
X$702 \$83__t14 topn__t42 cap_mim_2f0_m4m5_noshield c_length=4U c_width=4U
* device instance $703 r0 *1 396.8,102.6 cap_mim_2f0_m4m5_noshield
X$703 \$81__t21 topn__t43 cap_mim_2f0_m4m5_noshield c_length=4U c_width=4U
* device instance $704 r0 *1 403.2,102.6 cap_mim_2f0_m4m5_noshield
X$704 \$83__t11 topn__t35 cap_mim_2f0_m4m5_noshield c_length=4U c_width=4U
* device instance $705 r0 *1 409.6,102.6 cap_mim_2f0_m4m5_noshield
X$705 \$81__t5 topn__t12 cap_mim_2f0_m4m5_noshield c_length=4U c_width=4U
* device instance $706 r0 *1 416,102.6 cap_mim_2f0_m4m5_noshield
X$706 \$83__t12 topn__t36 cap_mim_2f0_m4m5_noshield c_length=4U c_width=4U
* device instance $707 r0 *1 422.4,102.6 cap_mim_2f0_m4m5_noshield
X$707 \$81__t18 topn__t38 cap_mim_2f0_m4m5_noshield c_length=4U c_width=4U
* device instance $708 r0 *1 2.6,109 cap_mim_2f0_m4m5_noshield
X$708 \$32__t20 topp__t253 cap_mim_2f0_m4m5_noshield c_length=4U c_width=4U
* device instance $709 r0 *1 9,109 cap_mim_2f0_m4m5_noshield
X$709 \$12__t126 topp__t254 cap_mim_2f0_m4m5_noshield c_length=4U c_width=4U
* device instance $710 r0 *1 15.4,109 cap_mim_2f0_m4m5_noshield
X$710 \$32__t21 topp__t255 cap_mim_2f0_m4m5_noshield c_length=4U c_width=4U
* device instance $711 r0 *1 21.8,109 cap_mim_2f0_m4m5_noshield
X$711 \$12__t127 topp__t256 cap_mim_2f0_m4m5_noshield c_length=4U c_width=4U
* device instance $712 r0 *1 28.2,109 cap_mim_2f0_m4m5_noshield
X$712 \$32__t23 topp__t266 cap_mim_2f0_m4m5_noshield c_length=4U c_width=4U
* device instance $713 r0 *1 34.6,109 cap_mim_2f0_m4m5_noshield
X$713 \$12__t129 topp__t258 cap_mim_2f0_m4m5_noshield c_length=4U c_width=4U
* device instance $714 r0 *1 41,109 cap_mim_2f0_m4m5_noshield
X$714 \$32__t18 topp__t250 cap_mim_2f0_m4m5_noshield c_length=4U c_width=4U
* device instance $715 r0 *1 47.4,109 cap_mim_2f0_m4m5_noshield
X$715 \$12__t125 topp__t251 cap_mim_2f0_m4m5_noshield c_length=4U c_width=4U
* device instance $716 r0 *1 53.8,109 cap_mim_2f0_m4m5_noshield
X$716 \$32__t19 topp__t252 cap_mim_2f0_m4m5_noshield c_length=4U c_width=4U
* device instance $717 r0 *1 60.2,109 cap_mim_2f0_m4m5_noshield
X$717 \$12__t131 topp__t262 cap_mim_2f0_m4m5_noshield c_length=4U c_width=4U
* device instance $718 r0 *1 66.6,109 cap_mim_2f0_m4m5_noshield
X$718 \$32__t22 topp__t263 cap_mim_2f0_m4m5_noshield c_length=4U c_width=4U
* device instance $719 r0 *1 73,109 cap_mim_2f0_m4m5_noshield
X$719 \$12__t25 topp__t42 cap_mim_2f0_m4m5_noshield c_length=4U c_width=4U
* device instance $720 r0 *1 79.4,109 cap_mim_2f0_m4m5_noshield
X$720 \$32__t13 topp__t216 cap_mim_2f0_m4m5_noshield c_length=4U c_width=4U
* device instance $721 r0 *1 85.8,109 cap_mim_2f0_m4m5_noshield
X$721 \$12__t108 topp__t217 cap_mim_2f0_m4m5_noshield c_length=4U c_width=4U
* device instance $722 r0 *1 92.2,109 cap_mim_2f0_m4m5_noshield
X$722 \$32__t14 topp__t218 cap_mim_2f0_m4m5_noshield c_length=4U c_width=4U
* device instance $723 r0 *1 98.6,109 cap_mim_2f0_m4m5_noshield
X$723 \$12__t109 topp__t219 cap_mim_2f0_m4m5_noshield c_length=4U c_width=4U
* device instance $724 r0 *1 105,109 cap_mim_2f0_m4m5_noshield
X$724 \$32__t15 topp__t220 cap_mim_2f0_m4m5_noshield c_length=4U c_width=4U
* device instance $725 r0 *1 111.4,109 cap_mim_2f0_m4m5_noshield
X$725 \$12__t115 topp__t231 cap_mim_2f0_m4m5_noshield c_length=4U c_width=4U
* device instance $726 r0 *1 117.8,109 cap_mim_2f0_m4m5_noshield
X$726 \$32__t16 topp__t223 cap_mim_2f0_m4m5_noshield c_length=4U c_width=4U
* device instance $727 r0 *1 124.2,109 cap_mim_2f0_m4m5_noshield
X$727 \$12__t111 topp__t224 cap_mim_2f0_m4m5_noshield c_length=4U c_width=4U
* device instance $728 r0 *1 130.6,109 cap_mim_2f0_m4m5_noshield
X$728 \$32__t17 topp__t225 cap_mim_2f0_m4m5_noshield c_length=4U c_width=4U
* device instance $729 r0 *1 137,109 cap_mim_2f0_m4m5_noshield
X$729 \$12__t112 topp__t226 cap_mim_2f0_m4m5_noshield c_length=4U c_width=4U
* device instance $730 r0 *1 143.4,109 cap_mim_2f0_m4m5_noshield
X$730 \$32__t12 topp__t206 cap_mim_2f0_m4m5_noshield c_length=4U c_width=4U
* device instance $731 r0 *1 149.8,109 cap_mim_2f0_m4m5_noshield
X$731 \$12__t200 topp__t398 cap_mim_2f0_m4m5_noshield c_length=4U c_width=4U
* device instance $732 r0 *1 156.2,109 cap_mim_2f0_m4m5_noshield
X$732 \$32__t45 topp__t406 cap_mim_2f0_m4m5_noshield c_length=4U c_width=4U
* device instance $733 r0 *1 162.6,109 cap_mim_2f0_m4m5_noshield
X$733 \$12__t222 topp__t443 cap_mim_2f0_m4m5_noshield c_length=4U c_width=4U
* device instance $734 r0 *1 169,109 cap_mim_2f0_m4m5_noshield
X$734 \$32__t47 topp__t409 cap_mim_2f0_m4m5_noshield c_length=4U c_width=4U
* device instance $735 r0 *1 175.4,109 cap_mim_2f0_m4m5_noshield
X$735 \$12__t205 topp__t410 cap_mim_2f0_m4m5_noshield c_length=4U c_width=4U
* device instance $736 r0 *1 181.8,109 cap_mim_2f0_m4m5_noshield
X$736 \$32__t46 topp__t408 cap_mim_2f0_m4m5_noshield c_length=4U c_width=4U
* device instance $737 r0 *1 188.2,109 cap_mim_2f0_m4m5_noshield
X$737 \$12__t198 topp__t395 cap_mim_2f0_m4m5_noshield c_length=4U c_width=4U
* device instance $738 r0 *1 194.6,109 cap_mim_2f0_m4m5_noshield
X$738 \$32__t44 topp__t396 cap_mim_2f0_m4m5_noshield c_length=4U c_width=4U
* device instance $739 r0 *1 201,109 cap_mim_2f0_m4m5_noshield
X$739 \$12__t199 topp__t397 cap_mim_2f0_m4m5_noshield c_length=4U c_width=4U
* device instance $740 r0 *1 224,109 cap_mim_2f0_m4m5_noshield
X$740 \$84__t10 topn__t123 cap_mim_2f0_m4m5_noshield c_length=4U c_width=4U
* device instance $741 r0 *1 230.4,109 cap_mim_2f0_m4m5_noshield
X$741 \$81__t235 topn__t476 cap_mim_2f0_m4m5_noshield c_length=4U c_width=4U
* device instance $742 r0 *1 236.8,109 cap_mim_2f0_m4m5_noshield
X$742 \$84__t57 topn__t478 cap_mim_2f0_m4m5_noshield c_length=4U c_width=4U
* device instance $743 r0 *1 243.2,109 cap_mim_2f0_m4m5_noshield
X$743 \$81__t236 topn__t477 cap_mim_2f0_m4m5_noshield c_length=4U c_width=4U
* device instance $744 r0 *1 249.6,109 cap_mim_2f0_m4m5_noshield
X$744 \$84__t55 topn__t469 cap_mim_2f0_m4m5_noshield c_length=4U c_width=4U
* device instance $745 r0 *1 256,109 cap_mim_2f0_m4m5_noshield
X$745 \$81__t243 topn__t488 cap_mim_2f0_m4m5_noshield c_length=4U c_width=4U
* device instance $746 r0 *1 262.4,109 cap_mim_2f0_m4m5_noshield
X$746 \$84__t58 topn__t489 cap_mim_2f0_m4m5_noshield c_length=4U c_width=4U
* device instance $747 r0 *1 268.8,109 cap_mim_2f0_m4m5_noshield
X$747 \$81__t244 topn__t491 cap_mim_2f0_m4m5_noshield c_length=4U c_width=4U
* device instance $748 r0 *1 275.2,109 cap_mim_2f0_m4m5_noshield
X$748 \$84__t60 topn__t492 cap_mim_2f0_m4m5_noshield c_length=4U c_width=4U
* device instance $749 r0 *1 281.6,109 cap_mim_2f0_m4m5_noshield
X$749 \$81__t245 topn__t493 cap_mim_2f0_m4m5_noshield c_length=4U c_width=4U
* device instance $750 r0 *1 288,109 cap_mim_2f0_m4m5_noshield
X$750 \$84__t53 topn__t436 cap_mim_2f0_m4m5_noshield c_length=4U c_width=4U
* device instance $751 r0 *1 294.4,109 cap_mim_2f0_m4m5_noshield
X$751 \$81__t50 topn__t102 cap_mim_2f0_m4m5_noshield c_length=4U c_width=4U
* device instance $752 r0 *1 300.8,109 cap_mim_2f0_m4m5_noshield
X$752 \$84__t8 topn__t103 cap_mim_2f0_m4m5_noshield c_length=4U c_width=4U
* device instance $753 r0 *1 307.2,109 cap_mim_2f0_m4m5_noshield
X$753 \$81__t38 topn__t73 cap_mim_2f0_m4m5_noshield c_length=4U c_width=4U
* device instance $754 r0 *1 313.6,109 cap_mim_2f0_m4m5_noshield
X$754 \$84__t3 topn__t74 cap_mim_2f0_m4m5_noshield c_length=4U c_width=4U
* device instance $755 r0 *1 320,109 cap_mim_2f0_m4m5_noshield
X$755 \$81__t39 topn__t75 cap_mim_2f0_m4m5_noshield c_length=4U c_width=4U
* device instance $756 r0 *1 326.4,109 cap_mim_2f0_m4m5_noshield
X$756 \$84__t4 topn__t76 cap_mim_2f0_m4m5_noshield c_length=4U c_width=4U
* device instance $757 r0 *1 332.8,109 cap_mim_2f0_m4m5_noshield
X$757 \$81__t40 topn__t77 cap_mim_2f0_m4m5_noshield c_length=4U c_width=4U
* device instance $758 r0 *1 339.2,109 cap_mim_2f0_m4m5_noshield
X$758 \$84__t5 topn__t78 cap_mim_2f0_m4m5_noshield c_length=4U c_width=4U
* device instance $759 r0 *1 345.6,109 cap_mim_2f0_m4m5_noshield
X$759 \$81__t41 topn__t79 cap_mim_2f0_m4m5_noshield c_length=4U c_width=4U
* device instance $760 r0 *1 352,109 cap_mim_2f0_m4m5_noshield
X$760 \$84__t6 topn__t80 cap_mim_2f0_m4m5_noshield c_length=4U c_width=4U
* device instance $761 r0 *1 358.4,109 cap_mim_2f0_m4m5_noshield
X$761 \$81__t51 topn__t104 cap_mim_2f0_m4m5_noshield c_length=4U c_width=4U
* device instance $762 r0 *1 364.8,109 cap_mim_2f0_m4m5_noshield
X$762 \$84__t59 topn__t490 cap_mim_2f0_m4m5_noshield c_length=4U c_width=4U
* device instance $763 r0 *1 371.2,109 cap_mim_2f0_m4m5_noshield
X$763 \$81__t208 topn__t414 cap_mim_2f0_m4m5_noshield c_length=4U c_width=4U
* device instance $764 r0 *1 377.6,109 cap_mim_2f0_m4m5_noshield
X$764 \$84__t1 topn__t69 cap_mim_2f0_m4m5_noshield c_length=4U c_width=4U
* device instance $765 r0 *1 384,109 cap_mim_2f0_m4m5_noshield
X$765 \$81__t212 topn__t423 cap_mim_2f0_m4m5_noshield c_length=4U c_width=4U
* device instance $766 r0 *1 390.4,109 cap_mim_2f0_m4m5_noshield
X$766 \$84__t52 topn__t424 cap_mim_2f0_m4m5_noshield c_length=4U c_width=4U
* device instance $767 r0 *1 396.8,109 cap_mim_2f0_m4m5_noshield
X$767 \$81__t209 topn__t415 cap_mim_2f0_m4m5_noshield c_length=4U c_width=4U
* device instance $768 r0 *1 403.2,109 cap_mim_2f0_m4m5_noshield
X$768 \$84__t2 topn__t70 cap_mim_2f0_m4m5_noshield c_length=4U c_width=4U
* device instance $769 r0 *1 409.6,109 cap_mim_2f0_m4m5_noshield
X$769 \$81__t37 topn__t71 cap_mim_2f0_m4m5_noshield c_length=4U c_width=4U
* device instance $770 r0 *1 416,109 cap_mim_2f0_m4m5_noshield
X$770 \$84__t7 topn__t81 cap_mim_2f0_m4m5_noshield c_length=4U c_width=4U
* device instance $771 r0 *1 422.4,109 cap_mim_2f0_m4m5_noshield
X$771 \$81__t204 topn__t408 cap_mim_2f0_m4m5_noshield c_length=4U c_width=4U
* device instance $772 r0 *1 2.6,115.4 cap_mim_2f0_m4m5_noshield
X$772 \$40__t15 topp__t237 cap_mim_2f0_m4m5_noshield c_length=4U c_width=4U
* device instance $773 r0 *1 9,115.4 cap_mim_2f0_m4m5_noshield
X$773 \$12__t119 topp__t238 cap_mim_2f0_m4m5_noshield c_length=4U c_width=4U
* device instance $774 r0 *1 15.4,115.4 cap_mim_2f0_m4m5_noshield
X$774 \$40__t16 topp__t248 cap_mim_2f0_m4m5_noshield c_length=4U c_width=4U
* device instance $775 r0 *1 21.8,115.4 cap_mim_2f0_m4m5_noshield
X$775 \$12__t104 topp__t208 cap_mim_2f0_m4m5_noshield c_length=4U c_width=4U
* device instance $776 r0 *1 28.2,115.4 cap_mim_2f0_m4m5_noshield
X$776 \$40__t10 topp__t209 cap_mim_2f0_m4m5_noshield c_length=4U c_width=4U
* device instance $777 r0 *1 34.6,115.4 cap_mim_2f0_m4m5_noshield
X$777 \$12__t105 topp__t210 cap_mim_2f0_m4m5_noshield c_length=4U c_width=4U
* device instance $778 r0 *1 41,115.4 cap_mim_2f0_m4m5_noshield
X$778 \$40__t11 topp__t211 cap_mim_2f0_m4m5_noshield c_length=4U c_width=4U
* device instance $779 r0 *1 47.4,115.4 cap_mim_2f0_m4m5_noshield
X$779 \$12__t106 topp__t212 cap_mim_2f0_m4m5_noshield c_length=4U c_width=4U
* device instance $780 r0 *1 53.8,115.4 cap_mim_2f0_m4m5_noshield
X$780 \$40__t17 topp__t259 cap_mim_2f0_m4m5_noshield c_length=4U c_width=4U
* device instance $781 r0 *1 60.2,115.4 cap_mim_2f0_m4m5_noshield
X$781 \$12__t130 topp__t260 cap_mim_2f0_m4m5_noshield c_length=4U c_width=4U
* device instance $782 r0 *1 66.6,115.4 cap_mim_2f0_m4m5_noshield
X$782 \$40__t18 topp__t261 cap_mim_2f0_m4m5_noshield c_length=4U c_width=4U
* device instance $783 r0 *1 73,115.4 cap_mim_2f0_m4m5_noshield
X$783 \$12__t27 topp__t46 cap_mim_2f0_m4m5_noshield c_length=4U c_width=4U
* device instance $784 r0 *1 79.4,115.4 cap_mim_2f0_m4m5_noshield
X$784 \$40__t14 topp__t230 cap_mim_2f0_m4m5_noshield c_length=4U c_width=4U
* device instance $785 r0 *1 85.8,115.4 cap_mim_2f0_m4m5_noshield
X$785 \$12__t110 topp__t222 cap_mim_2f0_m4m5_noshield c_length=4U c_width=4U
* device instance $786 r0 *1 92.2,115.4 cap_mim_2f0_m4m5_noshield
X$786 \$40__t9 topp__t198 cap_mim_2f0_m4m5_noshield c_length=4U c_width=4U
* device instance $787 r0 *1 98.6,115.4 cap_mim_2f0_m4m5_noshield
X$787 \$12__t100 topp__t199 cap_mim_2f0_m4m5_noshield c_length=4U c_width=4U
* device instance $788 r0 *1 105,115.4 cap_mim_2f0_m4m5_noshield
X$788 \$48__t8 topp__t200 cap_mim_2f0_m4m5_noshield c_length=4U c_width=4U
* device instance $789 r0 *1 111.4,115.4 cap_mim_2f0_m4m5_noshield
X$789 \$12__t101 topp__t201 cap_mim_2f0_m4m5_noshield c_length=4U c_width=4U
* device instance $790 r0 *1 117.8,115.4 cap_mim_2f0_m4m5_noshield
X$790 \$48__t9 topp__t202 cap_mim_2f0_m4m5_noshield c_length=4U c_width=4U
* device instance $791 r0 *1 124.2,115.4 cap_mim_2f0_m4m5_noshield
X$791 \$12__t102 topp__t203 cap_mim_2f0_m4m5_noshield c_length=4U c_width=4U
* device instance $792 r0 *1 130.6,115.4 cap_mim_2f0_m4m5_noshield
X$792 \$48__t10 topp__t204 cap_mim_2f0_m4m5_noshield c_length=4U c_width=4U
* device instance $793 r0 *1 137,115.4 cap_mim_2f0_m4m5_noshield
X$793 \$12__t107 topp__t214 cap_mim_2f0_m4m5_noshield c_length=4U c_width=4U
* device instance $794 r0 *1 143.4,115.4 cap_mim_2f0_m4m5_noshield
X$794 \$48__t1 topp__t47 cap_mim_2f0_m4m5_noshield c_length=4U c_width=4U
* device instance $795 r0 *1 149.8,115.4 cap_mim_2f0_m4m5_noshield
X$795 \$12__t201 topp__t399 cap_mim_2f0_m4m5_noshield c_length=4U c_width=4U
* device instance $796 r0 *1 156.2,115.4 cap_mim_2f0_m4m5_noshield
X$796 \$56__t4 topp__t400 cap_mim_2f0_m4m5_noshield c_length=4U c_width=4U
* device instance $797 r0 *1 162.6,115.4 cap_mim_2f0_m4m5_noshield
X$797 \$12__t202 topp__t401 cap_mim_2f0_m4m5_noshield c_length=4U c_width=4U
* device instance $798 r0 *1 169,115.4 cap_mim_2f0_m4m5_noshield
X$798 \$56__t5 topp__t402 cap_mim_2f0_m4m5_noshield c_length=4U c_width=4U
* device instance $799 r0 *1 175.4,115.4 cap_mim_2f0_m4m5_noshield
X$799 \$12__t203 topp__t403 cap_mim_2f0_m4m5_noshield c_length=4U c_width=4U
* device instance $800 r0 *1 181.8,115.4 cap_mim_2f0_m4m5_noshield
X$800 \$64__t2 topp__t404 cap_mim_2f0_m4m5_noshield c_length=4U c_width=4U
* device instance $801 r0 *1 188.2,115.4 cap_mim_2f0_m4m5_noshield
X$801 \$12__t204 topp__t405 cap_mim_2f0_m4m5_noshield c_length=4U c_width=4U
* device instance $802 r0 *1 194.6,115.4 cap_mim_2f0_m4m5_noshield
X$802 \$80__t0 topp__t412 cap_mim_2f0_m4m5_noshield c_length=4U c_width=4U
* device instance $803 r0 *1 201,115.4 cap_mim_2f0_m4m5_noshield
X$803 \$12__t206 topp__t411 cap_mim_2f0_m4m5_noshield c_length=4U c_width=4U
* device instance $804 r0 *1 224,115.4 cap_mim_2f0_m4m5_noshield
X$804 \$85__t1 topn__t2 cap_mim_2f0_m4m5_noshield c_length=4U c_width=4U
* device instance $805 r0 *1 230.4,115.4 cap_mim_2f0_m4m5_noshield
X$805 \$81__t4 topn__t11 cap_mim_2f0_m4m5_noshield c_length=4U c_width=4U
* device instance $806 r0 *1 236.8,115.4 cap_mim_2f0_m4m5_noshield
X$806 \$85__t2 topn__t3 cap_mim_2f0_m4m5_noshield c_length=4U c_width=4U
* device instance $807 r0 *1 243.2,115.4 cap_mim_2f0_m4m5_noshield
X$807 \$81__t0 topn__t4 cap_mim_2f0_m4m5_noshield c_length=4U c_width=4U
* device instance $808 r0 *1 249.6,115.4 cap_mim_2f0_m4m5_noshield
X$808 \$85__t3 topn__t5 cap_mim_2f0_m4m5_noshield c_length=4U c_width=4U
* device instance $809 r0 *1 256,115.4 cap_mim_2f0_m4m5_noshield
X$809 \$81__t1 topn__t6 cap_mim_2f0_m4m5_noshield c_length=4U c_width=4U
* device instance $810 r0 *1 262.4,115.4 cap_mim_2f0_m4m5_noshield
X$810 \$85__t4 topn__t7 cap_mim_2f0_m4m5_noshield c_length=4U c_width=4U
* device instance $811 r0 *1 268.8,115.4 cap_mim_2f0_m4m5_noshield
X$811 \$81__t2 topn__t8 cap_mim_2f0_m4m5_noshield c_length=4U c_width=4U
* device instance $812 r0 *1 275.2,115.4 cap_mim_2f0_m4m5_noshield
X$812 \$85__t5 topn__t9 cap_mim_2f0_m4m5_noshield c_length=4U c_width=4U
* device instance $813 r0 *1 281.6,115.4 cap_mim_2f0_m4m5_noshield
X$813 \$81__t3 topn__t10 cap_mim_2f0_m4m5_noshield c_length=4U c_width=4U
* device instance $814 r0 *1 288,115.4 cap_mim_2f0_m4m5_noshield
X$814 \$85__t0 topn__t1 cap_mim_2f0_m4m5_noshield c_length=4U c_width=4U
* device instance $815 r0 *1 294.4,115.4 cap_mim_2f0_m4m5_noshield
X$815 \$81__t31 topn__t57 cap_mim_2f0_m4m5_noshield c_length=4U c_width=4U
* device instance $816 r0 *1 300.8,115.4 cap_mim_2f0_m4m5_noshield
X$816 \$85__t7 topn__t58 cap_mim_2f0_m4m5_noshield c_length=4U c_width=4U
* device instance $817 r0 *1 307.2,115.4 cap_mim_2f0_m4m5_noshield
X$817 \$81__t32 topn__t59 cap_mim_2f0_m4m5_noshield c_length=4U c_width=4U
* device instance $818 r0 *1 313.6,115.4 cap_mim_2f0_m4m5_noshield
X$818 \$85__t8 topn__t60 cap_mim_2f0_m4m5_noshield c_length=4U c_width=4U
* device instance $819 r0 *1 320,115.4 cap_mim_2f0_m4m5_noshield
X$819 \$81__t33 topn__t61 cap_mim_2f0_m4m5_noshield c_length=4U c_width=4U
* device instance $820 r0 *1 326.4,115.4 cap_mim_2f0_m4m5_noshield
X$820 \$86__t2 topn__t62 cap_mim_2f0_m4m5_noshield c_length=4U c_width=4U
* device instance $821 r0 *1 332.8,115.4 cap_mim_2f0_m4m5_noshield
X$821 \$81__t34 topn__t63 cap_mim_2f0_m4m5_noshield c_length=4U c_width=4U
* device instance $822 r0 *1 339.2,115.4 cap_mim_2f0_m4m5_noshield
X$822 \$86__t4 topn__t89 cap_mim_2f0_m4m5_noshield c_length=4U c_width=4U
* device instance $823 r0 *1 345.6,115.4 cap_mim_2f0_m4m5_noshield
X$823 \$81__t49 topn__t99 cap_mim_2f0_m4m5_noshield c_length=4U c_width=4U
* device instance $824 r0 *1 352,115.4 cap_mim_2f0_m4m5_noshield
X$824 \$86__t5 topn__t100 cap_mim_2f0_m4m5_noshield c_length=4U c_width=4U
* device instance $825 r0 *1 358.4,115.4 cap_mim_2f0_m4m5_noshield
X$825 \$81__t52 topn__t105 cap_mim_2f0_m4m5_noshield c_length=4U c_width=4U
* device instance $826 r0 *1 364.8,115.4 cap_mim_2f0_m4m5_noshield
X$826 \$86__t14 topn__t495 cap_mim_2f0_m4m5_noshield c_length=4U c_width=4U
* device instance $827 r0 *1 371.2,115.4 cap_mim_2f0_m4m5_noshield
X$827 \$81__t248 topn__t499 cap_mim_2f0_m4m5_noshield c_length=4U c_width=4U
* device instance $828 r0 *1 377.6,115.4 cap_mim_2f0_m4m5_noshield
X$828 \$87__t3 topn__t427 cap_mim_2f0_m4m5_noshield c_length=4U c_width=4U
* device instance $829 r0 *1 384,115.4 cap_mim_2f0_m4m5_noshield
X$829 \$81__t203 topn__t407 cap_mim_2f0_m4m5_noshield c_length=4U c_width=4U
* device instance $830 r0 *1 390.4,115.4 cap_mim_2f0_m4m5_noshield
X$830 \$87__t2 topn__t422 cap_mim_2f0_m4m5_noshield c_length=4U c_width=4U
* device instance $831 r0 *1 396.8,115.4 cap_mim_2f0_m4m5_noshield
X$831 \$81__t205 topn__t409 cap_mim_2f0_m4m5_noshield c_length=4U c_width=4U
* device instance $832 r0 *1 403.2,115.4 cap_mim_2f0_m4m5_noshield
X$832 \$88__t1 topn__t410 cap_mim_2f0_m4m5_noshield c_length=4U c_width=4U
* device instance $833 r0 *1 409.6,115.4 cap_mim_2f0_m4m5_noshield
X$833 \$81__t206 topn__t411 cap_mim_2f0_m4m5_noshield c_length=4U c_width=4U
* device instance $834 r0 *1 416,115.4 cap_mim_2f0_m4m5_noshield
X$834 \$90__t0 topn__t412 cap_mim_2f0_m4m5_noshield c_length=4U c_width=4U
* device instance $835 r0 *1 422.4,115.4 cap_mim_2f0_m4m5_noshield
X$835 \$81__t207 topn__t413 cap_mim_2f0_m4m5_noshield c_length=4U c_width=4U
* device instance $836 r0 *1 2.6,121.8 cap_mim_2f0_m4m5_noshield
X$836 \$12__t118 topp__t236 cap_mim_2f0_m4m5_noshield c_length=4U c_width=4U
* device instance $837 r0 *1 9,121.8 cap_mim_2f0_m4m5_noshield
X$837 vcm__t0 topp__t213 cap_mim_2f0_m4m5_noshield c_length=4U c_width=4U
* device instance $838 r0 *1 15.4,121.8 cap_mim_2f0_m4m5_noshield
X$838 \$12__t120 topp__t239 cap_mim_2f0_m4m5_noshield c_length=4U c_width=4U
* device instance $839 r0 *1 21.8,121.8 cap_mim_2f0_m4m5_noshield
X$839 \$64__t0 topp__t249 cap_mim_2f0_m4m5_noshield c_length=4U c_width=4U
* device instance $840 r0 *1 28.2,121.8 cap_mim_2f0_m4m5_noshield
X$840 \$12__t132 topp__t264 cap_mim_2f0_m4m5_noshield c_length=4U c_width=4U
* device instance $841 r0 *1 34.6,121.8 cap_mim_2f0_m4m5_noshield
X$841 \$56__t1 topp__t265 cap_mim_2f0_m4m5_noshield c_length=4U c_width=4U
* device instance $842 r0 *1 41,121.8 cap_mim_2f0_m4m5_noshield
X$842 \$12__t128 topp__t257 cap_mim_2f0_m4m5_noshield c_length=4U c_width=4U
* device instance $843 r0 *1 47.4,121.8 cap_mim_2f0_m4m5_noshield
X$843 \$56__t0 topp__t232 cap_mim_2f0_m4m5_noshield c_length=4U c_width=4U
* device instance $844 r0 *1 53.8,121.8 cap_mim_2f0_m4m5_noshield
X$844 \$12__t116 topp__t233 cap_mim_2f0_m4m5_noshield c_length=4U c_width=4U
* device instance $845 r0 *1 60.2,121.8 cap_mim_2f0_m4m5_noshield
X$845 \$48__t11 topp__t234 cap_mim_2f0_m4m5_noshield c_length=4U c_width=4U
* device instance $846 r0 *1 66.6,121.8 cap_mim_2f0_m4m5_noshield
X$846 \$12__t117 topp__t235 cap_mim_2f0_m4m5_noshield c_length=4U c_width=4U
* device instance $847 r0 *1 73,121.8 cap_mim_2f0_m4m5_noshield
X$847 \$48__t0 topp__t41 cap_mim_2f0_m4m5_noshield c_length=4U c_width=4U
* device instance $848 r0 *1 79.4,121.8 cap_mim_2f0_m4m5_noshield
X$848 \$12__t28 topp__t50 cap_mim_2f0_m4m5_noshield c_length=4U c_width=4U
* device instance $849 r0 *1 85.8,121.8 cap_mim_2f0_m4m5_noshield
X$849 \$48__t3 topp__t51 cap_mim_2f0_m4m5_noshield c_length=4U c_width=4U
* device instance $850 r0 *1 92.2,121.8 cap_mim_2f0_m4m5_noshield
X$850 \$12__t30 topp__t53 cap_mim_2f0_m4m5_noshield c_length=4U c_width=4U
* device instance $851 r0 *1 98.6,121.8 cap_mim_2f0_m4m5_noshield
X$851 \$48__t2 topp__t49 cap_mim_2f0_m4m5_noshield c_length=4U c_width=4U
* device instance $852 r0 *1 105,121.8 cap_mim_2f0_m4m5_noshield
X$852 \$12__t75 topp__t147 cap_mim_2f0_m4m5_noshield c_length=4U c_width=4U
* device instance $853 r0 *1 111.4,121.8 cap_mim_2f0_m4m5_noshield
X$853 \$40__t12 topp__t221 cap_mim_2f0_m4m5_noshield c_length=4U c_width=4U
* device instance $854 r0 *1 117.8,121.8 cap_mim_2f0_m4m5_noshield
X$854 \$12__t113 topp__t227 cap_mim_2f0_m4m5_noshield c_length=4U c_width=4U
* device instance $855 r0 *1 124.2,121.8 cap_mim_2f0_m4m5_noshield
X$855 \$40__t13 topp__t228 cap_mim_2f0_m4m5_noshield c_length=4U c_width=4U
* device instance $856 r0 *1 130.6,121.8 cap_mim_2f0_m4m5_noshield
X$856 \$12__t114 topp__t229 cap_mim_2f0_m4m5_noshield c_length=4U c_width=4U
* device instance $857 r0 *1 137,121.8 cap_mim_2f0_m4m5_noshield
X$857 \$40__t0 topp__t48 cap_mim_2f0_m4m5_noshield c_length=4U c_width=4U
* device instance $858 r0 *1 143.4,121.8 cap_mim_2f0_m4m5_noshield
X$858 \$12__t103 topp__t207 cap_mim_2f0_m4m5_noshield c_length=4U c_width=4U
* device instance $859 r0 *1 149.8,121.8 cap_mim_2f0_m4m5_noshield
X$859 \$40__t19 topp__t413 cap_mim_2f0_m4m5_noshield c_length=4U c_width=4U
* device instance $860 r0 *1 156.2,121.8 cap_mim_2f0_m4m5_noshield
X$860 \$12__t207 topp__t414 cap_mim_2f0_m4m5_noshield c_length=4U c_width=4U
* device instance $861 r0 *1 162.6,121.8 cap_mim_2f0_m4m5_noshield
X$861 \$40__t20 topp__t415 cap_mim_2f0_m4m5_noshield c_length=4U c_width=4U
* device instance $862 r0 *1 169,121.8 cap_mim_2f0_m4m5_noshield
X$862 \$12__t208 topp__t417 cap_mim_2f0_m4m5_noshield c_length=4U c_width=4U
* device instance $863 r0 *1 175.4,121.8 cap_mim_2f0_m4m5_noshield
X$863 \$40__t22 topp__t418 cap_mim_2f0_m4m5_noshield c_length=4U c_width=4U
* device instance $864 r0 *1 181.8,121.8 cap_mim_2f0_m4m5_noshield
X$864 \$12__t209 topp__t419 cap_mim_2f0_m4m5_noshield c_length=4U c_width=4U
* device instance $865 r0 *1 188.2,121.8 cap_mim_2f0_m4m5_noshield
X$865 \$40__t23 topp__t420 cap_mim_2f0_m4m5_noshield c_length=4U c_width=4U
* device instance $866 r0 *1 194.6,121.8 cap_mim_2f0_m4m5_noshield
X$866 \$12__t210 topp__t421 cap_mim_2f0_m4m5_noshield c_length=4U c_width=4U
* device instance $867 r0 *1 201,121.8 cap_mim_2f0_m4m5_noshield
X$867 \$40__t21 topp__t416 cap_mim_2f0_m4m5_noshield c_length=4U c_width=4U
* device instance $868 r0 *1 224,121.8 cap_mim_2f0_m4m5_noshield
X$868 \$81__t246 topn__t494 cap_mim_2f0_m4m5_noshield c_length=4U c_width=4U
* device instance $869 r0 *1 230.4,121.8 cap_mim_2f0_m4m5_noshield
X$869 vcm__t1 topn__t425 cap_mim_2f0_m4m5_noshield c_length=4U c_width=4U
* device instance $870 r0 *1 236.8,121.8 cap_mim_2f0_m4m5_noshield
X$870 \$81__t213 topn__t426 cap_mim_2f0_m4m5_noshield c_length=4U c_width=4U
* device instance $871 r0 *1 243.2,121.8 cap_mim_2f0_m4m5_noshield
X$871 \$88__t2 topn__t428 cap_mim_2f0_m4m5_noshield c_length=4U c_width=4U
* device instance $872 r0 *1 249.6,121.8 cap_mim_2f0_m4m5_noshield
X$872 \$81__t214 topn__t429 cap_mim_2f0_m4m5_noshield c_length=4U c_width=4U
* device instance $873 r0 *1 256,121.8 cap_mim_2f0_m4m5_noshield
X$873 \$87__t4 topn__t430 cap_mim_2f0_m4m5_noshield c_length=4U c_width=4U
* device instance $874 r0 *1 262.4,121.8 cap_mim_2f0_m4m5_noshield
X$874 \$81__t215 topn__t431 cap_mim_2f0_m4m5_noshield c_length=4U c_width=4U
* device instance $875 r0 *1 268.8,121.8 cap_mim_2f0_m4m5_noshield
X$875 \$87__t5 topn__t432 cap_mim_2f0_m4m5_noshield c_length=4U c_width=4U
* device instance $876 r0 *1 275.2,121.8 cap_mim_2f0_m4m5_noshield
X$876 \$81__t216 topn__t433 cap_mim_2f0_m4m5_noshield c_length=4U c_width=4U
* device instance $877 r0 *1 281.6,121.8 cap_mim_2f0_m4m5_noshield
X$877 \$86__t13 topn__t434 cap_mim_2f0_m4m5_noshield c_length=4U c_width=4U
* device instance $878 r0 *1 288,121.8 cap_mim_2f0_m4m5_noshield
X$878 \$81__t217 topn__t435 cap_mim_2f0_m4m5_noshield c_length=4U c_width=4U
* device instance $879 r0 *1 294.4,121.8 cap_mim_2f0_m4m5_noshield
X$879 \$86__t3 topn__t72 cap_mim_2f0_m4m5_noshield c_length=4U c_width=4U
* device instance $880 r0 *1 300.8,121.8 cap_mim_2f0_m4m5_noshield
X$880 \$81__t25 topn__t48 cap_mim_2f0_m4m5_noshield c_length=4U c_width=4U
* device instance $881 r0 *1 307.2,121.8 cap_mim_2f0_m4m5_noshield
X$881 \$86__t0 topn__t49 cap_mim_2f0_m4m5_noshield c_length=4U c_width=4U
* device instance $882 r0 *1 313.6,121.8 cap_mim_2f0_m4m5_noshield
X$882 \$81__t26 topn__t50 cap_mim_2f0_m4m5_noshield c_length=4U c_width=4U
* device instance $883 r0 *1 320,121.8 cap_mim_2f0_m4m5_noshield
X$883 \$86__t1 topn__t51 cap_mim_2f0_m4m5_noshield c_length=4U c_width=4U
* device instance $884 r0 *1 326.4,121.8 cap_mim_2f0_m4m5_noshield
X$884 \$81__t27 topn__t52 cap_mim_2f0_m4m5_noshield c_length=4U c_width=4U
* device instance $885 r0 *1 332.8,121.8 cap_mim_2f0_m4m5_noshield
X$885 \$85__t6 topn__t53 cap_mim_2f0_m4m5_noshield c_length=4U c_width=4U
* device instance $886 r0 *1 339.2,121.8 cap_mim_2f0_m4m5_noshield
X$886 \$81__t28 topn__t54 cap_mim_2f0_m4m5_noshield c_length=4U c_width=4U
* device instance $887 r0 *1 345.6,121.8 cap_mim_2f0_m4m5_noshield
X$887 \$85__t9 topn__t64 cap_mim_2f0_m4m5_noshield c_length=4U c_width=4U
* device instance $888 r0 *1 352,121.8 cap_mim_2f0_m4m5_noshield
X$888 \$81__t30 topn__t56 cap_mim_2f0_m4m5_noshield c_length=4U c_width=4U
* device instance $889 r0 *1 358.4,121.8 cap_mim_2f0_m4m5_noshield
X$889 \$85__t12 topn__t101 cap_mim_2f0_m4m5_noshield c_length=4U c_width=4U
* device instance $890 r0 *1 364.8,121.8 cap_mim_2f0_m4m5_noshield
X$890 \$81__t247 topn__t496 cap_mim_2f0_m4m5_noshield c_length=4U c_width=4U
* device instance $891 r0 *1 371.2,121.8 cap_mim_2f0_m4m5_noshield
X$891 \$85__t29 topn__t416 cap_mim_2f0_m4m5_noshield c_length=4U c_width=4U
* device instance $892 r0 *1 377.6,121.8 cap_mim_2f0_m4m5_noshield
X$892 \$81__t210 topn__t417 cap_mim_2f0_m4m5_noshield c_length=4U c_width=4U
* device instance $893 r0 *1 384,121.8 cap_mim_2f0_m4m5_noshield
X$893 \$85__t30 topn__t418 cap_mim_2f0_m4m5_noshield c_length=4U c_width=4U
* device instance $894 r0 *1 390.4,121.8 cap_mim_2f0_m4m5_noshield
X$894 \$81__t211 topn__t419 cap_mim_2f0_m4m5_noshield c_length=4U c_width=4U
* device instance $895 r0 *1 396.8,121.8 cap_mim_2f0_m4m5_noshield
X$895 \$85__t31 topn__t475 cap_mim_2f0_m4m5_noshield c_length=4U c_width=4U
* device instance $896 r0 *1 403.2,121.8 cap_mim_2f0_m4m5_noshield
X$896 \$81__t35 topn__t65 cap_mim_2f0_m4m5_noshield c_length=4U c_width=4U
* device instance $897 r0 *1 409.6,121.8 cap_mim_2f0_m4m5_noshield
X$897 \$85__t10 topn__t66 cap_mim_2f0_m4m5_noshield c_length=4U c_width=4U
* device instance $898 r0 *1 416,121.8 cap_mim_2f0_m4m5_noshield
X$898 \$81__t36 topn__t67 cap_mim_2f0_m4m5_noshield c_length=4U c_width=4U
* device instance $899 r0 *1 422.4,121.8 cap_mim_2f0_m4m5_noshield
X$899 \$85__t11 topn__t68 cap_mim_2f0_m4m5_noshield c_length=4U c_width=4U
* device instance $900 r0 *1 2.6,128.2 cap_mim_2f0_m4m5_noshield
X$900 \$12__t137 topp__t275 cap_mim_2f0_m4m5_noshield c_length=4U c_width=4U
* device instance $901 r0 *1 9,128.2 cap_mim_2f0_m4m5_noshield
X$901 \$32__t31 topp__t282 cap_mim_2f0_m4m5_noshield c_length=4U c_width=4U
* device instance $902 r0 *1 15.4,128.2 cap_mim_2f0_m4m5_noshield
X$902 \$12__t141 topp__t283 cap_mim_2f0_m4m5_noshield c_length=4U c_width=4U
* device instance $903 r0 *1 21.8,128.2 cap_mim_2f0_m4m5_noshield
X$903 \$32__t32 topp__t284 cap_mim_2f0_m4m5_noshield c_length=4U c_width=4U
* device instance $904 r0 *1 28.2,128.2 cap_mim_2f0_m4m5_noshield
X$904 \$12__t142 topp__t285 cap_mim_2f0_m4m5_noshield c_length=4U c_width=4U
* device instance $905 r0 *1 34.6,128.2 cap_mim_2f0_m4m5_noshield
X$905 \$32__t33 topp__t286 cap_mim_2f0_m4m5_noshield c_length=4U c_width=4U
* device instance $906 r0 *1 41,128.2 cap_mim_2f0_m4m5_noshield
X$906 \$12__t143 topp__t287 cap_mim_2f0_m4m5_noshield c_length=4U c_width=4U
* device instance $907 r0 *1 47.4,128.2 cap_mim_2f0_m4m5_noshield
X$907 \$32__t34 topp__t288 cap_mim_2f0_m4m5_noshield c_length=4U c_width=4U
* device instance $908 r0 *1 53.8,128.2 cap_mim_2f0_m4m5_noshield
X$908 \$12__t144 topp__t289 cap_mim_2f0_m4m5_noshield c_length=4U c_width=4U
* device instance $909 r0 *1 60.2,128.2 cap_mim_2f0_m4m5_noshield
X$909 \$32__t39 topp__t299 cap_mim_2f0_m4m5_noshield c_length=4U c_width=4U
* device instance $910 r0 *1 66.6,128.2 cap_mim_2f0_m4m5_noshield
X$910 \$12__t146 topp__t291 cap_mim_2f0_m4m5_noshield c_length=4U c_width=4U
* device instance $911 r0 *1 73,128.2 cap_mim_2f0_m4m5_noshield
X$911 \$32__t35 topp__t292 cap_mim_2f0_m4m5_noshield c_length=4U c_width=4U
* device instance $912 r0 *1 79.4,128.2 cap_mim_2f0_m4m5_noshield
X$912 \$12__t147 topp__t293 cap_mim_2f0_m4m5_noshield c_length=4U c_width=4U
* device instance $913 r0 *1 85.8,128.2 cap_mim_2f0_m4m5_noshield
X$913 \$32__t36 topp__t294 cap_mim_2f0_m4m5_noshield c_length=4U c_width=4U
* device instance $914 r0 *1 92.2,128.2 cap_mim_2f0_m4m5_noshield
X$914 \$12__t148 topp__t295 cap_mim_2f0_m4m5_noshield c_length=4U c_width=4U
* device instance $915 r0 *1 98.6,128.2 cap_mim_2f0_m4m5_noshield
X$915 \$32__t37 topp__t296 cap_mim_2f0_m4m5_noshield c_length=4U c_width=4U
* device instance $916 r0 *1 105,128.2 cap_mim_2f0_m4m5_noshield
X$916 \$12__t149 topp__t297 cap_mim_2f0_m4m5_noshield c_length=4U c_width=4U
* device instance $917 r0 *1 111.4,128.2 cap_mim_2f0_m4m5_noshield
X$917 \$32__t38 topp__t298 cap_mim_2f0_m4m5_noshield c_length=4U c_width=4U
* device instance $918 r0 *1 117.8,128.2 cap_mim_2f0_m4m5_noshield
X$918 \$12__t145 topp__t290 cap_mim_2f0_m4m5_noshield c_length=4U c_width=4U
* device instance $919 r0 *1 124.2,128.2 cap_mim_2f0_m4m5_noshield
X$919 \$32__t24 topp__t268 cap_mim_2f0_m4m5_noshield c_length=4U c_width=4U
* device instance $920 r0 *1 130.6,128.2 cap_mim_2f0_m4m5_noshield
X$920 \$12__t134 topp__t269 cap_mim_2f0_m4m5_noshield c_length=4U c_width=4U
* device instance $921 r0 *1 137,128.2 cap_mim_2f0_m4m5_noshield
X$921 \$32__t25 topp__t270 cap_mim_2f0_m4m5_noshield c_length=4U c_width=4U
* device instance $922 r0 *1 143.4,128.2 cap_mim_2f0_m4m5_noshield
X$922 \$12__t135 topp__t271 cap_mim_2f0_m4m5_noshield c_length=4U c_width=4U
* device instance $923 r0 *1 149.8,128.2 cap_mim_2f0_m4m5_noshield
X$923 \$32__t26 topp__t272 cap_mim_2f0_m4m5_noshield c_length=4U c_width=4U
* device instance $924 r0 *1 156.2,128.2 cap_mim_2f0_m4m5_noshield
X$924 \$12__t136 topp__t273 cap_mim_2f0_m4m5_noshield c_length=4U c_width=4U
* device instance $925 r0 *1 162.6,128.2 cap_mim_2f0_m4m5_noshield
X$925 \$32__t27 topp__t274 cap_mim_2f0_m4m5_noshield c_length=4U c_width=4U
* device instance $926 r0 *1 169,128.2 cap_mim_2f0_m4m5_noshield
X$926 \$12__t140 topp__t281 cap_mim_2f0_m4m5_noshield c_length=4U c_width=4U
* device instance $927 r0 *1 175.4,128.2 cap_mim_2f0_m4m5_noshield
X$927 \$32__t28 topp__t276 cap_mim_2f0_m4m5_noshield c_length=4U c_width=4U
* device instance $928 r0 *1 181.8,128.2 cap_mim_2f0_m4m5_noshield
X$928 \$12__t138 topp__t277 cap_mim_2f0_m4m5_noshield c_length=4U c_width=4U
* device instance $929 r0 *1 188.2,128.2 cap_mim_2f0_m4m5_noshield
X$929 \$32__t29 topp__t278 cap_mim_2f0_m4m5_noshield c_length=4U c_width=4U
* device instance $930 r0 *1 194.6,128.2 cap_mim_2f0_m4m5_noshield
X$930 \$12__t139 topp__t279 cap_mim_2f0_m4m5_noshield c_length=4U c_width=4U
* device instance $931 r0 *1 201,128.2 cap_mim_2f0_m4m5_noshield
X$931 \$32__t30 topp__t280 cap_mim_2f0_m4m5_noshield c_length=4U c_width=4U
* device instance $932 r0 *1 224,128.2 cap_mim_2f0_m4m5_noshield
X$932 \$81__t23 topn__t45 cap_mim_2f0_m4m5_noshield c_length=4U c_width=4U
* device instance $933 r0 *1 230.4,128.2 cap_mim_2f0_m4m5_noshield
X$933 \$84__t0 topn__t46 cap_mim_2f0_m4m5_noshield c_length=4U c_width=4U
* device instance $934 r0 *1 236.8,128.2 cap_mim_2f0_m4m5_noshield
X$934 \$81__t24 topn__t47 cap_mim_2f0_m4m5_noshield c_length=4U c_width=4U
* device instance $935 r0 *1 243.2,128.2 cap_mim_2f0_m4m5_noshield
X$935 \$84__t9 topn__t117 cap_mim_2f0_m4m5_noshield c_length=4U c_width=4U
* device instance $936 r0 *1 249.6,128.2 cap_mim_2f0_m4m5_noshield
X$936 \$81__t78 topn__t157 cap_mim_2f0_m4m5_noshield c_length=4U c_width=4U
* device instance $937 r0 *1 256,128.2 cap_mim_2f0_m4m5_noshield
X$937 \$84__t12 topn__t158 cap_mim_2f0_m4m5_noshield c_length=4U c_width=4U
* device instance $938 r0 *1 262.4,128.2 cap_mim_2f0_m4m5_noshield
X$938 \$81__t79 topn__t159 cap_mim_2f0_m4m5_noshield c_length=4U c_width=4U
* device instance $939 r0 *1 268.8,128.2 cap_mim_2f0_m4m5_noshield
X$939 \$84__t13 topn__t160 cap_mim_2f0_m4m5_noshield c_length=4U c_width=4U
* device instance $940 r0 *1 275.2,128.2 cap_mim_2f0_m4m5_noshield
X$940 \$81__t80 topn__t161 cap_mim_2f0_m4m5_noshield c_length=4U c_width=4U
* device instance $941 r0 *1 281.6,128.2 cap_mim_2f0_m4m5_noshield
X$941 \$84__t14 topn__t162 cap_mim_2f0_m4m5_noshield c_length=4U c_width=4U
* device instance $942 r0 *1 288,128.2 cap_mim_2f0_m4m5_noshield
X$942 \$81__t11 topn__t26 cap_mim_2f0_m4m5_noshield c_length=4U c_width=4U
* device instance $943 r0 *1 294.4,128.2 cap_mim_2f0_m4m5_noshield
X$943 \$84__t31 topn__t328 cap_mim_2f0_m4m5_noshield c_length=4U c_width=4U
* device instance $944 r0 *1 300.8,128.2 cap_mim_2f0_m4m5_noshield
X$944 \$81__t111 topn__t222 cap_mim_2f0_m4m5_noshield c_length=4U c_width=4U
* device instance $945 r0 *1 307.2,128.2 cap_mim_2f0_m4m5_noshield
X$945 \$84__t24 topn__t223 cap_mim_2f0_m4m5_noshield c_length=4U c_width=4U
* device instance $946 r0 *1 313.6,128.2 cap_mim_2f0_m4m5_noshield
X$946 \$81__t112 topn__t224 cap_mim_2f0_m4m5_noshield c_length=4U c_width=4U
* device instance $947 r0 *1 320,128.2 cap_mim_2f0_m4m5_noshield
X$947 \$84__t37 topn__t358 cap_mim_2f0_m4m5_noshield c_length=4U c_width=4U
* device instance $948 r0 *1 326.4,128.2 cap_mim_2f0_m4m5_noshield
X$948 \$81__t188 topn__t375 cap_mim_2f0_m4m5_noshield c_length=4U c_width=4U
* device instance $949 r0 *1 332.8,128.2 cap_mim_2f0_m4m5_noshield
X$949 \$84__t38 topn__t360 cap_mim_2f0_m4m5_noshield c_length=4U c_width=4U
* device instance $950 r0 *1 339.2,128.2 cap_mim_2f0_m4m5_noshield
X$950 \$81__t181 topn__t361 cap_mim_2f0_m4m5_noshield c_length=4U c_width=4U
* device instance $951 r0 *1 345.6,128.2 cap_mim_2f0_m4m5_noshield
X$951 \$84__t39 topn__t362 cap_mim_2f0_m4m5_noshield c_length=4U c_width=4U
* device instance $952 r0 *1 352,128.2 cap_mim_2f0_m4m5_noshield
X$952 \$81__t182 topn__t363 cap_mim_2f0_m4m5_noshield c_length=4U c_width=4U
* device instance $953 r0 *1 358.4,128.2 cap_mim_2f0_m4m5_noshield
X$953 \$84__t40 topn__t364 cap_mim_2f0_m4m5_noshield c_length=4U c_width=4U
* device instance $954 r0 *1 364.8,128.2 cap_mim_2f0_m4m5_noshield
X$954 \$81__t183 topn__t365 cap_mim_2f0_m4m5_noshield c_length=4U c_width=4U
* device instance $955 r0 *1 371.2,128.2 cap_mim_2f0_m4m5_noshield
X$955 \$84__t41 topn__t366 cap_mim_2f0_m4m5_noshield c_length=4U c_width=4U
* device instance $956 r0 *1 377.6,128.2 cap_mim_2f0_m4m5_noshield
X$956 \$81__t184 topn__t367 cap_mim_2f0_m4m5_noshield c_length=4U c_width=4U
* device instance $957 r0 *1 384,128.2 cap_mim_2f0_m4m5_noshield
X$957 \$84__t42 topn__t368 cap_mim_2f0_m4m5_noshield c_length=4U c_width=4U
* device instance $958 r0 *1 390.4,128.2 cap_mim_2f0_m4m5_noshield
X$958 \$81__t185 topn__t369 cap_mim_2f0_m4m5_noshield c_length=4U c_width=4U
* device instance $959 r0 *1 396.8,128.2 cap_mim_2f0_m4m5_noshield
X$959 \$84__t43 topn__t370 cap_mim_2f0_m4m5_noshield c_length=4U c_width=4U
* device instance $960 r0 *1 403.2,128.2 cap_mim_2f0_m4m5_noshield
X$960 \$81__t186 topn__t371 cap_mim_2f0_m4m5_noshield c_length=4U c_width=4U
* device instance $961 r0 *1 409.6,128.2 cap_mim_2f0_m4m5_noshield
X$961 \$84__t44 topn__t372 cap_mim_2f0_m4m5_noshield c_length=4U c_width=4U
* device instance $962 r0 *1 416,128.2 cap_mim_2f0_m4m5_noshield
X$962 \$81__t187 topn__t373 cap_mim_2f0_m4m5_noshield c_length=4U c_width=4U
* device instance $963 r0 *1 422.4,128.2 cap_mim_2f0_m4m5_noshield
X$963 \$84__t45 topn__t374 cap_mim_2f0_m4m5_noshield c_length=4U c_width=4U
* device instance $964 r0 *1 2.6,134.6 cap_mim_2f0_m4m5_noshield
X$964 \$12__t5 topp__t5 cap_mim_2f0_m4m5_noshield c_length=4U c_width=4U
* device instance $965 r0 *1 9,134.6 cap_mim_2f0_m4m5_noshield
X$965 \$24__t6 topp__t26 cap_mim_2f0_m4m5_noshield c_length=4U c_width=4U
* device instance $966 r0 *1 15.4,134.6 cap_mim_2f0_m4m5_noshield
X$966 \$12__t12 topp__t16 cap_mim_2f0_m4m5_noshield c_length=4U c_width=4U
* device instance $967 r0 *1 21.8,134.6 cap_mim_2f0_m4m5_noshield
X$967 \$24__t8 topp__t30 cap_mim_2f0_m4m5_noshield c_length=4U c_width=4U
* device instance $968 r0 *1 28.2,134.6 cap_mim_2f0_m4m5_noshield
X$968 \$12__t18 topp__t31 cap_mim_2f0_m4m5_noshield c_length=4U c_width=4U
* device instance $969 r0 *1 34.6,134.6 cap_mim_2f0_m4m5_noshield
X$969 \$24__t9 topp__t32 cap_mim_2f0_m4m5_noshield c_length=4U c_width=4U
* device instance $970 r0 *1 41,134.6 cap_mim_2f0_m4m5_noshield
X$970 \$12__t19 topp__t33 cap_mim_2f0_m4m5_noshield c_length=4U c_width=4U
* device instance $971 r0 *1 47.4,134.6 cap_mim_2f0_m4m5_noshield
X$971 \$24__t10 topp__t34 cap_mim_2f0_m4m5_noshield c_length=4U c_width=4U
* device instance $972 r0 *1 53.8,134.6 cap_mim_2f0_m4m5_noshield
X$972 \$12__t3 topp__t2 cap_mim_2f0_m4m5_noshield c_length=4U c_width=4U
* device instance $973 r0 *1 60.2,134.6 cap_mim_2f0_m4m5_noshield
X$973 \$24__t0 topp__t3 cap_mim_2f0_m4m5_noshield c_length=4U c_width=4U
* device instance $974 r0 *1 66.6,134.6 cap_mim_2f0_m4m5_noshield
X$974 \$12__t4 topp__t4 cap_mim_2f0_m4m5_noshield c_length=4U c_width=4U
* device instance $975 r0 *1 73,134.6 cap_mim_2f0_m4m5_noshield
X$975 \$24__t86 topp__t334 cap_mim_2f0_m4m5_noshield c_length=4U c_width=4U
* device instance $976 r0 *1 79.4,134.6 cap_mim_2f0_m4m5_noshield
X$976 \$12__t24 topp__t40 cap_mim_2f0_m4m5_noshield c_length=4U c_width=4U
* device instance $977 r0 *1 85.8,134.6 cap_mim_2f0_m4m5_noshield
X$977 \$24__t16 topp__t58 cap_mim_2f0_m4m5_noshield c_length=4U c_width=4U
* device instance $978 r0 *1 92.2,134.6 cap_mim_2f0_m4m5_noshield
X$978 \$12__t33 topp__t59 cap_mim_2f0_m4m5_noshield c_length=4U c_width=4U
* device instance $979 r0 *1 98.6,134.6 cap_mim_2f0_m4m5_noshield
X$979 \$24__t12 topp__t43 cap_mim_2f0_m4m5_noshield c_length=4U c_width=4U
* device instance $980 r0 *1 105,134.6 cap_mim_2f0_m4m5_noshield
X$980 \$12__t31 topp__t54 cap_mim_2f0_m4m5_noshield c_length=4U c_width=4U
* device instance $981 r0 *1 111.4,134.6 cap_mim_2f0_m4m5_noshield
X$981 \$24__t15 topp__t57 cap_mim_2f0_m4m5_noshield c_length=4U c_width=4U
* device instance $982 r0 *1 117.8,134.6 cap_mim_2f0_m4m5_noshield
X$982 \$12__t32 topp__t55 cap_mim_2f0_m4m5_noshield c_length=4U c_width=4U
* device instance $983 r0 *1 124.2,134.6 cap_mim_2f0_m4m5_noshield
X$983 \$24__t14 topp__t56 cap_mim_2f0_m4m5_noshield c_length=4U c_width=4U
* device instance $984 r0 *1 130.6,134.6 cap_mim_2f0_m4m5_noshield
X$984 \$12__t36 topp__t64 cap_mim_2f0_m4m5_noshield c_length=4U c_width=4U
* device instance $985 r0 *1 137,134.6 cap_mim_2f0_m4m5_noshield
X$985 \$24__t19 topp__t65 cap_mim_2f0_m4m5_noshield c_length=4U c_width=4U
* device instance $986 r0 *1 143.4,134.6 cap_mim_2f0_m4m5_noshield
X$986 \$12__t22 topp__t38 cap_mim_2f0_m4m5_noshield c_length=4U c_width=4U
* device instance $987 r0 *1 149.8,134.6 cap_mim_2f0_m4m5_noshield
X$987 \$24__t79 topp__t307 cap_mim_2f0_m4m5_noshield c_length=4U c_width=4U
* device instance $988 r0 *1 156.2,134.6 cap_mim_2f0_m4m5_noshield
X$988 \$12__t153 topp__t305 cap_mim_2f0_m4m5_noshield c_length=4U c_width=4U
* device instance $989 r0 *1 162.6,134.6 cap_mim_2f0_m4m5_noshield
X$989 \$24__t92 topp__t344 cap_mim_2f0_m4m5_noshield c_length=4U c_width=4U
* device instance $990 r0 *1 169,134.6 cap_mim_2f0_m4m5_noshield
X$990 \$12__t150 topp__t300 cap_mim_2f0_m4m5_noshield c_length=4U c_width=4U
* device instance $991 r0 *1 175.4,134.6 cap_mim_2f0_m4m5_noshield
X$991 \$24__t78 topp__t306 cap_mim_2f0_m4m5_noshield c_length=4U c_width=4U
* device instance $992 r0 *1 181.8,134.6 cap_mim_2f0_m4m5_noshield
X$992 \$12__t155 topp__t310 cap_mim_2f0_m4m5_noshield c_length=4U c_width=4U
* device instance $993 r0 *1 188.2,134.6 cap_mim_2f0_m4m5_noshield
X$993 \$24__t81 topp__t311 cap_mim_2f0_m4m5_noshield c_length=4U c_width=4U
* device instance $994 r0 *1 194.6,134.6 cap_mim_2f0_m4m5_noshield
X$994 \$12__t157 topp__t314 cap_mim_2f0_m4m5_noshield c_length=4U c_width=4U
* device instance $995 r0 *1 201,134.6 cap_mim_2f0_m4m5_noshield
X$995 \$24__t83 topp__t315 cap_mim_2f0_m4m5_noshield c_length=4U c_width=4U
* device instance $996 r0 *1 224,134.6 cap_mim_2f0_m4m5_noshield
X$996 \$81__t66 topn__t131 cap_mim_2f0_m4m5_noshield c_length=4U c_width=4U
* device instance $997 r0 *1 230.4,134.6 cap_mim_2f0_m4m5_noshield
X$997 \$83__t29 topn__t118 cap_mim_2f0_m4m5_noshield c_length=4U c_width=4U
* device instance $998 r0 *1 236.8,134.6 cap_mim_2f0_m4m5_noshield
X$998 \$81__t59 topn__t119 cap_mim_2f0_m4m5_noshield c_length=4U c_width=4U
* device instance $999 r0 *1 243.2,134.6 cap_mim_2f0_m4m5_noshield
X$999 \$83__t30 topn__t121 cap_mim_2f0_m4m5_noshield c_length=4U c_width=4U
* device instance $1000 r0 *1 249.6,134.6 cap_mim_2f0_m4m5_noshield
X$1000 \$81__t62 topn__t124 cap_mim_2f0_m4m5_noshield c_length=4U c_width=4U
* device instance $1001 r0 *1 256,134.6 cap_mim_2f0_m4m5_noshield
X$1001 \$83__t31 topn__t125 cap_mim_2f0_m4m5_noshield c_length=4U c_width=4U
* device instance $1002 r0 *1 262.4,134.6 cap_mim_2f0_m4m5_noshield
X$1002 \$81__t63 topn__t126 cap_mim_2f0_m4m5_noshield c_length=4U c_width=4U
* device instance $1003 r0 *1 268.8,134.6 cap_mim_2f0_m4m5_noshield
X$1003 \$83__t32 topn__t127 cap_mim_2f0_m4m5_noshield c_length=4U c_width=4U
* device instance $1004 r0 *1 275.2,134.6 cap_mim_2f0_m4m5_noshield
X$1004 \$81__t64 topn__t128 cap_mim_2f0_m4m5_noshield c_length=4U c_width=4U
* device instance $1005 r0 *1 281.6,134.6 cap_mim_2f0_m4m5_noshield
X$1005 \$83__t33 topn__t129 cap_mim_2f0_m4m5_noshield c_length=4U c_width=4U
* device instance $1006 r0 *1 288,134.6 cap_mim_2f0_m4m5_noshield
X$1006 \$81__t61 topn__t122 cap_mim_2f0_m4m5_noshield c_length=4U c_width=4U
* device instance $1007 r0 *1 294.4,134.6 cap_mim_2f0_m4m5_noshield
X$1007 \$83__t74 topn__t264 cap_mim_2f0_m4m5_noshield c_length=4U c_width=4U
* device instance $1008 r0 *1 300.8,134.6 cap_mim_2f0_m4m5_noshield
X$1008 \$81__t133 topn__t265 cap_mim_2f0_m4m5_noshield c_length=4U c_width=4U
* device instance $1009 r0 *1 307.2,134.6 cap_mim_2f0_m4m5_noshield
X$1009 \$83__t75 topn__t266 cap_mim_2f0_m4m5_noshield c_length=4U c_width=4U
* device instance $1010 r0 *1 313.6,134.6 cap_mim_2f0_m4m5_noshield
X$1010 \$81__t135 topn__t269 cap_mim_2f0_m4m5_noshield c_length=4U c_width=4U
* device instance $1011 r0 *1 320,134.6 cap_mim_2f0_m4m5_noshield
X$1011 \$83__t77 topn__t270 cap_mim_2f0_m4m5_noshield c_length=4U c_width=4U
* device instance $1012 r0 *1 326.4,134.6 cap_mim_2f0_m4m5_noshield
X$1012 \$81__t157 topn__t311 cap_mim_2f0_m4m5_noshield c_length=4U c_width=4U
* device instance $1013 r0 *1 332.8,134.6 cap_mim_2f0_m4m5_noshield
X$1013 \$83__t88 topn__t312 cap_mim_2f0_m4m5_noshield c_length=4U c_width=4U
* device instance $1014 r0 *1 339.2,134.6 cap_mim_2f0_m4m5_noshield
X$1014 \$81__t158 topn__t313 cap_mim_2f0_m4m5_noshield c_length=4U c_width=4U
* device instance $1015 r0 *1 345.6,134.6 cap_mim_2f0_m4m5_noshield
X$1015 \$83__t87 topn__t298 cap_mim_2f0_m4m5_noshield c_length=4U c_width=4U
* device instance $1016 r0 *1 352,134.6 cap_mim_2f0_m4m5_noshield
X$1016 \$81__t127 topn__t253 cap_mim_2f0_m4m5_noshield c_length=4U c_width=4U
* device instance $1017 r0 *1 358.4,134.6 cap_mim_2f0_m4m5_noshield
X$1017 \$83__t84 topn__t283 cap_mim_2f0_m4m5_noshield c_length=4U c_width=4U
* device instance $1018 r0 *1 364.8,134.6 cap_mim_2f0_m4m5_noshield
X$1018 \$81__t123 topn__t247 cap_mim_2f0_m4m5_noshield c_length=4U c_width=4U
* device instance $1019 r0 *1 371.2,134.6 cap_mim_2f0_m4m5_noshield
X$1019 \$83__t123 topn__t473 cap_mim_2f0_m4m5_noshield c_length=4U c_width=4U
* device instance $1020 r0 *1 377.6,134.6 cap_mim_2f0_m4m5_noshield
X$1020 \$81__t139 topn__t277 cap_mim_2f0_m4m5_noshield c_length=4U c_width=4U
* device instance $1021 r0 *1 384,134.6 cap_mim_2f0_m4m5_noshield
X$1021 \$83__t81 topn__t278 cap_mim_2f0_m4m5_noshield c_length=4U c_width=4U
* device instance $1022 r0 *1 390.4,134.6 cap_mim_2f0_m4m5_noshield
X$1022 \$81__t140 topn__t279 cap_mim_2f0_m4m5_noshield c_length=4U c_width=4U
* device instance $1023 r0 *1 396.8,134.6 cap_mim_2f0_m4m5_noshield
X$1023 \$83__t82 topn__t280 cap_mim_2f0_m4m5_noshield c_length=4U c_width=4U
* device instance $1024 r0 *1 403.2,134.6 cap_mim_2f0_m4m5_noshield
X$1024 \$81__t141 topn__t281 cap_mim_2f0_m4m5_noshield c_length=4U c_width=4U
* device instance $1025 r0 *1 409.6,134.6 cap_mim_2f0_m4m5_noshield
X$1025 \$83__t83 topn__t282 cap_mim_2f0_m4m5_noshield c_length=4U c_width=4U
* device instance $1026 r0 *1 416,134.6 cap_mim_2f0_m4m5_noshield
X$1026 \$81__t102 topn__t205 cap_mim_2f0_m4m5_noshield c_length=4U c_width=4U
* device instance $1027 r0 *1 422.4,134.6 cap_mim_2f0_m4m5_noshield
X$1027 \$83__t122 topn__t472 cap_mim_2f0_m4m5_noshield c_length=4U c_width=4U
* device instance $1028 r0 *1 2.6,141 cap_mim_2f0_m4m5_noshield
X$1028 \$12__t6 topp__t6 cap_mim_2f0_m4m5_noshield c_length=4U c_width=4U
* device instance $1029 r0 *1 9,141 cap_mim_2f0_m4m5_noshield
X$1029 \$24__t1 topp__t7 cap_mim_2f0_m4m5_noshield c_length=4U c_width=4U
* device instance $1030 r0 *1 15.4,141 cap_mim_2f0_m4m5_noshield
X$1030 \$12__t7 topp__t8 cap_mim_2f0_m4m5_noshield c_length=4U c_width=4U
* device instance $1031 r0 *1 21.8,141 cap_mim_2f0_m4m5_noshield
X$1031 \$24__t5 topp__t17 cap_mim_2f0_m4m5_noshield c_length=4U c_width=4U
* device instance $1032 r0 *1 28.2,141 cap_mim_2f0_m4m5_noshield
X$1032 \$12__t8 topp__t9 cap_mim_2f0_m4m5_noshield c_length=4U c_width=4U
* device instance $1033 r0 *1 34.6,141 cap_mim_2f0_m4m5_noshield
X$1033 \$24__t2 topp__t10 cap_mim_2f0_m4m5_noshield c_length=4U c_width=4U
* device instance $1034 r0 *1 41,141 cap_mim_2f0_m4m5_noshield
X$1034 \$12__t9 topp__t11 cap_mim_2f0_m4m5_noshield c_length=4U c_width=4U
* device instance $1035 r0 *1 47.4,141 cap_mim_2f0_m4m5_noshield
X$1035 \$24__t3 topp__t12 cap_mim_2f0_m4m5_noshield c_length=4U c_width=4U
* device instance $1036 r0 *1 53.8,141 cap_mim_2f0_m4m5_noshield
X$1036 \$12__t10 topp__t13 cap_mim_2f0_m4m5_noshield c_length=4U c_width=4U
* device instance $1037 r0 *1 60.2,141 cap_mim_2f0_m4m5_noshield
X$1037 \$24__t4 topp__t14 cap_mim_2f0_m4m5_noshield c_length=4U c_width=4U
* device instance $1038 r0 *1 66.6,141 cap_mim_2f0_m4m5_noshield
X$1038 \$12__t11 topp__t15 cap_mim_2f0_m4m5_noshield c_length=4U c_width=4U
* device instance $1039 r0 *1 73,141 cap_mim_2f0_m4m5_noshield
X$1039 \$24__t31 topp__t101 cap_mim_2f0_m4m5_noshield c_length=4U c_width=4U
* device instance $1040 r0 *1 79.4,141 cap_mim_2f0_m4m5_noshield
X$1040 \$12__t34 topp__t60 cap_mim_2f0_m4m5_noshield c_length=4U c_width=4U
* device instance $1041 r0 *1 85.8,141 cap_mim_2f0_m4m5_noshield
X$1041 \$24__t11 topp__t36 cap_mim_2f0_m4m5_noshield c_length=4U c_width=4U
* device instance $1042 r0 *1 92.2,141 cap_mim_2f0_m4m5_noshield
X$1042 \$12__t21 topp__t37 cap_mim_2f0_m4m5_noshield c_length=4U c_width=4U
* device instance $1043 r0 *1 98.6,141 cap_mim_2f0_m4m5_noshield
X$1043 \$24__t21 topp__t68 cap_mim_2f0_m4m5_noshield c_length=4U c_width=4U
* device instance $1044 r0 *1 105,141 cap_mim_2f0_m4m5_noshield
X$1044 \$12__t38 topp__t69 cap_mim_2f0_m4m5_noshield c_length=4U c_width=4U
* device instance $1045 r0 *1 111.4,141 cap_mim_2f0_m4m5_noshield
X$1045 \$24__t20 topp__t66 cap_mim_2f0_m4m5_noshield c_length=4U c_width=4U
* device instance $1046 r0 *1 117.8,141 cap_mim_2f0_m4m5_noshield
X$1046 \$12__t37 topp__t67 cap_mim_2f0_m4m5_noshield c_length=4U c_width=4U
* device instance $1047 r0 *1 124.2,141 cap_mim_2f0_m4m5_noshield
X$1047 \$24__t17 topp__t61 cap_mim_2f0_m4m5_noshield c_length=4U c_width=4U
* device instance $1048 r0 *1 130.6,141 cap_mim_2f0_m4m5_noshield
X$1048 \$12__t35 topp__t62 cap_mim_2f0_m4m5_noshield c_length=4U c_width=4U
* device instance $1049 r0 *1 137,141 cap_mim_2f0_m4m5_noshield
X$1049 \$24__t18 topp__t63 cap_mim_2f0_m4m5_noshield c_length=4U c_width=4U
* device instance $1050 r0 *1 143.4,141 cap_mim_2f0_m4m5_noshield
X$1050 \$12__t23 topp__t39 cap_mim_2f0_m4m5_noshield c_length=4U c_width=4U
* device instance $1051 r0 *1 149.8,141 cap_mim_2f0_m4m5_noshield
X$1051 \$24__t80 topp__t308 cap_mim_2f0_m4m5_noshield c_length=4U c_width=4U
* device instance $1052 r0 *1 156.2,141 cap_mim_2f0_m4m5_noshield
X$1052 \$12__t154 topp__t309 cap_mim_2f0_m4m5_noshield c_length=4U c_width=4U
* device instance $1053 r0 *1 162.6,141 cap_mim_2f0_m4m5_noshield
X$1053 \$24__t82 topp__t312 cap_mim_2f0_m4m5_noshield c_length=4U c_width=4U
* device instance $1054 r0 *1 169,141 cap_mim_2f0_m4m5_noshield
X$1054 \$12__t156 topp__t313 cap_mim_2f0_m4m5_noshield c_length=4U c_width=4U
* device instance $1055 r0 *1 175.4,141 cap_mim_2f0_m4m5_noshield
X$1055 \$24__t87 topp__t335 cap_mim_2f0_m4m5_noshield c_length=4U c_width=4U
* device instance $1056 r0 *1 181.8,141 cap_mim_2f0_m4m5_noshield
X$1056 \$12__t151 topp__t301 cap_mim_2f0_m4m5_noshield c_length=4U c_width=4U
* device instance $1057 r0 *1 188.2,141 cap_mim_2f0_m4m5_noshield
X$1057 \$24__t76 topp__t302 cap_mim_2f0_m4m5_noshield c_length=4U c_width=4U
* device instance $1058 r0 *1 194.6,141 cap_mim_2f0_m4m5_noshield
X$1058 \$12__t152 topp__t303 cap_mim_2f0_m4m5_noshield c_length=4U c_width=4U
* device instance $1059 r0 *1 201,141 cap_mim_2f0_m4m5_noshield
X$1059 \$24__t77 topp__t304 cap_mim_2f0_m4m5_noshield c_length=4U c_width=4U
* device instance $1060 r0 *1 224,141 cap_mim_2f0_m4m5_noshield
X$1060 \$81__t65 topn__t130 cap_mim_2f0_m4m5_noshield c_length=4U c_width=4U
* device instance $1061 r0 *1 230.4,141 cap_mim_2f0_m4m5_noshield
X$1061 \$83__t38 topn__t140 cap_mim_2f0_m4m5_noshield c_length=4U c_width=4U
* device instance $1062 r0 *1 236.8,141 cap_mim_2f0_m4m5_noshield
X$1062 \$81__t67 topn__t132 cap_mim_2f0_m4m5_noshield c_length=4U c_width=4U
* device instance $1063 r0 *1 243.2,141 cap_mim_2f0_m4m5_noshield
X$1063 \$83__t34 topn__t133 cap_mim_2f0_m4m5_noshield c_length=4U c_width=4U
* device instance $1064 r0 *1 249.6,141 cap_mim_2f0_m4m5_noshield
X$1064 \$81__t68 topn__t134 cap_mim_2f0_m4m5_noshield c_length=4U c_width=4U
* device instance $1065 r0 *1 256,141 cap_mim_2f0_m4m5_noshield
X$1065 \$83__t35 topn__t135 cap_mim_2f0_m4m5_noshield c_length=4U c_width=4U
* device instance $1066 r0 *1 262.4,141 cap_mim_2f0_m4m5_noshield
X$1066 \$81__t69 topn__t136 cap_mim_2f0_m4m5_noshield c_length=4U c_width=4U
* device instance $1067 r0 *1 268.8,141 cap_mim_2f0_m4m5_noshield
X$1067 \$83__t36 topn__t137 cap_mim_2f0_m4m5_noshield c_length=4U c_width=4U
* device instance $1068 r0 *1 275.2,141 cap_mim_2f0_m4m5_noshield
X$1068 \$81__t70 topn__t138 cap_mim_2f0_m4m5_noshield c_length=4U c_width=4U
* device instance $1069 r0 *1 281.6,141 cap_mim_2f0_m4m5_noshield
X$1069 \$83__t37 topn__t139 cap_mim_2f0_m4m5_noshield c_length=4U c_width=4U
* device instance $1070 r0 *1 288,141 cap_mim_2f0_m4m5_noshield
X$1070 \$81__t60 topn__t120 cap_mim_2f0_m4m5_noshield c_length=4U c_width=4U
* device instance $1071 r0 *1 294.4,141 cap_mim_2f0_m4m5_noshield
X$1071 \$83__t69 topn__t254 cap_mim_2f0_m4m5_noshield c_length=4U c_width=4U
* device instance $1072 r0 *1 300.8,141 cap_mim_2f0_m4m5_noshield
X$1072 \$81__t128 topn__t255 cap_mim_2f0_m4m5_noshield c_length=4U c_width=4U
* device instance $1073 r0 *1 307.2,141 cap_mim_2f0_m4m5_noshield
X$1073 \$83__t70 topn__t256 cap_mim_2f0_m4m5_noshield c_length=4U c_width=4U
* device instance $1074 r0 *1 313.6,141 cap_mim_2f0_m4m5_noshield
X$1074 \$81__t129 topn__t257 cap_mim_2f0_m4m5_noshield c_length=4U c_width=4U
* device instance $1075 r0 *1 320,141 cap_mim_2f0_m4m5_noshield
X$1075 \$83__t71 topn__t258 cap_mim_2f0_m4m5_noshield c_length=4U c_width=4U
* device instance $1076 r0 *1 326.4,141 cap_mim_2f0_m4m5_noshield
X$1076 \$81__t130 topn__t259 cap_mim_2f0_m4m5_noshield c_length=4U c_width=4U
* device instance $1077 r0 *1 332.8,141 cap_mim_2f0_m4m5_noshield
X$1077 \$83__t72 topn__t260 cap_mim_2f0_m4m5_noshield c_length=4U c_width=4U
* device instance $1078 r0 *1 339.2,141 cap_mim_2f0_m4m5_noshield
X$1078 \$81__t131 topn__t261 cap_mim_2f0_m4m5_noshield c_length=4U c_width=4U
* device instance $1079 r0 *1 345.6,141 cap_mim_2f0_m4m5_noshield
X$1079 \$83__t73 topn__t262 cap_mim_2f0_m4m5_noshield c_length=4U c_width=4U
* device instance $1080 r0 *1 352,141 cap_mim_2f0_m4m5_noshield
X$1080 \$81__t132 topn__t263 cap_mim_2f0_m4m5_noshield c_length=4U c_width=4U
* device instance $1081 r0 *1 358.4,141 cap_mim_2f0_m4m5_noshield
X$1081 \$83__t76 topn__t268 cap_mim_2f0_m4m5_noshield c_length=4U c_width=4U
* device instance $1082 r0 *1 364.8,141 cap_mim_2f0_m4m5_noshield
X$1082 \$81__t124 topn__t248 cap_mim_2f0_m4m5_noshield c_length=4U c_width=4U
* device instance $1083 r0 *1 371.2,141 cap_mim_2f0_m4m5_noshield
X$1083 \$83__t124 topn__t474 cap_mim_2f0_m4m5_noshield c_length=4U c_width=4U
* device instance $1084 r0 *1 377.6,141 cap_mim_2f0_m4m5_noshield
X$1084 \$81__t242 topn__t486 cap_mim_2f0_m4m5_noshield c_length=4U c_width=4U
* device instance $1085 r0 *1 384,141 cap_mim_2f0_m4m5_noshield
X$1085 \$83__t125 topn__t487 cap_mim_2f0_m4m5_noshield c_length=4U c_width=4U
* device instance $1086 r0 *1 390.4,141 cap_mim_2f0_m4m5_noshield
X$1086 \$81__t136 topn__t271 cap_mim_2f0_m4m5_noshield c_length=4U c_width=4U
* device instance $1087 r0 *1 396.8,141 cap_mim_2f0_m4m5_noshield
X$1087 \$83__t78 topn__t272 cap_mim_2f0_m4m5_noshield c_length=4U c_width=4U
* device instance $1088 r0 *1 403.2,141 cap_mim_2f0_m4m5_noshield
X$1088 \$81__t137 topn__t273 cap_mim_2f0_m4m5_noshield c_length=4U c_width=4U
* device instance $1089 r0 *1 409.6,141 cap_mim_2f0_m4m5_noshield
X$1089 \$83__t79 topn__t274 cap_mim_2f0_m4m5_noshield c_length=4U c_width=4U
* device instance $1090 r0 *1 416,141 cap_mim_2f0_m4m5_noshield
X$1090 \$81__t138 topn__t275 cap_mim_2f0_m4m5_noshield c_length=4U c_width=4U
* device instance $1091 r0 *1 422.4,141 cap_mim_2f0_m4m5_noshield
X$1091 \$83__t80 topn__t276 cap_mim_2f0_m4m5_noshield c_length=4U c_width=4U
* device instance $1092 r0 *1 2.6,147.4 cap_mim_2f0_m4m5_noshield
X$1092 \$24__t88 topp__t336 cap_mim_2f0_m4m5_noshield c_length=4U c_width=4U
* device instance $1093 r0 *1 9,147.4 cap_mim_2f0_m4m5_noshield
X$1093 \$12__t168 topp__t337 cap_mim_2f0_m4m5_noshield c_length=4U c_width=4U
* device instance $1094 r0 *1 15.4,147.4 cap_mim_2f0_m4m5_noshield
X$1094 \$24__t89 topp__t338 cap_mim_2f0_m4m5_noshield c_length=4U c_width=4U
* device instance $1095 r0 *1 21.8,147.4 cap_mim_2f0_m4m5_noshield
X$1095 \$12__t169 topp__t339 cap_mim_2f0_m4m5_noshield c_length=4U c_width=4U
* device instance $1096 r0 *1 28.2,147.4 cap_mim_2f0_m4m5_noshield
X$1096 \$24__t90 topp__t340 cap_mim_2f0_m4m5_noshield c_length=4U c_width=4U
* device instance $1097 r0 *1 34.6,147.4 cap_mim_2f0_m4m5_noshield
X$1097 \$12__t170 topp__t341 cap_mim_2f0_m4m5_noshield c_length=4U c_width=4U
* device instance $1098 r0 *1 41,147.4 cap_mim_2f0_m4m5_noshield
X$1098 \$24__t91 topp__t342 cap_mim_2f0_m4m5_noshield c_length=4U c_width=4U
* device instance $1099 r0 *1 47.4,147.4 cap_mim_2f0_m4m5_noshield
X$1099 \$12__t133 topp__t267 cap_mim_2f0_m4m5_noshield c_length=4U c_width=4U
* device instance $1100 r0 *1 53.8,147.4 cap_mim_2f0_m4m5_noshield
X$1100 \$24__t71 topp__t215 cap_mim_2f0_m4m5_noshield c_length=4U c_width=4U
* device instance $1101 r0 *1 60.2,147.4 cap_mim_2f0_m4m5_noshield
X$1101 \$12__t46 topp__t87 cap_mim_2f0_m4m5_noshield c_length=4U c_width=4U
* device instance $1102 r0 *1 66.6,147.4 cap_mim_2f0_m4m5_noshield
X$1102 \$24__t25 topp__t88 cap_mim_2f0_m4m5_noshield c_length=4U c_width=4U
* device instance $1103 r0 *1 73,147.4 cap_mim_2f0_m4m5_noshield
X$1103 \$12__t47 topp__t89 cap_mim_2f0_m4m5_noshield c_length=4U c_width=4U
* device instance $1104 r0 *1 79.4,147.4 cap_mim_2f0_m4m5_noshield
X$1104 \$24__t26 topp__t90 cap_mim_2f0_m4m5_noshield c_length=4U c_width=4U
* device instance $1105 r0 *1 85.8,147.4 cap_mim_2f0_m4m5_noshield
X$1105 \$12__t48 topp__t91 cap_mim_2f0_m4m5_noshield c_length=4U c_width=4U
* device instance $1106 r0 *1 92.2,147.4 cap_mim_2f0_m4m5_noshield
X$1106 \$24__t27 topp__t92 cap_mim_2f0_m4m5_noshield c_length=4U c_width=4U
* device instance $1107 r0 *1 98.6,147.4 cap_mim_2f0_m4m5_noshield
X$1107 \$12__t49 topp__t93 cap_mim_2f0_m4m5_noshield c_length=4U c_width=4U
* device instance $1108 r0 *1 105,147.4 cap_mim_2f0_m4m5_noshield
X$1108 \$24__t28 topp__t94 cap_mim_2f0_m4m5_noshield c_length=4U c_width=4U
* device instance $1109 r0 *1 111.4,147.4 cap_mim_2f0_m4m5_noshield
X$1109 \$12__t53 topp__t104 cap_mim_2f0_m4m5_noshield c_length=4U c_width=4U
* device instance $1110 r0 *1 117.8,147.4 cap_mim_2f0_m4m5_noshield
X$1110 \$24__t29 topp__t97 cap_mim_2f0_m4m5_noshield c_length=4U c_width=4U
* device instance $1111 r0 *1 124.2,147.4 cap_mim_2f0_m4m5_noshield
X$1111 \$12__t51 topp__t98 cap_mim_2f0_m4m5_noshield c_length=4U c_width=4U
* device instance $1112 r0 *1 130.6,147.4 cap_mim_2f0_m4m5_noshield
X$1112 \$24__t30 topp__t99 cap_mim_2f0_m4m5_noshield c_length=4U c_width=4U
* device instance $1113 r0 *1 137,147.4 cap_mim_2f0_m4m5_noshield
X$1113 \$12__t52 topp__t100 cap_mim_2f0_m4m5_noshield c_length=4U c_width=4U
* device instance $1114 r0 *1 143.4,147.4 cap_mim_2f0_m4m5_noshield
X$1114 \$24__t32 topp__t102 cap_mim_2f0_m4m5_noshield c_length=4U c_width=4U
* device instance $1115 r0 *1 149.8,147.4 cap_mim_2f0_m4m5_noshield
X$1115 \$12__t172 topp__t346 cap_mim_2f0_m4m5_noshield c_length=4U c_width=4U
* device instance $1116 r0 *1 156.2,147.4 cap_mim_2f0_m4m5_noshield
X$1116 \$24__t96 topp__t354 cap_mim_2f0_m4m5_noshield c_length=4U c_width=4U
* device instance $1117 r0 *1 162.6,147.4 cap_mim_2f0_m4m5_noshield
X$1117 \$12__t173 topp__t347 cap_mim_2f0_m4m5_noshield c_length=4U c_width=4U
* device instance $1118 r0 *1 169,147.4 cap_mim_2f0_m4m5_noshield
X$1118 \$24__t93 topp__t348 cap_mim_2f0_m4m5_noshield c_length=4U c_width=4U
* device instance $1119 r0 *1 175.4,147.4 cap_mim_2f0_m4m5_noshield
X$1119 \$12__t174 topp__t349 cap_mim_2f0_m4m5_noshield c_length=4U c_width=4U
* device instance $1120 r0 *1 181.8,147.4 cap_mim_2f0_m4m5_noshield
X$1120 \$24__t94 topp__t350 cap_mim_2f0_m4m5_noshield c_length=4U c_width=4U
* device instance $1121 r0 *1 188.2,147.4 cap_mim_2f0_m4m5_noshield
X$1121 \$12__t175 topp__t351 cap_mim_2f0_m4m5_noshield c_length=4U c_width=4U
* device instance $1122 r0 *1 194.6,147.4 cap_mim_2f0_m4m5_noshield
X$1122 \$24__t95 topp__t352 cap_mim_2f0_m4m5_noshield c_length=4U c_width=4U
* device instance $1123 r0 *1 201,147.4 cap_mim_2f0_m4m5_noshield
X$1123 \$12__t176 topp__t353 cap_mim_2f0_m4m5_noshield c_length=4U c_width=4U
* device instance $1124 r0 *1 224,147.4 cap_mim_2f0_m4m5_noshield
X$1124 \$83__t47 topn__t164 cap_mim_2f0_m4m5_noshield c_length=4U c_width=4U
* device instance $1125 r0 *1 230.4,147.4 cap_mim_2f0_m4m5_noshield
X$1125 \$81__t81 topn__t163 cap_mim_2f0_m4m5_noshield c_length=4U c_width=4U
* device instance $1126 r0 *1 236.8,147.4 cap_mim_2f0_m4m5_noshield
X$1126 \$83__t39 topn__t141 cap_mim_2f0_m4m5_noshield c_length=4U c_width=4U
* device instance $1127 r0 *1 243.2,147.4 cap_mim_2f0_m4m5_noshield
X$1127 \$81__t71 topn__t142 cap_mim_2f0_m4m5_noshield c_length=4U c_width=4U
* device instance $1128 r0 *1 249.6,147.4 cap_mim_2f0_m4m5_noshield
X$1128 \$83__t40 topn__t143 cap_mim_2f0_m4m5_noshield c_length=4U c_width=4U
* device instance $1129 r0 *1 256,147.4 cap_mim_2f0_m4m5_noshield
X$1129 \$81__t72 topn__t144 cap_mim_2f0_m4m5_noshield c_length=4U c_width=4U
* device instance $1130 r0 *1 262.4,147.4 cap_mim_2f0_m4m5_noshield
X$1130 \$83__t41 topn__t145 cap_mim_2f0_m4m5_noshield c_length=4U c_width=4U
* device instance $1131 r0 *1 268.8,147.4 cap_mim_2f0_m4m5_noshield
X$1131 \$81__t73 topn__t146 cap_mim_2f0_m4m5_noshield c_length=4U c_width=4U
* device instance $1132 r0 *1 275.2,147.4 cap_mim_2f0_m4m5_noshield
X$1132 \$83__t42 topn__t147 cap_mim_2f0_m4m5_noshield c_length=4U c_width=4U
* device instance $1133 r0 *1 281.6,147.4 cap_mim_2f0_m4m5_noshield
X$1133 \$81__t77 topn__t156 cap_mim_2f0_m4m5_noshield c_length=4U c_width=4U
* device instance $1134 r0 *1 288,147.4 cap_mim_2f0_m4m5_noshield
X$1134 \$83__t43 topn__t148 cap_mim_2f0_m4m5_noshield c_length=4U c_width=4U
* device instance $1135 r0 *1 294.4,147.4 cap_mim_2f0_m4m5_noshield
X$1135 \$81__t125 topn__t249 cap_mim_2f0_m4m5_noshield c_length=4U c_width=4U
* device instance $1136 r0 *1 300.8,147.4 cap_mim_2f0_m4m5_noshield
X$1136 \$83__t67 topn__t250 cap_mim_2f0_m4m5_noshield c_length=4U c_width=4U
* device instance $1137 r0 *1 307.2,147.4 cap_mim_2f0_m4m5_noshield
X$1137 \$81__t113 topn__t225 cap_mim_2f0_m4m5_noshield c_length=4U c_width=4U
* device instance $1138 r0 *1 313.6,147.4 cap_mim_2f0_m4m5_noshield
X$1138 \$83__t57 topn__t226 cap_mim_2f0_m4m5_noshield c_length=4U c_width=4U
* device instance $1139 r0 *1 320,147.4 cap_mim_2f0_m4m5_noshield
X$1139 \$81__t114 topn__t227 cap_mim_2f0_m4m5_noshield c_length=4U c_width=4U
* device instance $1140 r0 *1 326.4,147.4 cap_mim_2f0_m4m5_noshield
X$1140 \$83__t58 topn__t228 cap_mim_2f0_m4m5_noshield c_length=4U c_width=4U
* device instance $1141 r0 *1 332.8,147.4 cap_mim_2f0_m4m5_noshield
X$1141 \$81__t115 topn__t229 cap_mim_2f0_m4m5_noshield c_length=4U c_width=4U
* device instance $1142 r0 *1 339.2,147.4 cap_mim_2f0_m4m5_noshield
X$1142 \$83__t59 topn__t230 cap_mim_2f0_m4m5_noshield c_length=4U c_width=4U
* device instance $1143 r0 *1 345.6,147.4 cap_mim_2f0_m4m5_noshield
X$1143 \$81__t116 topn__t231 cap_mim_2f0_m4m5_noshield c_length=4U c_width=4U
* device instance $1144 r0 *1 352,147.4 cap_mim_2f0_m4m5_noshield
X$1144 \$83__t60 topn__t232 cap_mim_2f0_m4m5_noshield c_length=4U c_width=4U
* device instance $1145 r0 *1 358.4,147.4 cap_mim_2f0_m4m5_noshield
X$1145 \$81__t117 topn__t233 cap_mim_2f0_m4m5_noshield c_length=4U c_width=4U
* device instance $1146 r0 *1 364.8,147.4 cap_mim_2f0_m4m5_noshield
X$1146 \$83__t61 topn__t234 cap_mim_2f0_m4m5_noshield c_length=4U c_width=4U
* device instance $1147 r0 *1 371.2,147.4 cap_mim_2f0_m4m5_noshield
X$1147 \$81__t118 topn__t235 cap_mim_2f0_m4m5_noshield c_length=4U c_width=4U
* device instance $1148 r0 *1 377.6,147.4 cap_mim_2f0_m4m5_noshield
X$1148 \$83__t68 topn__t252 cap_mim_2f0_m4m5_noshield c_length=4U c_width=4U
* device instance $1149 r0 *1 384,147.4 cap_mim_2f0_m4m5_noshield
X$1149 \$81__t119 topn__t237 cap_mim_2f0_m4m5_noshield c_length=4U c_width=4U
* device instance $1150 r0 *1 390.4,147.4 cap_mim_2f0_m4m5_noshield
X$1150 \$83__t63 topn__t238 cap_mim_2f0_m4m5_noshield c_length=4U c_width=4U
* device instance $1151 r0 *1 396.8,147.4 cap_mim_2f0_m4m5_noshield
X$1151 \$81__t120 topn__t239 cap_mim_2f0_m4m5_noshield c_length=4U c_width=4U
* device instance $1152 r0 *1 403.2,147.4 cap_mim_2f0_m4m5_noshield
X$1152 \$83__t64 topn__t240 cap_mim_2f0_m4m5_noshield c_length=4U c_width=4U
* device instance $1153 r0 *1 409.6,147.4 cap_mim_2f0_m4m5_noshield
X$1153 \$81__t121 topn__t241 cap_mim_2f0_m4m5_noshield c_length=4U c_width=4U
* device instance $1154 r0 *1 416,147.4 cap_mim_2f0_m4m5_noshield
X$1154 \$83__t65 topn__t242 cap_mim_2f0_m4m5_noshield c_length=4U c_width=4U
* device instance $1155 r0 *1 422.4,147.4 cap_mim_2f0_m4m5_noshield
X$1155 \$81__t122 topn__t243 cap_mim_2f0_m4m5_noshield c_length=4U c_width=4U
* device instance $1156 r0 *1 2.6,153.8 cap_mim_2f0_m4m5_noshield
X$1156 \$24__t35 topp__t120 cap_mim_2f0_m4m5_noshield c_length=4U c_width=4U
* device instance $1157 r0 *1 9,153.8 cap_mim_2f0_m4m5_noshield
X$1157 \$12__t17 topp__t28 cap_mim_2f0_m4m5_noshield c_length=4U c_width=4U
* device instance $1158 r0 *1 15.4,153.8 cap_mim_2f0_m4m5_noshield
X$1158 \$24__t7 topp__t29 cap_mim_2f0_m4m5_noshield c_length=4U c_width=4U
* device instance $1159 r0 *1 21.8,153.8 cap_mim_2f0_m4m5_noshield
X$1159 \$12__t68 topp__t136 cap_mim_2f0_m4m5_noshield c_length=4U c_width=4U
* device instance $1160 r0 *1 28.2,153.8 cap_mim_2f0_m4m5_noshield
X$1160 \$24__t40 topp__t137 cap_mim_2f0_m4m5_noshield c_length=4U c_width=4U
* device instance $1161 r0 *1 34.6,153.8 cap_mim_2f0_m4m5_noshield
X$1161 \$12__t69 topp__t138 cap_mim_2f0_m4m5_noshield c_length=4U c_width=4U
* device instance $1162 r0 *1 41,153.8 cap_mim_2f0_m4m5_noshield
X$1162 \$24__t36 topp__t130 cap_mim_2f0_m4m5_noshield c_length=4U c_width=4U
* device instance $1163 r0 *1 47.4,153.8 cap_mim_2f0_m4m5_noshield
X$1163 \$12__t54 topp__t105 cap_mim_2f0_m4m5_noshield c_length=4U c_width=4U
* device instance $1164 r0 *1 53.8,153.8 cap_mim_2f0_m4m5_noshield
X$1164 \$24__t33 topp__t117 cap_mim_2f0_m4m5_noshield c_length=4U c_width=4U
* device instance $1165 r0 *1 60.2,153.8 cap_mim_2f0_m4m5_noshield
X$1165 \$12__t61 topp__t118 cap_mim_2f0_m4m5_noshield c_length=4U c_width=4U
* device instance $1166 r0 *1 66.6,153.8 cap_mim_2f0_m4m5_noshield
X$1166 \$24__t34 topp__t119 cap_mim_2f0_m4m5_noshield c_length=4U c_width=4U
* device instance $1167 r0 *1 73,153.8 cap_mim_2f0_m4m5_noshield
X$1167 \$12__t167 topp__t333 cap_mim_2f0_m4m5_noshield c_length=4U c_width=4U
* device instance $1168 r0 *1 79.4,153.8 cap_mim_2f0_m4m5_noshield
X$1168 \$24__t24 topp__t74 cap_mim_2f0_m4m5_noshield c_length=4U c_width=4U
* device instance $1169 r0 *1 85.8,153.8 cap_mim_2f0_m4m5_noshield
X$1169 \$12__t41 topp__t75 cap_mim_2f0_m4m5_noshield c_length=4U c_width=4U
* device instance $1170 r0 *1 92.2,153.8 cap_mim_2f0_m4m5_noshield
X$1170 \$24__t37 topp__t131 cap_mim_2f0_m4m5_noshield c_length=4U c_width=4U
* device instance $1171 r0 *1 98.6,153.8 cap_mim_2f0_m4m5_noshield
X$1171 \$12__t66 topp__t132 cap_mim_2f0_m4m5_noshield c_length=4U c_width=4U
* device instance $1172 r0 *1 105,153.8 cap_mim_2f0_m4m5_noshield
X$1172 \$24__t38 topp__t133 cap_mim_2f0_m4m5_noshield c_length=4U c_width=4U
* device instance $1173 r0 *1 111.4,153.8 cap_mim_2f0_m4m5_noshield
X$1173 \$12__t67 topp__t134 cap_mim_2f0_m4m5_noshield c_length=4U c_width=4U
* device instance $1174 r0 *1 117.8,153.8 cap_mim_2f0_m4m5_noshield
X$1174 \$24__t22 topp__t70 cap_mim_2f0_m4m5_noshield c_length=4U c_width=4U
* device instance $1175 r0 *1 124.2,153.8 cap_mim_2f0_m4m5_noshield
X$1175 \$12__t39 topp__t71 cap_mim_2f0_m4m5_noshield c_length=4U c_width=4U
* device instance $1176 r0 *1 130.6,153.8 cap_mim_2f0_m4m5_noshield
X$1176 \$24__t23 topp__t72 cap_mim_2f0_m4m5_noshield c_length=4U c_width=4U
* device instance $1177 r0 *1 137,153.8 cap_mim_2f0_m4m5_noshield
X$1177 \$12__t40 topp__t73 cap_mim_2f0_m4m5_noshield c_length=4U c_width=4U
* device instance $1178 r0 *1 143.4,153.8 cap_mim_2f0_m4m5_noshield
X$1178 \$24__t39 topp__t135 cap_mim_2f0_m4m5_noshield c_length=4U c_width=4U
* device instance $1179 r0 *1 149.8,153.8 cap_mim_2f0_m4m5_noshield
X$1179 \$12__t179 topp__t358 cap_mim_2f0_m4m5_noshield c_length=4U c_width=4U
* device instance $1180 r0 *1 156.2,153.8 cap_mim_2f0_m4m5_noshield
X$1180 \$24__t84 topp__t329 cap_mim_2f0_m4m5_noshield c_length=4U c_width=4U
* device instance $1181 r0 *1 162.6,153.8 cap_mim_2f0_m4m5_noshield
X$1181 \$12__t166 topp__t330 cap_mim_2f0_m4m5_noshield c_length=4U c_width=4U
* device instance $1182 r0 *1 169,153.8 cap_mim_2f0_m4m5_noshield
X$1182 \$24__t85 topp__t331 cap_mim_2f0_m4m5_noshield c_length=4U c_width=4U
* device instance $1183 r0 *1 175.4,153.8 cap_mim_2f0_m4m5_noshield
X$1183 \$12__t162 topp__t323 cap_mim_2f0_m4m5_noshield c_length=4U c_width=4U
* device instance $1184 r0 *1 181.8,153.8 cap_mim_2f0_m4m5_noshield
X$1184 \$24__t98 topp__t363 cap_mim_2f0_m4m5_noshield c_length=4U c_width=4U
* device instance $1185 r0 *1 188.2,153.8 cap_mim_2f0_m4m5_noshield
X$1185 \$12__t177 topp__t355 cap_mim_2f0_m4m5_noshield c_length=4U c_width=4U
* device instance $1186 r0 *1 194.6,153.8 cap_mim_2f0_m4m5_noshield
X$1186 \$24__t97 topp__t356 cap_mim_2f0_m4m5_noshield c_length=4U c_width=4U
* device instance $1187 r0 *1 201,153.8 cap_mim_2f0_m4m5_noshield
X$1187 \$12__t178 topp__t357 cap_mim_2f0_m4m5_noshield c_length=4U c_width=4U
* device instance $1188 r0 *1 224,153.8 cap_mim_2f0_m4m5_noshield
X$1188 \$83__t44 topn__t150 cap_mim_2f0_m4m5_noshield c_length=4U c_width=4U
* device instance $1189 r0 *1 230.4,153.8 cap_mim_2f0_m4m5_noshield
X$1189 \$81__t74 topn__t151 cap_mim_2f0_m4m5_noshield c_length=4U c_width=4U
* device instance $1190 r0 *1 236.8,153.8 cap_mim_2f0_m4m5_noshield
X$1190 \$83__t45 topn__t152 cap_mim_2f0_m4m5_noshield c_length=4U c_width=4U
* device instance $1191 r0 *1 243.2,153.8 cap_mim_2f0_m4m5_noshield
X$1191 \$81__t75 topn__t153 cap_mim_2f0_m4m5_noshield c_length=4U c_width=4U
* device instance $1192 r0 *1 249.6,153.8 cap_mim_2f0_m4m5_noshield
X$1192 \$83__t46 topn__t154 cap_mim_2f0_m4m5_noshield c_length=4U c_width=4U
* device instance $1193 r0 *1 256,153.8 cap_mim_2f0_m4m5_noshield
X$1193 \$81__t76 topn__t155 cap_mim_2f0_m4m5_noshield c_length=4U c_width=4U
* device instance $1194 r0 *1 262.4,153.8 cap_mim_2f0_m4m5_noshield
X$1194 \$83__t49 topn__t172 cap_mim_2f0_m4m5_noshield c_length=4U c_width=4U
* device instance $1195 r0 *1 268.8,153.8 cap_mim_2f0_m4m5_noshield
X$1195 \$81__t85 topn__t173 cap_mim_2f0_m4m5_noshield c_length=4U c_width=4U
* device instance $1196 r0 *1 275.2,153.8 cap_mim_2f0_m4m5_noshield
X$1196 \$83__t50 topn__t174 cap_mim_2f0_m4m5_noshield c_length=4U c_width=4U
* device instance $1197 r0 *1 281.6,153.8 cap_mim_2f0_m4m5_noshield
X$1197 \$81__t86 topn__t175 cap_mim_2f0_m4m5_noshield c_length=4U c_width=4U
* device instance $1198 r0 *1 288,153.8 cap_mim_2f0_m4m5_noshield
X$1198 \$83__t48 topn__t171 cap_mim_2f0_m4m5_noshield c_length=4U c_width=4U
* device instance $1199 r0 *1 294.4,153.8 cap_mim_2f0_m4m5_noshield
X$1199 \$81__t156 topn__t310 cap_mim_2f0_m4m5_noshield c_length=4U c_width=4U
* device instance $1200 r0 *1 300.8,153.8 cap_mim_2f0_m4m5_noshield
X$1200 \$83__t54 topn__t216 cap_mim_2f0_m4m5_noshield c_length=4U c_width=4U
* device instance $1201 r0 *1 307.2,153.8 cap_mim_2f0_m4m5_noshield
X$1201 \$81__t108 topn__t217 cap_mim_2f0_m4m5_noshield c_length=4U c_width=4U
* device instance $1202 r0 *1 313.6,153.8 cap_mim_2f0_m4m5_noshield
X$1202 \$83__t55 topn__t218 cap_mim_2f0_m4m5_noshield c_length=4U c_width=4U
* device instance $1203 r0 *1 320,153.8 cap_mim_2f0_m4m5_noshield
X$1203 \$81__t109 topn__t219 cap_mim_2f0_m4m5_noshield c_length=4U c_width=4U
* device instance $1204 r0 *1 326.4,153.8 cap_mim_2f0_m4m5_noshield
X$1204 \$83__t56 topn__t220 cap_mim_2f0_m4m5_noshield c_length=4U c_width=4U
* device instance $1205 r0 *1 332.8,153.8 cap_mim_2f0_m4m5_noshield
X$1205 \$81__t134 topn__t267 cap_mim_2f0_m4m5_noshield c_length=4U c_width=4U
* device instance $1206 r0 *1 339.2,153.8 cap_mim_2f0_m4m5_noshield
X$1206 \$83__t85 topn__t284 cap_mim_2f0_m4m5_noshield c_length=4U c_width=4U
* device instance $1207 r0 *1 345.6,153.8 cap_mim_2f0_m4m5_noshield
X$1207 \$81__t142 topn__t285 cap_mim_2f0_m4m5_noshield c_length=4U c_width=4U
* device instance $1208 r0 *1 352,153.8 cap_mim_2f0_m4m5_noshield
X$1208 \$83__t86 topn__t286 cap_mim_2f0_m4m5_noshield c_length=4U c_width=4U
* device instance $1209 r0 *1 358.4,153.8 cap_mim_2f0_m4m5_noshield
X$1209 \$81__t153 topn__t307 cap_mim_2f0_m4m5_noshield c_length=4U c_width=4U
* device instance $1210 r0 *1 364.8,153.8 cap_mim_2f0_m4m5_noshield
X$1210 \$83__t66 topn__t244 cap_mim_2f0_m4m5_noshield c_length=4U c_width=4U
* device instance $1211 r0 *1 371.2,153.8 cap_mim_2f0_m4m5_noshield
X$1211 \$81__t100 topn__t201 cap_mim_2f0_m4m5_noshield c_length=4U c_width=4U
* device instance $1212 r0 *1 377.6,153.8 cap_mim_2f0_m4m5_noshield
X$1212 \$83__t62 topn__t236 cap_mim_2f0_m4m5_noshield c_length=4U c_width=4U
* device instance $1213 r0 *1 384,153.8 cap_mim_2f0_m4m5_noshield
X$1213 \$81__t94 topn__t191 cap_mim_2f0_m4m5_noshield c_length=4U c_width=4U
* device instance $1214 r0 *1 390.4,153.8 cap_mim_2f0_m4m5_noshield
X$1214 \$83__t51 topn__t202 cap_mim_2f0_m4m5_noshield c_length=4U c_width=4U
* device instance $1215 r0 *1 396.8,153.8 cap_mim_2f0_m4m5_noshield
X$1215 \$81__t106 topn__t212 cap_mim_2f0_m4m5_noshield c_length=4U c_width=4U
* device instance $1216 r0 *1 403.2,153.8 cap_mim_2f0_m4m5_noshield
X$1216 \$83__t52 topn__t213 cap_mim_2f0_m4m5_noshield c_length=4U c_width=4U
* device instance $1217 r0 *1 409.6,153.8 cap_mim_2f0_m4m5_noshield
X$1217 \$81__t107 topn__t214 cap_mim_2f0_m4m5_noshield c_length=4U c_width=4U
* device instance $1218 r0 *1 416,153.8 cap_mim_2f0_m4m5_noshield
X$1218 \$83__t53 topn__t215 cap_mim_2f0_m4m5_noshield c_length=4U c_width=4U
* device instance $1219 r0 *1 422.4,153.8 cap_mim_2f0_m4m5_noshield
X$1219 \$81__t126 topn__t251 cap_mim_2f0_m4m5_noshield c_length=4U c_width=4U
* device instance $1220 r0 *1 2.6,160.2 cap_mim_2f0_m4m5_noshield
X$1220 \$32__t6 topp__t77 cap_mim_2f0_m4m5_noshield c_length=4U c_width=4U
* device instance $1221 r0 *1 9,160.2 cap_mim_2f0_m4m5_noshield
X$1221 \$12__t13 topp__t18 cap_mim_2f0_m4m5_noshield c_length=4U c_width=4U
* device instance $1222 r0 *1 15.4,160.2 cap_mim_2f0_m4m5_noshield
X$1222 \$32__t0 topp__t19 cap_mim_2f0_m4m5_noshield c_length=4U c_width=4U
* device instance $1223 r0 *1 21.8,160.2 cap_mim_2f0_m4m5_noshield
X$1223 \$12__t14 topp__t20 cap_mim_2f0_m4m5_noshield c_length=4U c_width=4U
* device instance $1224 r0 *1 28.2,160.2 cap_mim_2f0_m4m5_noshield
X$1224 \$32__t1 topp__t21 cap_mim_2f0_m4m5_noshield c_length=4U c_width=4U
* device instance $1225 r0 *1 34.6,160.2 cap_mim_2f0_m4m5_noshield
X$1225 \$12__t15 topp__t22 cap_mim_2f0_m4m5_noshield c_length=4U c_width=4U
* device instance $1226 r0 *1 41,160.2 cap_mim_2f0_m4m5_noshield
X$1226 \$32__t2 topp__t23 cap_mim_2f0_m4m5_noshield c_length=4U c_width=4U
* device instance $1227 r0 *1 47.4,160.2 cap_mim_2f0_m4m5_noshield
X$1227 \$12__t16 topp__t24 cap_mim_2f0_m4m5_noshield c_length=4U c_width=4U
* device instance $1228 r0 *1 53.8,160.2 cap_mim_2f0_m4m5_noshield
X$1228 \$32__t3 topp__t25 cap_mim_2f0_m4m5_noshield c_length=4U c_width=4U
* device instance $1229 r0 *1 60.2,160.2 cap_mim_2f0_m4m5_noshield
X$1229 \$12__t20 topp__t35 cap_mim_2f0_m4m5_noshield c_length=4U c_width=4U
* device instance $1230 r0 *1 66.6,160.2 cap_mim_2f0_m4m5_noshield
X$1230 \$32__t4 topp__t27 cap_mim_2f0_m4m5_noshield c_length=4U c_width=4U
* device instance $1231 r0 *1 73,160.2 cap_mim_2f0_m4m5_noshield
X$1231 \$12__t171 topp__t343 cap_mim_2f0_m4m5_noshield c_length=4U c_width=4U
* device instance $1232 r0 *1 79.4,160.2 cap_mim_2f0_m4m5_noshield
X$1232 \$32__t5 topp__t76 cap_mim_2f0_m4m5_noshield c_length=4U c_width=4U
* device instance $1233 r0 *1 85.8,160.2 cap_mim_2f0_m4m5_noshield
X$1233 \$12__t45 topp__t86 cap_mim_2f0_m4m5_noshield c_length=4U c_width=4U
* device instance $1234 r0 *1 92.2,160.2 cap_mim_2f0_m4m5_noshield
X$1234 \$32__t7 topp__t78 cap_mim_2f0_m4m5_noshield c_length=4U c_width=4U
* device instance $1235 r0 *1 98.6,160.2 cap_mim_2f0_m4m5_noshield
X$1235 \$12__t42 topp__t79 cap_mim_2f0_m4m5_noshield c_length=4U c_width=4U
* device instance $1236 r0 *1 105,160.2 cap_mim_2f0_m4m5_noshield
X$1236 \$32__t8 topp__t80 cap_mim_2f0_m4m5_noshield c_length=4U c_width=4U
* device instance $1237 r0 *1 111.4,160.2 cap_mim_2f0_m4m5_noshield
X$1237 \$12__t43 topp__t81 cap_mim_2f0_m4m5_noshield c_length=4U c_width=4U
* device instance $1238 r0 *1 117.8,160.2 cap_mim_2f0_m4m5_noshield
X$1238 \$32__t9 topp__t82 cap_mim_2f0_m4m5_noshield c_length=4U c_width=4U
* device instance $1239 r0 *1 124.2,160.2 cap_mim_2f0_m4m5_noshield
X$1239 \$12__t44 topp__t83 cap_mim_2f0_m4m5_noshield c_length=4U c_width=4U
* device instance $1240 r0 *1 130.6,160.2 cap_mim_2f0_m4m5_noshield
X$1240 \$32__t10 topp__t84 cap_mim_2f0_m4m5_noshield c_length=4U c_width=4U
* device instance $1241 r0 *1 137,160.2 cap_mim_2f0_m4m5_noshield
X$1241 \$12__t70 topp__t139 cap_mim_2f0_m4m5_noshield c_length=4U c_width=4U
* device instance $1242 r0 *1 143.4,160.2 cap_mim_2f0_m4m5_noshield
X$1242 \$32__t11 topp__t103 cap_mim_2f0_m4m5_noshield c_length=4U c_width=4U
* device instance $1243 r0 *1 149.8,160.2 cap_mim_2f0_m4m5_noshield
X$1243 \$12__t180 topp__t359 cap_mim_2f0_m4m5_noshield c_length=4U c_width=4U
* device instance $1244 r0 *1 156.2,160.2 cap_mim_2f0_m4m5_noshield
X$1244 \$32__t40 topp__t321 cap_mim_2f0_m4m5_noshield c_length=4U c_width=4U
* device instance $1245 r0 *1 162.6,160.2 cap_mim_2f0_m4m5_noshield
X$1245 \$12__t161 topp__t322 cap_mim_2f0_m4m5_noshield c_length=4U c_width=4U
* device instance $1246 r0 *1 169,160.2 cap_mim_2f0_m4m5_noshield
X$1246 \$32__t43 topp__t332 cap_mim_2f0_m4m5_noshield c_length=4U c_width=4U
* device instance $1247 r0 *1 175.4,160.2 cap_mim_2f0_m4m5_noshield
X$1247 \$12__t163 topp__t324 cap_mim_2f0_m4m5_noshield c_length=4U c_width=4U
* device instance $1248 r0 *1 181.8,160.2 cap_mim_2f0_m4m5_noshield
X$1248 \$32__t41 topp__t325 cap_mim_2f0_m4m5_noshield c_length=4U c_width=4U
* device instance $1249 r0 *1 188.2,160.2 cap_mim_2f0_m4m5_noshield
X$1249 \$12__t164 topp__t326 cap_mim_2f0_m4m5_noshield c_length=4U c_width=4U
* device instance $1250 r0 *1 194.6,160.2 cap_mim_2f0_m4m5_noshield
X$1250 \$32__t42 topp__t327 cap_mim_2f0_m4m5_noshield c_length=4U c_width=4U
* device instance $1251 r0 *1 201,160.2 cap_mim_2f0_m4m5_noshield
X$1251 \$12__t165 topp__t328 cap_mim_2f0_m4m5_noshield c_length=4U c_width=4U
* device instance $1252 r0 *1 224,160.2 cap_mim_2f0_m4m5_noshield
X$1252 \$84__t15 topn__t176 cap_mim_2f0_m4m5_noshield c_length=4U c_width=4U
* device instance $1253 r0 *1 230.4,160.2 cap_mim_2f0_m4m5_noshield
X$1253 \$81__t87 topn__t177 cap_mim_2f0_m4m5_noshield c_length=4U c_width=4U
* device instance $1254 r0 *1 236.8,160.2 cap_mim_2f0_m4m5_noshield
X$1254 \$84__t16 topn__t178 cap_mim_2f0_m4m5_noshield c_length=4U c_width=4U
* device instance $1255 r0 *1 243.2,160.2 cap_mim_2f0_m4m5_noshield
X$1255 \$81__t88 topn__t179 cap_mim_2f0_m4m5_noshield c_length=4U c_width=4U
* device instance $1256 r0 *1 249.6,160.2 cap_mim_2f0_m4m5_noshield
X$1256 \$84__t17 topn__t180 cap_mim_2f0_m4m5_noshield c_length=4U c_width=4U
* device instance $1257 r0 *1 256,160.2 cap_mim_2f0_m4m5_noshield
X$1257 \$81__t93 topn__t190 cap_mim_2f0_m4m5_noshield c_length=4U c_width=4U
* device instance $1258 r0 *1 262.4,160.2 cap_mim_2f0_m4m5_noshield
X$1258 \$84__t18 topn__t182 cap_mim_2f0_m4m5_noshield c_length=4U c_width=4U
* device instance $1259 r0 *1 268.8,160.2 cap_mim_2f0_m4m5_noshield
X$1259 \$81__t89 topn__t183 cap_mim_2f0_m4m5_noshield c_length=4U c_width=4U
* device instance $1260 r0 *1 275.2,160.2 cap_mim_2f0_m4m5_noshield
X$1260 \$84__t19 topn__t184 cap_mim_2f0_m4m5_noshield c_length=4U c_width=4U
* device instance $1261 r0 *1 281.6,160.2 cap_mim_2f0_m4m5_noshield
X$1261 \$81__t90 topn__t185 cap_mim_2f0_m4m5_noshield c_length=4U c_width=4U
* device instance $1262 r0 *1 288,160.2 cap_mim_2f0_m4m5_noshield
X$1262 \$84__t11 topn__t149 cap_mim_2f0_m4m5_noshield c_length=4U c_width=4U
* device instance $1263 r0 *1 294.4,160.2 cap_mim_2f0_m4m5_noshield
X$1263 \$81__t148 topn__t297 cap_mim_2f0_m4m5_noshield c_length=4U c_width=4U
* device instance $1264 r0 *1 300.8,160.2 cap_mim_2f0_m4m5_noshield
X$1264 \$84__t30 topn__t314 cap_mim_2f0_m4m5_noshield c_length=4U c_width=4U
* device instance $1265 r0 *1 307.2,160.2 cap_mim_2f0_m4m5_noshield
X$1265 \$81__t149 topn__t299 cap_mim_2f0_m4m5_noshield c_length=4U c_width=4U
* device instance $1266 r0 *1 313.6,160.2 cap_mim_2f0_m4m5_noshield
X$1266 \$84__t26 topn__t300 cap_mim_2f0_m4m5_noshield c_length=4U c_width=4U
* device instance $1267 r0 *1 320,160.2 cap_mim_2f0_m4m5_noshield
X$1267 \$81__t150 topn__t301 cap_mim_2f0_m4m5_noshield c_length=4U c_width=4U
* device instance $1268 r0 *1 326.4,160.2 cap_mim_2f0_m4m5_noshield
X$1268 \$84__t27 topn__t302 cap_mim_2f0_m4m5_noshield c_length=4U c_width=4U
* device instance $1269 r0 *1 332.8,160.2 cap_mim_2f0_m4m5_noshield
X$1269 \$81__t151 topn__t303 cap_mim_2f0_m4m5_noshield c_length=4U c_width=4U
* device instance $1270 r0 *1 339.2,160.2 cap_mim_2f0_m4m5_noshield
X$1270 \$84__t28 topn__t304 cap_mim_2f0_m4m5_noshield c_length=4U c_width=4U
* device instance $1271 r0 *1 345.6,160.2 cap_mim_2f0_m4m5_noshield
X$1271 \$81__t152 topn__t305 cap_mim_2f0_m4m5_noshield c_length=4U c_width=4U
* device instance $1272 r0 *1 352,160.2 cap_mim_2f0_m4m5_noshield
X$1272 \$84__t29 topn__t306 cap_mim_2f0_m4m5_noshield c_length=4U c_width=4U
* device instance $1273 r0 *1 358.4,160.2 cap_mim_2f0_m4m5_noshield
X$1273 \$81__t154 topn__t308 cap_mim_2f0_m4m5_noshield c_length=4U c_width=4U
* device instance $1274 r0 *1 364.8,160.2 cap_mim_2f0_m4m5_noshield
X$1274 \$84__t25 topn__t245 cap_mim_2f0_m4m5_noshield c_length=4U c_width=4U
* device instance $1275 r0 *1 371.2,160.2 cap_mim_2f0_m4m5_noshield
X$1275 \$81__t95 topn__t192 cap_mim_2f0_m4m5_noshield c_length=4U c_width=4U
* device instance $1276 r0 *1 377.6,160.2 cap_mim_2f0_m4m5_noshield
X$1276 \$84__t20 topn__t193 cap_mim_2f0_m4m5_noshield c_length=4U c_width=4U
* device instance $1277 r0 *1 384,160.2 cap_mim_2f0_m4m5_noshield
X$1277 \$81__t96 topn__t194 cap_mim_2f0_m4m5_noshield c_length=4U c_width=4U
* device instance $1278 r0 *1 390.4,160.2 cap_mim_2f0_m4m5_noshield
X$1278 \$84__t21 topn__t195 cap_mim_2f0_m4m5_noshield c_length=4U c_width=4U
* device instance $1279 r0 *1 396.8,160.2 cap_mim_2f0_m4m5_noshield
X$1279 \$81__t97 topn__t196 cap_mim_2f0_m4m5_noshield c_length=4U c_width=4U
* device instance $1280 r0 *1 403.2,160.2 cap_mim_2f0_m4m5_noshield
X$1280 \$84__t22 topn__t197 cap_mim_2f0_m4m5_noshield c_length=4U c_width=4U
* device instance $1281 r0 *1 409.6,160.2 cap_mim_2f0_m4m5_noshield
X$1281 \$81__t98 topn__t198 cap_mim_2f0_m4m5_noshield c_length=4U c_width=4U
* device instance $1282 r0 *1 416,160.2 cap_mim_2f0_m4m5_noshield
X$1282 \$84__t23 topn__t199 cap_mim_2f0_m4m5_noshield c_length=4U c_width=4U
* device instance $1283 r0 *1 422.4,160.2 cap_mim_2f0_m4m5_noshield
X$1283 \$81__t99 topn__t200 cap_mim_2f0_m4m5_noshield c_length=4U c_width=4U
* device instance $1284 r0 *1 2.6,166.6 cap_mim_2f0_m4m5_noshield
X$1284 \$40__t2 topp__t106 cap_mim_2f0_m4m5_noshield c_length=4U c_width=4U
* device instance $1285 r0 *1 9,166.6 cap_mim_2f0_m4m5_noshield
X$1285 \$12__t55 topp__t107 cap_mim_2f0_m4m5_noshield c_length=4U c_width=4U
* device instance $1286 r0 *1 15.4,166.6 cap_mim_2f0_m4m5_noshield
X$1286 \$40__t3 topp__t108 cap_mim_2f0_m4m5_noshield c_length=4U c_width=4U
* device instance $1287 r0 *1 21.8,166.6 cap_mim_2f0_m4m5_noshield
X$1287 \$12__t56 topp__t109 cap_mim_2f0_m4m5_noshield c_length=4U c_width=4U
* device instance $1288 r0 *1 28.2,166.6 cap_mim_2f0_m4m5_noshield
X$1288 \$40__t4 topp__t110 cap_mim_2f0_m4m5_noshield c_length=4U c_width=4U
* device instance $1289 r0 *1 34.6,166.6 cap_mim_2f0_m4m5_noshield
X$1289 \$12__t57 topp__t111 cap_mim_2f0_m4m5_noshield c_length=4U c_width=4U
* device instance $1290 r0 *1 41,166.6 cap_mim_2f0_m4m5_noshield
X$1290 \$40__t7 topp__t121 cap_mim_2f0_m4m5_noshield c_length=4U c_width=4U
* device instance $1291 r0 *1 47.4,166.6 cap_mim_2f0_m4m5_noshield
X$1291 \$12__t59 topp__t113 cap_mim_2f0_m4m5_noshield c_length=4U c_width=4U
* device instance $1292 r0 *1 53.8,166.6 cap_mim_2f0_m4m5_noshield
X$1292 \$40__t5 topp__t114 cap_mim_2f0_m4m5_noshield c_length=4U c_width=4U
* device instance $1293 r0 *1 60.2,166.6 cap_mim_2f0_m4m5_noshield
X$1293 \$12__t60 topp__t115 cap_mim_2f0_m4m5_noshield c_length=4U c_width=4U
* device instance $1294 r0 *1 66.6,166.6 cap_mim_2f0_m4m5_noshield
X$1294 \$40__t6 topp__t116 cap_mim_2f0_m4m5_noshield c_length=4U c_width=4U
* device instance $1295 r0 *1 73,166.6 cap_mim_2f0_m4m5_noshield
X$1295 \$12__t50 topp__t96 cap_mim_2f0_m4m5_noshield c_length=4U c_width=4U
* device instance $1296 r0 *1 79.4,166.6 cap_mim_2f0_m4m5_noshield
X$1296 \$40__t1 topp__t85 cap_mim_2f0_m4m5_noshield c_length=4U c_width=4U
* device instance $1297 r0 *1 85.8,166.6 cap_mim_2f0_m4m5_noshield
X$1297 \$12__t58 topp__t112 cap_mim_2f0_m4m5_noshield c_length=4U c_width=4U
* device instance $1298 r0 *1 92.2,166.6 cap_mim_2f0_m4m5_noshield
X$1298 \$40__t8 topp__t122 cap_mim_2f0_m4m5_noshield c_length=4U c_width=4U
* device instance $1299 r0 *1 98.6,166.6 cap_mim_2f0_m4m5_noshield
X$1299 \$12__t62 topp__t123 cap_mim_2f0_m4m5_noshield c_length=4U c_width=4U
* device instance $1300 r0 *1 105,166.6 cap_mim_2f0_m4m5_noshield
X$1300 \$48__t5 topp__t124 cap_mim_2f0_m4m5_noshield c_length=4U c_width=4U
* device instance $1301 r0 *1 111.4,166.6 cap_mim_2f0_m4m5_noshield
X$1301 \$12__t63 topp__t125 cap_mim_2f0_m4m5_noshield c_length=4U c_width=4U
* device instance $1302 r0 *1 117.8,166.6 cap_mim_2f0_m4m5_noshield
X$1302 \$48__t6 topp__t126 cap_mim_2f0_m4m5_noshield c_length=4U c_width=4U
* device instance $1303 r0 *1 124.2,166.6 cap_mim_2f0_m4m5_noshield
X$1303 \$12__t64 topp__t127 cap_mim_2f0_m4m5_noshield c_length=4U c_width=4U
* device instance $1304 r0 *1 130.6,166.6 cap_mim_2f0_m4m5_noshield
X$1304 \$48__t7 topp__t128 cap_mim_2f0_m4m5_noshield c_length=4U c_width=4U
* device instance $1305 r0 *1 137,166.6 cap_mim_2f0_m4m5_noshield
X$1305 \$12__t65 topp__t129 cap_mim_2f0_m4m5_noshield c_length=4U c_width=4U
* device instance $1306 r0 *1 143.4,166.6 cap_mim_2f0_m4m5_noshield
X$1306 \$48__t4 topp__t95 cap_mim_2f0_m4m5_noshield c_length=4U c_width=4U
* device instance $1307 r0 *1 149.8,166.6 cap_mim_2f0_m4m5_noshield
X$1307 \$12__t181 topp__t360 cap_mim_2f0_m4m5_noshield c_length=4U c_width=4U
* device instance $1308 r0 *1 156.2,166.6 cap_mim_2f0_m4m5_noshield
X$1308 \$56__t3 topp__t361 cap_mim_2f0_m4m5_noshield c_length=4U c_width=4U
* device instance $1309 r0 *1 162.6,166.6 cap_mim_2f0_m4m5_noshield
X$1309 \$12__t182 topp__t362 cap_mim_2f0_m4m5_noshield c_length=4U c_width=4U
* device instance $1310 r0 *1 169,166.6 cap_mim_2f0_m4m5_noshield
X$1310 \$56__t2 topp__t345 cap_mim_2f0_m4m5_noshield c_length=4U c_width=4U
* device instance $1311 r0 *1 175.4,166.6 cap_mim_2f0_m4m5_noshield
X$1311 \$12__t158 topp__t316 cap_mim_2f0_m4m5_noshield c_length=4U c_width=4U
* device instance $1312 r0 *1 181.8,166.6 cap_mim_2f0_m4m5_noshield
X$1312 \$64__t1 topp__t317 cap_mim_2f0_m4m5_noshield c_length=4U c_width=4U
* device instance $1313 r0 *1 188.2,166.6 cap_mim_2f0_m4m5_noshield
X$1313 \$12__t159 topp__t318 cap_mim_2f0_m4m5_noshield c_length=4U c_width=4U
* device instance $1314 r0 *1 194.6,166.6 cap_mim_2f0_m4m5_noshield
X$1314 \$72__t0 topp__t319 cap_mim_2f0_m4m5_noshield c_length=4U c_width=4U
* device instance $1315 r0 *1 201,166.6 cap_mim_2f0_m4m5_noshield
X$1315 \$12__t160 topp__t320 cap_mim_2f0_m4m5_noshield c_length=4U c_width=4U
* device instance $1316 r0 *1 224,166.6 cap_mim_2f0_m4m5_noshield
X$1316 \$85__t17 topn__t186 cap_mim_2f0_m4m5_noshield c_length=4U c_width=4U
* device instance $1317 r0 *1 230.4,166.6 cap_mim_2f0_m4m5_noshield
X$1317 \$81__t91 topn__t187 cap_mim_2f0_m4m5_noshield c_length=4U c_width=4U
* device instance $1318 r0 *1 236.8,166.6 cap_mim_2f0_m4m5_noshield
X$1318 \$85__t18 topn__t188 cap_mim_2f0_m4m5_noshield c_length=4U c_width=4U
* device instance $1319 r0 *1 243.2,166.6 cap_mim_2f0_m4m5_noshield
X$1319 \$81__t92 topn__t189 cap_mim_2f0_m4m5_noshield c_length=4U c_width=4U
* device instance $1320 r0 *1 249.6,166.6 cap_mim_2f0_m4m5_noshield
X$1320 \$85__t16 topn__t181 cap_mim_2f0_m4m5_noshield c_length=4U c_width=4U
* device instance $1321 r0 *1 256,166.6 cap_mim_2f0_m4m5_noshield
X$1321 \$81__t82 topn__t165 cap_mim_2f0_m4m5_noshield c_length=4U c_width=4U
* device instance $1322 r0 *1 262.4,166.6 cap_mim_2f0_m4m5_noshield
X$1322 \$85__t13 topn__t166 cap_mim_2f0_m4m5_noshield c_length=4U c_width=4U
* device instance $1323 r0 *1 268.8,166.6 cap_mim_2f0_m4m5_noshield
X$1323 \$81__t83 topn__t167 cap_mim_2f0_m4m5_noshield c_length=4U c_width=4U
* device instance $1324 r0 *1 275.2,166.6 cap_mim_2f0_m4m5_noshield
X$1324 \$85__t14 topn__t168 cap_mim_2f0_m4m5_noshield c_length=4U c_width=4U
* device instance $1325 r0 *1 281.6,166.6 cap_mim_2f0_m4m5_noshield
X$1325 \$81__t84 topn__t169 cap_mim_2f0_m4m5_noshield c_length=4U c_width=4U
* device instance $1326 r0 *1 288,166.6 cap_mim_2f0_m4m5_noshield
X$1326 \$85__t15 topn__t170 cap_mim_2f0_m4m5_noshield c_length=4U c_width=4U
* device instance $1327 r0 *1 294.4,166.6 cap_mim_2f0_m4m5_noshield
X$1327 \$81__t143 topn__t287 cap_mim_2f0_m4m5_noshield c_length=4U c_width=4U
* device instance $1328 r0 *1 300.8,166.6 cap_mim_2f0_m4m5_noshield
X$1328 \$85__t19 topn__t288 cap_mim_2f0_m4m5_noshield c_length=4U c_width=4U
* device instance $1329 r0 *1 307.2,166.6 cap_mim_2f0_m4m5_noshield
X$1329 \$81__t144 topn__t289 cap_mim_2f0_m4m5_noshield c_length=4U c_width=4U
* device instance $1330 r0 *1 313.6,166.6 cap_mim_2f0_m4m5_noshield
X$1330 \$85__t20 topn__t290 cap_mim_2f0_m4m5_noshield c_length=4U c_width=4U
* device instance $1331 r0 *1 320,166.6 cap_mim_2f0_m4m5_noshield
X$1331 \$81__t145 topn__t291 cap_mim_2f0_m4m5_noshield c_length=4U c_width=4U
* device instance $1332 r0 *1 326.4,166.6 cap_mim_2f0_m4m5_noshield
X$1332 \$86__t7 topn__t292 cap_mim_2f0_m4m5_noshield c_length=4U c_width=4U
* device instance $1333 r0 *1 332.8,166.6 cap_mim_2f0_m4m5_noshield
X$1333 \$81__t146 topn__t293 cap_mim_2f0_m4m5_noshield c_length=4U c_width=4U
* device instance $1334 r0 *1 339.2,166.6 cap_mim_2f0_m4m5_noshield
X$1334 \$86__t8 topn__t294 cap_mim_2f0_m4m5_noshield c_length=4U c_width=4U
* device instance $1335 r0 *1 345.6,166.6 cap_mim_2f0_m4m5_noshield
X$1335 \$81__t147 topn__t295 cap_mim_2f0_m4m5_noshield c_length=4U c_width=4U
* device instance $1336 r0 *1 352,166.6 cap_mim_2f0_m4m5_noshield
X$1336 \$86__t9 topn__t296 cap_mim_2f0_m4m5_noshield c_length=4U c_width=4U
* device instance $1337 r0 *1 358.4,166.6 cap_mim_2f0_m4m5_noshield
X$1337 \$81__t155 topn__t309 cap_mim_2f0_m4m5_noshield c_length=4U c_width=4U
* device instance $1338 r0 *1 364.8,166.6 cap_mim_2f0_m4m5_noshield
X$1338 \$86__t6 topn__t246 cap_mim_2f0_m4m5_noshield c_length=4U c_width=4U
* device instance $1339 r0 *1 371.2,166.6 cap_mim_2f0_m4m5_noshield
X$1339 \$81__t101 topn__t203 cap_mim_2f0_m4m5_noshield c_length=4U c_width=4U
* device instance $1340 r0 *1 377.6,166.6 cap_mim_2f0_m4m5_noshield
X$1340 \$87__t0 topn__t204 cap_mim_2f0_m4m5_noshield c_length=4U c_width=4U
* device instance $1341 r0 *1 384,166.6 cap_mim_2f0_m4m5_noshield
X$1341 \$81__t110 topn__t221 cap_mim_2f0_m4m5_noshield c_length=4U c_width=4U
* device instance $1342 r0 *1 390.4,166.6 cap_mim_2f0_m4m5_noshield
X$1342 \$87__t1 topn__t206 cap_mim_2f0_m4m5_noshield c_length=4U c_width=4U
* device instance $1343 r0 *1 396.8,166.6 cap_mim_2f0_m4m5_noshield
X$1343 \$81__t103 topn__t207 cap_mim_2f0_m4m5_noshield c_length=4U c_width=4U
* device instance $1344 r0 *1 403.2,166.6 cap_mim_2f0_m4m5_noshield
X$1344 \$88__t0 topn__t208 cap_mim_2f0_m4m5_noshield c_length=4U c_width=4U
* device instance $1345 r0 *1 409.6,166.6 cap_mim_2f0_m4m5_noshield
X$1345 \$81__t104 topn__t209 cap_mim_2f0_m4m5_noshield c_length=4U c_width=4U
* device instance $1346 r0 *1 416,166.6 cap_mim_2f0_m4m5_noshield
X$1346 \$89__t0 topn__t210 cap_mim_2f0_m4m5_noshield c_length=4U c_width=4U
* device instance $1347 r0 *1 422.4,166.6 cap_mim_2f0_m4m5_noshield
X$1347 \$81__t105 topn__t211 cap_mim_2f0_m4m5_noshield c_length=4U c_width=4U
* device instance $1348 r0 *1 575.65,82.885 ppolyf_u_1k
X$1348 vdd__t7 XCMP_pop__t0 vss__t119 ppolyf_u_1k r_length=150U r_width=1U
* device instance $1349 r0 *1 581.85,82.885 ppolyf_u_1k
X$1349 vdd__t8 XCMP_pon__t2 vss__t120 ppolyf_u_1k r_length=150U r_width=1U
* device instance _100_t0 r0 *1 0,0
R_100_t0 \$100__t0 \$100 135.591504929
* device instance _100_t1 r0 *1 0,0
R_100_t1 \$100__t1 \$100 36.2048686624
* device instance _100_t2 r0 *1 0,0
R_100_t2 \$100__t2 \$100 166.824926409
* device instance _100 r0 *1 0,0
C_100 \$100 vsubs 7.017453e-15
* device instance _102_t0 r0 *1 0,0
R_102_t0 \$102__t0 \$102 162.444438203
* device instance _102_t1 r0 *1 0,0
R_102_t1 \$102__t1 \$102 43.7126105743
* device instance _102_t2 r0 *1 0,0
R_102_t2 \$102__t2 \$102 200.179851222
* device instance _102 r0 *1 0,0
C_102 \$102 vsubs 7.547896e-15
* device instance _104_t0 r0 *1 0,0
R_104_t0 \$104__t0 \$104 135.591504929
* device instance _104_t1 r0 *1 0,0
R_104_t1 \$104__t1 \$104 36.2048686624
* device instance _104_t2 r0 *1 0,0
R_104_t2 \$104__t2 \$104 166.824926409
* device instance _104 r0 *1 0,0
C_104 \$104 vsubs 7.017453e-15
* device instance _106_t0 r0 *1 0,0
R_106_t0 \$106__t0 \$106 162.444438203
* device instance _106_t1 r0 *1 0,0
R_106_t1 \$106__t1 \$106 43.7126105743
* device instance _106_t2 r0 *1 0,0
R_106_t2 \$106__t2 \$106 200.179851222
* device instance _106 r0 *1 0,0
C_106 \$106 vsubs 7.547896e-15
* device instance _108_t0 r0 *1 0,0
R_108_t0 \$108__t0 \$108 135.591504929
* device instance _108_t1 r0 *1 0,0
R_108_t1 \$108__t1 \$108 36.2048686624
* device instance _108_t2 r0 *1 0,0
R_108_t2 \$108__t2 \$108 166.824926409
* device instance _108 r0 *1 0,0
C_108 \$108 vsubs 7.006437e-15
* device instance _11_t0 r0 *1 0,0
R_11_t0 \$11__t0 \$11 162.444438203
* device instance _11_t1 r0 *1 0,0
R_11_t1 \$11__t1 \$11 43.7126105743
* device instance _11_t2 r0 *1 0,0
R_11_t2 \$11__t2 \$11 200.179851222
* device instance _11 r0 *1 0,0
C_11 \$11 vsubs 7.553404e-15
* device instance _110_t0 r0 *1 0,0
R_110_t0 \$110__t0 \$110 162.444438203
* device instance _110_t1 r0 *1 0,0
R_110_t1 \$110__t1 \$110 43.7126105743
* device instance _110_t2 r0 *1 0,0
R_110_t2 \$110__t2 \$110 200.179851222
* device instance _110 r0 *1 0,0
C_110 \$110 vsubs 7.53688e-15
* device instance _112_t0 r0 *1 0,0
R_112_t0 \$112__t0 \$112 135.591504929
* device instance _112_t1 r0 *1 0,0
R_112_t1 \$112__t1 \$112 36.2048686624
* device instance _112_t2 r0 *1 0,0
R_112_t2 \$112__t2 \$112 166.824926409
* device instance _112 r0 *1 0,0
C_112 \$112 vsubs 7.017453e-15
* device instance _114_t0 r0 *1 0,0
R_114_t0 \$114__t0 \$114 162.444438203
* device instance _114_t1 r0 *1 0,0
R_114_t1 \$114__t1 \$114 43.7126105743
* device instance _114_t2 r0 *1 0,0
R_114_t2 \$114__t2 \$114 200.179851222
* device instance _114 r0 *1 0,0
C_114 \$114 vsubs 7.547896e-15
* device instance _116_t0 r0 *1 0,0
R_116_t0 \$116__t0 \$116 135.591504929
* device instance _116_t1 r0 *1 0,0
R_116_t1 \$116__t1 \$116 36.2048686624
* device instance _116_t2 r0 *1 0,0
R_116_t2 \$116__t2 \$116 166.824926409
* device instance _116 r0 *1 0,0
C_116 \$116 vsubs 7.017453e-15
* device instance _118_t0 r0 *1 0,0
R_118_t0 \$118__t0 \$118 162.444438203
* device instance _118_t1 r0 *1 0,0
R_118_t1 \$118__t1 \$118 43.7126105743
* device instance _118_t2 r0 *1 0,0
R_118_t2 \$118__t2 \$118 200.179851222
* device instance _118 r0 *1 0,0
C_118 \$118 vsubs 7.547896e-15
* device instance _12_t0 r0 *1 0,0
R_12_t0 \$12__t0 \$12 19.6806022307
* device instance _12_t1 r0 *1 0,0
R_12_t1 \$12__t1 \$12 17.174848773
* device instance _12_t2 r0 *1 0,0
R_12_t2 \$12__t2 \$12 14.3358568146
* device instance _12_t3 r0 *1 0,0
R_12_t3 \$12__t3 \$12 6.98328450259
* device instance _12_t4 r0 *1 0,0
R_12_t4 \$12__t4 \$12 5.37363550905
* device instance _12_t5 r0 *1 0,0
R_12_t5 \$12__t5 \$12 13.8900074897
* device instance _12_t6 r0 *1 0,0
R_12_t6 \$12__t6 \$12 14.0935194732
* device instance _12_t7 r0 *1 0,0
R_12_t7 \$12__t7 \$12 12.3650740074
* device instance _12_t8 r0 *1 0,0
R_12_t8 \$12__t8 \$12 10.659423169
* device instance _12_t9 r0 *1 0,0
R_12_t9 \$12__t9 \$12 8.9895512902
* device instance _12_t10 r0 *1 0,0
R_12_t10 \$12__t10 \$12 7.37978627883
* device instance _12_t11 r0 *1 0,0
R_12_t11 \$12__t11 \$12 5.87970591622
* device instance _12_t12 r0 *1 0,0
R_12_t12 \$12__t12 \$12 12.1326036831
* device instance _12_t13 r0 *1 0,0
R_12_t13 \$12__t13 \$12 14.2031435449
* device instance _12_t14 r0 *1 0,0
R_12_t14 \$12__t14 \$12 12.6185297136
* device instance _12_t15 r0 *1 0,0
R_12_t15 \$12__t15 \$12 11.0989089882
* device instance _12_t16 r0 *1 0,0
R_12_t16 \$12__t16 \$12 9.67495490125
* device instance _12_t17 r0 *1 0,0
R_12_t17 \$12__t17 \$12 13.8271089247
* device instance _12_t18 r0 *1 0,0
R_12_t18 \$12__t18 \$12 10.3888555297
* device instance _12_t19 r0 *1 0,0
R_12_t19 \$12__t19 \$12 8.66700924899
* device instance _12_t20 r0 *1 0,0
R_12_t20 \$12__t20 \$12 8.39548729808
* device instance _12_t21 r0 *1 0,0
R_12_t21 \$12__t21 \$12 3.76454286673
* device instance _12_t22 r0 *1 0,0
R_12_t22 \$12__t22 \$12 6.72341273483
* device instance _12_t23 r0 *1 0,0
R_12_t23 \$12__t23 \$12 7.13437186302
* device instance _12_t24 r0 *1 0,0
R_12_t24 \$12__t24 \$12 3.93015747041
* device instance _12_t25 r0 *1 0,0
R_12_t25 \$12__t25 \$12 3.83728589275
* device instance _12_t26 r0 *1 0,0
R_12_t26 \$12__t26 \$12 4.13586553434
* device instance _12_t27 r0 *1 0,0
R_12_t27 \$12__t27 \$12 3.73620972133
* device instance _12_t28 r0 *1 0,0
R_12_t28 \$12__t28 \$12 2.98354384107
* device instance _12_t29 r0 *1 0,0
R_12_t29 \$12__t29 \$12 4.59359610415
* device instance _12_t30 r0 *1 0,0
R_12_t30 \$12__t30 \$12 1.39003454191
* device instance _12_t31 r0 *1 0,0
R_12_t31 \$12__t31 \$12 2.82275487998
* device instance _12_t32 r0 *1 0,0
R_12_t32 \$12__t32 \$12 3.73089444029
* device instance _12_t33 r0 *1 0,0
R_12_t33 \$12__t33 \$12 2.91149444759
* device instance _12_t34 r0 *1 0,0
R_12_t34 \$12__t34 \$12 4.59794745722
* device instance _12_t35 r0 *1 0,0
R_12_t35 \$12__t35 \$12 5.65921086652
* device instance _12_t36 r0 *1 0,0
R_12_t36 \$12__t36 \$12 5.13144078741
* device instance _12_t37 r0 *1 0,0
R_12_t37 \$12__t37 \$12 4.4288323971
* device instance _12_t38 r0 *1 0,0
R_12_t38 \$12__t38 \$12 3.69633983686
* device instance _12_t39 r0 *1 0,0
R_12_t39 \$12__t39 \$12 6.42249017571
* device instance _12_t40 r0 *1 0,0
R_12_t40 \$12__t40 \$12 7.54259456661
* device instance _12_t41 r0 *1 0,0
R_12_t41 \$12__t41 \$12 5.75188838103
* device instance _12_t42 r0 *1 0,0
R_12_t42 \$12__t42 \$12 6.31549435701
* device instance _12_t43 r0 *1 0,0
R_12_t43 \$12__t43 \$12 6.52739271659
* device instance _12_t44 r0 *1 0,0
R_12_t44 \$12__t44 \$12 7.19643838282
* device instance _12_t45 r0 *1 0,0
R_12_t45 \$12__t45 \$12 6.60488949857
* device instance _12_t46 r0 *1 0,0
R_12_t46 \$12__t46 \$12 7.14273316354
* device instance _12_t47 r0 *1 0,0
R_12_t47 \$12__t47 \$12 5.86161877766
* device instance _12_t48 r0 *1 0,0
R_12_t48 \$12__t48 \$12 4.91518009453
* device instance _12_t49 r0 *1 0,0
R_12_t49 \$12__t49 \$12 4.51883824083
* device instance _12_t50 r0 *1 0,0
R_12_t50 \$12__t50 \$12 8.12278343404
* device instance _12_t51 r0 *1 0,0
R_12_t51 \$12__t51 \$12 5.68534567736
* device instance _12_t52 r0 *1 0,0
R_12_t52 \$12__t52 \$12 6.92571355242
* device instance _12_t53 r0 *1 0,0
R_12_t53 \$12__t53 \$12 4.81053902904
* device instance _12_t54 r0 *1 0,0
R_12_t54 \$12__t54 \$12 9.11396768705
* device instance _12_t55 r0 *1 0,0
R_12_t55 \$12__t55 \$12 14.6247992346
* device instance _12_t56 r0 *1 0,0
R_12_t56 \$12__t56 \$12 13.0913237768
* device instance _12_t57 r0 *1 0,0
R_12_t57 \$12__t57 \$12 11.6336256955
* device instance _12_t58 r0 *1 0,0
R_12_t58 \$12__t58 \$12 7.46860304096
* device instance _12_t59 r0 *1 0,0
R_12_t59 \$12__t59 \$12 10.283978726
* device instance _12_t60 r0 *1 0,0
R_12_t60 \$12__t60 \$12 9.09063656007
* device instance _12_t61 r0 *1 0,0
R_12_t61 \$12__t61 \$12 7.7423421283
* device instance _12_t62 r0 *1 0,0
R_12_t62 \$12__t62 \$12 7.21394032887
* device instance _12_t63 r0 *1 0,0
R_12_t63 \$12__t63 \$12 7.4001568748
* device instance _12_t64 r0 *1 0,0
R_12_t64 \$12__t64 \$12 7.99651120757
* device instance _12_t65 r0 *1 0,0
R_12_t65 \$12__t65 \$12 8.92112908952
* device instance _12_t66 r0 *1 0,0
R_12_t66 \$12__t66 \$12 5.4171139579
* device instance _12_t67 r0 *1 0,0
R_12_t67 \$12__t67 \$12 5.6627299367
* device instance _12_t68 r0 *1 0,0
R_12_t68 \$12__t68 \$12 12.1937257142
* device instance _12_t69 r0 *1 0,0
R_12_t69 \$12__t69 \$12 10.6134553934
* device instance _12_t70 r0 *1 0,0
R_12_t70 \$12__t70 \$12 8.21164284031
* device instance _12_t71 r0 *1 0,0
R_12_t71 \$12__t71 \$12 9.29876442464
* device instance _12_t72 r0 *1 0,0
R_12_t72 \$12__t72 \$12 7.54228025454
* device instance _12_t73 r0 *1 0,0
R_12_t73 \$12__t73 \$12 10.6436280847
* device instance _12_t74 r0 *1 0,0
R_12_t74 \$12__t74 \$12 5.8108042532
* device instance _12_t75 r0 *1 0,0
R_12_t75 \$12__t75 \$12 1.19303865059
* device instance _12_t76 r0 *1 0,0
R_12_t76 \$12__t76 \$12 5.8913545712
* device instance _12_t77 r0 *1 0,0
R_12_t77 \$12__t77 \$12 3.88200521568
* device instance _12_t78 r0 *1 0,0
R_12_t78 \$12__t78 \$12 5.54186947101
* device instance _12_t79 r0 *1 0,0
R_12_t79 \$12__t79 \$12 3.30174890553
* device instance _12_t80 r0 *1 0,0
R_12_t80 \$12__t80 \$12 11.2474118214
* device instance _12_t81 r0 *1 0,0
R_12_t81 \$12__t81 \$12 9.5111913699
* device instance _12_t82 r0 *1 0,0
R_12_t82 \$12__t82 \$12 12.3514603071
* device instance _12_t83 r0 *1 0,0
R_12_t83 \$12__t83 \$12 6.14501322366
* device instance _12_t84 r0 *1 0,0
R_12_t84 \$12__t84 \$12 12.8456422826
* device instance _12_t85 r0 *1 0,0
R_12_t85 \$12__t85 \$12 11.0683572056
* device instance _12_t86 r0 *1 0,0
R_12_t86 \$12__t86 \$12 7.80267472652
* device instance _12_t87 r0 *1 0,0
R_12_t87 \$12__t87 \$12 14.0815768879
* device instance _12_t88 r0 *1 0,0
R_12_t88 \$12__t88 \$12 5.62940353335
* device instance _12_t89 r0 *1 0,0
R_12_t89 \$12__t89 \$12 7.11075090194
* device instance _12_t90 r0 *1 0,0
R_12_t90 \$12__t90 \$12 1.77952467539
* device instance _12_t91 r0 *1 0,0
R_12_t91 \$12__t91 \$12 2.42653967069
* device instance _12_t92 r0 *1 0,0
R_12_t92 \$12__t92 \$12 2.67627530726
* device instance _12_t93 r0 *1 0,0
R_12_t93 \$12__t93 \$12 2.6278897209
* device instance _12_t94 r0 *1 0,0
R_12_t94 \$12__t94 \$12 4.3906802333
* device instance _12_t95 r0 *1 0,0
R_12_t95 \$12__t95 \$12 4.3664294274
* device instance _12_t96 r0 *1 0,0
R_12_t96 \$12__t96 \$12 4.56121007286
* device instance _12_t97 r0 *1 0,0
R_12_t97 \$12__t97 \$12 3.71958324344
* device instance _12_t98 r0 *1 0,0
R_12_t98 \$12__t98 \$12 3.65054032973
* device instance _12_t99 r0 *1 0,0
R_12_t99 \$12__t99 \$12 3.1438569025
* device instance _12_t100 r0 *1 0,0
R_12_t100 \$12__t100 \$12 0.143483218318
* device instance _12_t101 r0 *1 0,0
R_12_t101 \$12__t101 \$12 1.65589073826
* device instance _12_t102 r0 *1 0,0
R_12_t102 \$12__t102 \$12 3.45309192727
* device instance _12_t103 r0 *1 0,0
R_12_t103 \$12__t103 \$12 6.21769048057
* device instance _12_t104 r0 *1 0,0
R_12_t104 \$12__t104 \$12 10.9253105491
* device instance _12_t105 r0 *1 0,0
R_12_t105 \$12__t105 \$12 9.12802822019
* device instance _12_t106 r0 *1 0,0
R_12_t106 \$12__t106 \$12 7.33074831116
* device instance _12_t107 r0 *1 0,0
R_12_t107 \$12__t107 \$12 5.25035204508
* device instance _12_t108 r0 *1 0,0
R_12_t108 \$12__t108 \$12 2.12724791451
* device instance _12_t109 r0 *1 0,0
R_12_t109 \$12__t109 \$12 0.886615686121
* device instance _12_t110 r0 *1 0,0
R_12_t110 \$12__t110 \$12 1.93899039421
* device instance _12_t111 r0 *1 0,0
R_12_t111 \$12__t111 \$12 3.56221052145
* device instance _12_t112 r0 *1 0,0
R_12_t112 \$12__t112 \$12 5.32275272188
* device instance _12_t113 r0 *1 0,0
R_12_t113 \$12__t113 \$12 2.71568949512
* device instance _12_t114 r0 *1 0,0
R_12_t114 \$12__t114 \$12 4.44826715295
* device instance _12_t115 r0 *1 0,0
R_12_t115 \$12__t115 \$12 1.87282515948
* device instance _12_t116 r0 *1 0,0
R_12_t116 \$12__t116 \$12 6.497819523
* device instance _12_t117 r0 *1 0,0
R_12_t117 \$12__t117 \$12 4.72560627788
* device instance _12_t118 r0 *1 0,0
R_12_t118 \$12__t118 \$12 13.6523882223
* device instance _12_t119 r0 *1 0,0
R_12_t119 \$12__t119 \$12 12.7225942723
* device instance _12_t120 r0 *1 0,0
R_12_t120 \$12__t120 \$12 11.8598258099
* device instance _12_t121 r0 *1 0,0
R_12_t121 \$12__t121 \$12 8.97081651293
* device instance _12_t122 r0 *1 0,0
R_12_t122 \$12__t122 \$12 7.35695331171
* device instance _12_t123 r0 *1 0,0
R_12_t123 \$12__t123 \$12 5.85102197661
* device instance _12_t124 r0 *1 0,0
R_12_t124 \$12__t124 \$12 13.0002410402
* device instance _12_t125 r0 *1 0,0
R_12_t125 \$12__t125 \$12 7.38277527374
* device instance _12_t126 r0 *1 0,0
R_12_t126 \$12__t126 \$12 12.7526430577
* device instance _12_t127 r0 *1 0,0
R_12_t127 \$12__t127 \$12 10.9602878856
* device instance _12_t128 r0 *1 0,0
R_12_t128 \$12__t128 \$12 8.28084811063
* device instance _12_t129 r0 *1 0,0
R_12_t129 \$12__t129 \$12 9.16986363745
* device instance _12_t130 r0 *1 0,0
R_12_t130 \$12__t130 \$12 5.5334731799
* device instance _12_t131 r0 *1 0,0
R_12_t131 \$12__t131 \$12 5.60221611272
* device instance _12_t132 r0 *1 0,0
R_12_t132 \$12__t132 \$12 10.0689480745
* device instance _12_t133 r0 *1 0,0
R_12_t133 \$12__t133 \$12 8.61041128022
* device instance _12_t134 r0 *1 0,0
R_12_t134 \$12__t134 \$12 4.71718371829
* device instance _12_t135 r0 *1 0,0
R_12_t135 \$12__t135 \$12 6.41283217309
* device instance _12_t136 r0 *1 0,0
R_12_t136 \$12__t136 \$12 8.15214657292
* device instance _12_t137 r0 *1 0,0
R_12_t137 \$12__t137 \$12 13.7423595405
* device instance _12_t138 r0 *1 0,0
R_12_t138 \$12__t138 \$12 11.6835395892
* device instance _12_t139 r0 *1 0,0
R_12_t139 \$12__t139 \$12 13.4617838214
* device instance _12_t140 r0 *1 0,0
R_12_t140 \$12__t140 \$12 9.91216696947
* device instance _12_t141 r0 *1 0,0
R_12_t141 \$12__t141 \$12 11.9632859119
* device instance _12_t142 r0 *1 0,0
R_12_t142 \$12__t142 \$12 10.1906063066
* device instance _12_t143 r0 *1 0,0
R_12_t143 \$12__t143 \$12 8.42835612676
* device instance _12_t144 r0 *1 0,0
R_12_t144 \$12__t144 \$12 6.68478871181
* device instance _12_t145 r0 *1 0,0
R_12_t145 \$12__t145 \$12 3.13683136333
* device instance _12_t146 r0 *1 0,0
R_12_t146 \$12__t146 \$12 4.979567879
* device instance _12_t147 r0 *1 0,0
R_12_t147 \$12__t147 \$12 3.37139072486
* device instance _12_t148 r0 *1 0,0
R_12_t148 \$12__t148 \$12 2.09688759731
* device instance _12_t149 r0 *1 0,0
R_12_t149 \$12__t149 \$12 1.97182220037
* device instance _12_t150 r0 *1 0,0
R_12_t150 \$12__t150 \$12 10.115874473
* device instance _12_t151 r0 *1 0,0
R_12_t151 \$12__t151 \$12 12.0946245387
* device instance _12_t152 r0 *1 0,0
R_12_t152 \$12__t152 \$12 13.820074857
* device instance _12_t153 r0 *1 0,0
R_12_t153 \$12__t153 \$12 8.39865203881
* device instance _12_t154 r0 *1 0,0
R_12_t154 \$12__t154 \$12 8.73111328217
* device instance _12_t155 r0 *1 0,0
R_12_t155 \$12__t155 \$12 11.8568528563
* device instance _12_t156 r0 *1 0,0
R_12_t156 \$12__t156 \$12 10.3935508576
* device instance _12_t157 r0 *1 0,0
R_12_t157 \$12__t157 \$12 13.6124753802
* device instance _12_t158 r0 *1 0,0
R_12_t158 \$12__t158 \$12 12.8559908431
* device instance _12_t159 r0 *1 0,0
R_12_t159 \$12__t159 \$12 14.3791788837
* device instance _12_t160 r0 *1 0,0
R_12_t160 \$12__t160 \$12 15.9594972727
* device instance _12_t161 r0 *1 0,0
R_12_t161 \$12__t161 \$12 10.867255066
* device instance _12_t162 r0 *1 0,0
R_12_t162 \$12__t162 \$12 11.9407156034
* device instance _12_t163 r0 *1 0,0
R_12_t163 \$12__t163 \$12 12.3742084378
* device instance _12_t164 r0 *1 0,0
R_12_t164 \$12__t164 \$12 13.9501010489
* device instance _12_t165 r0 *1 0,0
R_12_t165 \$12__t165 \$12 15.5740196193
* device instance _12_t166 r0 *1 0,0
R_12_t166 \$12__t166 \$12 10.3709636644
* device instance _12_t167 r0 *1 0,0
R_12_t167 \$12__t167 \$12 6.57904242886
* device instance _12_t168 r0 *1 0,0
R_12_t168 \$12__t168 \$12 13.5005080138
* device instance _12_t169 r0 *1 0,0
R_12_t169 \$12__t169 \$12 11.8220862036
* device instance _12_t170 r0 *1 0,0
R_12_t170 \$12__t170 \$12 10.1843119945
* device instance _12_t171 r0 *1 0,0
R_12_t171 \$12__t171 \$12 7.33649402789
* device instance _12_t172 r0 *1 0,0
R_12_t172 \$12__t172 \$12 8.37068360215
* device instance _12_t173 r0 *1 0,0
R_12_t173 \$12__t173 \$12 9.93134747869
* device instance _12_t174 r0 *1 0,0
R_12_t174 \$12__t174 \$12 11.5609456592
* device instance _12_t175 r0 *1 0,0
R_12_t175 \$12__t175 \$12 13.2340375301
* device instance _12_t176 r0 *1 0,0
R_12_t176 \$12__t176 \$12 14.9360140994
* device instance _12_t177 r0 *1 0,0
R_12_t177 \$12__t177 \$12 13.5670547258
* device instance _12_t178 r0 *1 0,0
R_12_t178 \$12__t178 \$12 15.2318659974
* device instance _12_t179 r0 *1 0,0
R_12_t179 \$12__t179 \$12 8.88783261281
* device instance _12_t180 r0 *1 0,0
R_12_t180 \$12__t180 \$12 9.46223619944
* device instance _12_t181 r0 *1 0,0
R_12_t181 \$12__t181 \$12 10.0841152309
* device instance _12_t182 r0 *1 0,0
R_12_t182 \$12__t182 \$12 11.4128304449
* device instance _12_t183 r0 *1 0,0
R_12_t183 \$12__t183 \$12 12.6405915478
* device instance _12_t184 r0 *1 0,0
R_12_t184 \$12__t184 \$12 10.9778322889
* device instance _12_t185 r0 *1 0,0
R_12_t185 \$12__t185 \$12 9.36490960274
* device instance _12_t186 r0 *1 0,0
R_12_t186 \$12__t186 \$12 7.83267163806
* device instance _12_t187 r0 *1 0,0
R_12_t187 \$12__t187 \$12 6.43897826753
* device instance _12_t188 r0 *1 0,0
R_12_t188 \$12__t188 \$12 5.29439517676
* device instance _12_t189 r0 *1 0,0
R_12_t189 \$12__t189 \$12 14.0671236762
* device instance _12_t190 r0 *1 0,0
R_12_t190 \$12__t190 \$12 4.53347853838
* device instance _12_t191 r0 *1 0,0
R_12_t191 \$12__t191 \$12 5.14820899635
* device instance _12_t192 r0 *1 0,0
R_12_t192 \$12__t192 \$12 6.23828238381
* device instance _12_t193 r0 *1 0,0
R_12_t193 \$12__t193 \$12 7.60189195848
* device instance _12_t194 r0 *1 0,0
R_12_t194 \$12__t194 \$12 9.11711788969
* device instance _12_t195 r0 *1 0,0
R_12_t195 \$12__t195 \$12 10.7198600223
* device instance _12_t196 r0 *1 0,0
R_12_t196 \$12__t196 \$12 12.3761642766
* device instance _12_t197 r0 *1 0,0
R_12_t197 \$12__t197 \$12 4.58925728891
* device instance _12_t198 r0 *1 0,0
R_12_t198 \$12__t198 \$12 12.4702019901
* device instance _12_t199 r0 *1 0,0
R_12_t199 \$12__t199 \$12 14.2636147419
* device instance _12_t200 r0 *1 0,0
R_12_t200 \$12__t200 \$12 7.1017274163
* device instance _12_t201 r0 *1 0,0
R_12_t201 \$12__t201 \$12 7.04762600841
* device instance _12_t202 r0 *1 0,0
R_12_t202 \$12__t202 \$12 8.84490537709
* device instance _12_t203 r0 *1 0,0
R_12_t203 \$12__t203 \$12 10.6421874125
* device instance _12_t204 r0 *1 0,0
R_12_t204 \$12__t204 \$12 12.4394709588
* device instance _12_t205 r0 *1 0,0
R_12_t205 \$12__t205 \$12 10.6780921921
* device instance _12_t206 r0 *1 0,0
R_12_t206 \$12__t206 \$12 14.2367554437
* device instance _12_t207 r0 *1 0,0
R_12_t207 \$12__t207 \$12 7.99954699832
* device instance _12_t208 r0 *1 0,0
R_12_t208 \$12__t208 \$12 9.78704819966
* device instance _12_t209 r0 *1 0,0
R_12_t209 \$12__t209 \$12 11.5775798751
* device instance _12_t210 r0 *1 0,0
R_12_t210 \$12__t210 \$12 13.3699245355
* device instance _12_t211 r0 *1 0,0
R_12_t211 \$12__t211 \$12 7.2674034559
* device instance _12_t212 r0 *1 0,0
R_12_t212 \$12__t212 \$12 9.02100170524
* device instance _12_t213 r0 *1 0,0
R_12_t213 \$12__t213 \$12 8.71182275161
* device instance _12_t214 r0 *1 0,0
R_12_t214 \$12__t214 \$12 14.4854087843
* device instance _12_t215 r0 *1 0,0
R_12_t215 \$12__t215 \$12 12.7232975215
* device instance _12_t216 r0 *1 0,0
R_12_t216 \$12__t216 \$12 13.8078957688
* device instance _12_t217 r0 *1 0,0
R_12_t217 \$12__t217 \$12 10.3773511042
* device instance _12_t218 r0 *1 0,0
R_12_t218 \$12__t218 \$12 7.53730020901
* device instance _12_t219 r0 *1 0,0
R_12_t219 \$12__t219 \$12 10.9726029277
* device instance _12_t220 r0 *1 0,0
R_12_t220 \$12__t220 \$12 14.3468228608
* device instance _12_t221 r0 *1 0,0
R_12_t221 \$12__t221 \$12 12.565291814
* device instance _12_t222 r0 *1 0,0
R_12_t222 \$12__t222 \$12 8.88807352977
* device instance _12_t223 r0 *1 0,0
R_12_t223 \$12__t223 \$12 10.7889885327
* device instance _12_t224 r0 *1 0,0
R_12_t224 \$12__t224 \$12 9.23981673065
* device instance _12_t225 r0 *1 0,0
R_12_t225 \$12__t225 \$12 12.0807060738
* device instance _12_t226 r0 *1 0,0
R_12_t226 \$12__t226 \$12 5.46830743259
* device instance _12_t227 r0 *1 0,0
R_12_t227 \$12__t227 \$12 6.07220915328
* device instance _12_t228 r0 *1 0,0
R_12_t228 \$12__t228 \$12 7.09235820042
* device instance _12_t229 r0 *1 0,0
R_12_t229 \$12__t229 \$12 8.37805757339
* device instance _12_t230 r0 *1 0,0
R_12_t230 \$12__t230 \$12 9.82561120648
* device instance _12_t231 r0 *1 0,0
R_12_t231 \$12__t231 \$12 11.3733858405
* device instance _12_t232 r0 *1 0,0
R_12_t232 \$12__t232 \$12 14.6409663043
* device instance _12_t233 r0 *1 0,0
R_12_t233 \$12__t233 \$12 6.76767198167
* device instance _12_t234 r0 *1 0,0
R_12_t234 \$12__t234 \$12 6.31266630192
* device instance _12_t235 r0 *1 0,0
R_12_t235 \$12__t235 \$12 6.35284272159
* device instance _12_t236 r0 *1 0,0
R_12_t236 \$12__t236 \$12 6.87953112277
* device instance _12_t237 r0 *1 0,0
R_12_t237 \$12__t237 \$12 12.9855942641
* device instance _12_t238 r0 *1 0,0
R_12_t238 \$12__t238 \$12 7.79472701966
* device instance _12_t239 r0 *1 0,0
R_12_t239 \$12__t239 \$12 8.98042722653
* device instance _12_t240 r0 *1 0,0
R_12_t240 \$12__t240 \$12 10.344025331
* device instance _12_t241 r0 *1 0,0
R_12_t241 \$12__t241 \$12 8.77986842326
* device instance _12_t242 r0 *1 0,0
R_12_t242 \$12__t242 \$12 8.16271186934
* device instance _12_t243 r0 *1 0,0
R_12_t243 \$12__t243 \$12 5.42158015448
* device instance _12_t244 r0 *1 0,0
R_12_t244 \$12__t244 \$12 11.8241333697
* device instance _12_t245 r0 *1 0,0
R_12_t245 \$12__t245 \$12 13.3821479165
* device instance _12_t246 r0 *1 0,0
R_12_t246 \$12__t246 \$12 14.9938026795
* device instance _12_t247 r0 *1 0,0
R_12_t247 \$12__t247 \$12 7.62977688282
* device instance _12_t248 r0 *1 0,0
R_12_t248 \$12__t248 \$12 6.91066355813
* device instance _12_t249 r0 *1 0,0
R_12_t249 \$12__t249 \$12 5.94517952492
* device instance _12_t250 r0 *1 0,0
R_12_t250 \$12__t250 \$12 14.737072189
* device instance _12_t251 r0 *1 0,0
R_12_t251 \$12__t251 \$12 13.1326604457
* device instance _12_t252 r0 *1 0,0
R_12_t252 \$12__t252 \$12 11.5850216694
* device instance _12_t253 r0 *1 0,0
R_12_t253 \$12__t253 \$12 10.1202355109
* device instance _12_t254 r0 *1 0,0
R_12_t254 \$12__t254 \$12 14.3779369951
* device instance _12_t255 r0 *1 0,0
R_12_t255 \$12__t255 \$12 9.58973108736
* device instance _12_t256 r0 *1 0,0
R_12_t256 \$12__t256 \$12 11.1245899975
* device instance _12_t257 r0 *1 0,0
R_12_t257 \$12__t257 \$12 12.7283363373
* device instance _12_t258 r0 *1 0,0
R_12_t258 \$12__t258 \$12 16.5893289842
* device instance _12_t259 r0 *1 0,0
R_12_t259 \$12__t259 \$12 16.7770271186
* device instance _12_t260 r0 *1 0,0
R_12_t260 \$12__t260 \$12 16.9722863422
* device instance _12_t261 r0 *1 0,0
R_12_t261 \$12__t261 \$12 19.43344224
* device instance _12_t262 r0 *1 0,0
R_12_t262 \$12__t262 \$12 19.1916208898
* device instance _12_t263 r0 *1 0,0
R_12_t263 \$12__t263 \$12 18.9553425032
* device instance _12 r0 *1 0,0
C_12 \$12 vsubs 5.64037401e-13
* device instance _120_t0 r0 *1 0,0
R_120_t0 \$120__t0 \$120 135.591504929
* device instance _120_t1 r0 *1 0,0
R_120_t1 \$120__t1 \$120 36.2048686624
* device instance _120_t2 r0 *1 0,0
R_120_t2 \$120__t2 \$120 166.824926409
* device instance _120 r0 *1 0,0
C_120 \$120 vsubs 7.017453e-15
* device instance _122_t0 r0 *1 0,0
R_122_t0 \$122__t0 \$122 162.444438203
* device instance _122_t1 r0 *1 0,0
R_122_t1 \$122__t1 \$122 43.7126105743
* device instance _122_t2 r0 *1 0,0
R_122_t2 \$122__t2 \$122 200.179851222
* device instance _122 r0 *1 0,0
C_122 \$122 vsubs 7.547896e-15
* device instance _124_t0 r0 *1 0,0
R_124_t0 \$124__t0 \$124 135.591504929
* device instance _124_t1 r0 *1 0,0
R_124_t1 \$124__t1 \$124 36.2048686624
* device instance _124_t2 r0 *1 0,0
R_124_t2 \$124__t2 \$124 166.824926409
* device instance _124 r0 *1 0,0
C_124 \$124 vsubs 7.017453e-15
* device instance _126_t0 r0 *1 0,0
R_126_t0 \$126__t0 \$126 162.444438203
* device instance _126_t1 r0 *1 0,0
R_126_t1 \$126__t1 \$126 43.7126105743
* device instance _126_t2 r0 *1 0,0
R_126_t2 \$126__t2 \$126 200.179851222
* device instance _126 r0 *1 0,0
C_126 \$126 vsubs 7.547896e-15
* device instance _127_t0 r0 *1 0,0
R_127_t0 \$127__t0 \$127 81.7777390336
* device instance _127_t1 r0 *1 0,0
R_127_t1 \$127__t1 \$127 21.4987692264
* device instance _127_t2 r0 *1 0,0
R_127_t2 \$127__t2 \$127 100.29899174
* device instance _127 r0 *1 0,0
C_127 \$127 vsubs 5.956568e-15
* device instance _129_t0 r0 *1 0,0
R_129_t0 \$129__t0 \$129 108.687402234
* device instance _129_t1 r0 *1 0,0
R_129_t1 \$129__t1 \$129 28.7964709909
* device instance _129_t2 r0 *1 0,0
R_129_t2 \$129__t2 \$129 133.512826775
* device instance _129 r0 *1 0,0
C_129 \$129 vsubs 6.487011e-15
* device instance _130_t0 r0 *1 0,0
R_130_t0 \$130__t0 \$130 81.7777390336
* device instance _130_t1 r0 *1 0,0
R_130_t1 \$130__t1 \$130 21.4987692264
* device instance _130_t2 r0 *1 0,0
R_130_t2 \$130__t2 \$130 100.29899174
* device instance _130 r0 *1 0,0
C_130 \$130 vsubs 5.956568e-15
* device instance _132_t0 r0 *1 0,0
R_132_t0 \$132__t0 \$132 108.687402234
* device instance _132_t1 r0 *1 0,0
R_132_t1 \$132__t1 \$132 28.7964709909
* device instance _132_t2 r0 *1 0,0
R_132_t2 \$132__t2 \$132 133.512826775
* device instance _132 r0 *1 0,0
C_132 \$132 vsubs 6.487011e-15
* device instance _133_t0 r0 *1 0,0
R_133_t0 \$133__t0 \$133 81.7777390336
* device instance _133_t1 r0 *1 0,0
R_133_t1 \$133__t1 \$133 21.4987692264
* device instance _133_t2 r0 *1 0,0
R_133_t2 \$133__t2 \$133 100.29899174
* device instance _133 r0 *1 0,0
C_133 \$133 vsubs 5.956568e-15
* device instance _135_t0 r0 *1 0,0
R_135_t0 \$135__t0 \$135 108.687402234
* device instance _135_t1 r0 *1 0,0
R_135_t1 \$135__t1 \$135 28.7964709909
* device instance _135_t2 r0 *1 0,0
R_135_t2 \$135__t2 \$135 133.512826775
* device instance _135 r0 *1 0,0
C_135 \$135 vsubs 6.487011e-15
* device instance _136_t0 r0 *1 0,0
R_136_t0 \$136__t0 \$136 81.7777390336
* device instance _136_t1 r0 *1 0,0
R_136_t1 \$136__t1 \$136 21.4987692264
* device instance _136_t2 r0 *1 0,0
R_136_t2 \$136__t2 \$136 100.29899174
* device instance _136 r0 *1 0,0
C_136 \$136 vsubs 5.956568e-15
* device instance _138_t0 r0 *1 0,0
R_138_t0 \$138__t0 \$138 108.687402234
* device instance _138_t1 r0 *1 0,0
R_138_t1 \$138__t1 \$138 28.7964709909
* device instance _138_t2 r0 *1 0,0
R_138_t2 \$138__t2 \$138 133.512826775
* device instance _138 r0 *1 0,0
C_138 \$138 vsubs 6.487011e-15
* device instance _139_t0 r0 *1 0,0
R_139_t0 \$139__t0 \$139 81.7777390336
* device instance _139_t1 r0 *1 0,0
R_139_t1 \$139__t1 \$139 21.4987692264
* device instance _139_t2 r0 *1 0,0
R_139_t2 \$139__t2 \$139 100.29899174
* device instance _139 r0 *1 0,0
C_139 \$139 vsubs 5.95106e-15
* device instance _141_t0 r0 *1 0,0
R_141_t0 \$141__t0 \$141 108.687402234
* device instance _141_t1 r0 *1 0,0
R_141_t1 \$141__t1 \$141 28.7964709909
* device instance _141_t2 r0 *1 0,0
R_141_t2 \$141__t2 \$141 133.512826775
* device instance _141 r0 *1 0,0
C_141 \$141 vsubs 6.467838e-15
* device instance _142_t0 r0 *1 0,0
R_142_t0 \$142__t0 \$142 81.7777390336
* device instance _142_t1 r0 *1 0,0
R_142_t1 \$142__t1 \$142 21.4987692264
* device instance _142_t2 r0 *1 0,0
R_142_t2 \$142__t2 \$142 100.29899174
* device instance _142 r0 *1 0,0
C_142 \$142 vsubs 5.956568e-15
* device instance _144_t0 r0 *1 0,0
R_144_t0 \$144__t0 \$144 108.687402234
* device instance _144_t1 r0 *1 0,0
R_144_t1 \$144__t1 \$144 28.7964709909
* device instance _144_t2 r0 *1 0,0
R_144_t2 \$144__t2 \$144 133.512826775
* device instance _144 r0 *1 0,0
C_144 \$144 vsubs 6.487011e-15
* device instance _145_t0 r0 *1 0,0
R_145_t0 \$145__t0 \$145 81.7777390336
* device instance _145_t1 r0 *1 0,0
R_145_t1 \$145__t1 \$145 21.4987692264
* device instance _145_t2 r0 *1 0,0
R_145_t2 \$145__t2 \$145 100.29899174
* device instance _145 r0 *1 0,0
C_145 \$145 vsubs 5.956568e-15
* device instance _147_t0 r0 *1 0,0
R_147_t0 \$147__t0 \$147 108.687402234
* device instance _147_t1 r0 *1 0,0
R_147_t1 \$147__t1 \$147 28.7964709909
* device instance _147_t2 r0 *1 0,0
R_147_t2 \$147__t2 \$147 133.512826775
* device instance _147 r0 *1 0,0
C_147 \$147 vsubs 6.487011e-15
* device instance _148_t0 r0 *1 0,0
R_148_t0 \$148__t0 \$148 81.7777390336
* device instance _148_t1 r0 *1 0,0
R_148_t1 \$148__t1 \$148 21.4987692264
* device instance _148_t2 r0 *1 0,0
R_148_t2 \$148__t2 \$148 100.29899174
* device instance _148 r0 *1 0,0
C_148 \$148 vsubs 5.956568e-15
* device instance _150_t0 r0 *1 0,0
R_150_t0 \$150__t0 \$150 108.687402234
* device instance _150_t1 r0 *1 0,0
R_150_t1 \$150__t1 \$150 28.7964709909
* device instance _150_t2 r0 *1 0,0
R_150_t2 \$150__t2 \$150 133.512826775
* device instance _150 r0 *1 0,0
C_150 \$150 vsubs 6.487011e-15
* device instance _151_t0 r0 *1 0,0
R_151_t0 \$151__t0 \$151 81.7777390336
* device instance _151_t1 r0 *1 0,0
R_151_t1 \$151__t1 \$151 21.4987692264
* device instance _151_t2 r0 *1 0,0
R_151_t2 \$151__t2 \$151 100.29899174
* device instance _151 r0 *1 0,0
C_151 \$151 vsubs 5.956568e-15
* device instance _153_t0 r0 *1 0,0
R_153_t0 \$153__t0 \$153 108.687402234
* device instance _153_t1 r0 *1 0,0
R_153_t1 \$153__t1 \$153 28.7964709909
* device instance _153_t2 r0 *1 0,0
R_153_t2 \$153__t2 \$153 133.512826775
* device instance _153 r0 *1 0,0
C_153 \$153 vsubs 6.487011e-15
* device instance _155_t0 r0 *1 0,0
R_155_t0 \$155__t0 \$155 83.9757876327
* device instance _155_t1 r0 *1 0,0
R_155_t1 \$155__t1 \$155 55.7216923353
* device instance _155_t2 r0 *1 0,0
R_155_t2 \$155__t2 \$155 129.232920032
* device instance _155 r0 *1 0,0
C_155 \$155 vsubs 1.2229309e-14
* device instance _158_t0 r0 *1 0,0
R_158_t0 \$158__t0 \$158 116.441606648
* device instance _158_t1 r0 *1 0,0
R_158_t1 \$158__t1 \$158 38.3284435294
* device instance _158_t2 r0 *1 0,0
R_158_t2 \$158__t2 \$158 96.330049823
* device instance _158 r0 *1 0,0
C_158 \$158 vsubs 5.501903e-15
* device instance _159_t0 r0 *1 0,0
R_159_t0 \$159__t0 \$159 102.132345174
* device instance _159_t1 r0 *1 0,0
R_159_t1 \$159__t1 \$159 41.0884060087
* device instance _159_t2 r0 *1 0,0
R_159_t2 \$159__t2 \$159 143.185648818
* device instance _159 r0 *1 0,0
C_159 \$159 vsubs 6.152711e-15
* device instance _160_t0 r0 *1 0,0
R_160_t0 \$160__t0 \$160 126.339587274
* device instance _160_t1 r0 *1 0,0
R_160_t1 \$160__t1 \$160 36.8132107224
* device instance _160_t2 r0 *1 0,0
R_160_t2 \$160__t2 \$160 89.5605020032
* device instance _160 r0 *1 0,0
C_160 \$160 vsubs 5.871013e-15
* device instance _161_t0 r0 *1 0,0
R_161_t0 \$161__t0 \$161 151.618326391
* device instance _161_t1 r0 *1 0,0
R_161_t1 \$161__t1 \$161 121.893663486
* device instance _161_t2 r0 *1 0,0
R_161_t2 \$161__t2 \$161 8.04232371666
* device instance _161_t3 r0 *1 0,0
R_161_t3 \$161__t3 \$161 183.328414339
* device instance _161_t4 r0 *1 0,0
R_161_t4 \$161__t4 \$161 221.55265974
* device instance _161_t5 r0 *1 0,0
R_161_t5 \$161__t5 \$161 55.3315793354
* device instance _161_t6 r0 *1 0,0
R_161_t6 \$161__t6 \$161 84.3367329922
* device instance _161 r0 *1 0,0
C_161 \$161 vsubs 1.1575909e-14
* device instance _162_t0 r0 *1 0,0
R_162_t0 \$162__t0 \$162 193.38334863
* device instance _162_t1 r0 *1 0,0
R_162_t1 \$162__t1 \$162 8.52407184515
* device instance _162_t2 r0 *1 0,0
R_162_t2 \$162__t2 \$162 182.664160008
* device instance _162_t3 r0 *1 0,0
R_162_t3 \$162__t3 \$162 248.748487549
* device instance _162_t4 r0 *1 0,0
R_162_t4 \$162__t4 \$162 139.314164435
* device instance _162_t5 r0 *1 0,0
R_162_t5 \$162__t5 \$162 85.3846939574
* device instance _162_t6 r0 *1 0,0
R_162_t6 \$162__t6 \$162 44.8862735761
* device instance _162 r0 *1 0,0
C_162 \$162 vsubs 1.14312e-14
* device instance _163_t0 r0 *1 0,0
R_163_t0 \$163__t0 \$163 92.1370227791
* device instance _163_t1 r0 *1 0,0
R_163_t1 \$163__t1 \$163 71.3937163151
* device instance _163_t2 r0 *1 0,0
R_163_t2 \$163__t2 \$163 100.382188226
* device instance _163_t3 r0 *1 0,0
R_163_t3 \$163__t3 \$163 63.3502726796
* device instance _163 r0 *1 0,0
C_163 \$163 vsubs 6.120116e-15
* device instance _164_t0 r0 *1 0,0
R_164_t0 \$164__t0 \$164 129.031727689
* device instance _164_t1 r0 *1 0,0
R_164_t1 \$164__t1 \$164 54.3298745163
* device instance _164_t2 r0 *1 0,0
R_164_t2 \$164__t2 \$164 160.22824861
* device instance _164_t3 r0 *1 0,0
R_164_t3 \$164__t3 \$164 23.1475491847
* device instance _164 r0 *1 0,0
C_164 \$164 vsubs 4.58088e-15
* device instance _167_t0 r0 *1 0,0
R_167_t0 \$167__t0 \$167 114.0827
* device instance _167_t1 r0 *1 0,0
R_167_t1 \$167__t1 \$167 114.0827
* device instance _167 r0 *1 0,0
C_167 \$167 vsubs 3.595591e-15
* device instance _168_t0 r0 *1 0,0
R_168_t0 \$168__t0 \$168 80.3351
* device instance _168_t1 r0 *1 0,0
R_168_t1 \$168__t1 \$168 80.3351
* device instance _168 r0 *1 0,0
C_168 \$168 vsubs 3.058914e-15
* device instance _17_t0 r0 *1 0,0
R_17_t0 \$17__t0 \$17 81.7777390336
* device instance _17_t1 r0 *1 0,0
R_17_t1 \$17__t1 \$17 21.4987692264
* device instance _17_t2 r0 *1 0,0
R_17_t2 \$17__t2 \$17 100.29899174
* device instance _17 r0 *1 0,0
C_17 \$17 vsubs 5.962076e-15
* device instance _171_t0 r0 *1 0,0
R_171_t0 \$171__t0 \$171 84.9620979822
* device instance _171_t1 r0 *1 0,0
R_171_t1 \$171__t1 \$171 24.9695335856
* device instance _171_t2 r0 *1 0,0
R_171_t2 \$171__t2 \$171 86.6725684323
* device instance _171 r0 *1 0,0
C_171 \$171 vsubs 3.621691e-15
* device instance _172_t0 r0 *1 0,0
R_172_t0 \$172__t0 \$172 84.9620979822
* device instance _172_t1 r0 *1 0,0
R_172_t1 \$172__t1 \$172 24.9695335856
* device instance _172_t2 r0 *1 0,0
R_172_t2 \$172__t2 \$172 86.6725684323
* device instance _172 r0 *1 0,0
C_172 \$172 vsubs 3.621691e-15
* device instance _19_t0 r0 *1 0,0
R_19_t0 \$19__t0 \$19 108.687402234
* device instance _19_t1 r0 *1 0,0
R_19_t1 \$19__t1 \$19 28.7964709909
* device instance _19_t2 r0 *1 0,0
R_19_t2 \$19__t2 \$19 133.512826775
* device instance _19 r0 *1 0,0
C_19 \$19 vsubs 6.492519e-15
* device instance _21_t0 r0 *1 0,0
R_21_t0 \$21__t0 \$21 135.591504929
* device instance _21_t1 r0 *1 0,0
R_21_t1 \$21__t1 \$21 36.2048686624
* device instance _21_t2 r0 *1 0,0
R_21_t2 \$21__t2 \$21 166.824926409
* device instance _21 r0 *1 0,0
C_21 \$21 vsubs 7.022961e-15
* device instance _23_t0 r0 *1 0,0
R_23_t0 \$23__t0 \$23 162.444438203
* device instance _23_t1 r0 *1 0,0
R_23_t1 \$23__t1 \$23 43.7126105743
* device instance _23_t2 r0 *1 0,0
R_23_t2 \$23__t2 \$23 200.179851222
* device instance _23 r0 *1 0,0
C_23 \$23 vsubs 7.553404e-15
* device instance _24_t0 r0 *1 0,0
R_24_t0 \$24__t0 \$24 9.55115737603
* device instance _24_t1 r0 *1 0,0
R_24_t1 \$24__t1 \$24 19.8700104676
* device instance _24_t2 r0 *1 0,0
R_24_t2 \$24__t2 \$24 14.897725426
* device instance _24_t3 r0 *1 0,0
R_24_t3 \$24__t3 \$24 12.5148157706
* device instance _24_t4 r0 *1 0,0
R_24_t4 \$24__t4 \$24 10.2652957245
* device instance _24_t5 r0 *1 0,0
R_24_t5 \$24__t5 \$24 17.359179808
* device instance _24_t6 r0 *1 0,0
R_24_t6 \$24__t6 \$24 19.5106541892
* device instance _24_t7 r0 *1 0,0
R_24_t7 \$24__t7 \$24 19.6260262215
* device instance _24_t8 r0 *1 0,0
R_24_t8 \$24__t8 \$24 16.9466644068
* device instance _24_t9 r0 *1 0,0
R_24_t9 \$24__t9 \$24 14.4149413381
* device instance _24_t10 r0 *1 0,0
R_24_t10 \$24__t10 \$24 11.9360347135
* device instance _24_t11 r0 *1 0,0
R_24_t11 \$24__t11 \$24 6.71710773354
* device instance _24_t12 r0 *1 0,0
R_24_t12 \$24__t12 \$24 4.68565946996
* device instance _24_t13 r0 *1 0,0
R_24_t13 \$24__t13 \$24 7.31688453105
* device instance _24_t14 r0 *1 0,0
R_24_t14 \$24__t14 \$24 6.79429131622
* device instance _24_t15 r0 *1 0,0
R_24_t15 \$24__t15 \$24 5.19810097632
* device instance _24_t16 r0 *1 0,0
R_24_t16 \$24__t16 \$24 5.5648762084
* device instance _24_t17 r0 *1 0,0
R_24_t17 \$24__t17 \$24 7.76621423726
* device instance _24_t18 r0 *1 0,0
R_24_t18 \$24__t18 \$24 9.67127271597
* device instance _24_t19 r0 *1 0,0
R_24_t19 \$24__t19 \$24 8.90964796484
* device instance _24_t20 r0 *1 0,0
R_24_t20 \$24__t20 \$24 6.41653667092
* device instance _24_t21 r0 *1 0,0
R_24_t21 \$24__t21 \$24 6.00891785246
* device instance _24_t22 r0 *1 0,0
R_24_t22 \$24__t22 \$24 9.37255027548
* device instance _24_t23 r0 *1 0,0
R_24_t23 \$24__t23 \$24 10.6782716399
* device instance _24_t24 r0 *1 0,0
R_24_t24 \$24__t24 \$24 9.68328915444
* device instance _24_t25 r0 *1 0,0
R_24_t25 \$24__t25 \$24 10.1343048081
* device instance _24_t26 r0 *1 0,0
R_24_t26 \$24__t26 \$24 8.51914044609
* device instance _24_t27 r0 *1 0,0
R_24_t27 \$24__t27 \$24 7.51828873979
* device instance _24_t28 r0 *1 0,0
R_24_t28 \$24__t28 \$24 7.38585599964
* device instance _24_t29 r0 *1 0,0
R_24_t29 \$24__t29 \$24 8.16421237831
* device instance _24_t30 r0 *1 0,0
R_24_t30 \$24__t30 \$24 9.63509991161
* device instance _24_t31 r0 *1 0,0
R_24_t31 \$24__t31 \$24 8.25889039087
* device instance _24_t32 r0 *1 0,0
R_24_t32 \$24__t32 \$24 11.5366038544
* device instance _24_t33 r0 *1 0,0
R_24_t33 \$24__t33 \$24 12.9653438247
* device instance _24_t34 r0 *1 0,0
R_24_t34 \$24__t34 \$24 11.1307892286
* device instance _24_t35 r0 *1 0,0
R_24_t35 \$24__t35 \$24 22.0385059258
* device instance _24_t36 r0 *1 0,0
R_24_t36 \$24__t36 \$24 15.0460328251
* device instance _24_t37 r0 *1 0,0
R_24_t37 \$24__t37 \$24 8.81561118035
* device instance _24_t38 r0 *1 0,0
R_24_t38 \$24__t38 \$24 8.70294224706
* device instance _24_t39 r0 *1 0,0
R_24_t39 \$24__t39 \$24 12.4210934866
* device instance _24_t40 r0 *1 0,0
R_24_t40 \$24__t40 \$24 17.2841938976
* device instance _24_t41 r0 *1 0,0
R_24_t41 \$24__t41 \$24 14.3968660347
* device instance _24_t42 r0 *1 0,0
R_24_t42 \$24__t42 \$24 12.4660124327
* device instance _24_t43 r0 *1 0,0
R_24_t43 \$24__t43 \$24 9.85487202827
* device instance _24_t44 r0 *1 0,0
R_24_t44 \$24__t44 \$24 7.071640247
* device instance _24_t45 r0 *1 0,0
R_24_t45 \$24__t45 \$24 6.5607810065
* device instance _24_t46 r0 *1 0,0
R_24_t46 \$24__t46 \$24 5.45423683172
* device instance _24_t47 r0 *1 0,0
R_24_t47 \$24__t47 \$24 3.7010283775
* device instance _24_t48 r0 *1 0,0
R_24_t48 \$24__t48 \$24 8.88037413057
* device instance _24_t49 r0 *1 0,0
R_24_t49 \$24__t49 \$24 7.73802813512
* device instance _24_t50 r0 *1 0,0
R_24_t50 \$24__t50 \$24 15.3207692124
* device instance _24_t51 r0 *1 0,0
R_24_t51 \$24__t51 \$24 12.7422805785
* device instance _24_t52 r0 *1 0,0
R_24_t52 \$24__t52 \$24 16.9312921054
* device instance _24_t53 r0 *1 0,0
R_24_t53 \$24__t53 \$24 19.4973035247
* device instance _24_t54 r0 *1 0,0
R_24_t54 \$24__t54 \$24 20.3645305774
* device instance _24_t55 r0 *1 0,0
R_24_t55 \$24__t55 \$24 15.0917765982
* device instance _24_t56 r0 *1 0,0
R_24_t56 \$24__t56 \$24 17.7256669112
* device instance _24_t57 r0 *1 0,0
R_24_t57 \$24__t57 \$24 10.202095425
* device instance _24_t58 r0 *1 0,0
R_24_t58 \$24__t58 \$24 6.75585763107
* device instance _24_t59 r0 *1 0,0
R_24_t59 \$24__t59 \$24 9.12698885734
* device instance _24_t60 r0 *1 0,0
R_24_t60 \$24__t60 \$24 9.50085122343
* device instance _24_t61 r0 *1 0,0
R_24_t61 \$24__t61 \$24 2.18164294876
* device instance _24_t62 r0 *1 0,0
R_24_t62 \$24__t62 \$24 4.10646573912
* device instance _24_t63 r0 *1 0,0
R_24_t63 \$24__t63 \$24 4.77330609208
* device instance _24_t64 r0 *1 0,0
R_24_t64 \$24__t64 \$24 2.59487238285
* device instance _24_t65 r0 *1 0,0
R_24_t65 \$24__t65 \$24 3.42400559633
* device instance _24_t66 r0 *1 0,0
R_24_t66 \$24__t66 \$24 4.88132248825
* device instance _24_t67 r0 *1 0,0
R_24_t67 \$24__t67 \$24 5.51788592273
* device instance _24_t68 r0 *1 0,0
R_24_t68 \$24__t68 \$24 4.62975404422
* device instance _24_t69 r0 *1 0,0
R_24_t69 \$24__t69 \$24 5.14776374765
* device instance _24_t70 r0 *1 0,0
R_24_t70 \$24__t70 \$24 17.9210355676
* device instance _24_t71 r0 *1 0,0
R_24_t71 \$24__t71 \$24 12.1206355273
* device instance _24_t72 r0 *1 0,0
R_24_t72 \$24__t72 \$24 7.27412063772
* device instance _24_t73 r0 *1 0,0
R_24_t73 \$24__t73 \$24 9.52385557761
* device instance _24_t74 r0 *1 0,0
R_24_t74 \$24__t74 \$24 11.9141991977
* device instance _24_t75 r0 *1 0,0
R_24_t75 \$24__t75 \$24 20.5348083509
* device instance _24_t76 r0 *1 0,0
R_24_t76 \$24__t76 \$24 19.1620500416
* device instance _24_t77 r0 *1 0,0
R_24_t77 \$24__t77 \$24 21.6976969367
* device instance _24_t78 r0 *1 0,0
R_24_t78 \$24__t78 \$24 16.232802401
* device instance _24_t79 r0 *1 0,0
R_24_t79 \$24__t79 \$24 11.2551566343
* device instance _24_t80 r0 *1 0,0
R_24_t80 \$24__t80 \$24 11.8671917467
* device instance _24_t81 r0 *1 0,0
R_24_t81 \$24__t81 \$24 18.7891583821
* device instance _24_t82 r0 *1 0,0
R_24_t82 \$24__t82 \$24 14.2198542748
* device instance _24_t83 r0 *1 0,0
R_24_t83 \$24__t83 \$24 21.369098326
* device instance _24_t84 r0 *1 0,0
R_24_t84 \$24__t84 \$24 14.4436468119
* device instance _24_t85 r0 *1 0,0
R_24_t85 \$24__t85 \$24 16.6442661205
* device instance _24_t86 r0 *1 0,0
R_24_t86 \$24__t86 \$24 7.35238610243
* device instance _24_t87 r0 *1 0,0
R_24_t87 \$24__t87 \$24 16.6629998163
* device instance _24_t88 r0 *1 0,0
R_24_t88 \$24__t88 \$24 21.5523875367
* device instance _24_t89 r0 *1 0,0
R_24_t89 \$24__t89 \$24 19.0785369024
* device instance _24_t90 r0 *1 0,0
R_24_t90 \$24__t90 \$24 16.6599226824
* device instance _24_t91 r0 *1 0,0
R_24_t91 \$24__t91 \$24 14.3245512622
* device instance _24_t92 r0 *1 0,0
R_24_t92 \$24__t92 \$24 13.7132259701
* device instance _24_t93 r0 *1 0,0
R_24_t93 \$24__t93 \$24 15.9950385989
* device instance _24_t94 r0 *1 0,0
R_24_t94 \$24__t94 \$24 18.3937819081
* device instance _24_t95 r0 *1 0,0
R_24_t95 \$24__t95 \$24 20.8542191803
* device instance _24_t96 r0 *1 0,0
R_24_t96 \$24__t96 \$24 13.6904564686
* device instance _24_t97 r0 *1 0,0
R_24_t97 \$24__t97 \$24 21.3562354484
* device instance _24_t98 r0 *1 0,0
R_24_t98 \$24__t98 \$24 18.9610534462
* device instance _24_t99 r0 *1 0,0
R_24_t99 \$24__t99 \$24 21.6822617661
* device instance _24_t100 r0 *1 0,0
R_24_t100 \$24__t100 \$24 19.8531543821
* device instance _24_t101 r0 *1 0,0
R_24_t101 \$24__t101 \$24 17.339883118
* device instance _24_t102 r0 *1 0,0
R_24_t102 \$24__t102 \$24 14.8752359917
* device instance _24_t103 r0 *1 0,0
R_24_t103 \$24__t103 \$24 12.4880357427
* device instance _24_t104 r0 *1 0,0
R_24_t104 \$24__t104 \$24 10.2326301238
* device instance _24_t105 r0 *1 0,0
R_24_t105 \$24__t105 \$24 8.21825367262
* device instance _24_t106 r0 *1 0,0
R_24_t106 \$24__t106 \$24 6.66708026374
* device instance _24_t107 r0 *1 0,0
R_24_t107 \$24__t107 \$24 5.95294185229
* device instance _24_t108 r0 *1 0,0
R_24_t108 \$24__t108 \$24 6.36414690185
* device instance _24_t109 r0 *1 0,0
R_24_t109 \$24__t109 \$24 7.72298559613
* device instance _24_t110 r0 *1 0,0
R_24_t110 \$24__t110 \$24 9.63659373875
* device instance _24_t111 r0 *1 0,0
R_24_t111 \$24__t111 \$24 11.8389468658
* device instance _24_t112 r0 *1 0,0
R_24_t112 \$24__t112 \$24 14.1962910133
* device instance _24_t113 r0 *1 0,0
R_24_t113 \$24__t113 \$24 16.6428959564
* device instance _24_t114 r0 *1 0,0
R_24_t114 \$24__t114 \$24 19.1445706334
* device instance _24_t115 r0 *1 0,0
R_24_t115 \$24__t115 \$24 12.0250382035
* device instance _24_t116 r0 *1 0,0
R_24_t116 \$24__t116 \$24 11.2319975385
* device instance _24_t117 r0 *1 0,0
R_24_t117 \$24__t117 \$24 11.7318922356
* device instance _24_t118 r0 *1 0,0
R_24_t118 \$24__t118 \$24 13.6942244888
* device instance _24_t119 r0 *1 0,0
R_24_t119 \$24__t119 \$24 19.8007929916
* device instance _24_t120 r0 *1 0,0
R_24_t120 \$24__t120 \$24 21.3569094465
* device instance _24_t121 r0 *1 0,0
R_24_t121 \$24__t121 \$24 18.7752946861
* device instance _24_t122 r0 *1 0,0
R_24_t122 \$24__t122 \$24 16.2167534245
* device instance _24_t123 r0 *1 0,0
R_24_t123 \$24__t123 \$24 17.1902343893
* device instance _24_t124 r0 *1 0,0
R_24_t124 \$24__t124 \$24 14.5950061753
* device instance _24_t125 r0 *1 0,0
R_24_t125 \$24__t125 \$24 19.6241472357
* device instance _24_t126 r0 *1 0,0
R_24_t126 \$24__t126 \$24 16.9864625508
* device instance _24_t127 r0 *1 0,0
R_24_t127 \$24__t127 \$24 14.3544403196
* device instance _24_t128 r0 *1 0,0
R_24_t128 \$24__t128 \$24 21.1920515705
* device instance _24_t129 r0 *1 0,0
R_24_t129 \$24__t129 \$24 21.2357630582
* device instance _24_t130 r0 *1 0,0
R_24_t130 \$24__t130 \$24 21.2961235546
* device instance _24_t131 r0 *1 0,0
R_24_t131 \$24__t131 \$24 21.3729920023
* device instance _24_t132 r0 *1 0,0
R_24_t132 \$24__t132 \$24 23.061340248
* device instance _24_t133 r0 *1 0,0
R_24_t133 \$24__t133 \$24 23.230869417
* device instance _24_t134 r0 *1 0,0
R_24_t134 \$24__t134 \$24 23.4143937909
* device instance _24_t135 r0 *1 0,0
R_24_t135 \$24__t135 \$24 23.6115870328
* device instance _24 r0 *1 0,0
C_24 \$24 vsubs 3.07467522e-13
* device instance _25_t0 r0 *1 0,0
R_25_t0 \$25__t0 \$25 81.7777390336
* device instance _25_t1 r0 *1 0,0
R_25_t1 \$25__t1 \$25 21.4987692264
* device instance _25_t2 r0 *1 0,0
R_25_t2 \$25__t2 \$25 100.29899174
* device instance _25 r0 *1 0,0
C_25 \$25 vsubs 5.962076e-15
* device instance _27_t0 r0 *1 0,0
R_27_t0 \$27__t0 \$27 108.687402234
* device instance _27_t1 r0 *1 0,0
R_27_t1 \$27__t1 \$27 28.7964709909
* device instance _27_t2 r0 *1 0,0
R_27_t2 \$27__t2 \$27 133.512826775
* device instance _27 r0 *1 0,0
C_27 \$27 vsubs 6.492519e-15
* device instance _29_t0 r0 *1 0,0
R_29_t0 \$29__t0 \$29 135.591504929
* device instance _29_t1 r0 *1 0,0
R_29_t1 \$29__t1 \$29 36.2048686624
* device instance _29_t2 r0 *1 0,0
R_29_t2 \$29__t2 \$29 166.824926409
* device instance _29 r0 *1 0,0
C_29 \$29 vsubs 7.022961e-15
* device instance _31_t0 r0 *1 0,0
R_31_t0 \$31__t0 \$31 162.444438203
* device instance _31_t1 r0 *1 0,0
R_31_t1 \$31__t1 \$31 43.7126105743
* device instance _31_t2 r0 *1 0,0
R_31_t2 \$31__t2 \$31 200.179851222
* device instance _31 r0 *1 0,0
C_31 \$31 vsubs 7.553404e-15
* device instance _32_t0 r0 *1 0,0
R_32_t0 \$32__t0 \$32 32.3071372691
* device instance _32_t1 r0 *1 0,0
R_32_t1 \$32__t1 \$32 28.984307841
* device instance _32_t2 r0 *1 0,0
R_32_t2 \$32__t2 \$32 25.8445429061
* device instance _32_t3 r0 *1 0,0
R_32_t3 \$32__t3 \$32 22.9630574954
* device instance _32_t4 r0 *1 0,0
R_32_t4 \$32__t4 \$32 20.4493260416
* device instance _32_t5 r0 *1 0,0
R_32_t5 \$32__t5 \$32 18.4542454758
* device instance _32_t6 r0 *1 0,0
R_32_t6 \$32__t6 \$32 35.7620392391
* device instance _32_t7 r0 *1 0,0
R_32_t7 \$32__t7 \$32 17.1596833046
* device instance _32_t8 r0 *1 0,0
R_32_t8 \$32__t8 \$32 16.7290645481
* device instance _32_t9 r0 *1 0,0
R_32_t9 \$32__t9 \$32 17.227297661
* device instance _32_t10 r0 *1 0,0
R_32_t10 \$32__t10 \$32 18.5798084828
* device instance _32_t11 r0 *1 0,0
R_32_t11 \$32__t11 \$32 20.6191681772
* device instance _32_t12 r0 *1 0,0
R_32_t12 \$32__t12 \$32 12.0844632275
* device instance _32_t13 r0 *1 0,0
R_32_t13 \$32__t13 \$32 7.83857967109
* device instance _32_t14 r0 *1 0,0
R_32_t14 \$32__t14 \$32 3.91648902628
* device instance _32_t15 r0 *1 0,0
R_32_t15 \$32__t15 \$32 0.86357155652
* device instance _32_t16 r0 *1 0,0
R_32_t16 \$32__t16 \$32 4.20284901951
* device instance _32_t17 r0 *1 0,0
R_32_t17 \$32__t17 \$32 8.12978710888
* device instance _32_t18 r0 *1 0,0
R_32_t18 \$32__t18 \$32 19.7186346689
* device instance _32_t19 r0 *1 0,0
R_32_t19 \$32__t19 \$32 15.7539253748
* device instance _32_t20 r0 *1 0,0
R_32_t20 \$32__t20 \$32 31.6197344346
* device instance _32_t21 r0 *1 0,0
R_32_t21 \$32__t21 \$32 27.6520392323
* device instance _32_t22 r0 *1 0,0
R_32_t22 \$32__t22 \$32 11.7923318616
* device instance _32_t23 r0 *1 0,0
R_32_t23 \$32__t23 \$32 23.6848951064
* device instance _32_t24 r0 *1 0,0
R_32_t24 \$32__t24 \$32 9.13917403003
* device instance _32_t25 r0 *1 0,0
R_32_t25 \$32__t25 \$32 12.1535862098
* device instance _32_t26 r0 *1 0,0
R_32_t26 \$32__t26 \$32 15.6014783939
* device instance _32_t27 r0 *1 0,0
R_32_t27 \$32__t27 \$32 19.2513353536
* device instance _32_t28 r0 *1 0,0
R_32_t28 \$32__t28 \$32 23.0072382573
* device instance _32_t29 r0 *1 0,0
R_32_t29 \$32__t29 \$32 26.8246794215
* device instance _32_t30 r0 *1 0,0
R_32_t30 \$32__t30 \$32 30.6806967719
* device instance _32_t31 r0 *1 0,0
R_32_t31 \$32__t31 \$32 30.3951846927
* device instance _32_t32 r0 *1 0,0
R_32_t32 \$32__t32 \$32 26.5414878586
* device instance _32_t33 r0 *1 0,0
R_32_t33 \$32__t33 \$32 22.7276311457
* device instance _32_t34 r0 *1 0,0
R_32_t34 \$32__t34 \$32 18.9776492684
* device instance _32_t35 r0 *1 0,0
R_32_t35 \$32__t35 \$32 11.9120537184
* device instance _32_t36 r0 *1 0,0
R_32_t36 \$32__t36 \$32 8.94633565039
* device instance _32_t37 r0 *1 0,0
R_32_t37 \$32__t37 \$32 7.0489810509
* device instance _32_t38 r0 *1 0,0
R_32_t38 \$32__t38 \$32 7.13096491717
* device instance _32_t39 r0 *1 0,0
R_32_t39 \$32__t39 \$32 15.3384627821
* device instance _32_t40 r0 *1 0,0
R_32_t40 \$32__t40 \$32 23.1646762094
* device instance _32_t41 r0 *1 0,0
R_32_t41 \$32__t41 \$32 29.2239699998
* device instance _32_t42 r0 *1 0,0
R_32_t42 \$32__t42 \$32 32.5580480625
* device instance _32_t43 r0 *1 0,0
R_32_t43 \$32__t43 \$32 26.0684803156
* device instance _32_t44 r0 *1 0,0
R_32_t44 \$32__t44 \$32 27.9447785609
* device instance _32_t45 r0 *1 0,0
R_32_t45 \$32__t45 \$32 16.0463821177
* device instance _32_t46 r0 *1 0,0
R_32_t46 \$32__t46 \$32 23.9775849019
* device instance _32_t47 r0 *1 0,0
R_32_t47 \$32__t47 \$32 20.0112423688
* device instance _32_t48 r0 *1 0,0
R_32_t48 \$32__t48 \$32 9.25664270182
* device instance _32_t49 r0 *1 0,0
R_32_t49 \$32__t49 \$32 10.7719182053
* device instance _32_t50 r0 *1 0,0
R_32_t50 \$32__t50 \$32 13.3377031022
* device instance _32_t51 r0 *1 0,0
R_32_t51 \$32__t51 \$32 16.4701469566
* device instance _32_t52 r0 *1 0,0
R_32_t52 \$32__t52 \$32 19.9034788921
* device instance _32_t53 r0 *1 0,0
R_32_t53 \$32__t53 \$32 23.506222958
* device instance _32_t54 r0 *1 0,0
R_32_t54 \$32__t54 \$32 27.2111719336
* device instance _32_t55 r0 *1 0,0
R_32_t55 \$32__t55 \$32 30.9816809221
* device instance _32_t56 r0 *1 0,0
R_32_t56 \$32__t56 \$32 13.5538539911
* device instance _32_t57 r0 *1 0,0
R_32_t57 \$32__t57 \$32 10.9326027187
* device instance _32_t58 r0 *1 0,0
R_32_t58 \$32__t58 \$32 9.31922533814
* device instance _32_t59 r0 *1 0,0
R_32_t59 \$32__t59 \$32 31.2618370328
* device instance _32_t60 r0 *1 0,0
R_32_t60 \$32__t60 \$32 16.7153650373
* device instance _32_t61 r0 *1 0,0
R_32_t61 \$32__t61 \$32 20.1646029753
* device instance _32_t62 r0 *1 0,0
R_32_t62 \$32__t62 \$32 23.7766758081
* device instance _32_t63 r0 *1 0,0
R_32_t63 \$32__t63 \$32 27.4874648944
* device instance _32_t64 r0 *1 0,0
R_32_t64 \$32__t64 \$32 32.1199641948
* device instance _32_t65 r0 *1 0,0
R_32_t65 \$32__t65 \$32 31.8009661534
* device instance _32_t66 r0 *1 0,0
R_32_t66 \$32__t66 \$32 31.5040641348
* device instance _32_t67 r0 *1 0,0
R_32_t67 \$32__t67 \$32 31.2298883447
* device instance _32_t68 r0 *1 0,0
R_32_t68 \$32__t68 \$32 31.6999030897
* device instance _32_t69 r0 *1 0,0
R_32_t69 \$32__t69 \$32 31.5896961094
* device instance _32_t70 r0 *1 0,0
R_32_t70 \$32__t70 \$32 31.5044315132
* device instance _32_t71 r0 *1 0,0
R_32_t71 \$32__t71 \$32 31.4443122035
* device instance _32 r0 *1 0,0
C_32 \$32 vsubs 1.74844138e-13
* device instance _33_t0 r0 *1 0,0
R_33_t0 \$33__t0 \$33 81.7777390336
* device instance _33_t1 r0 *1 0,0
R_33_t1 \$33__t1 \$33 21.4987692264
* device instance _33_t2 r0 *1 0,0
R_33_t2 \$33__t2 \$33 100.29899174
* device instance _33 r0 *1 0,0
C_33 \$33 vsubs 5.962076e-15
* device instance _35_t0 r0 *1 0,0
R_35_t0 \$35__t0 \$35 108.687402234
* device instance _35_t1 r0 *1 0,0
R_35_t1 \$35__t1 \$35 28.7964709909
* device instance _35_t2 r0 *1 0,0
R_35_t2 \$35__t2 \$35 133.512826775
* device instance _35 r0 *1 0,0
C_35 \$35 vsubs 6.492519e-15
* device instance _37_t0 r0 *1 0,0
R_37_t0 \$37__t0 \$37 135.591504929
* device instance _37_t1 r0 *1 0,0
R_37_t1 \$37__t1 \$37 36.2048686624
* device instance _37_t2 r0 *1 0,0
R_37_t2 \$37__t2 \$37 166.824926409
* device instance _37 r0 *1 0,0
C_37 \$37 vsubs 7.022961e-15
* device instance _39_t0 r0 *1 0,0
R_39_t0 \$39__t0 \$39 162.444438203
* device instance _39_t1 r0 *1 0,0
R_39_t1 \$39__t1 \$39 43.7126105743
* device instance _39_t2 r0 *1 0,0
R_39_t2 \$39__t2 \$39 200.179851222
* device instance _39 r0 *1 0,0
C_39 \$39 vsubs 7.553404e-15
* device instance _40_t0 r0 *1 0,0
R_40_t0 \$40__t0 \$40 15.5564453991
* device instance _40_t1 r0 *1 0,0
R_40_t1 \$40__t1 \$40 37.7357410999
* device instance _40_t2 r0 *1 0,0
R_40_t2 \$40__t2 \$40 63.5750648064
* device instance _40_t3 r0 *1 0,0
R_40_t3 \$40__t3 \$40 58.4834694729
* device instance _40_t4 r0 *1 0,0
R_40_t4 \$40__t4 \$40 53.5995561817
* device instance _40_t5 r0 *1 0,0
R_40_t5 \$40__t5 \$40 44.7248423133
* device instance _40_t6 r0 *1 0,0
R_40_t6 \$40__t6 \$40 40.9281614018
* device instance _40_t7 r0 *1 0,0
R_40_t7 \$40__t7 \$40 48.9854828392
* device instance _40_t8 r0 *1 0,0
R_40_t8 \$40__t8 \$40 35.3118507277
* device instance _40_t9 r0 *1 0,0
R_40_t9 \$40__t9 \$40 14.6331400903
* device instance _40_t10 r0 *1 0,0
R_40_t10 \$40__t10 \$40 42.8965547564
* device instance _40_t11 r0 *1 0,0
R_40_t11 \$40__t11 \$40 36.9699812833
* device instance _40_t12 r0 *1 0,0
R_40_t12 \$40__t12 \$40 12.3169961247
* device instance _40_t13 r0 *1 0,0
R_40_t13 \$40__t13 \$40 12.6420429946
* device instance _40_t14 r0 *1 0,0
R_40_t14 \$40__t14 \$40 19.7784767727
* device instance _40_t15 r0 *1 0,0
R_40_t15 \$40__t15 \$40 54.8542692252
* device instance _40_t16 r0 *1 0,0
R_40_t16 \$40__t16 \$40 48.8622368367
* device instance _40_t17 r0 *1 0,0
R_40_t17 \$40__t17 \$40 31.1048791516
* device instance _40_t18 r0 *1 0,0
R_40_t18 \$40__t18 \$40 25.3439614667
* device instance _40_t19 r0 *1 0,0
R_40_t19 \$40__t19 \$40 19.9562927585
* device instance _40_t20 r0 *1 0,0
R_40_t20 \$40__t20 \$40 25.0713608069
* device instance _40_t21 r0 *1 0,0
R_40_t21 \$40__t21 \$40 41.9993449693
* device instance _40_t22 r0 *1 0,0
R_40_t22 \$40__t22 \$40 30.5444189598
* device instance _40_t23 r0 *1 0,0
R_40_t23 \$40__t23 \$40 36.2135169695
* device instance _40_t24 r0 *1 0,0
R_40_t24 \$40__t24 \$40 12.8057653363
* device instance _40_t25 r0 *1 0,0
R_40_t25 \$40__t25 \$40 12.4849817103
* device instance _40_t26 r0 *1 0,0
R_40_t26 \$40__t26 \$40 15.6897854742
* device instance _40_t27 r0 *1 0,0
R_40_t27 \$40__t27 \$40 42.0489161884
* device instance _40_t28 r0 *1 0,0
R_40_t28 \$40__t28 \$40 36.2709964858
* device instance _40_t29 r0 *1 0,0
R_40_t29 \$40__t29 \$40 30.6125448854
* device instance _40_t30 r0 *1 0,0
R_40_t30 \$40__t30 \$40 25.1543138941
* device instance _40_t31 r0 *1 0,0
R_40_t31 \$40__t31 \$40 20.0604086558
* device instance _40_t32 r0 *1 0,0
R_40_t32 \$40__t32 \$40 54.3327639614
* device instance _40_t33 r0 *1 0,0
R_40_t33 \$40__t33 \$40 53.4462950467
* device instance _40_t34 r0 *1 0,0
R_40_t34 \$40__t34 \$40 51.736545064
* device instance _40_t35 r0 *1 0,0
R_40_t35 \$40__t35 \$40 52.5805420858
* device instance _40_t36 r0 *1 0,0
R_40_t36 \$40__t36 \$40 49.661812123
* device instance _40_t37 r0 *1 0,0
R_40_t37 \$40__t37 \$40 49.0131313723
* device instance _40_t38 r0 *1 0,0
R_40_t38 \$40__t38 \$40 48.3945063803
* device instance _40_t39 r0 *1 0,0
R_40_t39 \$40__t39 \$40 47.8071039279
* device instance _40 r0 *1 0,0
C_40 \$40 vsubs 1.4581235e-13
* device instance _41_t0 r0 *1 0,0
R_41_t0 \$41__t0 \$41 81.7777390336
* device instance _41_t1 r0 *1 0,0
R_41_t1 \$41__t1 \$41 21.4987692264
* device instance _41_t2 r0 *1 0,0
R_41_t2 \$41__t2 \$41 100.29899174
* device instance _41 r0 *1 0,0
C_41 \$41 vsubs 5.956568e-15
* device instance _43_t0 r0 *1 0,0
R_43_t0 \$43__t0 \$43 108.687402234
* device instance _43_t1 r0 *1 0,0
R_43_t1 \$43__t1 \$43 28.7964709909
* device instance _43_t2 r0 *1 0,0
R_43_t2 \$43__t2 \$43 133.512826775
* device instance _43 r0 *1 0,0
C_43 \$43 vsubs 6.473346e-15
* device instance _45_t0 r0 *1 0,0
R_45_t0 \$45__t0 \$45 135.591504929
* device instance _45_t1 r0 *1 0,0
R_45_t1 \$45__t1 \$45 36.2048686624
* device instance _45_t2 r0 *1 0,0
R_45_t2 \$45__t2 \$45 166.824926409
* device instance _45 r0 *1 0,0
C_45 \$45 vsubs 7.017453e-15
* device instance _47_t0 r0 *1 0,0
R_47_t0 \$47__t0 \$47 162.444438203
* device instance _47_t1 r0 *1 0,0
R_47_t1 \$47__t1 \$47 43.7126105743
* device instance _47_t2 r0 *1 0,0
R_47_t2 \$47__t2 \$47 200.179851222
* device instance _47 r0 *1 0,0
C_47 \$47 vsubs 7.547896e-15
* device instance _48_t0 r0 *1 0,0
R_48_t0 \$48__t0 \$48 59.2408490213
* device instance _48_t1 r0 *1 0,0
R_48_t1 \$48__t1 \$48 25.0326142029
* device instance _48_t2 r0 *1 0,0
R_48_t2 \$48__t2 \$48 43.9123071765
* device instance _48_t3 r0 *1 0,0
R_48_t3 \$48__t3 \$48 51.2766367586
* device instance _48_t4 r0 *1 0,0
R_48_t4 \$48__t4 \$48 62.8853192817
* device instance _48_t5 r0 *1 0,0
R_48_t5 \$48__t5 \$48 68.6564414303
* device instance _48_t6 r0 *1 0,0
R_48_t6 \$48__t6 \$48 65.4329972861
* device instance _48_t7 r0 *1 0,0
R_48_t7 \$48__t7 \$48 63.4699084418
* device instance _48_t8 r0 *1 0,0
R_48_t8 \$48__t8 \$48 37.2260035799
* device instance _48_t9 r0 *1 0,0
R_48_t9 \$48__t9 \$48 30.8795324853
* device instance _48_t10 r0 *1 0,0
R_48_t10 \$48__t10 \$48 26.4669165237
* device instance _48_t11 r0 *1 0,0
R_48_t11 \$48__t11 \$48 67.5932309337
* device instance _48_t12 r0 *1 0,0
R_48_t12 \$48__t12 \$48 33.3002485168
* device instance _48_t13 r0 *1 0,0
R_48_t13 \$48__t13 \$48 42.5430288882
* device instance _48_t14 r0 *1 0,0
R_48_t14 \$48__t14 \$48 51.8661163235
* device instance _48_t15 r0 *1 0,0
R_48_t15 \$48__t15 \$48 61.232840027
* device instance _48_t16 r0 *1 0,0
R_48_t16 \$48__t16 \$48 89.3670527186
* device instance _48_t17 r0 *1 0,0
R_48_t17 \$48__t17 \$48 87.6600196013
* device instance _48_t18 r0 *1 0,0
R_48_t18 \$48__t18 \$48 85.9718503238
* device instance _48_t19 r0 *1 0,0
R_48_t19 \$48__t19 \$48 84.303678131
* device instance _48_t20 r0 *1 0,0
R_48_t20 \$48__t20 \$48 76.856093944
* device instance _48_t21 r0 *1 0,0
R_48_t21 \$48__t21 \$48 75.4322511095
* device instance _48_t22 r0 *1 0,0
R_48_t22 \$48__t22 \$48 74.0422914643
* device instance _48_t23 r0 *1 0,0
R_48_t23 \$48__t23 \$48 78.3119718301
* device instance _48 r0 *1 0,0
C_48 \$48 vsubs 1.32779351e-13
* device instance _49_t0 r0 *1 0,0
R_49_t0 \$49__t0 \$49 81.7777390336
* device instance _49_t1 r0 *1 0,0
R_49_t1 \$49__t1 \$49 21.4987692264
* device instance _49_t2 r0 *1 0,0
R_49_t2 \$49__t2 \$49 100.29899174
* device instance _49 r0 *1 0,0
C_49 \$49 vsubs 5.962076e-15
* device instance _5_t0 r0 *1 0,0
R_5_t0 \$5__t0 \$5 100.29899174
* device instance _5_t1 r0 *1 0,0
R_5_t1 \$5__t1 \$5 21.4987692264
* device instance _5_t2 r0 *1 0,0
R_5_t2 \$5__t2 \$5 81.7777390336
* device instance _5 r0 *1 0,0
C_5 \$5 vsubs 5.962076e-15
* device instance _51_t0 r0 *1 0,0
R_51_t0 \$51__t0 \$51 108.687402234
* device instance _51_t1 r0 *1 0,0
R_51_t1 \$51__t1 \$51 28.7964709909
* device instance _51_t2 r0 *1 0,0
R_51_t2 \$51__t2 \$51 133.512826775
* device instance _51 r0 *1 0,0
C_51 \$51 vsubs 6.492519e-15
* device instance _53_t0 r0 *1 0,0
R_53_t0 \$53__t0 \$53 135.591504929
* device instance _53_t1 r0 *1 0,0
R_53_t1 \$53__t1 \$53 36.2048686624
* device instance _53_t2 r0 *1 0,0
R_53_t2 \$53__t2 \$53 166.824926409
* device instance _53 r0 *1 0,0
C_53 \$53 vsubs 7.022961e-15
* device instance _55_t0 r0 *1 0,0
R_55_t0 \$55__t0 \$55 162.444438203
* device instance _55_t1 r0 *1 0,0
R_55_t1 \$55__t1 \$55 43.7126105743
* device instance _55_t2 r0 *1 0,0
R_55_t2 \$55__t2 \$55 200.179851222
* device instance _55 r0 *1 0,0
C_55 \$55 vsubs 7.553404e-15
* device instance _56_t0 r0 *1 0,0
R_56_t0 \$56__t0 \$56 124.337752899
* device instance _56_t1 r0 *1 0,0
R_56_t1 \$56__t1 \$56 134.098215711
* device instance _56_t2 r0 *1 0,0
R_56_t2 \$56__t2 \$56 86.3849133
* device instance _56_t3 r0 *1 0,0
R_56_t3 \$56__t3 \$56 88.7698933301
* device instance _56_t4 r0 *1 0,0
R_56_t4 \$56__t4 \$56 49.8327480374
* device instance _56_t5 r0 *1 0,0
R_56_t5 \$56__t5 \$56 45.4484549899
* device instance _56_t6 r0 *1 0,0
R_56_t6 \$56__t6 \$56 114.737828634
* device instance _56_t7 r0 *1 0,0
R_56_t7 \$56__t7 \$56 125.248648618
* device instance _56_t8 r0 *1 0,0
R_56_t8 \$56__t8 \$56 87.8405388707
* device instance _56_t9 r0 *1 0,0
R_56_t9 \$56__t9 \$56 94.0731642829
* device instance _56_t10 r0 *1 0,0
R_56_t10 \$56__t10 \$56 89.9037133955
* device instance _56_t11 r0 *1 0,0
R_56_t11 \$56__t11 \$56 91.9815797066
* device instance _56_t12 r0 *1 0,0
R_56_t12 \$56__t12 \$56 77.5069685996
* device instance _56_t13 r0 *1 0,0
R_56_t13 \$56__t13 \$56 79.3861242797
* device instance _56_t14 r0 *1 0,0
R_56_t14 \$56__t14 \$56 75.655267792
* device instance _56_t15 r0 *1 0,0
R_56_t15 \$56__t15 \$56 73.8330875536
* device instance _56 r0 *1 0,0
C_56 \$56 vsubs 1.26906803e-13
* device instance _57_t0 r0 *1 0,0
R_57_t0 \$57__t0 \$57 81.7777390336
* device instance _57_t1 r0 *1 0,0
R_57_t1 \$57__t1 \$57 21.4987692264
* device instance _57_t2 r0 *1 0,0
R_57_t2 \$57__t2 \$57 100.29899174
* device instance _57 r0 *1 0,0
C_57 \$57 vsubs 5.962076e-15
* device instance _59_t0 r0 *1 0,0
R_59_t0 \$59__t0 \$59 108.687402234
* device instance _59_t1 r0 *1 0,0
R_59_t1 \$59__t1 \$59 28.7964709909
* device instance _59_t2 r0 *1 0,0
R_59_t2 \$59__t2 \$59 133.512826775
* device instance _59 r0 *1 0,0
C_59 \$59 vsubs 6.492519e-15
* device instance _61_t0 r0 *1 0,0
R_61_t0 \$61__t0 \$61 135.591504929
* device instance _61_t1 r0 *1 0,0
R_61_t1 \$61__t1 \$61 36.2048686624
* device instance _61_t2 r0 *1 0,0
R_61_t2 \$61__t2 \$61 166.824926409
* device instance _61 r0 *1 0,0
C_61 \$61 vsubs 7.022961e-15
* device instance _63_t0 r0 *1 0,0
R_63_t0 \$63__t0 \$63 162.444438203
* device instance _63_t1 r0 *1 0,0
R_63_t1 \$63__t1 \$63 43.7126105743
* device instance _63_t2 r0 *1 0,0
R_63_t2 \$63__t2 \$63 200.179851222
* device instance _63 r0 *1 0,0
C_63 \$63 vsubs 7.553404e-15
* device instance _64_t0 r0 *1 0,0
R_64_t0 \$64__t0 \$64 252.863932211
* device instance _64_t1 r0 *1 0,0
R_64_t1 \$64__t1 \$64 146.949644361
* device instance _64_t2 r0 *1 0,0
R_64_t2 \$64__t2 \$64 102.380518794
* device instance _64_t3 r0 *1 0,0
R_64_t3 \$64__t3 \$64 240.807918259
* device instance _64_t4 r0 *1 0,0
R_64_t4 \$64__t4 \$64 101.451203335
* device instance _64_t5 r0 *1 0,0
R_64_t5 \$64__t5 \$64 98.6087679444
* device instance _64_t6 r0 *1 0,0
R_64_t6 \$64__t6 \$64 95.7793979853
* device instance _64_t7 r0 *1 0,0
R_64_t7 \$64__t7 \$64 92.9642864051
* device instance _64_t8 r0 *1 0,0
R_64_t8 \$64__t8 \$64 75.5205672098
* device instance _64_t9 r0 *1 0,0
R_64_t9 \$64__t9 \$64 78.0795365719
* device instance _64_t10 r0 *1 0,0
R_64_t10 \$64__t10 \$64 80.6730035165
* device instance _64_t11 r0 *1 0,0
R_64_t11 \$64__t11 \$64 72.9997234076
* device instance _64 r0 *1 0,0
C_64 \$64 vsubs 1.24716345e-13
* device instance _65_t0 r0 *1 0,0
R_65_t0 \$65__t0 \$65 81.7777390336
* device instance _65_t1 r0 *1 0,0
R_65_t1 \$65__t1 \$65 21.4987692264
* device instance _65_t2 r0 *1 0,0
R_65_t2 \$65__t2 \$65 100.29899174
* device instance _65 r0 *1 0,0
C_65 \$65 vsubs 5.962076e-15
* device instance _67_t0 r0 *1 0,0
R_67_t0 \$67__t0 \$67 108.687402234
* device instance _67_t1 r0 *1 0,0
R_67_t1 \$67__t1 \$67 28.7964709909
* device instance _67_t2 r0 *1 0,0
R_67_t2 \$67__t2 \$67 133.512826775
* device instance _67 r0 *1 0,0
C_67 \$67 vsubs 6.492519e-15
* device instance _69_t0 r0 *1 0,0
R_69_t0 \$69__t0 \$69 135.591504929
* device instance _69_t1 r0 *1 0,0
R_69_t1 \$69__t1 \$69 36.2048686624
* device instance _69_t2 r0 *1 0,0
R_69_t2 \$69__t2 \$69 166.824926409
* device instance _69 r0 *1 0,0
C_69 \$69 vsubs 7.022961e-15
* device instance _7_t0 r0 *1 0,0
R_7_t0 \$7__t0 \$7 108.687402234
* device instance _7_t1 r0 *1 0,0
R_7_t1 \$7__t1 \$7 28.7964709909
* device instance _7_t2 r0 *1 0,0
R_7_t2 \$7__t2 \$7 133.512826775
* device instance _7 r0 *1 0,0
C_7 \$7 vsubs 6.492519e-15
* device instance _71_t0 r0 *1 0,0
R_71_t0 \$71__t0 \$71 162.444438203
* device instance _71_t1 r0 *1 0,0
R_71_t1 \$71__t1 \$71 43.7126105743
* device instance _71_t2 r0 *1 0,0
R_71_t2 \$71__t2 \$71 200.179851222
* device instance _71 r0 *1 0,0
C_71 \$71 vsubs 7.553404e-15
* device instance _72_t0 r0 *1 0,0
R_72_t0 \$72__t0 \$72 254.061525599
* device instance _72_t1 r0 *1 0,0
R_72_t1 \$72__t1 \$72 430.2150524
* device instance _72_t2 r0 *1 0,0
R_72_t2 \$72__t2 \$72 100.985621919
* device instance _72_t3 r0 *1 0,0
R_72_t3 \$72__t3 \$72 97.1320607937
* device instance _72_t4 r0 *1 0,0
R_72_t4 \$72__t4 \$72 93.2917599877
* device instance _72_t5 r0 *1 0,0
R_72_t5 \$72__t5 \$72 89.466427095
* device instance _72_t6 r0 *1 0,0
R_72_t6 \$72__t6 \$72 61.8779217555
* device instance _72_t7 r0 *1 0,0
R_72_t7 \$72__t7 \$72 65.2488695775
* device instance _72_t8 r0 *1 0,0
R_72_t8 \$72__t8 \$72 68.6886206694
* device instance _72_t9 r0 *1 0,0
R_72_t9 \$72__t9 \$72 72.187340204
* device instance _72 r0 *1 0,0
C_72 \$72 vsubs 8.8233851e-14
* device instance _73_t0 r0 *1 0,0
R_73_t0 \$73__t0 \$73 81.7777390336
* device instance _73_t1 r0 *1 0,0
R_73_t1 \$73__t1 \$73 21.4987692264
* device instance _73_t2 r0 *1 0,0
R_73_t2 \$73__t2 \$73 100.29899174
* device instance _73 r0 *1 0,0
C_73 \$73 vsubs 5.962076e-15
* device instance _75_t0 r0 *1 0,0
R_75_t0 \$75__t0 \$75 108.687402234
* device instance _75_t1 r0 *1 0,0
R_75_t1 \$75__t1 \$75 28.7964709909
* device instance _75_t2 r0 *1 0,0
R_75_t2 \$75__t2 \$75 133.512826775
* device instance _75 r0 *1 0,0
C_75 \$75 vsubs 6.492519e-15
* device instance _77_t0 r0 *1 0,0
R_77_t0 \$77__t0 \$77 135.591504929
* device instance _77_t1 r0 *1 0,0
R_77_t1 \$77__t1 \$77 36.2048686624
* device instance _77_t2 r0 *1 0,0
R_77_t2 \$77__t2 \$77 166.824926409
* device instance _77 r0 *1 0,0
C_77 \$77 vsubs 7.022961e-15
* device instance _79_t0 r0 *1 0,0
R_79_t0 \$79__t0 \$79 162.444438203
* device instance _79_t1 r0 *1 0,0
R_79_t1 \$79__t1 \$79 43.7126105743
* device instance _79_t2 r0 *1 0,0
R_79_t2 \$79__t2 \$79 200.179851222
* device instance _79 r0 *1 0,0
C_79 \$79 vsubs 7.553404e-15
* device instance _80_t0 r0 *1 0,0
R_80_t0 \$80__t0 \$80 623.00385451
* device instance _80_t1 r0 *1 0,0
R_80_t1 \$80__t1 \$80 111.771352504
* device instance _80_t2 r0 *1 0,0
R_80_t2 \$80__t2 \$80 119.71349543
* device instance _80_t3 r0 *1 0,0
R_80_t3 \$80__t3 \$80 103.86395309
* device instance _80_t4 r0 *1 0,0
R_80_t4 \$80__t4 \$80 95.9998829198
* device instance _80_t5 r0 *1 0,0
R_80_t5 \$80__t5 \$80 57.2067469074
* device instance _80_t6 r0 *1 0,0
R_80_t6 \$80__t6 \$80 63.1623495827
* device instance _80_t7 r0 *1 0,0
R_80_t7 \$80__t7 \$80 47.3179103542
* device instance _80_t8 r0 *1 0,0
R_80_t8 \$80__t8 \$80 51.856654702
* device instance _80 r0 *1 0,0
C_80 \$80 vsubs 6.7094976e-14
* device instance _81_t0 r0 *1 0,0
R_81_t0 \$81__t0 \$81 9.2615116777
* device instance _81_t1 r0 *1 0,0
R_81_t1 \$81__t1 \$81 7.59443071306
* device instance _81_t2 r0 *1 0,0
R_81_t2 \$81__t2 \$81 5.92743411782
* device instance _81_t3 r0 *1 0,0
R_81_t3 \$81__t3 \$81 4.26062092343
* device instance _81_t4 r0 *1 0,0
R_81_t4 \$81__t4 \$81 10.9286384021
* device instance _81_t5 r0 *1 0,0
R_81_t5 \$81__t5 \$81 12.5401074035
* device instance _81_t6 r0 *1 0,0
R_81_t6 \$81__t6 \$81 8.93661557642
* device instance _81_t7 r0 *1 0,0
R_81_t7 \$81__t7 \$81 10.4945565393
* device instance _81_t8 r0 *1 0,0
R_81_t8 \$81__t8 \$81 13.6879110586
* device instance _81_t9 r0 *1 0,0
R_81_t9 \$81__t9 \$81 9.44735631673
* device instance _81_t10 r0 *1 0,0
R_81_t10 \$81__t10 \$81 11.0591509351
* device instance _81_t11 r0 *1 0,0
R_81_t11 \$81__t11 \$81 3.76183540881
* device instance _81_t12 r0 *1 0,0
R_81_t12 \$81__t12 \$81 12.0817074133
* device instance _81_t13 r0 *1 0,0
R_81_t13 \$81__t13 \$81 6.31077962818
* device instance _81_t14 r0 *1 0,0
R_81_t14 \$81__t14 \$81 6.01363598057
* device instance _81_t15 r0 *1 0,0
R_81_t15 \$81__t15 \$81 2.71678527375
* device instance _81_t16 r0 *1 0,0
R_81_t16 \$81__t16 \$81 12.6852834222
* device instance _81_t17 r0 *1 0,0
R_81_t17 \$81__t17 \$81 7.85872644976
* device instance _81_t18 r0 *1 0,0
R_81_t18 \$81__t18 \$81 14.1924348811
* device instance _81_t19 r0 *1 0,0
R_81_t19 \$81__t19 \$81 7.62216895664
* device instance _81_t20 r0 *1 0,0
R_81_t20 \$81__t20 \$81 9.25150904267
* device instance _81_t21 r0 *1 0,0
R_81_t21 \$81__t21 \$81 10.8923228742
* device instance _81_t22 r0 *1 0,0
R_81_t22 \$81__t22 \$81 14.3208704227
* device instance _81_t23 r0 *1 0,0
R_81_t23 \$81__t23 \$81 11.8639881145
* device instance _81_t24 r0 *1 0,0
R_81_t24 \$81__t24 \$81 10.2134722881
* device instance _81_t25 r0 *1 0,0
R_81_t25 \$81__t25 \$81 1.9004215103
* device instance _81_t26 r0 *1 0,0
R_81_t26 \$81__t26 \$81 0.726851095343
* device instance _81_t27 r0 *1 0,0
R_81_t27 \$81__t27 \$81 1.73330354502
* device instance _81_t28 r0 *1 0,0
R_81_t28 \$81__t28 \$81 3.3226025808
* device instance _81_t29 r0 *1 0,0
R_81_t29 \$81__t29 \$81 2.77210255808
* device instance _81_t30 r0 *1 0,0
R_81_t30 \$81__t30 \$81 4.96330058601
* device instance _81_t31 r0 *1 0,0
R_81_t31 \$81__t31 \$81 2.5943446478
* device instance _81_t32 r0 *1 0,0
R_81_t32 \$81__t32 \$81 0.931491125222
* device instance _81_t33 r0 *1 0,0
R_81_t33 \$81__t33 \$81 0.751029525081
* device instance _81_t34 r0 *1 0,0
R_81_t34 \$81__t34 \$81 2.41241228755
* device instance _81_t35 r0 *1 0,0
R_81_t35 \$81__t35 \$81 11.6019908877
* device instance _81_t36 r0 *1 0,0
R_81_t36 \$81__t36 \$81 13.2664029672
* device instance _81_t37 r0 *1 0,0
R_81_t37 \$81__t37 \$81 12.4491767358
* device instance _81_t38 r0 *1 0,0
R_81_t38 \$81__t38 \$81 1.32292799948
* device instance _81_t39 r0 *1 0,0
R_81_t39 \$81__t39 \$81 1.2027086609
* device instance _81_t40 r0 *1 0,0
R_81_t40 \$81__t40 \$81 2.58885994611
* device instance _81_t41 r0 *1 0,0
R_81_t41 \$81__t41 \$81 4.18535561028
* device instance _81_t42 r0 *1 0,0
R_81_t42 \$81__t42 \$81 4.44853839778
* device instance _81_t43 r0 *1 0,0
R_81_t43 \$81__t43 \$81 3.68069300916
* device instance _81_t44 r0 *1 0,0
R_81_t44 \$81__t44 \$81 3.86950428053
* device instance _81_t45 r0 *1 0,0
R_81_t45 \$81__t45 \$81 3.79022461596
* device instance _81_t46 r0 *1 0,0
R_81_t46 \$81__t46 \$81 4.73298524931
* device instance _81_t47 r0 *1 0,0
R_81_t47 \$81__t47 \$81 5.99965117047
* device instance _81_t48 r0 *1 0,0
R_81_t48 \$81__t48 \$81 3.4481551553
* device instance _81_t49 r0 *1 0,0
R_81_t49 \$81__t49 \$81 4.07857068212
* device instance _81_t50 r0 *1 0,0
R_81_t50 \$81__t50 \$81 2.75918229318
* device instance _81_t51 r0 *1 0,0
R_81_t51 \$81__t51 \$81 5.82164284501
* device instance _81_t52 r0 *1 0,0
R_81_t52 \$81__t52 \$81 5.7453513939
* device instance _81_t53 r0 *1 0,0
R_81_t53 \$81__t53 \$81 3.55480096788
* device instance _81_t54 r0 *1 0,0
R_81_t54 \$81__t54 \$81 2.99574500126
* device instance _81_t55 r0 *1 0,0
R_81_t55 \$81__t55 \$81 4.84268682502
* device instance _81_t56 r0 *1 0,0
R_81_t56 \$81__t56 \$81 3.14410229145
* device instance _81_t57 r0 *1 0,0
R_81_t57 \$81__t57 \$81 2.00559985637
* device instance _81_t58 r0 *1 0,0
R_81_t58 \$81__t58 \$81 1.92841914921
* device instance _81_t59 r0 *1 0,0
R_81_t59 \$81__t59 \$81 10.3731404095
* device instance _81_t60 r0 *1 0,0
R_81_t60 \$81__t60 \$81 4.70268930594
* device instance _81_t61 r0 *1 0,0
R_81_t61 \$81__t61 \$81 4.17593479562
* device instance _81_t62 r0 *1 0,0
R_81_t62 \$81__t62 \$81 8.75911880389
* device instance _81_t63 r0 *1 0,0
R_81_t63 \$81__t63 \$81 7.16949095496
* device instance _81_t64 r0 *1 0,0
R_81_t64 \$81__t64 \$81 5.62497617347
* device instance _81_t65 r0 *1 0,0
R_81_t65 \$81__t65 \$81 12.1950028719
* device instance _81_t66 r0 *1 0,0
R_81_t66 \$81__t66 \$81 12.0017182001
* device instance _81_t67 r0 *1 0,0
R_81_t67 \$81__t67 \$81 10.5961737078
* device instance _81_t68 r0 *1 0,0
R_81_t68 \$81__t68 \$81 9.02214040634
* device instance _81_t69 r0 *1 0,0
R_81_t69 \$81__t69 \$81 7.48855499039
* device instance _81_t70 r0 *1 0,0
R_81_t70 \$81__t70 \$81 6.02637637747
* device instance _81_t71 r0 *1 0,0
R_81_t71 \$81__t71 \$81 10.1099321179
* device instance _81_t72 r0 *1 0,0
R_81_t72 \$81__t72 \$81 8.60874594393
* device instance _81_t73 r0 *1 0,0
R_81_t73 \$81__t73 \$81 7.18119795666
* device instance _81_t74 r0 *1 0,0
R_81_t74 \$81__t74 \$81 11.9719163261
* device instance _81_t75 r0 *1 0,0
R_81_t75 \$81__t75 \$81 10.4722128393
* device instance _81_t76 r0 *1 0,0
R_81_t76 \$81__t76 \$81 9.03144623254
* device instance _81_t77 r0 *1 0,0
R_81_t77 \$81__t77 \$81 5.88115800883
* device instance _81_t78 r0 *1 0,0
R_81_t78 \$81__t78 \$81 8.5694303455
* device instance _81_t79 r0 *1 0,0
R_81_t79 \$81__t79 \$81 6.93646702428
* device instance _81_t80 r0 *1 0,0
R_81_t80 \$81__t80 \$81 5.32478461327
* device instance _81_t81 r0 *1 0,0
R_81_t81 \$81__t81 \$81 11.6563401716
* device instance _81_t82 r0 *1 0,0
R_81_t82 \$81__t82 \$81 10.0324243456
* device instance _81_t83 r0 *1 0,0
R_81_t83 \$81__t83 \$81 8.83790900694
* device instance _81_t84 r0 *1 0,0
R_81_t84 \$81__t84 \$81 7.81837905496
* device instance _81_t85 r0 *1 0,0
R_81_t85 \$81__t85 \$81 7.68284572388
* device instance _81_t86 r0 *1 0,0
R_81_t86 \$81__t86 \$81 6.48417564914
* device instance _81_t87 r0 *1 0,0
R_81_t87 \$81__t87 \$81 12.3358471278
* device instance _81_t88 r0 *1 0,0
R_81_t88 \$81__t88 \$81 10.8863945176
* device instance _81_t89 r0 *1 0,0
R_81_t89 \$81__t89 \$81 8.23847451035
* device instance _81_t90 r0 *1 0,0
R_81_t90 \$81__t90 \$81 7.13378424748
* device instance _81_t91 r0 *1 0,0
R_81_t91 \$81__t91 \$81 12.7439906512
* device instance _81_t92 r0 *1 0,0
R_81_t92 \$81__t92 \$81 11.346795096
* device instance _81_t93 r0 *1 0,0
R_81_t93 \$81__t93 \$81 9.50859426477
* device instance _81_t94 r0 *1 0,0
R_81_t94 \$81__t94 \$81 10.3115133562
* device instance _81_t95 r0 *1 0,0
R_81_t95 \$81__t95 \$81 9.36379685665
* device instance _81_t96 r0 *1 0,0
R_81_t96 \$81__t96 \$81 10.7318987852
* device instance _81_t97 r0 *1 0,0
R_81_t97 \$81__t97 \$81 12.1748071675
* device instance _81_t98 r0 *1 0,0
R_81_t98 \$81__t98 \$81 13.66885239
* device instance _81_t99 r0 *1 0,0
R_81_t99 \$81__t99 \$81 15.1989618008
* device instance _81_t100 r0 *1 0,0
R_81_t100 \$81__t100 \$81 8.87887085906
* device instance _81_t101 r0 *1 0,0
R_81_t101 \$81__t101 \$81 9.89529509059
* device instance _81_t102 r0 *1 0,0
R_81_t102 \$81__t102 \$81 13.4603740557
* device instance _81_t103 r0 *1 0,0
R_81_t103 \$81__t103 \$81 12.5881731368
* device instance _81_t104 r0 *1 0,0
R_81_t104 \$81__t104 \$81 14.0382940209
* device instance _81_t105 r0 *1 0,0
R_81_t105 \$81__t105 \$81 15.5320511582
* device instance _81_t106 r0 *1 0,0
R_81_t106 \$81__t106 \$81 11.8059131677
* device instance _81_t107 r0 *1 0,0
R_81_t107 \$81__t107 \$81 13.3413335848
* device instance _81_t108 r0 *1 0,0
R_81_t108 \$81__t108 \$81 4.9758736833
* device instance _81_t109 r0 *1 0,0
R_81_t109 \$81__t109 \$81 4.94526930948
* device instance _81_t110 r0 *1 0,0
R_81_t110 \$81__t110 \$81 11.198652816
* device instance _81_t111 r0 *1 0,0
R_81_t111 \$81__t111 \$81 2.34708290747
* device instance _81_t112 r0 *1 0,0
R_81_t112 \$81__t112 \$81 1.55740449869
* device instance _81_t113 r0 *1 0,0
R_81_t113 \$81__t113 \$81 4.15966399942
* device instance _81_t114 r0 *1 0,0
R_81_t114 \$81__t114 \$81 4.12300548377
* device instance _81_t115 r0 *1 0,0
R_81_t115 \$81__t115 \$81 4.71750590002
* device instance _81_t116 r0 *1 0,0
R_81_t116 \$81__t116 \$81 5.7506406322
* device instance _81_t117 r0 *1 0,0
R_81_t117 \$81__t117 \$81 7.0316563846
* device instance _81_t118 r0 *1 0,0
R_81_t118 \$81__t118 \$81 8.44854031225
* device instance _81_t119 r0 *1 0,0
R_81_t119 \$81__t119 \$81 9.94337937377
* device instance _81_t120 r0 *1 0,0
R_81_t120 \$81__t120 \$81 11.4857769176
* device instance _81_t121 r0 *1 0,0
R_81_t121 \$81__t121 \$81 13.0588922768
* device instance _81_t122 r0 *1 0,0
R_81_t122 \$81__t122 \$81 14.6528352771
* device instance _81_t123 r0 *1 0,0
R_81_t123 \$81__t123 \$81 6.99803955423
* device instance _81_t124 r0 *1 0,0
R_81_t124 \$81__t124 \$81 7.32457595316
* device instance _81_t125 r0 *1 0,0
R_81_t125 \$81__t125 \$81 4.81308144781
* device instance _81_t126 r0 *1 0,0
R_81_t126 \$81__t126 \$81 14.9051030182
* device instance _81_t127 r0 *1 0,0
R_81_t127 \$81__t127 \$81 5.46063867502
* device instance _81_t128 r0 *1 0,0
R_81_t128 \$81__t128 \$81 3.6705148467
* device instance _81_t129 r0 *1 0,0
R_81_t129 \$81__t129 \$81 3.22325764372
* device instance _81_t130 r0 *1 0,0
R_81_t130 \$81__t130 \$81 3.58683962593
* device instance _81_t131 r0 *1 0,0
R_81_t131 \$81__t131 \$81 4.57173547276
* device instance _81_t132 r0 *1 0,0
R_81_t132 \$81__t132 \$81 5.87328102767
* device instance _81_t133 r0 *1 0,0
R_81_t133 \$81__t133 \$81 2.96577543804
* device instance _81_t134 r0 *1 0,0
R_81_t134 \$81__t134 \$81 5.4508142732
* device instance _81_t135 r0 *1 0,0
R_81_t135 \$81__t135 \$81 2.39009090766
* device instance _81_t136 r0 *1 0,0
R_81_t136 \$81__t136 \$81 10.4228274868
* device instance _81_t137 r0 *1 0,0
R_81_t137 \$81__t137 \$81 12.0194538097
* device instance _81_t138 r0 *1 0,0
R_81_t138 \$81__t138 \$81 13.6329939856
* device instance _81_t139 r0 *1 0,0
R_81_t139 \$81__t139 \$81 8.58404674571
* device instance _81_t140 r0 *1 0,0
R_81_t140 \$81__t140 \$81 10.1960030173
* device instance _81_t141 r0 *1 0,0
R_81_t141 \$81__t141 \$81 11.8232996491
* device instance _81_t142 r0 *1 0,0
R_81_t142 \$81__t142 \$81 6.36603345929
* device instance _81_t143 r0 *1 0,0
R_81_t143 \$81__t143 \$81 7.05016202263
* device instance _81_t144 r0 *1 0,0
R_81_t144 \$81__t144 \$81 6.62131679579
* device instance _81_t145 r0 *1 0,0
R_81_t145 \$81__t145 \$81 6.59834871323
* device instance _81_t146 r0 *1 0,0
R_81_t146 \$81__t146 \$81 6.98526258912
* device instance _81_t147 r0 *1 0,0
R_81_t147 \$81__t147 \$81 7.72067997024
* device instance _81_t148 r0 *1 0,0
R_81_t148 \$81__t148 \$81 6.2824048889
* device instance _81_t149 r0 *1 0,0
R_81_t149 \$81__t149 \$81 5.79703913674
* device instance _81_t150 r0 *1 0,0
R_81_t150 \$81__t150 \$81 5.77079131351
* device instance _81_t151 r0 *1 0,0
R_81_t151 \$81__t151 \$81 6.20948629772
* device instance _81_t152 r0 *1 0,0
R_81_t152 \$81__t152 \$81 7.02657283784
* device instance _81_t153 r0 *1 0,0
R_81_t153 \$81__t153 \$81 7.54325565225
* device instance _81_t154 r0 *1 0,0
R_81_t154 \$81__t154 \$81 8.10845544329
* device instance _81_t155 r0 *1 0,0
R_81_t155 \$81__t155 \$81 8.71683560893
* device instance _81_t156 r0 *1 0,0
R_81_t156 \$81__t156 \$81 5.53373900246
* device instance _81_t157 r0 *1 0,0
R_81_t157 \$81__t157 \$81 2.86156656593
* device instance _81_t158 r0 *1 0,0
R_81_t158 \$81__t158 \$81 4.02789150077
* device instance _81_t159 r0 *1 0,0
R_81_t159 \$81__t159 \$81 12.5163996431
* device instance _81_t160 r0 *1 0,0
R_81_t160 \$81__t160 \$81 10.9645365714
* device instance _81_t161 r0 *1 0,0
R_81_t161 \$81__t161 \$81 9.45204647104
* device instance _81_t162 r0 *1 0,0
R_81_t162 \$81__t162 \$81 8.00128869765
* device instance _81_t163 r0 *1 0,0
R_81_t163 \$81__t163 \$81 6.65277214566
* device instance _81_t164 r0 *1 0,0
R_81_t164 \$81__t164 \$81 5.48246766404
* device instance _81_t165 r0 *1 0,0
R_81_t165 \$81__t165 \$81 4.62761755322
* device instance _81_t166 r0 *1 0,0
R_81_t166 \$81__t166 \$81 4.28153650187
* device instance _81_t167 r0 *1 0,0
R_81_t167 \$81__t167 \$81 4.56153301876
* device instance _81_t168 r0 *1 0,0
R_81_t168 \$81__t168 \$81 5.3705614429
* device instance _81_t169 r0 *1 0,0
R_81_t169 \$81__t169 \$81 6.51441440262
* device instance _81_t170 r0 *1 0,0
R_81_t170 \$81__t170 \$81 7.8480301906
* device instance _81_t171 r0 *1 0,0
R_81_t171 \$81__t171 \$81 9.70239605257
* device instance _81_t172 r0 *1 0,0
R_81_t172 \$81__t172 \$81 8.33205786292
* device instance _81_t173 r0 *1 0,0
R_81_t173 \$81__t173 \$81 14.1997288829
* device instance _81_t174 r0 *1 0,0
R_81_t174 \$81__t174 \$81 12.6586352037
* device instance _81_t175 r0 *1 0,0
R_81_t175 \$81__t175 \$81 11.1538830977
* device instance _81_t176 r0 *1 0,0
R_81_t176 \$81__t176 \$81 9.29004191608
* device instance _81_t177 r0 *1 0,0
R_81_t177 \$81__t177 \$81 10.7971059918
* device instance _81_t178 r0 *1 0,0
R_81_t178 \$81__t178 \$81 12.3454216154
* device instance _81_t179 r0 *1 0,0
R_81_t179 \$81__t179 \$81 13.9212316262
* device instance _81_t180 r0 *1 0,0
R_81_t180 \$81__t180 \$81 6.0559508395
* device instance _81_t181 r0 *1 0,0
R_81_t181 \$81__t181 \$81 3.59678803485
* device instance _81_t182 r0 *1 0,0
R_81_t182 \$81__t182 \$81 5.15087846535
* device instance _81_t183 r0 *1 0,0
R_81_t183 \$81__t183 \$81 6.75910732481
* device instance _81_t184 r0 *1 0,0
R_81_t184 \$81__t184 \$81 8.39040122748
* device instance _81_t185 r0 *1 0,0
R_81_t185 \$81__t185 \$81 10.0335164202
* device instance _81_t186 r0 *1 0,0
R_81_t186 \$81__t186 \$81 11.6834664726
* device instance _81_t187 r0 *1 0,0
R_81_t187 \$81__t187 \$81 13.3377150947
* device instance _81_t188 r0 *1 0,0
R_81_t188 \$81__t188 \$81 2.21394160648
* device instance _81_t189 r0 *1 0,0
R_81_t189 \$81__t189 \$81 5.35155994451
* device instance _81_t190 r0 *1 0,0
R_81_t190 \$81__t190 \$81 5.11499415203
* device instance _81_t191 r0 *1 0,0
R_81_t191 \$81__t191 \$81 5.40799912882
* device instance _81_t192 r0 *1 0,0
R_81_t192 \$81__t192 \$81 7.09007795215
* device instance _81_t193 r0 *1 0,0
R_81_t193 \$81__t193 \$81 6.20224914465
* device instance _81_t194 r0 *1 0,0
R_81_t194 \$81__t194 \$81 14.5208037045
* device instance _81_t195 r0 *1 0,0
R_81_t195 \$81__t195 \$81 11.5598679937
* device instance _81_t196 r0 *1 0,0
R_81_t196 \$81__t196 \$81 10.16651017
* device instance _81_t197 r0 *1 0,0
R_81_t197 \$81__t197 \$81 8.86818065367
* device instance _81_t198 r0 *1 0,0
R_81_t198 \$81__t198 \$81 7.71301790757
* device instance _81_t199 r0 *1 0,0
R_81_t199 \$81__t199 \$81 6.77465721977
* device instance _81_t200 r0 *1 0,0
R_81_t200 \$81__t200 \$81 6.15309952095
* device instance _81_t201 r0 *1 0,0
R_81_t201 \$81__t201 \$81 5.94849603264
* device instance _81_t202 r0 *1 0,0
R_81_t202 \$81__t202 \$81 13.0177757353
* device instance _81_t203 r0 *1 0,0
R_81_t203 \$81__t203 \$81 9.07940881881
* device instance _81_t204 r0 *1 0,0
R_81_t204 \$81__t204 \$81 14.1121548873
* device instance _81_t205 r0 *1 0,0
R_81_t205 \$81__t205 \$81 10.7465316511
* device instance _81_t206 r0 *1 0,0
R_81_t206 \$81__t206 \$81 12.4136835236
* device instance _81_t207 r0 *1 0,0
R_81_t207 \$81__t207 \$81 14.0808541213
* device instance _81_t208 r0 *1 0,0
R_81_t208 \$81__t208 \$81 7.47162414148
* device instance _81_t209 r0 *1 0,0
R_81_t209 \$81__t209 \$81 10.7875115436
* device instance _81_t210 r0 *1 0,0
R_81_t210 \$81__t210 \$81 8.27657154264
* device instance _81_t211 r0 *1 0,0
R_81_t211 \$81__t211 \$81 9.93852380873
* device instance _81_t212 r0 *1 0,0
R_81_t212 \$81__t212 \$81 9.12787638362
* device instance _81_t213 r0 *1 0,0
R_81_t213 \$81__t213 \$81 10.1201689671
* device instance _81_t214 r0 *1 0,0
R_81_t214 \$81__t214 \$81 8.4580104155
* device instance _81_t215 r0 *1 0,0
R_81_t215 \$81__t215 \$81 6.79833645248
* device instance _81_t216 r0 *1 0,0
R_81_t216 \$81__t216 \$81 5.14355275272
* device instance _81_t217 r0 *1 0,0
R_81_t217 \$81__t217 \$81 3.50060128909
* device instance _81_t218 r0 *1 0,0
R_81_t218 \$81__t218 \$81 6.18782920648
* device instance _81_t219 r0 *1 0,0
R_81_t219 \$81__t219 \$81 4.85959574918
* device instance _81_t220 r0 *1 0,0
R_81_t220 \$81__t220 \$81 8.03070698828
* device instance _81_t221 r0 *1 0,0
R_81_t221 \$81__t221 \$81 9.10491085343
* device instance _81_t222 r0 *1 0,0
R_81_t222 \$81__t222 \$81 10.6667371479
* device instance _81_t223 r0 *1 0,0
R_81_t223 \$81__t223 \$81 6.1496013188
* device instance _81_t224 r0 *1 0,0
R_81_t224 \$81__t224 \$81 12.2563648438
* device instance _81_t225 r0 *1 0,0
R_81_t225 \$81__t225 \$81 7.58807221772
* device instance _81_t226 r0 *1 0,0
R_81_t226 \$81__t226 \$81 9.62249839867
* device instance _81_t227 r0 *1 0,0
R_81_t227 \$81__t227 \$81 11.2361921575
* device instance _81_t228 r0 *1 0,0
R_81_t228 \$81__t228 \$81 7.79936746941
* device instance _81_t229 r0 *1 0,0
R_81_t229 \$81__t229 \$81 9.43028915907
* device instance _81_t230 r0 *1 0,0
R_81_t230 \$81__t230 \$81 11.0720319901
* device instance _81_t231 r0 *1 0,0
R_81_t231 \$81__t231 \$81 4.99697583837
* device instance _81_t232 r0 *1 0,0
R_81_t232 \$81__t232 \$81 6.47698634376
* device instance _81_t233 r0 *1 0,0
R_81_t233 \$81__t233 \$81 4.61602055029
* device instance _81_t234 r0 *1 0,0
R_81_t234 \$81__t234 \$81 7.21740864719
* device instance _81_t235 r0 *1 0,0
R_81_t235 \$81__t235 \$81 10.9689379659
* device instance _81_t236 r0 *1 0,0
R_81_t236 \$81__t236 \$81 9.30903117041
* device instance _81_t237 r0 *1 0,0
R_81_t237 \$81__t237 \$81 10.3147580061
* device instance _81_t238 r0 *1 0,0
R_81_t238 \$81__t238 \$81 11.7164035633
* device instance _81_t239 r0 *1 0,0
R_81_t239 \$81__t239 \$81 7.42629093362
* device instance _81_t240 r0 *1 0,0
R_81_t240 \$81__t240 \$81 13.1800345318
* device instance _81_t241 r0 *1 0,0
R_81_t241 \$81__t241 \$81 9.00409190628
* device instance _81_t242 r0 *1 0,0
R_81_t242 \$81__t242 \$81 8.85227167587
* device instance _81_t243 r0 *1 0,0
R_81_t243 \$81__t243 \$81 7.65230949655
* device instance _81_t244 r0 *1 0,0
R_81_t244 \$81__t244 \$81 6.00141133373
* device instance _81_t245 r0 *1 0,0
R_81_t245 \$81__t245 \$81 4.36295237524
* device instance _81_t246 r0 *1 0,0
R_81_t246 \$81__t246 \$81 11.7837607631
* device instance _81_t247 r0 *1 0,0
R_81_t247 \$81__t247 \$81 6.61727553987
* device instance _81_t248 r0 *1 0,0
R_81_t248 \$81__t248 \$81 7.41233462116
* device instance _81_t249 r0 *1 0,0
R_81_t249 \$81__t249 \$81 6.15540916964
* device instance _81_t250 r0 *1 0,0
R_81_t250 \$81__t250 \$81 6.86370904983
* device instance _81_t251 r0 *1 0,0
R_81_t251 \$81__t251 \$81 8.4765695409
* device instance _81_t252 r0 *1 0,0
R_81_t252 \$81__t252 \$81 9.85762612647
* device instance _81_t253 r0 *1 0,0
R_81_t253 \$81__t253 \$81 11.3160360808
* device instance _81_t254 r0 *1 0,0
R_81_t254 \$81__t254 \$81 12.825438409
* device instance _81_t255 r0 *1 0,0
R_81_t255 \$81__t255 \$81 7.83022524935
* device instance _81_t256 r0 *1 0,0
R_81_t256 \$81__t256 \$81 37.292404809
* device instance _81_t257 r0 *1 0,0
R_81_t257 \$81__t257 \$81 36.9295444756
* device instance _81_t258 r0 *1 0,0
R_81_t258 \$81__t258 \$81 36.566931706
* device instance _81_t259 r0 *1 0,0
R_81_t259 \$81__t259 \$81 36.2045739387
* device instance _81_t260 r0 *1 0,0
R_81_t260 \$81__t260 \$81 40.5096975078
* device instance _81_t261 r0 *1 0,0
R_81_t261 \$81__t261 \$81 40.1464388791
* device instance _81_t262 r0 *1 0,0
R_81_t262 \$81__t262 \$81 39.4205885435
* device instance _81_t263 r0 *1 0,0
R_81_t263 \$81__t263 \$81 39.7834005291
* device instance _81 r0 *1 0,0
C_81 \$81 vsubs 5.73982947e-13
* device instance _83_t0 r0 *1 0,0
R_83_t0 \$83__t0 \$83 13.034424285
* device instance _83_t1 r0 *1 0,0
R_83_t1 \$83__t1 \$83 12.2772364254
* device instance _83_t2 r0 *1 0,0
R_83_t2 \$83__t2 \$83 14.4890625705
* device instance _83_t3 r0 *1 0,0
R_83_t3 \$83__t3 \$83 16.7375363054
* device instance _83_t4 r0 *1 0,0
R_83_t4 \$83__t4 \$83 19.0096579782
* device instance _83_t5 r0 *1 0,0
R_83_t5 \$83__t5 \$83 21.2978604276
* device instance _83_t6 r0 *1 0,0
R_83_t6 \$83__t6 \$83 15.316772183
* device instance _83_t7 r0 *1 0,0
R_83_t7 \$83__t7 \$83 17.6159186886
* device instance _83_t8 r0 *1 0,0
R_83_t8 \$83__t8 \$83 3.39213210481
* device instance _83_t9 r0 *1 0,0
R_83_t9 \$83__t9 \$83 4.60053437284
* device instance _83_t10 r0 *1 0,0
R_83_t10 \$83__t10 \$83 19.9260497804
* device instance _83_t11 r0 *1 0,0
R_83_t11 \$83__t11 \$83 17.4359898995
* device instance _83_t12 r0 *1 0,0
R_83_t12 \$83__t12 \$83 19.7671599474
* device instance _83_t13 r0 *1 0,0
R_83_t13 \$83__t13 \$83 12.7902059786
* device instance _83_t14 r0 *1 0,0
R_83_t14 \$83__t14 \$83 15.1094891588
* device instance _83_t15 r0 *1 0,0
R_83_t15 \$83__t15 \$83 5.96038696917
* device instance _83_t16 r0 *1 0,0
R_83_t16 \$83__t16 \$83 8.1978133711
* device instance _83_t17 r0 *1 0,0
R_83_t17 \$83__t17 \$83 5.16930088244
* device instance _83_t18 r0 *1 0,0
R_83_t18 \$83__t18 \$83 4.45705583351
* device instance _83_t19 r0 *1 0,0
R_83_t19 \$83__t19 \$83 4.90089882223
* device instance _83_t20 r0 *1 0,0
R_83_t20 \$83__t20 \$83 6.25955743654
* device instance _83_t21 r0 *1 0,0
R_83_t21 \$83__t21 \$83 8.08424992253
* device instance _83_t22 r0 *1 0,0
R_83_t22 \$83__t22 \$83 3.58580414834
* device instance _83_t23 r0 *1 0,0
R_83_t23 \$83__t23 \$83 10.1261010163
* device instance _83_t24 r0 *1 0,0
R_83_t24 \$83__t24 \$83 8.57385511499
* device instance _83_t25 r0 *1 0,0
R_83_t25 \$83__t25 \$83 2.55952025284
* device instance _83_t26 r0 *1 0,0
R_83_t26 \$83__t26 \$83 2.28028786581
* device instance _83_t27 r0 *1 0,0
R_83_t27 \$83__t27 \$83 3.85461658926
* device instance _83_t28 r0 *1 0,0
R_83_t28 \$83__t28 \$83 6.4678481961
* device instance _83_t29 r0 *1 0,0
R_83_t29 \$83__t29 \$83 14.8504690887
* device instance _83_t30 r0 *1 0,0
R_83_t30 \$83__t30 \$83 12.5948866561
* device instance _83_t31 r0 *1 0,0
R_83_t31 \$83__t31 \$83 10.3795806793
* device instance _83_t32 r0 *1 0,0
R_83_t32 \$83__t32 \$83 8.23711161444
* device instance _83_t33 r0 *1 0,0
R_83_t33 \$83__t33 \$83 6.24292462655
* device instance _83_t34 r0 *1 0,0
R_83_t34 \$83__t34 \$83 12.9938063562
* device instance _83_t35 r0 *1 0,0
R_83_t35 \$83__t35 \$83 10.8601808835
* device instance _83_t36 r0 *1 0,0
R_83_t36 \$83__t36 \$83 8.83503488916
* device instance _83_t37 r0 *1 0,0
R_83_t37 \$83__t37 \$83 7.01298378985
* device instance _83_t38 r0 *1 0,0
R_83_t38 \$83__t38 \$83 15.1902687895
* device instance _83_t39 r0 *1 0,0
R_83_t39 \$83__t39 \$83 14.5387651449
* device instance _83_t40 r0 *1 0,0
R_83_t40 \$83__t40 \$83 12.4489085225
* device instance _83_t41 r0 *1 0,0
R_83_t41 \$83__t41 \$83 10.4682731305
* device instance _83_t42 r0 *1 0,0
R_83_t42 \$83__t42 \$83 8.67202102988
* device instance _83_t43 r0 *1 0,0
R_83_t43 \$83__t43 \$83 7.1995098877
* device instance _83_t44 r0 *1 0,0
R_83_t44 \$83__t44 \$83 17.1609607957
* device instance _83_t45 r0 *1 0,0
R_83_t45 \$83__t45 \$83 15.0694531891
* device instance _83_t46 r0 *1 0,0
R_83_t46 \$83__t46 \$83 13.0647637132
* device instance _83_t47 r0 *1 0,0
R_83_t47 \$83__t47 \$83 16.696881384
* device instance _83_t48 r0 *1 0,0
R_83_t48 \$83__t48 \$83 8.21861728659
* device instance _83_t49 r0 *1 0,0
R_83_t49 \$83__t49 \$83 11.1936352368
* device instance _83_t50 r0 *1 0,0
R_83_t50 \$83__t50 \$83 9.53502366137
* device instance _83_t51 r0 *1 0,0
R_83_t51 \$83__t51 \$83 16.6412130018
* device instance _83_t52 r0 *1 0,0
R_83_t52 \$83__t52 \$83 18.7788990974
* device instance _83_t53 r0 *1 0,0
R_83_t53 \$83__t53 \$83 20.9612480525
* device instance _83_t54 r0 *1 0,0
R_83_t54 \$83__t54 \$83 7.42862379292
* device instance _83_t55 r0 *1 0,0
R_83_t55 \$83__t55 \$83 7.337098901
* device instance _83_t56 r0 *1 0,0
R_83_t56 \$83__t56 \$83 7.96814762553
* device instance _83_t57 r0 *1 0,0
R_83_t57 \$83__t57 \$83 6.17416332815
* device instance _83_t58 r0 *1 0,0
R_83_t58 \$83__t58 \$83 6.91221014596
* device instance _83_t59 r0 *1 0,0
R_83_t59 \$83__t59 \$83 8.27325769416
* device instance _83_t60 r0 *1 0,0
R_83_t60 \$83__t60 \$83 10.0062342627
* device instance _83_t61 r0 *1 0,0
R_83_t61 \$83__t61 \$83 11.950416011
* device instance _83_t62 r0 *1 0,0
R_83_t62 \$83__t62 \$83 14.5678645143
* device instance _83_t63 r0 *1 0,0
R_83_t63 \$83__t63 \$83 16.1622165154
* device instance _83_t64 r0 *1 0,0
R_83_t64 \$83__t64 \$83 18.355770859
* device instance _83_t65 r0 *1 0,0
R_83_t65 \$83__t65 \$83 20.5830316629
* device instance _83_t66 r0 *1 0,0
R_83_t66 \$83__t66 \$83 12.5906779133
* device instance _83_t67 r0 *1 0,0
R_83_t67 \$83__t67 \$83 6.28265262261
* device instance _83_t68 r0 *1 0,0
R_83_t68 \$83__t68 \$83 14.0182006345
* device instance _83_t69 r0 *1 0,0
R_83_t69 \$83__t69 \$83 5.59605479365
* device instance _83_t70 r0 *1 0,0
R_83_t70 \$83__t70 \$83 4.94565509749
* device instance _83_t71 r0 *1 0,0
R_83_t71 \$83__t71 \$83 5.34910898245
* device instance _83_t72 r0 *1 0,0
R_83_t72 \$83__t72 \$83 6.61635979537
* device instance _83_t73 r0 *1 0,0
R_83_t73 \$83__t73 \$83 8.36356708889
* device instance _83_t74 r0 *1 0,0
R_83_t74 \$83__t74 \$83 4.59434386063
* device instance _83_t75 r0 *1 0,0
R_83_t75 \$83__t75 \$83 3.77513848746
* device instance _83_t76 r0 *1 0,0
R_83_t76 \$83__t76 \$83 10.3504627641
* device instance _83_t77 r0 *1 0,0
R_83_t77 \$83__t77 \$83 4.29012041349
* device instance _83_t78 r0 *1 0,0
R_83_t78 \$83__t78 \$83 16.8742193661
* device instance _83_t79 r0 *1 0,0
R_83_t79 \$83__t79 \$83 19.1301138022
* device instance _83_t80 r0 *1 0,0
R_83_t80 \$83__t80 \$83 21.4054436168
* device instance _83_t81 r0 *1 0,0
R_83_t81 \$83__t81 \$83 14.2940287557
* device instance _83_t82 r0 *1 0,0
R_83_t82 \$83__t82 \$83 16.5689904783
* device instance _83_t83 r0 *1 0,0
R_83_t83 \$83__t83 \$83 18.8614267844
* device instance _83_t84 r0 *1 0,0
R_83_t84 \$83__t84 \$83 9.84501120812
* device instance _83_t85 r0 *1 0,0
R_83_t85 \$83__t85 \$83 9.17384981097
* device instance _83_t86 r0 *1 0,0
R_83_t86 \$83__t86 \$83 10.7627808488
* device instance _83_t87 r0 *1 0,0
R_83_t87 \$83__t87 \$83 7.72925744858
* device instance _83_t88 r0 *1 0,0
R_83_t88 \$83__t88 \$83 5.79382284834
* device instance _83_t89 r0 *1 0,0
R_83_t89 \$83__t89 \$83 15.4260121049
* device instance _83_t90 r0 *1 0,0
R_83_t90 \$83__t90 \$83 13.2686316998
* device instance _83_t91 r0 *1 0,0
R_83_t91 \$83__t91 \$83 11.1875427321
* device instance _83_t92 r0 *1 0,0
R_83_t92 \$83__t92 \$83 9.23446939755
* device instance _83_t93 r0 *1 0,0
R_83_t93 \$83__t93 \$83 7.50996173081
* device instance _83_t94 r0 *1 0,0
R_83_t94 \$83__t94 \$83 6.20752872045
* device instance _83_t95 r0 *1 0,0
R_83_t95 \$83__t95 \$83 5.98586255002
* device instance _83_t96 r0 *1 0,0
R_83_t96 \$83__t96 \$83 7.14099436377
* device instance _83_t97 r0 *1 0,0
R_83_t97 \$83__t97 \$83 8.78446572149
* device instance _83_t98 r0 *1 0,0
R_83_t98 \$83__t98 \$83 10.6934401852
* device instance _83_t99 r0 *1 0,0
R_83_t99 \$83__t99 \$83 12.7492068556
* device instance _83_t100 r0 *1 0,0
R_83_t100 \$83__t100 \$83 5.62824021387
* device instance _83_t101 r0 *1 0,0
R_83_t101 \$83__t101 \$83 14.8910938274
* device instance _83_t102 r0 *1 0,0
R_83_t102 \$83__t102 \$83 17.0867452365
* device instance _83_t103 r0 *1 0,0
R_83_t103 \$83__t103 \$83 19.3178372922
* device instance _83_t104 r0 *1 0,0
R_83_t104 \$83__t104 \$83 21.5733771115
* device instance _83_t105 r0 *1 0,0
R_83_t105 \$83__t105 \$83 9.10884239346
* device instance _83_t106 r0 *1 0,0
R_83_t106 \$83__t106 \$83 4.34883462221
* device instance _83_t107 r0 *1 0,0
R_83_t107 \$83__t107 \$83 5.02187316017
* device instance _83_t108 r0 *1 0,0
R_83_t108 \$83__t108 \$83 11.3296774365
* device instance _83_t109 r0 *1 0,0
R_83_t109 \$83__t109 \$83 6.67740847906
* device instance _83_t110 r0 *1 0,0
R_83_t110 \$83__t110 \$83 12.815804539
* device instance _83_t111 r0 *1 0,0
R_83_t111 \$83__t111 \$83 15.038288076
* device instance _83_t112 r0 *1 0,0
R_83_t112 \$83__t112 \$83 8.57109583731
* device instance _83_t113 r0 *1 0,0
R_83_t113 \$83__t113 \$83 6.50256631576
* device instance _83_t114 r0 *1 0,0
R_83_t114 \$83__t114 \$83 15.8799280654
* device instance _83_t115 r0 *1 0,0
R_83_t115 \$83__t115 \$83 8.75580734618
* device instance _83_t116 r0 *1 0,0
R_83_t116 \$83__t116 \$83 11.0478388542
* device instance _83_t117 r0 *1 0,0
R_83_t117 \$83__t117 \$83 13.3587092149
* device instance _83_t118 r0 *1 0,0
R_83_t118 \$83__t118 \$83 15.6800914506
* device instance _83_t119 r0 *1 0,0
R_83_t119 \$83__t119 \$83 10.6465661685
* device instance _83_t120 r0 *1 0,0
R_83_t120 \$83__t120 \$83 6.97066827187
* device instance _83_t121 r0 *1 0,0
R_83_t121 \$83__t121 \$83 13.5927171438
* device instance _83_t122 r0 *1 0,0
R_83_t122 \$83__t122 \$83 21.1656604596
* device instance _83_t123 r0 *1 0,0
R_83_t123 \$83__t123 \$83 12.0464458718
* device instance _83_t124 r0 *1 0,0
R_83_t124 \$83__t124 \$83 12.4629327161
* device instance _83_t125 r0 *1 0,0
R_83_t125 \$83__t125 \$83 14.6467433859
* device instance _83_t126 r0 *1 0,0
R_83_t126 \$83__t126 \$83 10.7795505588
* device instance _83_t127 r0 *1 0,0
R_83_t127 \$83__t127 \$83 10.4829319747
* device instance _83_t128 r0 *1 0,0
R_83_t128 \$83__t128 \$83 42.8586309091
* device instance _83_t129 r0 *1 0,0
R_83_t129 \$83__t129 \$83 42.3552788565
* device instance _83_t130 r0 *1 0,0
R_83_t130 \$83__t130 \$83 41.8525318363
* device instance _83_t131 r0 *1 0,0
R_83_t131 \$83__t131 \$83 41.3504119169
* device instance _83_t132 r0 *1 0,0
R_83_t132 \$83__t132 \$83 47.3709981955
* device instance _83_t133 r0 *1 0,0
R_83_t133 \$83__t133 \$83 46.8661022771
* device instance _83_t134 r0 *1 0,0
R_83_t134 \$83__t134 \$83 46.3617189688
* device instance _83_t135 r0 *1 0,0
R_83_t135 \$83__t135 \$83 45.857865185
* device instance _83 r0 *1 0,0
C_83 \$83 vsubs 3.13607775e-13
* device instance _84_t0 r0 *1 0,0
R_84_t0 \$84__t0 \$84 19.5624231019
* device instance _84_t1 r0 *1 0,0
R_84_t1 \$84__t1 \$84 20.3805083417
* device instance _84_t2 r0 *1 0,0
R_84_t2 \$84__t2 \$84 27.2199222253
* device instance _84_t3 r0 *1 0,0
R_84_t3 \$84__t3 \$84 3.29053163373
* device instance _84_t4 r0 *1 0,0
R_84_t4 \$84__t4 \$84 6.70455757253
* device instance _84_t5 r0 *1 0,0
R_84_t5 \$84__t5 \$84 10.1225782947
* device instance _84_t6 r0 *1 0,0
R_84_t6 \$84__t6 \$84 13.5415691742
* device instance _84_t7 r0 *1 0,0
R_84_t7 \$84__t7 \$84 30.639707843
* device instance _84_t8 r0 *1 0,0
R_84_t8 \$84__t8 \$84 0.310015967392
* device instance _84_t9 r0 *1 0,0
R_84_t9 \$84__t9 \$84 16.2715659087
* device instance _84_t10 r0 *1 0,0
R_84_t10 \$84__t10 \$84 20.6625092752
* device instance _84_t11 r0 *1 0,0
R_84_t11 \$84__t11 \$84 13.8686336926
* device instance _84_t12 r0 *1 0,0
R_84_t12 \$84__t12 \$84 13.0472725847
* device instance _84_t13 r0 *1 0,0
R_84_t13 \$84__t13 \$84 9.95443579312
* device instance _84_t14 r0 *1 0,0
R_84_t14 \$84__t14 \$84 7.16535186132
* device instance _84_t15 r0 *1 0,0
R_84_t15 \$84__t15 \$84 24.6276605345
* device instance _84_t16 r0 *1 0,0
R_84_t16 \$84__t16 \$84 21.8380658545
* device instance _84_t17 r0 *1 0,0
R_84_t17 \$84__t17 \$84 19.2528590709
* device instance _84_t18 r0 *1 0,0
R_84_t18 \$84__t18 \$84 16.9657316325
* device instance _84_t19 r0 *1 0,0
R_84_t19 \$84__t19 \$84 15.1126279159
* device instance _84_t20 r0 *1 0,0
R_84_t20 \$84__t20 \$84 24.391545546
* device instance _84_t21 r0 *1 0,0
R_84_t21 \$84__t21 \$84 27.3135683191
* device instance _84_t22 r0 *1 0,0
R_84_t22 \$84__t22 \$84 30.3398506885
* device instance _84_t23 r0 *1 0,0
R_84_t23 \$84__t23 \$84 33.4421002714
* device instance _84_t24 r0 *1 0,0
R_84_t24 \$84__t24 \$84 5.10110123457
* device instance _84_t25 r0 *1 0,0
R_84_t25 \$84__t25 \$84 21.6161046259
* device instance _84_t26 r0 *1 0,0
R_84_t26 \$84__t26 \$84 13.7989119965
* device instance _84_t27 r0 *1 0,0
R_84_t27 \$84__t27 \$84 14.9844408003
* device instance _84_t28 r0 *1 0,0
R_84_t28 \$84__t28 \$84 16.7943134777
* device instance _84_t29 r0 *1 0,0
R_84_t29 \$84__t29 \$84 19.0514164711
* device instance _84_t30 r0 *1 0,0
R_84_t30 \$84__t30 \$84 13.4044203065
* device instance _84_t31 r0 *1 0,0
R_84_t31 \$84__t31 \$84 5.19478083386
* device instance _84_t32 r0 *1 0,0
R_84_t32 \$84__t32 \$84 23.7866336192
* device instance _84_t33 r0 *1 0,0
R_84_t33 \$84__t33 \$84 20.6498528172
* device instance _84_t34 r0 *1 0,0
R_84_t34 \$84__t34 \$84 17.6187658219
* device instance _84_t35 r0 *1 0,0
R_84_t35 \$84__t35 \$84 30.2449167612
* device instance _84_t36 r0 *1 0,0
R_84_t36 \$84__t36 \$84 26.992285227
* device instance _84_t37 r0 *1 0,0
R_84_t37 \$84__t37 \$84 6.96051183297
* device instance _84_t38 r0 *1 0,0
R_84_t38 \$84__t38 \$84 9.70918232534
* device instance _84_t39 r0 *1 0,0
R_84_t39 \$84__t39 \$84 12.7859189406
* device instance _84_t40 r0 *1 0,0
R_84_t40 \$84__t40 \$84 16.0026007312
* device instance _84_t41 r0 *1 0,0
R_84_t41 \$84__t41 \$84 19.2893427168
* device instance _84_t42 r0 *1 0,0
R_84_t42 \$84__t42 \$84 22.6156198236
* device instance _84_t43 r0 *1 0,0
R_84_t43 \$84__t43 \$84 25.9662431408
* device instance _84_t44 r0 *1 0,0
R_84_t44 \$84__t44 \$84 29.3328708272
* device instance _84_t45 r0 *1 0,0
R_84_t45 \$84__t45 \$84 32.7105616638
* device instance _84_t46 r0 *1 0,0
R_84_t46 \$84__t46 \$84 12.1904019767
* device instance _84_t47 r0 *1 0,0
R_84_t47 \$84__t47 \$84 10.1383629795
* device instance _84_t48 r0 *1 0,0
R_84_t48 \$84__t48 \$84 8.96431328841
* device instance _84_t49 r0 *1 0,0
R_84_t49 \$84__t49 \$84 9.01795025708
* device instance _84_t50 r0 *1 0,0
R_84_t50 \$84__t50 \$84 14.7586382191
* device instance _84_t51 r0 *1 0,0
R_84_t51 \$84__t51 \$84 33.5308592686
* device instance _84_t52 r0 *1 0,0
R_84_t52 \$84__t52 \$84 23.8001815218
* device instance _84_t53 r0 *1 0,0
R_84_t53 \$84__t53 \$84 3.57164200973
* device instance _84_t54 r0 *1 0,0
R_84_t54 \$84__t54 \$84 12.3866246769
* device instance _84_t55 r0 *1 0,0
R_84_t55 \$84__t55 \$84 13.8235382067
* device instance _84_t56 r0 *1 0,0
R_84_t56 \$84__t56 \$84 10.2800752052
* device instance _84_t57 r0 *1 0,0
R_84_t57 \$84__t57 \$84 17.242933231
* device instance _84_t58 r0 *1 0,0
R_84_t58 \$84__t58 \$84 10.4045026778
* device instance _84_t59 r0 *1 0,0
R_84_t59 \$84__t59 \$84 16.9609435275
* device instance _84_t60 r0 *1 0,0
R_84_t60 \$84__t60 \$84 6.98635446205
* device instance _84_t61 r0 *1 0,0
R_84_t61 \$84__t61 \$84 14.9856264743
* device instance _84_t62 r0 *1 0,0
R_84_t62 \$84__t62 \$84 17.863413337
* device instance _84_t63 r0 *1 0,0
R_84_t63 \$84__t63 \$84 20.9051686562
* device instance _84_t64 r0 *1 0,0
R_84_t64 \$84__t64 \$84 48.0276918136
* device instance _84_t65 r0 *1 0,0
R_84_t65 \$84__t65 \$84 47.3128497471
* device instance _84_t66 r0 *1 0,0
R_84_t66 \$84__t66 \$84 46.5997483009
* device instance _84_t67 r0 *1 0,0
R_84_t67 \$84__t67 \$84 45.8884686221
* device instance _84_t68 r0 *1 0,0
R_84_t68 \$84__t68 \$84 54.5489673842
* device instance _84_t69 r0 *1 0,0
R_84_t69 \$84__t69 \$84 53.8282216818
* device instance _84_t70 r0 *1 0,0
R_84_t70 \$84__t70 \$84 53.1088436745
* device instance _84_t71 r0 *1 0,0
R_84_t71 \$84__t71 \$84 52.3908897016
* device instance _84 r0 *1 0,0
C_84 \$84 vsubs 1.77182155e-13
* device instance _85_t0 r0 *1 0,0
R_85_t0 \$85__t0 \$85 5.79415215427
* device instance _85_t1 r0 *1 0,0
R_85_t1 \$85__t1 \$85 30.5020159979
* device instance _85_t2 r0 *1 0,0
R_85_t2 \$85__t2 \$85 25.072462352
* device instance _85_t3 r0 *1 0,0
R_85_t3 \$85__t3 \$85 19.6996442746
* device instance _85_t4 r0 *1 0,0
R_85_t4 \$85__t4 \$85 14.4470006713
* device instance _85_t5 r0 *1 0,0
R_85_t5 \$85__t5 \$85 9.51566602732
* device instance _85_t6 r0 *1 0,0
R_85_t6 \$85__t6 \$85 18.7857604464
* device instance _85_t7 r0 *1 0,0
R_85_t7 \$85__t7 \$85 6.14725354337
* device instance _85_t8 r0 *1 0,0
R_85_t8 \$85__t8 \$85 10.158616085
* device instance _85_t9 r0 *1 0,0
R_85_t9 \$85__t9 \$85 23.9017597558
* device instance _85_t10 r0 *1 0,0
R_85_t10 \$85__t10 \$85 50.8047650743
* device instance _85_t11 r0 *1 0,0
R_85_t11 \$85__t11 \$85 56.2731449656
* device instance _85_t12 r0 *1 0,0
R_85_t12 \$85__t12 \$85 29.1697732422
* device instance _85_t13 r0 *1 0,0
R_85_t13 \$85__t13 \$85 30.5275526285
* device instance _85_t14 r0 *1 0,0
R_85_t14 \$85__t14 \$85 28.5265409931
* device instance _85_t15 r0 *1 0,0
R_85_t15 \$85__t15 \$85 27.509777176
* device instance _85_t16 r0 *1 0,0
R_85_t16 \$85__t16 \$85 33.3360409412
* device instance _85_t17 r0 *1 0,0
R_85_t17 \$85__t17 \$85 40.6643409023
* device instance _85_t18 r0 *1 0,0
R_85_t18 \$85__t18 \$85 36.7674313691
* device instance _85_t19 r0 *1 0,0
R_85_t19 \$85__t19 \$85 27.5863076038
* device instance _85_t20 r0 *1 0,0
R_85_t20 \$85__t20 \$85 28.7474020017
* device instance _85_t21 r0 *1 0,0
R_85_t21 \$85__t21 \$85 57.4468658064
* device instance _85_t22 r0 *1 0,0
R_85_t22 \$85__t22 \$85 52.1018205145
* device instance _85_t23 r0 *1 0,0
R_85_t23 \$85__t23 \$85 46.8000987025
* device instance _85_t24 r0 *1 0,0
R_85_t24 \$85__t24 \$85 41.5582844196
* device instance _85_t25 r0 *1 0,0
R_85_t25 \$85__t25 \$85 36.4022663708
* device instance _85_t26 r0 *1 0,0
R_85_t26 \$85__t26 \$85 31.3743719883
* device instance _85_t27 r0 *1 0,0
R_85_t27 \$85__t27 \$85 26.5474983019
* device instance _85_t28 r0 *1 0,0
R_85_t28 \$85__t28 \$85 22.0540323345
* device instance _85_t29 r0 *1 0,0
R_85_t29 \$85__t29 \$85 34.5202759298
* device instance _85_t30 r0 *1 0,0
R_85_t30 \$85__t30 \$85 39.9201134422
* device instance _85_t31 r0 *1 0,0
R_85_t31 \$85__t31 \$85 45.3516669142
* device instance _85_t32 r0 *1 0,0
R_85_t32 \$85__t32 \$85 52.1523279446
* device instance _85_t33 r0 *1 0,0
R_85_t33 \$85__t33 \$85 51.0713235356
* device instance _85_t34 r0 *1 0,0
R_85_t34 \$85__t34 \$85 54.3353413936
* device instance _85_t35 r0 *1 0,0
R_85_t35 \$85__t35 \$85 53.2404769788
* device instance _85_t36 r0 *1 0,0
R_85_t36 \$85__t36 \$85 64.6574779839
* device instance _85_t37 r0 *1 0,0
R_85_t37 \$85__t37 \$85 63.5354736422
* device instance _85_t38 r0 *1 0,0
R_85_t38 \$85__t38 \$85 62.4181161136
* device instance _85_t39 r0 *1 0,0
R_85_t39 \$85__t39 \$85 61.3056594771
* device instance _85 r0 *1 0,0
C_85 \$85 vsubs 1.44349639e-13
* device instance _86_t0 r0 *1 0,0
R_86_t0 \$86__t0 \$86 31.3697488842
* device instance _86_t1 r0 *1 0,0
R_86_t1 \$86__t1 \$86 38.864779931
* device instance _86_t2 r0 *1 0,0
R_86_t2 \$86__t2 \$86 39.9380804289
* device instance _86_t3 r0 *1 0,0
R_86_t3 \$86__t3 \$86 27.2337538328
* device instance _86_t4 r0 *1 0,0
R_86_t4 \$86__t4 \$86 50.472760055
* device instance _86_t5 r0 *1 0,0
R_86_t5 \$86__t5 \$86 61.5140221704
* device instance _86_t6 r0 *1 0,0
R_86_t6 \$86__t6 \$86 97.8455159237
* device instance _86_t7 r0 *1 0,0
R_86_t7 \$86__t7 \$86 76.5788400168
* device instance _86_t8 r0 *1 0,0
R_86_t8 \$86__t8 \$86 82.5637207104
* device instance _86_t9 r0 *1 0,0
R_86_t9 \$86__t9 \$86 89.73986513
* device instance _86_t10 r0 *1 0,0
R_86_t10 \$86__t10 \$86 21.1843185636
* device instance _86_t11 r0 *1 0,0
R_86_t11 \$86__t11 \$86 34.893683157
* device instance _86_t12 r0 *1 0,0
R_86_t12 \$86__t12 \$86 26.289905862
* device instance _86_t13 r0 *1 0,0
R_86_t13 \$86__t13 \$86 27.9878496386
* device instance _86_t14 r0 *1 0,0
R_86_t14 \$86__t14 \$86 72.8318372444
* device instance _86_t15 r0 *1 0,0
R_86_t15 \$86__t15 \$86 22.145377228
* device instance _86_t16 r0 *1 0,0
R_86_t16 \$86__t16 \$86 71.2409054255
* device instance _86_t17 r0 *1 0,0
R_86_t17 \$86__t17 \$86 69.1997501482
* device instance _86_t18 r0 *1 0,0
R_86_t18 \$86__t18 \$86 67.203594104
* device instance _86_t19 r0 *1 0,0
R_86_t19 \$86__t19 \$86 65.2565669157
* device instance _86_t20 r0 *1 0,0
R_86_t20 \$86__t20 \$86 92.1979005812
* device instance _86_t21 r0 *1 0,0
R_86_t21 \$86__t21 \$86 89.960378837
* device instance _86_t22 r0 *1 0,0
R_86_t22 \$86__t22 \$86 85.5619074935
* device instance _86_t23 r0 *1 0,0
R_86_t23 \$86__t23 \$86 87.7477377179
* device instance _86 r0 *1 0,0
C_86 \$86 vsubs 1.2749138e-13
* device instance _87_t0 r0 *1 0,0
R_87_t0 \$87__t0 \$87 168.33607375
* device instance _87_t1 r0 *1 0,0
R_87_t1 \$87__t1 \$87 181.243358652
* device instance _87_t2 r0 *1 0,0
R_87_t2 \$87__t2 \$87 141.920059825
* device instance _87_t3 r0 *1 0,0
R_87_t3 \$87__t3 \$87 125.016727085
* device instance _87_t4 r0 *1 0,0
R_87_t4 \$87__t4 \$87 83.9329276865
* device instance _87_t5 r0 *1 0,0
R_87_t5 \$87__t5 \$87 72.2396640895
* device instance _87_t6 r0 *1 0,0
R_87_t6 \$87__t6 \$87 60.6425636404
* device instance _87_t7 r0 *1 0,0
R_87_t7 \$87__t7 \$87 43.0273545853
* device instance _87_t8 r0 *1 0,0
R_87_t8 \$87__t8 \$87 57.4802663024
* device instance _87_t9 r0 *1 0,0
R_87_t9 \$87__t9 \$87 55.7679108023
* device instance _87_t10 r0 *1 0,0
R_87_t10 \$87__t10 \$87 53.137056906
* device instance _87_t11 r0 *1 0,0
R_87_t11 \$87__t11 \$87 54.3131212759
* device instance _87_t12 r0 *1 0,0
R_87_t12 \$87__t12 \$87 78.3196641165
* device instance _87_t13 r0 *1 0,0
R_87_t13 \$87__t13 \$87 75.6541556398
* device instance _87_t14 r0 *1 0,0
R_87_t14 \$87__t14 \$87 81.1058858252
* device instance _87_t15 r0 *1 0,0
R_87_t15 \$87__t15 \$87 84.0008098181
* device instance _87 r0 *1 0,0
C_87 \$87 vsubs 1.17770046e-13
* device instance _88_t0 r0 *1 0,0
R_88_t0 \$88__t0 \$88 289.713773711
* device instance _88_t1 r0 *1 0,0
R_88_t1 \$88__t1 \$88 213.906295844
* device instance _88_t2 r0 *1 0,0
R_88_t2 \$88__t2 \$88 213.891180066
* device instance _88_t3 r0 *1 0,0
R_88_t3 \$88__t3 \$88 175.348726988
* device instance _88_t4 r0 *1 0,0
R_88_t4 \$88__t4 \$88 56.4680012372
* device instance _88_t5 r0 *1 0,0
R_88_t5 \$88__t5 \$88 54.3141014677
* device instance _88_t6 r0 *1 0,0
R_88_t6 \$88__t6 \$88 62.588173434
* device instance _88_t7 r0 *1 0,0
R_88_t7 \$88__t7 \$88 59.2541512659
* device instance _88_t8 r0 *1 0,0
R_88_t8 \$88__t8 \$88 66.4116942459
* device instance _88_t9 r0 *1 0,0
R_88_t9 \$88__t9 \$88 68.6226715932
* device instance _88_t10 r0 *1 0,0
R_88_t10 \$88__t10 \$88 71.3542900855
* device instance _88_t11 r0 *1 0,0
R_88_t11 \$88__t11 \$88 74.5493400619
* device instance _88 r0 *1 0,0
C_88 \$88 vsubs 1.11718715e-13
* device instance _89_t0 r0 *1 0,0
R_89_t0 \$89__t0 \$89 373.996867344
* device instance _89_t1 r0 *1 0,0
R_89_t1 \$89__t1 \$89 393.445773919
* device instance _89_t2 r0 *1 0,0
R_89_t2 \$89__t2 \$89 86.6479813766
* device instance _89_t3 r0 *1 0,0
R_89_t3 \$89__t3 \$89 78.9595246804
* device instance _89_t4 r0 *1 0,0
R_89_t4 \$89__t4 \$89 71.5104978885
* device instance _89_t5 r0 *1 0,0
R_89_t5 \$89__t5 \$89 64.3840584941
* device instance _89_t6 r0 *1 0,0
R_89_t6 \$89__t6 \$89 54.4557350201
* device instance _89_t7 r0 *1 0,0
R_89_t7 \$89__t7 \$89 54.5334241482
* device instance _89_t8 r0 *1 0,0
R_89_t8 \$89__t8 \$89 55.9890393869
* device instance _89_t9 r0 *1 0,0
R_89_t9 \$89__t9 \$89 58.7201977431
* device instance _89 r0 *1 0,0
C_89 \$89 vsubs 7.219247e-14
* device instance _9_t0 r0 *1 0,0
R_9_t0 \$9__t0 \$9 135.591504929
* device instance _9_t1 r0 *1 0,0
R_9_t1 \$9__t1 \$9 36.2048686624
* device instance _9_t2 r0 *1 0,0
R_9_t2 \$9__t2 \$9 166.824926409
* device instance _9 r0 *1 0,0
C_9 \$9 vsubs 7.022961e-15
* device instance _90_t0 r0 *1 0,0
R_90_t0 \$90__t0 \$90 438.262254277
* device instance _90_t1 r0 *1 0,0
R_90_t1 \$90__t1 \$90 116.734047769
* device instance _90_t2 r0 *1 0,0
R_90_t2 \$90__t2 \$90 98.772428992
* device instance _90_t3 r0 *1 0,0
R_90_t3 \$90__t3 \$90 81.3844454092
* device instance _90_t4 r0 *1 0,0
R_90_t4 \$90__t4 \$90 65.0318659218
* device instance _90_t5 r0 *1 0,0
R_90_t5 \$90__t5 \$90 130.228409648
* device instance _90_t6 r0 *1 0,0
R_90_t6 \$90__t6 \$90 114.651602343
* device instance _90_t7 r0 *1 0,0
R_90_t7 \$90__t7 \$90 100.343517804
* device instance _90_t8 r0 *1 0,0
R_90_t8 \$90__t8 \$90 87.9257278374
* device instance _90 r0 *1 0,0
C_90 \$90 vsubs 5.1062839e-14
* device instance _92_t0 r0 *1 0,0
R_92_t0 \$92__t0 \$92 135.591504929
* device instance _92_t1 r0 *1 0,0
R_92_t1 \$92__t1 \$92 36.2048686624
* device instance _92_t2 r0 *1 0,0
R_92_t2 \$92__t2 \$92 166.824926409
* device instance _92 r0 *1 0,0
C_92 \$92 vsubs 7.017453e-15
* device instance _94_t0 r0 *1 0,0
R_94_t0 \$94__t0 \$94 162.444438203
* device instance _94_t1 r0 *1 0,0
R_94_t1 \$94__t1 \$94 43.7126105743
* device instance _94_t2 r0 *1 0,0
R_94_t2 \$94__t2 \$94 200.179851222
* device instance _94 r0 *1 0,0
C_94 \$94 vsubs 7.547896e-15
* device instance _96_t0 r0 *1 0,0
R_96_t0 \$96__t0 \$96 135.591504929
* device instance _96_t1 r0 *1 0,0
R_96_t1 \$96__t1 \$96 36.2048686624
* device instance _96_t2 r0 *1 0,0
R_96_t2 \$96__t2 \$96 166.824926409
* device instance _96 r0 *1 0,0
C_96 \$96 vsubs 7.017453e-15
* device instance _98_t0 r0 *1 0,0
R_98_t0 \$98__t0 \$98 162.444438203
* device instance _98_t1 r0 *1 0,0
R_98_t1 \$98__t1 \$98 43.7126105743
* device instance _98_t2 r0 *1 0,0
R_98_t2 \$98__t2 \$98 200.179851222
* device instance _98 r0 *1 0,0
C_98 \$98 vsubs 7.547896e-15
* device instance XCMP_pon_t0 r0 *1 0,0
RXCMP_pon_t0 XCMP_pon__t0 XCMP_pon 62.0795529059
* device instance XCMP_pon_t1 r0 *1 0,0
RXCMP_pon_t1 XCMP_pon__t1 XCMP_pon 35.9690195653
* device instance XCMP_pon_t2 r0 *1 0,0
RXCMP_pon_t2 XCMP_pon__t2 XCMP_pon 93.6518275288
* device instance XCMP_pon r0 *1 0,0
CXCMP_pon XCMP_pon vsubs 1.414141e-14
* device instance XCMP_pop_t0 r0 *1 0,0
RXCMP_pop_t0 XCMP_pop__t0 XCMP_pop 75.940452855
* device instance XCMP_pop_t1 r0 *1 0,0
RXCMP_pop_t1 XCMP_pop__t1 XCMP_pop 32.959794498
* device instance XCMP_pop_t2 r0 *1 0,0
RXCMP_pop_t2 XCMP_pop__t2 XCMP_pop 46.717352647
* device instance XCMP_pop r0 *1 0,0
CXCMP_pop XCMP_pop vsubs 1.3000264e-14
* device instance cmpclk_t0 r0 *1 0,0
Rcmpclk_t0 cmpclk__t0 cmpclk 225.280143622
* device instance cmpclk_t1 r0 *1 0,0
Rcmpclk_t1 cmpclk__t1 cmpclk 11.9932814525
* device instance cmpclk_t2 r0 *1 0,0
Rcmpclk_t2 cmpclk__t2 cmpclk 72.4786334292
* device instance cmpclk_t3 r0 *1 0,0
Rcmpclk_t3 cmpclk__t3 cmpclk 102.435091231
* device instance cmpclk_t4 r0 *1 0,0
Rcmpclk_t4 cmpclk__t4 cmpclk 40.1974502653
* device instance cmpclk r0 *1 0,0
Ccmpclk cmpclk vsubs 6.31779e-15
* device instance dout_t0 r0 *1 0,0
Rdout_t0 dout__t0 dout 19.0113108636
* device instance dout_t1 r0 *1 0,0
Rdout_t1 dout__t1 dout 171.819344089
* device instance dout_t2 r0 *1 0,0
Rdout_t2 dout__t2 dout 101.498976799
* device instance dout_t3 r0 *1 0,0
Rdout_t3 dout__t3 dout 140.676620633
* device instance dout_t4 r0 *1 0,0
Rdout_t4 dout__t4 dout 81.1073476151
* device instance dout r0 *1 0,0
Cdout dout vsubs 7.71242e-15
* device instance doutb_t0 r0 *1 0,0
Rdoutb_t0 doutb__t0 doutb 203.889943473
* device instance doutb_t1 r0 *1 0,0
Rdoutb_t1 doutb__t1 doutb 73.9089276124
* device instance doutb_t2 r0 *1 0,0
Rdoutb_t2 doutb__t2 doutb 68.1966008872
* device instance doutb_t3 r0 *1 0,0
Rdoutb_t3 doutb__t3 doutb 17.5686860571
* device instance doutb_t4 r0 *1 0,0
Rdoutb_t4 doutb__t4 doutb 206.69534197
* device instance doutb r0 *1 0,0
Cdoutb doutb vsubs 8.067027e-15
* device instance hi_128_n_t0 r0 *1 0,0
Rhi_128_n_t0 hi_128_n__t0 hi_128_n 159.628415411
* device instance hi_128_n_t1 r0 *1 0,0
Rhi_128_n_t1 hi_128_n__t1 hi_128_n 17.8399437493
* device instance hi_128_n_t2 r0 *1 0,0
Rhi_128_n_t2 hi_128_n__t2 hi_128_n 156.869440839
* device instance hi_128_n r0 *1 0,0
Chi_128_n hi_128_n vsubs 4.857429e-15
* device instance hi_128_p_t0 r0 *1 0,0
Rhi_128_p_t0 hi_128_p__t0 hi_128_p 159.628415411
* device instance hi_128_p_t1 r0 *1 0,0
Rhi_128_p_t1 hi_128_p__t1 hi_128_p 17.8399437493
* device instance hi_128_p_t2 r0 *1 0,0
Rhi_128_p_t2 hi_128_p__t2 hi_128_p 156.869440839
* device instance hi_128_p r0 *1 0,0
Chi_128_p hi_128_p vsubs 4.857429e-15
* device instance hi_16_n_t0 r0 *1 0,0
Rhi_16_n_t0 hi_16_n__t0 hi_16_n 159.628415411
* device instance hi_16_n_t1 r0 *1 0,0
Rhi_16_n_t1 hi_16_n__t1 hi_16_n 17.8399437493
* device instance hi_16_n_t2 r0 *1 0,0
Rhi_16_n_t2 hi_16_n__t2 hi_16_n 156.869440839
* device instance hi_16_n r0 *1 0,0
Chi_16_n hi_16_n vsubs 4.851921e-15
* device instance hi_16_p_t0 r0 *1 0,0
Rhi_16_p_t0 hi_16_p__t0 hi_16_p 159.628415411
* device instance hi_16_p_t1 r0 *1 0,0
Rhi_16_p_t1 hi_16_p__t1 hi_16_p 17.8399437493
* device instance hi_16_p_t2 r0 *1 0,0
Rhi_16_p_t2 hi_16_p__t2 hi_16_p 156.869440839
* device instance hi_16_p r0 *1 0,0
Chi_16_p hi_16_p vsubs 4.851921e-15
* device instance hi_1_n_t0 r0 *1 0,0
Rhi_1_n_t0 hi_1_n__t0 hi_1_n 159.628415411
* device instance hi_1_n_t1 r0 *1 0,0
Rhi_1_n_t1 hi_1_n__t1 hi_1_n 17.8399437493
* device instance hi_1_n_t2 r0 *1 0,0
Rhi_1_n_t2 hi_1_n__t2 hi_1_n 156.869440839
* device instance hi_1_n r0 *1 0,0
Chi_1_n hi_1_n vsubs 4.857429e-15
* device instance hi_1_p_t0 r0 *1 0,0
Rhi_1_p_t0 hi_1_p__t0 hi_1_p 159.628415411
* device instance hi_1_p_t1 r0 *1 0,0
Rhi_1_p_t1 hi_1_p__t1 hi_1_p 17.8399437493
* device instance hi_1_p_t2 r0 *1 0,0
Rhi_1_p_t2 hi_1_p__t2 hi_1_p 156.869440839
* device instance hi_1_p r0 *1 0,0
Chi_1_p hi_1_p vsubs 4.857429e-15
* device instance hi_256_n_t0 r0 *1 0,0
Rhi_256_n_t0 hi_256_n__t0 hi_256_n 159.628415411
* device instance hi_256_n_t1 r0 *1 0,0
Rhi_256_n_t1 hi_256_n__t1 hi_256_n 17.8399437493
* device instance hi_256_n_t2 r0 *1 0,0
Rhi_256_n_t2 hi_256_n__t2 hi_256_n 156.869440839
* device instance hi_256_n r0 *1 0,0
Chi_256_n hi_256_n vsubs 4.857429e-15
* device instance hi_256_p_t0 r0 *1 0,0
Rhi_256_p_t0 hi_256_p__t0 hi_256_p 159.628415411
* device instance hi_256_p_t1 r0 *1 0,0
Rhi_256_p_t1 hi_256_p__t1 hi_256_p 17.8399437493
* device instance hi_256_p_t2 r0 *1 0,0
Rhi_256_p_t2 hi_256_p__t2 hi_256_p 156.869440839
* device instance hi_256_p r0 *1 0,0
Chi_256_p hi_256_p vsubs 4.857429e-15
* device instance hi_2_n_t0 r0 *1 0,0
Rhi_2_n_t0 hi_2_n__t0 hi_2_n 159.628415411
* device instance hi_2_n_t1 r0 *1 0,0
Rhi_2_n_t1 hi_2_n__t1 hi_2_n 17.8399437493
* device instance hi_2_n_t2 r0 *1 0,0
Rhi_2_n_t2 hi_2_n__t2 hi_2_n 156.869440839
* device instance hi_2_n r0 *1 0,0
Chi_2_n hi_2_n vsubs 4.857429e-15
* device instance hi_2_p_t0 r0 *1 0,0
Rhi_2_p_t0 hi_2_p__t0 hi_2_p 159.628415411
* device instance hi_2_p_t1 r0 *1 0,0
Rhi_2_p_t1 hi_2_p__t1 hi_2_p 17.8399437493
* device instance hi_2_p_t2 r0 *1 0,0
Rhi_2_p_t2 hi_2_p__t2 hi_2_p 156.869440839
* device instance hi_2_p r0 *1 0,0
Chi_2_p hi_2_p vsubs 4.857429e-15
* device instance hi_32_n_t0 r0 *1 0,0
Rhi_32_n_t0 hi_32_n__t0 hi_32_n 159.628415411
* device instance hi_32_n_t1 r0 *1 0,0
Rhi_32_n_t1 hi_32_n__t1 hi_32_n 17.8399437493
* device instance hi_32_n_t2 r0 *1 0,0
Rhi_32_n_t2 hi_32_n__t2 hi_32_n 156.869440839
* device instance hi_32_n r0 *1 0,0
Chi_32_n hi_32_n vsubs 4.857429e-15
* device instance hi_32_p_t0 r0 *1 0,0
Rhi_32_p_t0 hi_32_p__t0 hi_32_p 159.628415411
* device instance hi_32_p_t1 r0 *1 0,0
Rhi_32_p_t1 hi_32_p__t1 hi_32_p 17.8399437493
* device instance hi_32_p_t2 r0 *1 0,0
Rhi_32_p_t2 hi_32_p__t2 hi_32_p 156.869440839
* device instance hi_32_p r0 *1 0,0
Chi_32_p hi_32_p vsubs 4.857429e-15
* device instance hi_4_n_t0 r0 *1 0,0
Rhi_4_n_t0 hi_4_n__t0 hi_4_n 159.628415411
* device instance hi_4_n_t1 r0 *1 0,0
Rhi_4_n_t1 hi_4_n__t1 hi_4_n 17.8399437493
* device instance hi_4_n_t2 r0 *1 0,0
Rhi_4_n_t2 hi_4_n__t2 hi_4_n 156.869440839
* device instance hi_4_n r0 *1 0,0
Chi_4_n hi_4_n vsubs 4.857429e-15
* device instance hi_4_p_t0 r0 *1 0,0
Rhi_4_p_t0 hi_4_p__t0 hi_4_p 159.628415411
* device instance hi_4_p_t1 r0 *1 0,0
Rhi_4_p_t1 hi_4_p__t1 hi_4_p 17.8399437493
* device instance hi_4_p_t2 r0 *1 0,0
Rhi_4_p_t2 hi_4_p__t2 hi_4_p 156.869440839
* device instance hi_4_p r0 *1 0,0
Chi_4_p hi_4_p vsubs 4.857429e-15
* device instance hi_64_n_t0 r0 *1 0,0
Rhi_64_n_t0 hi_64_n__t0 hi_64_n 159.628415411
* device instance hi_64_n_t1 r0 *1 0,0
Rhi_64_n_t1 hi_64_n__t1 hi_64_n 17.8399437493
* device instance hi_64_n_t2 r0 *1 0,0
Rhi_64_n_t2 hi_64_n__t2 hi_64_n 156.869440839
* device instance hi_64_n r0 *1 0,0
Chi_64_n hi_64_n vsubs 4.857429e-15
* device instance hi_64_p_t0 r0 *1 0,0
Rhi_64_p_t0 hi_64_p__t0 hi_64_p 159.628415411
* device instance hi_64_p_t1 r0 *1 0,0
Rhi_64_p_t1 hi_64_p__t1 hi_64_p 17.8399437493
* device instance hi_64_p_t2 r0 *1 0,0
Rhi_64_p_t2 hi_64_p__t2 hi_64_p 156.869440839
* device instance hi_64_p r0 *1 0,0
Chi_64_p hi_64_p vsubs 4.857429e-15
* device instance hi_8_n_t0 r0 *1 0,0
Rhi_8_n_t0 hi_8_n__t0 hi_8_n 159.628415411
* device instance hi_8_n_t1 r0 *1 0,0
Rhi_8_n_t1 hi_8_n__t1 hi_8_n 17.8399437493
* device instance hi_8_n_t2 r0 *1 0,0
Rhi_8_n_t2 hi_8_n__t2 hi_8_n 156.869440839
* device instance hi_8_n r0 *1 0,0
Chi_8_n hi_8_n vsubs 4.857429e-15
* device instance hi_8_p_t0 r0 *1 0,0
Rhi_8_p_t0 hi_8_p__t0 hi_8_p 159.628415411
* device instance hi_8_p_t1 r0 *1 0,0
Rhi_8_p_t1 hi_8_p__t1 hi_8_p 17.8399437493
* device instance hi_8_p_t2 r0 *1 0,0
Rhi_8_p_t2 hi_8_p__t2 hi_8_p 156.869440839
* device instance hi_8_p r0 *1 0,0
Chi_8_p hi_8_p vsubs 4.857429e-15
* device instance ibias_t0 r0 *1 0,0
Ribias_t0 ibias__t0 ibias 70.34205
* device instance ibias_t1 r0 *1 0,0
Ribias_t1 ibias__t1 ibias 70.34205
* device instance ibias_t2 r0 *1 0,0
Ribias_t2 ibias__t2 ibias 140.6841
* device instance ibias r0 *1 0,0
Cibias ibias vsubs 5.518004e-15
* device instance lo_128_n_t0 r0 *1 0,0
Rlo_128_n_t0 lo_128_n__t0 lo_128_n 192.317036104
* device instance lo_128_n_t1 r0 *1 0,0
Rlo_128_n_t1 lo_128_n__t1 lo_128_n 21.6360274196
* device instance lo_128_n_t2 r0 *1 0,0
Rlo_128_n_t2 lo_128_n__t2 lo_128_n 188.273336477
* device instance lo_128_n r0 *1 0,0
Clo_128_n lo_128_n vsubs 5.390587e-15
* device instance lo_128_p_t0 r0 *1 0,0
Rlo_128_p_t0 lo_128_p__t0 lo_128_p 192.317036104
* device instance lo_128_p_t1 r0 *1 0,0
Rlo_128_p_t1 lo_128_p__t1 lo_128_p 21.6360274196
* device instance lo_128_p_t2 r0 *1 0,0
Rlo_128_p_t2 lo_128_p__t2 lo_128_p 188.273336477
* device instance lo_128_p r0 *1 0,0
Clo_128_p lo_128_p vsubs 5.394106e-15
* device instance lo_16_n_t0 r0 *1 0,0
Rlo_16_n_t0 lo_16_n__t0 lo_16_n 192.317036104
* device instance lo_16_n_t1 r0 *1 0,0
Rlo_16_n_t1 lo_16_n__t1 lo_16_n 21.6360274196
* device instance lo_16_n_t2 r0 *1 0,0
Rlo_16_n_t2 lo_16_n__t2 lo_16_n 188.273336477
* device instance lo_16_n r0 *1 0,0
Clo_16_n lo_16_n vsubs 5.385079e-15
* device instance lo_16_p_t0 r0 *1 0,0
Rlo_16_p_t0 lo_16_p__t0 lo_16_p 192.317036104
* device instance lo_16_p_t1 r0 *1 0,0
Rlo_16_p_t1 lo_16_p__t1 lo_16_p 21.6360274196
* device instance lo_16_p_t2 r0 *1 0,0
Rlo_16_p_t2 lo_16_p__t2 lo_16_p 188.273336477
* device instance lo_16_p r0 *1 0,0
Clo_16_p lo_16_p vsubs 5.388598e-15
* device instance lo_1_n_t0 r0 *1 0,0
Rlo_1_n_t0 lo_1_n__t0 lo_1_n 192.317036104
* device instance lo_1_n_t1 r0 *1 0,0
Rlo_1_n_t1 lo_1_n__t1 lo_1_n 21.6360274196
* device instance lo_1_n_t2 r0 *1 0,0
Rlo_1_n_t2 lo_1_n__t2 lo_1_n 188.273336477
* device instance lo_1_n r0 *1 0,0
Clo_1_n lo_1_n vsubs 5.390587e-15
* device instance lo_1_p_t0 r0 *1 0,0
Rlo_1_p_t0 lo_1_p__t0 lo_1_p 192.317036104
* device instance lo_1_p_t1 r0 *1 0,0
Rlo_1_p_t1 lo_1_p__t1 lo_1_p 21.6360274196
* device instance lo_1_p_t2 r0 *1 0,0
Rlo_1_p_t2 lo_1_p__t2 lo_1_p 188.273336477
* device instance lo_1_p r0 *1 0,0
Clo_1_p lo_1_p vsubs 5.394106e-15
* device instance lo_256_n_t0 r0 *1 0,0
Rlo_256_n_t0 lo_256_n__t0 lo_256_n 192.317036104
* device instance lo_256_n_t1 r0 *1 0,0
Rlo_256_n_t1 lo_256_n__t1 lo_256_n 21.6360274196
* device instance lo_256_n_t2 r0 *1 0,0
Rlo_256_n_t2 lo_256_n__t2 lo_256_n 188.273336477
* device instance lo_256_n r0 *1 0,0
Clo_256_n lo_256_n vsubs 5.390587e-15
* device instance lo_256_p_t0 r0 *1 0,0
Rlo_256_p_t0 lo_256_p__t0 lo_256_p 192.317036104
* device instance lo_256_p_t1 r0 *1 0,0
Rlo_256_p_t1 lo_256_p__t1 lo_256_p 21.6360274196
* device instance lo_256_p_t2 r0 *1 0,0
Rlo_256_p_t2 lo_256_p__t2 lo_256_p 188.273336477
* device instance lo_256_p r0 *1 0,0
Clo_256_p lo_256_p vsubs 5.394106e-15
* device instance lo_2_n_t0 r0 *1 0,0
Rlo_2_n_t0 lo_2_n__t0 lo_2_n 192.317036104
* device instance lo_2_n_t1 r0 *1 0,0
Rlo_2_n_t1 lo_2_n__t1 lo_2_n 21.6360274196
* device instance lo_2_n_t2 r0 *1 0,0
Rlo_2_n_t2 lo_2_n__t2 lo_2_n 188.273336477
* device instance lo_2_n r0 *1 0,0
Clo_2_n lo_2_n vsubs 5.390587e-15
* device instance lo_2_p_t0 r0 *1 0,0
Rlo_2_p_t0 lo_2_p__t0 lo_2_p 192.317036104
* device instance lo_2_p_t1 r0 *1 0,0
Rlo_2_p_t1 lo_2_p__t1 lo_2_p 21.6360274196
* device instance lo_2_p_t2 r0 *1 0,0
Rlo_2_p_t2 lo_2_p__t2 lo_2_p 188.273336477
* device instance lo_2_p r0 *1 0,0
Clo_2_p lo_2_p vsubs 5.394106e-15
* device instance lo_32_n_t0 r0 *1 0,0
Rlo_32_n_t0 lo_32_n__t0 lo_32_n 192.317036104
* device instance lo_32_n_t1 r0 *1 0,0
Rlo_32_n_t1 lo_32_n__t1 lo_32_n 21.6360274196
* device instance lo_32_n_t2 r0 *1 0,0
Rlo_32_n_t2 lo_32_n__t2 lo_32_n 188.273336477
* device instance lo_32_n r0 *1 0,0
Clo_32_n lo_32_n vsubs 5.390587e-15
* device instance lo_32_p_t0 r0 *1 0,0
Rlo_32_p_t0 lo_32_p__t0 lo_32_p 192.317036104
* device instance lo_32_p_t1 r0 *1 0,0
Rlo_32_p_t1 lo_32_p__t1 lo_32_p 21.6360274196
* device instance lo_32_p_t2 r0 *1 0,0
Rlo_32_p_t2 lo_32_p__t2 lo_32_p 188.273336477
* device instance lo_32_p r0 *1 0,0
Clo_32_p lo_32_p vsubs 5.394106e-15
* device instance lo_4_n_t0 r0 *1 0,0
Rlo_4_n_t0 lo_4_n__t0 lo_4_n 192.317036104
* device instance lo_4_n_t1 r0 *1 0,0
Rlo_4_n_t1 lo_4_n__t1 lo_4_n 21.6360274196
* device instance lo_4_n_t2 r0 *1 0,0
Rlo_4_n_t2 lo_4_n__t2 lo_4_n 188.273336477
* device instance lo_4_n r0 *1 0,0
Clo_4_n lo_4_n vsubs 5.390587e-15
* device instance lo_4_p_t0 r0 *1 0,0
Rlo_4_p_t0 lo_4_p__t0 lo_4_p 192.317036104
* device instance lo_4_p_t1 r0 *1 0,0
Rlo_4_p_t1 lo_4_p__t1 lo_4_p 21.6360274196
* device instance lo_4_p_t2 r0 *1 0,0
Rlo_4_p_t2 lo_4_p__t2 lo_4_p 188.273336477
* device instance lo_4_p r0 *1 0,0
Clo_4_p lo_4_p vsubs 5.394106e-15
* device instance lo_64_n_t0 r0 *1 0,0
Rlo_64_n_t0 lo_64_n__t0 lo_64_n 192.317036104
* device instance lo_64_n_t1 r0 *1 0,0
Rlo_64_n_t1 lo_64_n__t1 lo_64_n 21.6360274196
* device instance lo_64_n_t2 r0 *1 0,0
Rlo_64_n_t2 lo_64_n__t2 lo_64_n 188.273336477
* device instance lo_64_n r0 *1 0,0
Clo_64_n lo_64_n vsubs 5.390587e-15
* device instance lo_64_p_t0 r0 *1 0,0
Rlo_64_p_t0 lo_64_p__t0 lo_64_p 192.317036104
* device instance lo_64_p_t1 r0 *1 0,0
Rlo_64_p_t1 lo_64_p__t1 lo_64_p 21.6360274196
* device instance lo_64_p_t2 r0 *1 0,0
Rlo_64_p_t2 lo_64_p__t2 lo_64_p 188.273336477
* device instance lo_64_p r0 *1 0,0
Clo_64_p lo_64_p vsubs 5.394106e-15
* device instance lo_8_n_t0 r0 *1 0,0
Rlo_8_n_t0 lo_8_n__t0 lo_8_n 192.317036104
* device instance lo_8_n_t1 r0 *1 0,0
Rlo_8_n_t1 lo_8_n__t1 lo_8_n 21.6360274196
* device instance lo_8_n_t2 r0 *1 0,0
Rlo_8_n_t2 lo_8_n__t2 lo_8_n 188.273336477
* device instance lo_8_n r0 *1 0,0
Clo_8_n lo_8_n vsubs 5.390587e-15
* device instance lo_8_p_t0 r0 *1 0,0
Rlo_8_p_t0 lo_8_p__t0 lo_8_p 192.317036104
* device instance lo_8_p_t1 r0 *1 0,0
Rlo_8_p_t1 lo_8_p__t1 lo_8_p 21.6360274196
* device instance lo_8_p_t2 r0 *1 0,0
Rlo_8_p_t2 lo_8_p__t2 lo_8_p 188.273336477
* device instance lo_8_p r0 *1 0,0
Clo_8_p lo_8_p vsubs 5.394106e-15
* device instance pinn_t0 r0 *1 0,0
Rpinn_t0 pinn__t0 pinn 18.3699743913
* device instance pinn_t1 r0 *1 0,0
Rpinn_t1 pinn__t1 pinn 90.0297060612
* device instance pinn_t2 r0 *1 0,0
Rpinn_t2 pinn__t2 pinn 269.884755824
* device instance pinn_t3 r0 *1 0,0
Rpinn_t3 pinn__t3 pinn 197.931594322
* device instance pinn_t4 r0 *1 0,0
Rpinn_t4 pinn__t4 pinn 161.958109832
* device instance pinn_t5 r0 *1 0,0
Rpinn_t5 pinn__t5 pinn 233.907460461
* device instance pinn_t6 r0 *1 0,0
Rpinn_t6 pinn__t6 pinn 125.989047095
* device instance pinn_t7 r0 *1 0,0
Rpinn_t7 pinn__t7 pinn 54.0994759425
* device instance pinn_t8 r0 *1 0,0
Rpinn_t8 pinn__t8 pinn 305.862976071
* device instance pinn_t9 r0 *1 0,0
Rpinn_t9 pinn__t9 pinn 197.931594322
* device instance pinn_t10 r0 *1 0,0
Rpinn_t10 pinn__t10 pinn 269.884755824
* device instance pinn_t11 r0 *1 0,0
Rpinn_t11 pinn__t11 pinn 125.989047095
* device instance pinn_t12 r0 *1 0,0
Rpinn_t12 pinn__t12 pinn 305.862976071
* device instance pinn_t13 r0 *1 0,0
Rpinn_t13 pinn__t13 pinn 233.907460461
* device instance pinn_t14 r0 *1 0,0
Rpinn_t14 pinn__t14 pinn 161.958109832
* device instance pinn_t15 r0 *1 0,0
Rpinn_t15 pinn__t15 pinn 90.0297060612
* device instance pinn_t16 r0 *1 0,0
Rpinn_t16 pinn__t16 pinn 18.3699743913
* device instance pinn_t17 r0 *1 0,0
Rpinn_t17 pinn__t17 pinn 54.0994759425
* device instance pinn r0 *1 0,0
Cpinn pinn vsubs 8.37261e-14
* device instance pinp_t0 r0 *1 0,0
Rpinp_t0 pinp__t0 pinp 305.862976071
* device instance pinp_t1 r0 *1 0,0
Rpinp_t1 pinp__t1 pinp 269.884755824
* device instance pinp_t2 r0 *1 0,0
Rpinp_t2 pinp__t2 pinp 161.958109832
* device instance pinp_t3 r0 *1 0,0
Rpinp_t3 pinp__t3 pinp 233.907460461
* device instance pinp_t4 r0 *1 0,0
Rpinp_t4 pinp__t4 pinp 18.3699743913
* device instance pinp_t5 r0 *1 0,0
Rpinp_t5 pinp__t5 pinp 54.0994759425
* device instance pinp_t6 r0 *1 0,0
Rpinp_t6 pinp__t6 pinp 125.989047095
* device instance pinp_t7 r0 *1 0,0
Rpinp_t7 pinp__t7 pinp 197.931594322
* device instance pinp_t8 r0 *1 0,0
Rpinp_t8 pinp__t8 pinp 305.862976071
* device instance pinp_t9 r0 *1 0,0
Rpinp_t9 pinp__t9 pinp 90.0297060612
* device instance pinp_t10 r0 *1 0,0
Rpinp_t10 pinp__t10 pinp 197.931594322
* device instance pinp_t11 r0 *1 0,0
Rpinp_t11 pinp__t11 pinp 269.884755824
* device instance pinp_t12 r0 *1 0,0
Rpinp_t12 pinp__t12 pinp 125.989047095
* device instance pinp_t13 r0 *1 0,0
Rpinp_t13 pinp__t13 pinp 18.3699743913
* device instance pinp_t14 r0 *1 0,0
Rpinp_t14 pinp__t14 pinp 161.958109832
* device instance pinp_t15 r0 *1 0,0
Rpinp_t15 pinp__t15 pinp 233.907460461
* device instance pinp_t16 r0 *1 0,0
Rpinp_t16 pinp__t16 pinp 90.0297060612
* device instance pinp_t17 r0 *1 0,0
Rpinp_t17 pinp__t17 pinp 54.0994759425
* device instance pinp r0 *1 0,0
Cpinp pinp vsubs 8.378118e-14
* device instance rel_128_n_t0 r0 *1 0,0
Rrel_128_n_t0 rel_128_n__t0 rel_128_n 127.025622285
* device instance rel_128_n_t1 r0 *1 0,0
Rrel_128_n_t1 rel_128_n__t1 rel_128_n 14.1171220219
* device instance rel_128_n_t2 r0 *1 0,0
Rrel_128_n_t2 rel_128_n__t2 rel_128_n 125.307355693
* device instance rel_128_n r0 *1 0,0
Crel_128_n rel_128_n vsubs 4.320752e-15
* device instance rel_128_p_t0 r0 *1 0,0
Rrel_128_p_t0 rel_128_p__t0 rel_128_p 127.025622285
* device instance rel_128_p_t1 r0 *1 0,0
Rrel_128_p_t1 rel_128_p__t1 rel_128_p 14.1171220219
* device instance rel_128_p_t2 r0 *1 0,0
Rrel_128_p_t2 rel_128_p__t2 rel_128_p 125.307355693
* device instance rel_128_p r0 *1 0,0
Crel_128_p rel_128_p vsubs 4.320752e-15
* device instance rel_16_n_t0 r0 *1 0,0
Rrel_16_n_t0 rel_16_n__t0 rel_16_n 127.025622285
* device instance rel_16_n_t1 r0 *1 0,0
Rrel_16_n_t1 rel_16_n__t1 rel_16_n 14.1171220219
* device instance rel_16_n_t2 r0 *1 0,0
Rrel_16_n_t2 rel_16_n__t2 rel_16_n 125.307355693
* device instance rel_16_n r0 *1 0,0
Crel_16_n rel_16_n vsubs 4.320701e-15
* device instance rel_16_p_t0 r0 *1 0,0
Rrel_16_p_t0 rel_16_p__t0 rel_16_p 127.025622285
* device instance rel_16_p_t1 r0 *1 0,0
Rrel_16_p_t1 rel_16_p__t1 rel_16_p 14.1171220219
* device instance rel_16_p_t2 r0 *1 0,0
Rrel_16_p_t2 rel_16_p__t2 rel_16_p 125.307355693
* device instance rel_16_p r0 *1 0,0
Crel_16_p rel_16_p vsubs 4.320701e-15
* device instance rel_1_n_t0 r0 *1 0,0
Rrel_1_n_t0 rel_1_n__t0 rel_1_n 127.025622285
* device instance rel_1_n_t1 r0 *1 0,0
Rrel_1_n_t1 rel_1_n__t1 rel_1_n 14.1171220219
* device instance rel_1_n_t2 r0 *1 0,0
Rrel_1_n_t2 rel_1_n__t2 rel_1_n 125.307355693
* device instance rel_1_n r0 *1 0,0
Crel_1_n rel_1_n vsubs 4.320752e-15
* device instance rel_1_p_t0 r0 *1 0,0
Rrel_1_p_t0 rel_1_p__t0 rel_1_p 127.025622285
* device instance rel_1_p_t1 r0 *1 0,0
Rrel_1_p_t1 rel_1_p__t1 rel_1_p 14.1171220219
* device instance rel_1_p_t2 r0 *1 0,0
Rrel_1_p_t2 rel_1_p__t2 rel_1_p 125.307355693
* device instance rel_1_p r0 *1 0,0
Crel_1_p rel_1_p vsubs 4.320752e-15
* device instance rel_256_n_t0 r0 *1 0,0
Rrel_256_n_t0 rel_256_n__t0 rel_256_n 127.025622285
* device instance rel_256_n_t1 r0 *1 0,0
Rrel_256_n_t1 rel_256_n__t1 rel_256_n 14.1171220219
* device instance rel_256_n_t2 r0 *1 0,0
Rrel_256_n_t2 rel_256_n__t2 rel_256_n 125.307355693
* device instance rel_256_n r0 *1 0,0
Crel_256_n rel_256_n vsubs 4.320752e-15
* device instance rel_256_p_t0 r0 *1 0,0
Rrel_256_p_t0 rel_256_p__t0 rel_256_p 127.025622285
* device instance rel_256_p_t1 r0 *1 0,0
Rrel_256_p_t1 rel_256_p__t1 rel_256_p 14.1171220219
* device instance rel_256_p_t2 r0 *1 0,0
Rrel_256_p_t2 rel_256_p__t2 rel_256_p 125.307355693
* device instance rel_256_p r0 *1 0,0
Crel_256_p rel_256_p vsubs 4.320752e-15
* device instance rel_2_n_t0 r0 *1 0,0
Rrel_2_n_t0 rel_2_n__t0 rel_2_n 127.025622285
* device instance rel_2_n_t1 r0 *1 0,0
Rrel_2_n_t1 rel_2_n__t1 rel_2_n 14.1171220219
* device instance rel_2_n_t2 r0 *1 0,0
Rrel_2_n_t2 rel_2_n__t2 rel_2_n 125.307355693
* device instance rel_2_n r0 *1 0,0
Crel_2_n rel_2_n vsubs 4.320752e-15
* device instance rel_2_p_t0 r0 *1 0,0
Rrel_2_p_t0 rel_2_p__t0 rel_2_p 127.025622285
* device instance rel_2_p_t1 r0 *1 0,0
Rrel_2_p_t1 rel_2_p__t1 rel_2_p 14.1171220219
* device instance rel_2_p_t2 r0 *1 0,0
Rrel_2_p_t2 rel_2_p__t2 rel_2_p 125.307355693
* device instance rel_2_p r0 *1 0,0
Crel_2_p rel_2_p vsubs 4.320752e-15
* device instance rel_32_n_t0 r0 *1 0,0
Rrel_32_n_t0 rel_32_n__t0 rel_32_n 127.025622285
* device instance rel_32_n_t1 r0 *1 0,0
Rrel_32_n_t1 rel_32_n__t1 rel_32_n 14.1171220219
* device instance rel_32_n_t2 r0 *1 0,0
Rrel_32_n_t2 rel_32_n__t2 rel_32_n 125.307355693
* device instance rel_32_n r0 *1 0,0
Crel_32_n rel_32_n vsubs 4.320752e-15
* device instance rel_32_p_t0 r0 *1 0,0
Rrel_32_p_t0 rel_32_p__t0 rel_32_p 127.025622285
* device instance rel_32_p_t1 r0 *1 0,0
Rrel_32_p_t1 rel_32_p__t1 rel_32_p 14.1171220219
* device instance rel_32_p_t2 r0 *1 0,0
Rrel_32_p_t2 rel_32_p__t2 rel_32_p 125.307355693
* device instance rel_32_p r0 *1 0,0
Crel_32_p rel_32_p vsubs 4.320752e-15
* device instance rel_4_n_t0 r0 *1 0,0
Rrel_4_n_t0 rel_4_n__t0 rel_4_n 127.025622285
* device instance rel_4_n_t1 r0 *1 0,0
Rrel_4_n_t1 rel_4_n__t1 rel_4_n 14.1171220219
* device instance rel_4_n_t2 r0 *1 0,0
Rrel_4_n_t2 rel_4_n__t2 rel_4_n 125.307355693
* device instance rel_4_n r0 *1 0,0
Crel_4_n rel_4_n vsubs 4.320752e-15
* device instance rel_4_p_t0 r0 *1 0,0
Rrel_4_p_t0 rel_4_p__t0 rel_4_p 127.025622285
* device instance rel_4_p_t1 r0 *1 0,0
Rrel_4_p_t1 rel_4_p__t1 rel_4_p 14.1171220219
* device instance rel_4_p_t2 r0 *1 0,0
Rrel_4_p_t2 rel_4_p__t2 rel_4_p 125.307355693
* device instance rel_4_p r0 *1 0,0
Crel_4_p rel_4_p vsubs 4.320752e-15
* device instance rel_64_n_t0 r0 *1 0,0
Rrel_64_n_t0 rel_64_n__t0 rel_64_n 127.025622285
* device instance rel_64_n_t1 r0 *1 0,0
Rrel_64_n_t1 rel_64_n__t1 rel_64_n 14.1171220219
* device instance rel_64_n_t2 r0 *1 0,0
Rrel_64_n_t2 rel_64_n__t2 rel_64_n 125.307355693
* device instance rel_64_n r0 *1 0,0
Crel_64_n rel_64_n vsubs 4.320752e-15
* device instance rel_64_p_t0 r0 *1 0,0
Rrel_64_p_t0 rel_64_p__t0 rel_64_p 127.025622285
* device instance rel_64_p_t1 r0 *1 0,0
Rrel_64_p_t1 rel_64_p__t1 rel_64_p 14.1171220219
* device instance rel_64_p_t2 r0 *1 0,0
Rrel_64_p_t2 rel_64_p__t2 rel_64_p 125.307355693
* device instance rel_64_p r0 *1 0,0
Crel_64_p rel_64_p vsubs 4.320752e-15
* device instance rel_8_n_t0 r0 *1 0,0
Rrel_8_n_t0 rel_8_n__t0 rel_8_n 127.025622285
* device instance rel_8_n_t1 r0 *1 0,0
Rrel_8_n_t1 rel_8_n__t1 rel_8_n 14.1171220219
* device instance rel_8_n_t2 r0 *1 0,0
Rrel_8_n_t2 rel_8_n__t2 rel_8_n 125.307355693
* device instance rel_8_n r0 *1 0,0
Crel_8_n rel_8_n vsubs 4.320752e-15
* device instance rel_8_p_t0 r0 *1 0,0
Rrel_8_p_t0 rel_8_p__t0 rel_8_p 127.025622285
* device instance rel_8_p_t1 r0 *1 0,0
Rrel_8_p_t1 rel_8_p__t1 rel_8_p 14.1171220219
* device instance rel_8_p_t2 r0 *1 0,0
Rrel_8_p_t2 rel_8_p__t2 rel_8_p 125.307355693
* device instance rel_8_p r0 *1 0,0
Crel_8_p rel_8_p vsubs 4.320752e-15
* device instance sel_in_t0 r0 *1 0,0
Rsel_in_t0 sel_in__t0 sel_in 157.797645186
* device instance sel_in_t1 r0 *1 0,0
Rsel_in_t1 sel_in__t1 sel_in 148.648729445
* device instance sel_in_t2 r0 *1 0,0
Rsel_in_t2 sel_in__t2 sel_in 16.2004021299
* device instance sel_in_t3 r0 *1 0,0
Rsel_in_t3 sel_in__t3 sel_in 84.37764975
* device instance sel_in_t4 r0 *1 0,0
Rsel_in_t4 sel_in__t4 sel_in 139.236537157
* device instance sel_in_t5 r0 *1 0,0
Rsel_in_t5 sel_in__t5 sel_in 48.1891399383
* device instance sel_in_t6 r0 *1 0,0
Rsel_in_t6 sel_in__t6 sel_in 48.0517457372
* device instance sel_in_t7 r0 *1 0,0
Rsel_in_t7 sel_in__t7 sel_in 139.28401279
* device instance sel_in_t8 r0 *1 0,0
Rsel_in_t8 sel_in__t8 sel_in 102.514188461
* device instance sel_in_t9 r0 *1 0,0
Rsel_in_t9 sel_in__t9 sel_in 30.6654078867
* device instance sel_in_t10 r0 *1 0,0
Rsel_in_t10 sel_in__t10 sel_in 84.2992576345
* device instance sel_in_t11 r0 *1 0,0
Rsel_in_t11 sel_in__t11 sel_in 157.883944996
* device instance sel_in_t12 r0 *1 0,0
Rsel_in_t12 sel_in__t12 sel_in 121.001709895
* device instance sel_in_t13 r0 *1 0,0
Rsel_in_t13 sel_in__t13 sel_in 15.7870228217
* device instance sel_in_t14 r0 *1 0,0
Rsel_in_t14 sel_in__t14 sel_in 157.842063937
* device instance sel_in_t15 r0 *1 0,0
Rsel_in_t15 sel_in__t15 sel_in 30.4490443407
* device instance sel_in_t16 r0 *1 0,0
Rsel_in_t16 sel_in__t16 sel_in 65.8992632998
* device instance sel_in_t17 r0 *1 0,0
Rsel_in_t17 sel_in__t17 sel_in 102.449674944
* device instance sel_in_t18 r0 *1 0,0
Rsel_in_t18 sel_in__t18 sel_in 65.9995139608
* device instance sel_in_t19 r0 *1 0,0
Rsel_in_t19 sel_in__t19 sel_in 121.056337038
* device instance sel_in_t20 r0 *1 0,0
Rsel_in_t20 sel_in__t20 sel_in 111.461486602
* device instance sel_in_t21 r0 *1 0,0
Rsel_in_t21 sel_in__t21 sel_in 148.29853199
* device instance sel_in_t22 r0 *1 0,0
Rsel_in_t22 sel_in__t22 sel_in 74.7831919032
* device instance sel_in_t23 r0 *1 0,0
Rsel_in_t23 sel_in__t23 sel_in 111.698499336
* device instance sel_in_t24 r0 *1 0,0
Rsel_in_t24 sel_in__t24 sel_in 148.476753564
* device instance sel_in_t25 r0 *1 0,0
Rsel_in_t25 sel_in__t25 sel_in 75.1359937022
* device instance sel_in_t26 r0 *1 0,0
Rsel_in_t26 sel_in__t26 sel_in 148.826531653
* device instance sel_in_t27 r0 *1 0,0
Rsel_in_t27 sel_in__t27 sel_in 112.047076648
* device instance sel_in_t28 r0 *1 0,0
Rsel_in_t28 sel_in__t28 sel_in 75.4812071785
* device instance sel_in_t29 r0 *1 0,0
Rsel_in_t29 sel_in__t29 sel_in 11.9672283327
* device instance sel_in_t30 r0 *1 0,0
Rsel_in_t30 sel_in__t30 sel_in 75.1300264791
* device instance sel_in_t31 r0 *1 0,0
Rsel_in_t31 sel_in__t31 sel_in 111.810802818
* device instance sel_in_t32 r0 *1 0,0
Rsel_in_t32 sel_in__t32 sel_in 39.7231957361
* device instance sel_in_t33 r0 *1 0,0
Rsel_in_t33 sel_in__t33 sel_in 39.0517671956
* device instance sel_in_t34 r0 *1 0,0
Rsel_in_t34 sel_in__t34 sel_in 14.003796355
* device instance sel_in_t35 r0 *1 0,0
Rsel_in_t35 sel_in__t35 sel_in 38.7174763814
* device instance sel_in_t36 r0 *1 0,0
Rsel_in_t36 sel_in__t36 sel_in 39.3946028756
* device instance sel_in_t37 r0 *1 0,0
Rsel_in_t37 sel_in__t37 sel_in 120.997488601
* device instance sel_in_t38 r0 *1 0,0
Rsel_in_t38 sel_in__t38 sel_in 48.3109331548
* device instance sel_in_t39 r0 *1 0,0
Rsel_in_t39 sel_in__t39 sel_in 47.6217551578
* device instance sel_in_t40 r0 *1 0,0
Rsel_in_t40 sel_in__t40 sel_in 139.322174957
* device instance sel_in_t41 r0 *1 0,0
Rsel_in_t41 sel_in__t41 sel_in 102.502645232
* device instance sel_in_t42 r0 *1 0,0
Rsel_in_t42 sel_in__t42 sel_in 102.824641879
* device instance sel_in_t43 r0 *1 0,0
Rsel_in_t43 sel_in__t43 sel_in 139.559245959
* device instance sel_in_t44 r0 *1 0,0
Rsel_in_t44 sel_in__t44 sel_in 84.3702676287
* device instance sel_in_t45 r0 *1 0,0
Rsel_in_t45 sel_in__t45 sel_in 31.2748755219
* device instance sel_in_t46 r0 *1 0,0
Rsel_in_t46 sel_in__t46 sel_in 14.8691007584
* device instance sel_in_t47 r0 *1 0,0
Rsel_in_t47 sel_in__t47 sel_in 30.1993897444
* device instance sel_in_t48 r0 *1 0,0
Rsel_in_t48 sel_in__t48 sel_in 16.9471193819
* device instance sel_in_t49 r0 *1 0,0
Rsel_in_t49 sel_in__t49 sel_in 157.58801391
* device instance sel_in_t50 r0 *1 0,0
Rsel_in_t50 sel_in__t50 sel_in 65.8830062688
* device instance sel_in_t51 r0 *1 0,0
Rsel_in_t51 sel_in__t51 sel_in 66.3828683697
* device instance sel_in_t52 r0 *1 0,0
Rsel_in_t52 sel_in__t52 sel_in 83.9775408175
* device instance sel_in_t53 r0 *1 0,0
Rsel_in_t53 sel_in__t53 sel_in 120.723972556
* device instance sel_in r0 *1 0,0
Csel_in sel_in vsubs 1.11280818e-13
* device instance topn_t0 r0 *1 0,0
Rtopn_t0 topn__t0 topn 3.12984616884
* device instance topn_t1 r0 *1 0,0
Rtopn_t1 topn__t1 topn 0.673974533795
* device instance topn_t2 r0 *1 0,0
Rtopn_t2 topn__t2 topn 1.8644560288
* device instance topn_t3 r0 *1 0,0
Rtopn_t3 topn__t3 topn 1.62619005218
* device instance topn_t4 r0 *1 0,0
Rtopn_t4 topn__t4 topn 1.50707128271
* device instance topn_t5 r0 *1 0,0
Rtopn_t5 topn__t5 topn 1.38796524667
* device instance topn_t6 r0 *1 0,0
Rtopn_t6 topn__t6 topn 1.26887552981
* device instance topn_t7 r0 *1 0,0
Rtopn_t7 topn__t7 topn 1.14980720285
* device instance topn_t8 r0 *1 0,0
Rtopn_t8 topn__t8 topn 1.03076767835
* device instance topn_t9 r0 *1 0,0
Rtopn_t9 topn__t9 topn 0.911768237629
* device instance topn_t10 r0 *1 0,0
Rtopn_t10 topn__t10 topn 0.792826930024
* device instance topn_t11 r0 *1 0,0
Rtopn_t11 topn__t11 topn 1.74531894789
* device instance topn_t12 r0 *1 0,0
Rtopn_t12 topn__t12 topn 1.61978796528
* device instance topn_t13 r0 *1 0,0
Rtopn_t13 topn__t13 topn 1.07907020629
* device instance topn_t14 r0 *1 0,0
Rtopn_t14 topn__t14 topn 1.02642192598
* device instance topn_t15 r0 *1 0,0
Rtopn_t15 topn__t15 topn 1.13004594292
* device instance topn_t16 r0 *1 0,0
Rtopn_t16 topn__t16 topn 1.23647871211
* device instance topn_t17 r0 *1 0,0
Rtopn_t17 topn__t17 topn 1.34505363732
* device instance topn_t18 r0 *1 0,0
Rtopn_t18 topn__t18 topn 1.45529133801
* device instance topn_t19 r0 *1 0,0
Rtopn_t19 topn__t19 topn 1.67944091564
* device instance topn_t20 r0 *1 0,0
Rtopn_t20 topn__t20 topn 1.79289350173
* device instance topn_t21 r0 *1 0,0
Rtopn_t21 topn__t21 topn 1.90704649586
* device instance topn_t22 r0 *1 0,0
Rtopn_t22 topn__t22 topn 1.19007070482
* device instance topn_t23 r0 *1 0,0
Rtopn_t23 topn__t23 topn 1.30251985177
* device instance topn_t24 r0 *1 0,0
Rtopn_t24 topn__t24 topn 1.41607258128
* device instance topn_t25 r0 *1 0,0
Rtopn_t25 topn__t25 topn 1.53048327533
* device instance topn_t26 r0 *1 0,0
Rtopn_t26 topn__t26 topn 0.696235743734
* device instance topn_t27 r0 *1 0,0
Rtopn_t27 topn__t27 topn 1.56684089144
* device instance topn_t28 r0 *1 0,0
Rtopn_t28 topn__t28 topn 0.456508273565
* device instance topn_t29 r0 *1 0,0
Rtopn_t29 topn__t29 topn 0.7610838649
* device instance topn_t30 r0 *1 0,0
Rtopn_t30 topn__t30 topn 0.70359877473
* device instance topn_t31 r0 *1 0,0
Rtopn_t31 topn__t31 topn 0.419686170984
* device instance topn_t32 r0 *1 0,0
Rtopn_t32 topn__t32 topn 0.415074776163
* device instance topn_t33 r0 *1 0,0
Rtopn_t33 topn__t33 topn 1.6455729902
* device instance topn_t34 r0 *1 0,0
Rtopn_t34 topn__t34 topn 1.76120861499
* device instance topn_t35 r0 *1 0,0
Rtopn_t35 topn__t35 topn 1.50272473942
* device instance topn_t36 r0 *1 0,0
Rtopn_t36 topn__t36 topn 1.73714086127
* device instance topn_t37 r0 *1 0,0
Rtopn_t37 topn__t37 topn 0.970015797357
* device instance topn_t38 r0 *1 0,0
Rtopn_t38 topn__t38 topn 1.85472844394
* device instance topn_t39 r0 *1 0,0
Rtopn_t39 topn__t39 topn 0.925598851291
* device instance topn_t40 r0 *1 0,0
Rtopn_t40 topn__t40 topn 1.03932434614
* device instance topn_t41 r0 *1 0,0
Rtopn_t41 topn__t41 topn 1.15415374576
* device instance topn_t42 r0 *1 0,0
Rtopn_t42 topn__t42 topn 1.26978760061
* device instance topn_t43 r0 *1 0,0
Rtopn_t43 topn__t43 topn 1.38602458198
* device instance topn_t44 r0 *1 0,0
Rtopn_t44 topn__t44 topn 1.87728927296
* device instance topn_t45 r0 *1 0,0
Rtopn_t45 topn__t45 topn 1.87261817303
* device instance topn_t46 r0 *1 0,0
Rtopn_t46 topn__t46 topn 1.75403556649
* device instance topn_t47 r0 *1 0,0
Rtopn_t47 topn__t47 topn 1.63554169145
* device instance topn_t48 r0 *1 0,0
Rtopn_t48 topn__t48 topn 0.438020521801
* device instance topn_t49 r0 *1 0,0
Rtopn_t49 topn__t49 topn 0.320578909133
* device instance topn_t50 r0 *1 0,0
Rtopn_t50 topn__t50 topn 0.205167263111
* device instance topn_t51 r0 *1 0,0
Rtopn_t51 topn__t51 topn 0.0991477893565
* device instance topn_t52 r0 *1 0,0
Rtopn_t52 topn__t52 topn 0.0773360965254
* device instance topn_t53 r0 *1 0,0
Rtopn_t53 topn__t53 topn 0.174772334559
* device instance topn_t54 r0 *1 0,0
Rtopn_t54 topn__t54 topn 0.289004801756
* device instance topn_t55 r0 *1 0,0
Rtopn_t55 topn__t55 topn 0.51872635846
* device instance topn_t56 r0 *1 0,0
Rtopn_t56 topn__t56 topn 0.524139596568
* device instance topn_t57 r0 *1 0,0
Rtopn_t57 topn__t57 topn 0.555268144996
* device instance topn_t58 r0 *1 0,0
Rtopn_t58 topn__t58 topn 0.436826811104
* device instance topn_t59 r0 *1 0,0
Rtopn_t59 topn__t59 topn 0.318945955236
* device instance topn_t60 r0 *1 0,0
Rtopn_t60 topn__t60 topn 0.202606246777
* device instance topn_t61 r0 *1 0,0
Rtopn_t61 topn__t61 topn 0.0937335026272
* device instance topn_t62 r0 *1 0,0
Rtopn_t62 topn__t62 topn 0.0702606376735
* device instance topn_t63 r0 *1 0,0
Rtopn_t63 topn__t63 topn 0.171758709554
* device instance topn_t64 r0 *1 0,0
Rtopn_t64 topn__t64 topn 0.4060986227
* device instance topn_t65 r0 *1 0,0
Rtopn_t65 topn__t65 topn 1.47515180849
* device instance topn_t66 r0 *1 0,0
Rtopn_t66 topn__t66 topn 1.59424096927
* device instance topn_t67 r0 *1 0,0
Rtopn_t67 topn__t67 topn 1.71334456183
* device instance topn_t68 r0 *1 0,0
Rtopn_t68 topn__t68 topn 1.8324597721
* device instance topn_t69 r0 *1 0,0
Rtopn_t69 topn__t69 topn 1.01213220099
* device instance topn_t70 r0 *1 0,0
Rtopn_t70 topn__t70 topn 1.48404788948
* device instance topn_t71 r0 *1 0,0
Rtopn_t71 topn__t71 topn 1.60247606793
* device instance topn_t72 r0 *1 0,0
Rtopn_t72 topn__t72 topn 0.556207719711
* device instance topn_t73 r0 *1 0,0
Rtopn_t73 topn__t73 topn 0.359299481146
* device instance topn_t74 r0 *1 0,0
Rtopn_t74 topn__t74 topn 0.261570040378
* device instance topn_t75 r0 *1 0,0
Rtopn_t75 topn__t75 topn 0.190146165633
* device instance topn_t76 r0 *1 0,0
Rtopn_t76 topn__t76 topn 0.179739122054
* device instance topn_t77 r0 *1 0,0
Rtopn_t77 topn__t77 topn 0.23847567821
* device instance topn_t78 r0 *1 0,0
Rtopn_t78 topn__t78 topn 0.331434843686
* device instance topn_t79 r0 *1 0,0
Rtopn_t79 topn__t79 topn 0.437311526866
* device instance topn_t80 r0 *1 0,0
Rtopn_t80 topn__t80 topn 0.548678044814
* device instance topn_t81 r0 *1 0,0
Rtopn_t81 topn__t81 topn 1.72100983952
* device instance topn_t82 r0 *1 0,0
Rtopn_t82 topn__t82 topn 0.406979802704
* device instance topn_t83 r0 *1 0,0
Rtopn_t83 topn__t83 topn 0.497015971303
* device instance topn_t84 r0 *1 0,0
Rtopn_t84 topn__t84 topn 0.597353413869
* device instance topn_t85 r0 *1 0,0
Rtopn_t85 topn__t85 topn 0.689690673742
* device instance topn_t86 r0 *1 0,0
Rtopn_t86 topn__t86 topn 0.766997098082
* device instance topn_t87 r0 *1 0,0
Rtopn_t87 topn__t87 topn 0.686133732241
* device instance topn_t88 r0 *1 0,0
Rtopn_t88 topn__t88 topn 0.617809321701
* device instance topn_t89 r0 *1 0,0
Rtopn_t89 topn__t89 topn 0.287192375976
* device instance topn_t90 r0 *1 0,0
Rtopn_t90 topn__t90 topn 0.537352589214
* device instance topn_t91 r0 *1 0,0
Rtopn_t91 topn__t91 topn 0.533758740281
* device instance topn_t92 r0 *1 0,0
Rtopn_t92 topn__t92 topn 0.556293888091
* device instance topn_t93 r0 *1 0,0
Rtopn_t93 topn__t93 topn 0.602030976312
* device instance topn_t94 r0 *1 0,0
Rtopn_t94 topn__t94 topn 0.666208385087
* device instance topn_t95 r0 *1 0,0
Rtopn_t95 topn__t95 topn 0.744069780122
* device instance topn_t96 r0 *1 0,0
Rtopn_t96 topn__t96 topn 0.598471532739
* device instance topn_t97 r0 *1 0,0
Rtopn_t97 topn__t97 topn 0.831781204663
* device instance topn_t98 r0 *1 0,0
Rtopn_t98 topn__t98 topn 0.566578438394
* device instance topn_t99 r0 *1 0,0
Rtopn_t99 topn__t99 topn 0.404810791284
* device instance topn_t100 r0 *1 0,0
Rtopn_t100 topn__t100 topn 0.523142430004
* device instance topn_t101 r0 *1 0,0
Rtopn_t101 topn__t101 topn 0.64260598459
* device instance topn_t102 r0 *1 0,0
Rtopn_t102 topn__t102 topn 0.579389599179
* device instance topn_t103 r0 *1 0,0
Rtopn_t103 topn__t103 topn 0.467105189106
* device instance topn_t104 r0 *1 0,0
Rtopn_t104 topn__t104 topn 0.662772760153
* device instance topn_t105 r0 *1 0,0
Rtopn_t105 topn__t105 topn 0.64179290804
* device instance topn_t106 r0 *1 0,0
Rtopn_t106 topn__t106 topn 0.443679576843
* device instance topn_t107 r0 *1 0,0
Rtopn_t107 topn__t107 topn 0.335639916127
* device instance topn_t108 r0 *1 0,0
Rtopn_t108 topn__t108 topn 0.575519147675
* device instance topn_t109 r0 *1 0,0
Rtopn_t109 topn__t109 topn 0.664099777647
* device instance topn_t110 r0 *1 0,0
Rtopn_t110 topn__t110 topn 0.625680279246
* device instance topn_t111 r0 *1 0,0
Rtopn_t111 topn__t111 topn 0.523422164118
* device instance topn_t112 r0 *1 0,0
Rtopn_t112 topn__t112 topn 0.429976303244
* device instance topn_t113 r0 *1 0,0
Rtopn_t113 topn__t113 topn 0.352423594873
* device instance topn_t114 r0 *1 0,0
Rtopn_t114 topn__t114 topn 0.303214558531
* device instance topn_t115 r0 *1 0,0
Rtopn_t115 topn__t115 topn 0.296799016502
* device instance topn_t116 r0 *1 0,0
Rtopn_t116 topn__t116 topn 0.4998299445
* device instance topn_t117 r0 *1 0,0
Rtopn_t117 topn__t117 topn 1.51715733852
* device instance topn_t118 r0 *1 0,0
Rtopn_t118 topn__t118 topn 1.77045556339
* device instance topn_t119 r0 *1 0,0
Rtopn_t119 topn__t119 topn 1.65313906188
* device instance topn_t120 r0 *1 0,0
Rtopn_t120 topn__t120 topn 0.793033660787
* device instance topn_t121 r0 *1 0,0
Rtopn_t121 topn__t121 topn 1.53611149441
* device instance topn_t122 r0 *1 0,0
Rtopn_t122 topn__t122 topn 0.736624968551
* device instance topn_t123 r0 *1 0,0
Rtopn_t123 topn__t123 topn 1.87178147178
* device instance topn_t124 r0 *1 0,0
Rtopn_t124 topn__t124 topn 1.41944432721
* device instance topn_t125 r0 *1 0,0
Rtopn_t125 topn__t125 topn 1.3032343543
* device instance topn_t126 r0 *1 0,0
Rtopn_t126 topn__t126 topn 1.1876157947
* device instance topn_t127 r0 *1 0,0
Rtopn_t127 topn__t127 topn 1.07277988368
* device instance topn_t128 r0 *1 0,0
Rtopn_t128 topn__t128 topn 0.959007816046
* device instance topn_t129 r0 *1 0,0
Rtopn_t129 topn__t129 topn 0.846728535636
* device instance topn_t130 r0 *1 0,0
Rtopn_t130 topn__t130 topn 1.91072159099
* device instance topn_t131 r0 *1 0,0
Rtopn_t131 topn__t131 topn 1.8880071386
* device instance topn_t132 r0 *1 0,0
Rtopn_t132 topn__t132 topn 1.6790338891
* device instance topn_t133 r0 *1 0,0
Rtopn_t133 topn__t133 topn 1.56394519281
* device instance topn_t134 r0 *1 0,0
Rtopn_t134 topn__t134 topn 1.44952000362
* device instance topn_t135 r0 *1 0,0
Rtopn_t135 topn__t135 topn 1.33592882485
* device instance topn_t136 r0 *1 0,0
Rtopn_t136 topn__t136 topn 1.22340398833
* device instance topn_t137 r0 *1 0,0
Rtopn_t137 topn__t137 topn 1.11226917681
* device instance topn_t138 r0 *1 0,0
Rtopn_t138 topn__t138 topn 1.00298655728
* device instance topn_t139 r0 *1 0,0
Rtopn_t139 topn__t139 topn 0.896233929233
* device instance topn_t140 r0 *1 0,0
Rtopn_t140 topn__t140 topn 1.79465844795
* device instance topn_t141 r0 *1 0,0
Rtopn_t141 topn__t141 topn 1.71284989214
* device instance topn_t142 r0 *1 0,0
Rtopn_t142 topn__t142 topn 1.60019515009
* device instance topn_t143 r0 *1 0,0
Rtopn_t143 topn__t143 topn 1.48855909965
* device instance topn_t144 r0 *1 0,0
Rtopn_t144 topn__t144 topn 1.37818931114
* device instance topn_t145 r0 *1 0,0
Rtopn_t145 topn__t145 topn 1.26941611418
* device instance topn_t146 r0 *1 0,0
Rtopn_t146 topn__t146 topn 1.16268769407
* device instance topn_t147 r0 *1 0,0
Rtopn_t147 topn__t147 topn 1.05862268365
* device instance topn_t148 r0 *1 0,0
Rtopn_t148 topn__t148 topn 0.862323801945
* device instance topn_t149 r0 *1 0,0
Rtopn_t149 topn__t149 topn 1.0287098581
* device instance topn_t150 r0 *1 0,0
Rtopn_t150 topn__t150 topn 1.97703586517
* device instance topn_t151 r0 *1 0,0
Rtopn_t151 topn__t151 topn 1.86510395387
* device instance topn_t152 r0 *1 0,0
Rtopn_t152 topn__t152 topn 1.75412901882
* device instance topn_t153 r0 *1 0,0
Rtopn_t153 topn__t153 topn 1.64430483185
* device instance topn_t154 r0 *1 0,0
Rtopn_t154 topn__t154 topn 1.53587826823
* device instance topn_t155 r0 *1 0,0
Rtopn_t155 topn__t155 topn 1.4291674636
* device instance topn_t156 r0 *1 0,0
Rtopn_t156 topn__t156 topn 0.958089352914
* device instance topn_t157 r0 *1 0,0
Rtopn_t157 topn__t157 topn 1.39891031328
* device instance topn_t158 r0 *1 0,0
Rtopn_t158 topn__t158 topn 1.28083865057
* device instance topn_t159 r0 *1 0,0
Rtopn_t159 topn__t159 topn 1.16299576198
* device instance topn_t160 r0 *1 0,0
Rtopn_t160 topn__t160 topn 1.04545901181
* device instance topn_t161 r0 *1 0,0
Rtopn_t161 topn__t161 topn 0.928344686955
* device instance topn_t162 r0 *1 0,0
Rtopn_t162 topn__t162 topn 0.811835623523
* device instance topn_t163 r0 *1 0,0
Rtopn_t163 topn__t163 topn 1.82633482611
* device instance topn_t164 r0 *1 0,0
Rtopn_t164 topn__t164 topn 1.94050430314
* device instance topn_t165 r0 *1 0,0
Rtopn_t165 topn__t165 topn 1.55370173797
* device instance topn_t166 r0 *1 0,0
Rtopn_t166 topn__t166 topn 1.45808113086
* device instance topn_t167 r0 *1 0,0
Rtopn_t167 topn__t167 topn 1.36617201961
* device instance topn_t168 r0 *1 0,0
Rtopn_t168 topn__t168 topn 1.27877492139
* device instance topn_t169 r0 *1 0,0
Rtopn_t169 topn__t169 topn 1.19687865776
* device instance topn_t170 r0 *1 0,0
Rtopn_t170 topn__t170 topn 1.12168875034
* device instance topn_t171 r0 *1 0,0
Rtopn_t171 topn__t171 topn 0.941656094903
* device instance topn_t172 r0 *1 0,0
Rtopn_t172 topn__t172 topn 1.32458715553
* device instance topn_t173 r0 *1 0,0
Rtopn_t173 topn__t173 topn 1.22268415202
* device instance topn_t174 r0 *1 0,0
Rtopn_t174 topn__t174 topn 1.12418674962
* device instance topn_t175 r0 *1 0,0
Rtopn_t175 topn__t175 topn 1.03007236146
* device instance topn_t176 r0 *1 0,0
Rtopn_t176 topn__t176 topn 2.01995014376
* device instance topn_t177 r0 *1 0,0
Rtopn_t177 topn__t177 topn 1.91053409543
* device instance topn_t178 r0 *1 0,0
Rtopn_t178 topn__t178 topn 1.80235856193
* device instance topn_t179 r0 *1 0,0
Rtopn_t179 topn__t179 topn 1.69566097765
* device instance topn_t180 r0 *1 0,0
Rtopn_t180 topn__t180 topn 1.59073876733
* device instance topn_t181 r0 *1 0,0
Rtopn_t181 topn__t181 topn 1.65238963516
* device instance topn_t182 r0 *1 0,0
Rtopn_t182 topn__t182 topn 1.38782524248
* device instance topn_t183 r0 *1 0,0
Rtopn_t183 topn__t183 topn 1.29092381908
* device instance topn_t184 r0 *1 0,0
Rtopn_t184 topn__t184 topn 1.19804992346
* device instance topn_t185 r0 *1 0,0
Rtopn_t185 topn__t185 topn 1.11021477243
* device instance topn_t186 r0 *1 0,0
Rtopn_t186 topn__t186 topn 2.0688499858
* device instance topn_t187 r0 *1 0,0
Rtopn_t187 topn__t187 topn 1.96216263605
* device instance topn_t188 r0 *1 0,0
Rtopn_t188 topn__t188 topn 1.85699705607
* device instance topn_t189 r0 *1 0,0
Rtopn_t189 topn__t189 topn 1.75362705032
* device instance topn_t190 r0 *1 0,0
Rtopn_t190 topn__t190 topn 1.48796754336
* device instance topn_t191 r0 *1 0,0
Rtopn_t191 topn__t191 topn 1.29668511935
* device instance topn_t192 r0 *1 0,0
Rtopn_t192 topn__t192 topn 1.17370457717
* device instance topn_t193 r0 *1 0,0
Rtopn_t193 topn__t193 topn 1.26532379154
* device instance topn_t194 r0 *1 0,0
Rtopn_t194 topn__t194 topn 1.36122006664
* device instance topn_t195 r0 *1 0,0
Rtopn_t195 topn__t195 topn 1.46055118075
* device instance topn_t196 r0 *1 0,0
Rtopn_t196 topn__t196 topn 1.56266226127
* device instance topn_t197 r0 *1 0,0
Rtopn_t197 topn__t197 topn 1.66704254397
* device instance topn_t198 r0 *1 0,0
Rtopn_t198 topn__t198 topn 1.77329136169
* device instance topn_t199 r0 *1 0,0
Rtopn_t199 topn__t199 topn 1.88109212237
* device instance topn_t200 r0 *1 0,0
Rtopn_t200 topn__t200 topn 1.99019265442
* device instance topn_t201 r0 *1 0,0
Rtopn_t201 topn__t201 topn 1.09820520095
* device instance topn_t202 r0 *1 0,0
Rtopn_t202 topn__t202 topn 1.40060057851
* device instance topn_t203 r0 *1 0,0
Rtopn_t203 topn__t203 topn 1.25599526868
* device instance topn_t204 r0 *1 0,0
Rtopn_t204 topn__t204 topn 1.34200818847
* device instance topn_t205 r0 *1 0,0
Rtopn_t205 topn__t205 topn 1.73864313331
* device instance topn_t206 r0 *1 0,0
Rtopn_t206 topn__t206 topn 1.52746568933
* device instance topn_t207 r0 *1 0,0
Rtopn_t207 topn__t207 topn 1.62537842464
* device instance topn_t208 r0 *1 0,0
Rtopn_t208 topn__t208 topn 1.72597002404
* device instance topn_t209 r0 *1 0,0
Rtopn_t209 topn__t209 topn 1.82879849462
* device instance topn_t210 r0 *1 0,0
Rtopn_t210 topn__t210 topn 1.93350698301
* device instance topn_t211 r0 *1 0,0
Rtopn_t211 topn__t211 topn 2.03980599131
* device instance topn_t212 r0 *1 0,0
Rtopn_t212 topn__t212 topn 1.50677986837
* device instance topn_t213 r0 *1 0,0
Rtopn_t213 topn__t213 topn 1.61477647751
* device instance topn_t214 r0 *1 0,0
Rtopn_t214 topn__t214 topn 1.72424896182
* device instance topn_t215 r0 *1 0,0
Rtopn_t215 topn__t215 topn 1.83493318728
* device instance topn_t216 r0 *1 0,0
Rtopn_t216 topn__t216 topn 0.789488563415
* device instance topn_t217 r0 *1 0,0
Rtopn_t217 topn__t217 topn 0.730890587725
* device instance topn_t218 r0 *1 0,0
Rtopn_t218 topn__t218 topn 0.688130670801
* device instance topn_t219 r0 *1 0,0
Rtopn_t219 topn__t219 topn 0.664274414966
* device instance topn_t220 r0 *1 0,0
Rtopn_t220 topn__t220 topn 0.661370611738
* device instance topn_t221 r0 *1 0,0
Rtopn_t221 topn__t221 topn 1.43278112435
* device instance topn_t222 r0 *1 0,0
Rtopn_t222 topn__t222 topn 0.470446810541
* device instance topn_t223 r0 *1 0,0
Rtopn_t223 topn__t223 topn 0.363633140693
* device instance topn_t224 r0 *1 0,0
Rtopn_t224 topn__t224 topn 0.267491737969
* device instance topn_t225 r0 *1 0,0
Rtopn_t225 topn__t225 topn 0.625369642337
* device instance topn_t226 r0 *1 0,0
Rtopn_t226 topn__t226 topn 0.574812976914
* device instance topn_t227 r0 *1 0,0
Rtopn_t227 topn__t227 topn 0.546028054875
* device instance topn_t228 r0 *1 0,0
Rtopn_t228 topn__t228 topn 0.542491681413
* device instance topn_t229 r0 *1 0,0
Rtopn_t229 topn__t229 topn 0.56467842309
* device instance topn_t230 r0 *1 0,0
Rtopn_t230 topn__t230 topn 0.609786952972
* device instance topn_t231 r0 *1 0,0
Rtopn_t231 topn__t231 topn 0.673225403513
* device instance topn_t232 r0 *1 0,0
Rtopn_t232 topn__t232 topn 0.750359026911
* device instance topn_t233 r0 *1 0,0
Rtopn_t233 topn__t233 topn 0.837411967915
* device instance topn_t234 r0 *1 0,0
Rtopn_t234 topn__t234 topn 0.93160766858
* device instance topn_t235 r0 *1 0,0
Rtopn_t235 topn__t235 topn 1.03099020447
* device instance topn_t236 r0 *1 0,0
Rtopn_t236 topn__t236 topn 1.19562390673
* device instance topn_t237 r0 *1 0,0
Rtopn_t237 topn__t237 topn 1.24027353316
* device instance topn_t238 r0 *1 0,0
Rtopn_t238 topn__t238 topn 1.34854296144
* device instance topn_t239 r0 *1 0,0
Rtopn_t239 topn__t239 topn 1.4585169557
* device instance topn_t240 r0 *1 0,0
Rtopn_t240 topn__t240 topn 1.56983731981
* device instance topn_t241 r0 *1 0,0
Rtopn_t241 topn__t241 topn 1.68223679091
* device instance topn_t242 r0 *1 0,0
Rtopn_t242 topn__t242 topn 1.79551272346
* device instance topn_t243 r0 *1 0,0
Rtopn_t243 topn__t243 topn 1.90950914346
* device instance topn_t244 r0 *1 0,0
Rtopn_t244 topn__t244 topn 1.00548829423
* device instance topn_t245 r0 *1 0,0
Rtopn_t245 topn__t245 topn 1.08744401277
* device instance topn_t246 r0 *1 0,0
Rtopn_t246 topn__t246 topn 1.17578746438
* device instance topn_t247 r0 *1 0,0
Rtopn_t247 topn__t247 topn 0.816643651203
* device instance topn_t248 r0 *1 0,0
Rtopn_t248 topn__t248 topn 0.867866865307
* device instance topn_t249 r0 *1 0,0
Rtopn_t249 topn__t249 topn 0.773099851276
* device instance topn_t250 r0 *1 0,0
Rtopn_t250 topn__t250 topn 0.692949009736
* device instance topn_t251 r0 *1 0,0
Rtopn_t251 topn__t251 topn 1.94662246741
* device instance topn_t252 r0 *1 0,0
Rtopn_t252 topn__t252 topn 1.134196925
* device instance topn_t253 r0 *1 0,0
Rtopn_t253 topn__t253 topn 0.601708130374
* device instance topn_t254 r0 *1 0,0
Rtopn_t254 topn__t254 topn 0.694970091287
* device instance topn_t255 r0 *1 0,0
Rtopn_t255 topn__t255 topn 0.604548077357
* device instance topn_t256 r0 *1 0,0
Rtopn_t256 topn__t256 topn 0.525725439082
* device instance topn_t257 r0 *1 0,0
Rtopn_t257 topn__t257 topn 0.464445913073
* device instance topn_t258 r0 *1 0,0
Rtopn_t258 topn__t258 topn 0.428306764424
* device instance topn_t259 r0 *1 0,0
Rtopn_t259 topn__t259 topn 0.423789183608
* device instance topn_t260 r0 *1 0,0
Rtopn_t260 topn__t260 topn 0.451842637701
* device instance topn_t261 r0 *1 0,0
Rtopn_t261 topn__t261 topn 0.507089908947
* device instance topn_t262 r0 *1 0,0
Rtopn_t262 topn__t262 topn 0.581835450687
* device instance topn_t263 r0 *1 0,0
Rtopn_t263 topn__t263 topn 0.66958100108
* device instance topn_t264 r0 *1 0,0
Rtopn_t264 topn__t264 topn 0.629839173865
* device instance topn_t265 r0 *1 0,0
Rtopn_t265 topn__t265 topn 0.52838653937
* device instance topn_t266 r0 *1 0,0
Rtopn_t266 topn__t266 topn 0.436005956896
* device instance topn_t267 r0 *1 0,0
Rtopn_t267 topn__t267 topn 0.679687857161
* device instance topn_t268 r0 *1 0,0
Rtopn_t268 topn__t268 topn 0.76587130234
* device instance topn_t269 r0 *1 0,0
Rtopn_t269 topn__t269 topn 0.359755421531
* device instance topn_t270 r0 *1 0,0
Rtopn_t270 topn__t270 topn 0.311706017912
* device instance topn_t271 r0 *1 0,0
Rtopn_t271 topn__t271 topn 1.30532301236
* device instance topn_t272 r0 *1 0,0
Rtopn_t272 topn__t272 topn 1.41865138699
* device instance topn_t273 r0 *1 0,0
Rtopn_t273 topn__t273 topn 1.53286961559
* device instance topn_t274 r0 *1 0,0
Rtopn_t274 topn__t274 topn 1.64779266548
* device instance topn_t275 r0 *1 0,0
Rtopn_t275 topn__t275 topn 1.76328273055
* device instance topn_t276 r0 *1 0,0
Rtopn_t276 topn__t276 topn 1.87923527444
* device instance topn_t277 r0 *1 0,0
Rtopn_t277 topn__t277 topn 1.0418333214
* device instance topn_t278 r0 *1 0,0
Rtopn_t278 topn__t278 topn 1.15641361197
* device instance topn_t279 r0 *1 0,0
Rtopn_t279 topn__t279 topn 1.27184201997
* device instance topn_t280 r0 *1 0,0
Rtopn_t280 topn__t280 topn 1.38790695472
* device instance topn_t281 r0 *1 0,0
Rtopn_t281 topn__t281 topn 1.5044611047
* device instance topn_t282 r0 *1 0,0
Rtopn_t282 topn__t282 topn 1.62139897175
* device instance topn_t283 r0 *1 0,0
Rtopn_t283 topn__t283 topn 0.707299659903
* device instance topn_t284 r0 *1 0,0
Rtopn_t284 topn__t284 topn 0.717602947097
* device instance topn_t285 r0 *1 0,0
Rtopn_t285 topn__t285 topn 0.772234618237
* device instance topn_t286 r0 *1 0,0
Rtopn_t286 topn__t286 topn 0.840328823101
* device instance topn_t287 r0 *1 0,0
Rtopn_t287 topn__t287 topn 1.05464055169
* device instance topn_t288 r0 *1 0,0
Rtopn_t288 topn__t288 topn 0.997377382604
* device instance topn_t289 r0 *1 0,0
Rtopn_t289 topn__t289 topn 0.951667222716
* device instance topn_t290 r0 *1 0,0
Rtopn_t290 topn__t290 topn 0.919235155803
* device instance topn_t291 r0 *1 0,0
Rtopn_t291 topn__t291 topn 0.901515363122
* device instance topn_t292 r0 *1 0,0
Rtopn_t292 topn__t292 topn 0.899377861434
* device instance topn_t293 r0 *1 0,0
Rtopn_t293 topn__t293 topn 0.912932108504
* device instance topn_t294 r0 *1 0,0
Rtopn_t294 topn__t294 topn 0.941500632634
* device instance topn_t295 r0 *1 0,0
Rtopn_t295 topn__t295 topn 0.983776273942
* device instance topn_t296 r0 *1 0,0
Rtopn_t296 topn__t296 topn 1.03808572984
* device instance topn_t297 r0 *1 0,0
Rtopn_t297 topn__t297 topn 0.955157061843
* device instance topn_t298 r0 *1 0,0
Rtopn_t298 topn__t298 topn 0.502241424842
* device instance topn_t299 r0 *1 0,0
Rtopn_t299 topn__t299 topn 0.840076676443
* device instance topn_t300 r0 *1 0,0
Rtopn_t300 topn__t300 topn 0.803151038831
* device instance topn_t301 r0 *1 0,0
Rtopn_t301 topn__t301 topn 0.782807939061
* device instance topn_t302 r0 *1 0,0
Rtopn_t302 topn__t302 topn 0.780345344799
* device instance topn_t303 r0 *1 0,0
Rtopn_t303 topn__t303 topn 0.795929239474
* device instance topn_t304 r0 *1 0,0
Rtopn_t304 topn__t304 topn 0.828541948703
* device instance topn_t305 r0 *1 0,0
Rtopn_t305 topn__t305 topn 0.876284244228
* device instance topn_t306 r0 *1 0,0
Rtopn_t306 topn__t306 topn 0.936845932912
* device instance topn_t307 r0 *1 0,0
Rtopn_t307 topn__t307 topn 0.918897527298
* device instance topn_t308 r0 *1 0,0
Rtopn_t308 topn__t308 topn 1.00791886417
* device instance topn_t309 r0 *1 0,0
Rtopn_t309 topn__t309 topn 1.10265231022
* device instance topn_t310 r0 *1 0,0
Rtopn_t310 topn__t310 topn 0.860695789296
* device instance topn_t311 r0 *1 0,0
Rtopn_t311 topn__t311 topn 0.305468867962
* device instance topn_t312 r0 *1 0,0
Rtopn_t312 topn__t312 topn 0.343330345871
* device instance topn_t313 r0 *1 0,0
Rtopn_t313 topn__t313 topn 0.413345053081
* device instance topn_t314 r0 *1 0,0
Rtopn_t314 topn__t314 topn 0.891526759465
* device instance topn_t315 r0 *1 0,0
Rtopn_t315 topn__t315 topn 1.97412850427
* device instance topn_t316 r0 *1 0,0
Rtopn_t316 topn__t316 topn 1.86202183068
* device instance topn_t317 r0 *1 0,0
Rtopn_t317 topn__t317 topn 1.75085155107
* device instance topn_t318 r0 *1 0,0
Rtopn_t318 topn__t318 topn 1.64080800803
* device instance topn_t319 r0 *1 0,0
Rtopn_t319 topn__t319 topn 1.53213400002
* device instance topn_t320 r0 *1 0,0
Rtopn_t320 topn__t320 topn 1.42514286238
* device instance topn_t321 r0 *1 0,0
Rtopn_t321 topn__t321 topn 1.32024379256
* device instance topn_t322 r0 *1 0,0
Rtopn_t322 topn__t322 topn 1.21797745249
* device instance topn_t323 r0 *1 0,0
Rtopn_t323 topn__t323 topn 1.11906585472
* device instance topn_t324 r0 *1 0,0
Rtopn_t324 topn__t324 topn 1.02448114137
* device instance topn_t325 r0 *1 0,0
Rtopn_t325 topn__t325 topn 0.935536605513
* device instance topn_t326 r0 *1 0,0
Rtopn_t326 topn__t326 topn 0.853996358831
* device instance topn_t327 r0 *1 0,0
Rtopn_t327 topn__t327 topn 0.782179474896
* device instance topn_t328 r0 *1 0,0
Rtopn_t328 topn__t328 topn 0.582086979322
* device instance topn_t329 r0 *1 0,0
Rtopn_t329 topn__t329 topn 0.67973256453
* device instance topn_t330 r0 *1 0,0
Rtopn_t330 topn__t330 topn 0.655570772354
* device instance topn_t331 r0 *1 0,0
Rtopn_t331 topn__t331 topn 0.652628244298
* device instance topn_t332 r0 *1 0,0
Rtopn_t332 topn__t332 topn 0.671184119566
* device instance topn_t333 r0 *1 0,0
Rtopn_t333 topn__t333 topn 0.709553753333
* device instance topn_t334 r0 *1 0,0
Rtopn_t334 topn__t334 topn 0.764760645424
* device instance topn_t335 r0 *1 0,0
Rtopn_t335 topn__t335 topn 0.833465698226
* device instance topn_t336 r0 *1 0,0
Rtopn_t336 topn__t336 topn 0.912625446095
* device instance topn_t337 r0 *1 0,0
Rtopn_t337 topn__t337 topn 0.999759595608
* device instance topn_t338 r0 *1 0,0
Rtopn_t338 topn__t338 topn 1.09296258059
* device instance topn_t339 r0 *1 0,0
Rtopn_t339 topn__t339 topn 1.3562241628
* device instance topn_t340 r0 *1 0,0
Rtopn_t340 topn__t340 topn 1.25994770026
* device instance topn_t341 r0 *1 0,0
Rtopn_t341 topn__t341 topn 1.1679068218
* device instance topn_t342 r0 *1 0,0
Rtopn_t342 topn__t342 topn 1.08118379143
* device instance topn_t343 r0 *1 0,0
Rtopn_t343 topn__t343 topn 1.00116149881
* device instance topn_t344 r0 *1 0,0
Rtopn_t344 topn__t344 topn 0.722989343221
* device instance topn_t345 r0 *1 0,0
Rtopn_t345 topn__t345 topn 1.87748008852
* device instance topn_t346 r0 *1 0,0
Rtopn_t346 topn__t346 topn 1.76945928559
* device instance topn_t347 r0 *1 0,0
Rtopn_t347 topn__t347 topn 1.66296565008
* device instance topn_t348 r0 *1 0,0
Rtopn_t348 topn__t348 topn 1.55831230912
* device instance topn_t349 r0 *1 0,0
Rtopn_t349 topn__t349 topn 1.45589617128
* device instance topn_t350 r0 *1 0,0
Rtopn_t350 topn__t350 topn 1.19081025589
* device instance topn_t351 r0 *1 0,0
Rtopn_t351 topn__t351 topn 1.29224797849
* device instance topn_t352 r0 *1 0,0
Rtopn_t352 topn__t352 topn 1.39649365187
* device instance topn_t353 r0 *1 0,0
Rtopn_t353 topn__t353 topn 1.5029631103
* device instance topn_t354 r0 *1 0,0
Rtopn_t354 topn__t354 topn 1.61121556954
* device instance topn_t355 r0 *1 0,0
Rtopn_t355 topn__t355 topn 1.72091458868
* device instance topn_t356 r0 *1 0,0
Rtopn_t356 topn__t356 topn 1.83180030052
* device instance topn_t357 r0 *1 0,0
Rtopn_t357 topn__t357 topn 1.94366961437
* device instance topn_t358 r0 *1 0,0
Rtopn_t358 topn__t358 topn 0.198213289574
* device instance topn_t359 r0 *1 0,0
Rtopn_t359 topn__t359 topn 0.820308277849
* device instance topn_t360 r0 *1 0,0
Rtopn_t360 topn__t360 topn 0.24495630826
* device instance topn_t361 r0 *1 0,0
Rtopn_t361 topn__t361 topn 0.336127951036
* device instance topn_t362 r0 *1 0,0
Rtopn_t362 topn__t362 topn 0.440879025798
* device instance topn_t363 r0 *1 0,0
Rtopn_t363 topn__t363 topn 0.551525648288
* device instance topn_t364 r0 *1 0,0
Rtopn_t364 topn__t364 topn 0.665132073697
* device instance topn_t365 r0 *1 0,0
Rtopn_t365 topn__t365 topn 0.780406765482
* device instance topn_t366 r0 *1 0,0
Rtopn_t366 topn__t366 topn 0.896706570273
* device instance topn_t367 r0 *1 0,0
Rtopn_t367 topn__t367 topn 1.01367871446
* device instance topn_t368 r0 *1 0,0
Rtopn_t368 topn__t368 topn 1.13111463103
* device instance topn_t369 r0 *1 0,0
Rtopn_t369 topn__t369 topn 1.24888349749
* device instance topn_t370 r0 *1 0,0
Rtopn_t370 topn__t370 topn 1.366899258
* device instance topn_t371 r0 *1 0,0
Rtopn_t371 topn__t371 topn 1.48510305438
* device instance topn_t372 r0 *1 0,0
Rtopn_t372 topn__t372 topn 1.60345330214
* device instance topn_t373 r0 *1 0,0
Rtopn_t373 topn__t373 topn 1.72191980405
* device instance topn_t374 r0 *1 0,0
Rtopn_t374 topn__t374 topn 1.84048011139
* device instance topn_t375 r0 *1 0,0
Rtopn_t375 topn__t375 topn 0.188252744615
* device instance topn_t376 r0 *1 0,0
Rtopn_t376 topn__t376 topn 0.787354598765
* device instance topn_t377 r0 *1 0,0
Rtopn_t377 topn__t377 topn 0.771597542178
* device instance topn_t378 r0 *1 0,0
Rtopn_t378 topn__t378 topn 0.774087966192
* device instance topn_t379 r0 *1 0,0
Rtopn_t379 topn__t379 topn 0.794654328071
* device instance topn_t380 r0 *1 0,0
Rtopn_t380 topn__t380 topn 0.831957169721
* device instance topn_t381 r0 *1 0,0
Rtopn_t381 topn__t381 topn 0.883880010402
* device instance topn_t382 r0 *1 0,0
Rtopn_t382 topn__t382 topn 0.94802369313
* device instance topn_t383 r0 *1 0,0
Rtopn_t383 topn__t383 topn 0.929572058508
* device instance topn_t384 r0 *1 0,0
Rtopn_t384 topn__t384 topn 0.989493266292
* device instance topn_t385 r0 *1 0,0
Rtopn_t385 topn__t385 topn 1.04718764984
* device instance topn_t386 r0 *1 0,0
Rtopn_t386 topn__t386 topn 0.868503302601
* device instance topn_t387 r0 *1 0,0
Rtopn_t387 topn__t387 topn 2.03596261333
* device instance topn_t388 r0 *1 0,0
Rtopn_t388 topn__t388 topn 1.92945187399
* device instance topn_t389 r0 *1 0,0
Rtopn_t389 topn__t389 topn 1.82451067813
* device instance topn_t390 r0 *1 0,0
Rtopn_t390 topn__t390 topn 1.98677897906
* device instance topn_t391 r0 *1 0,0
Rtopn_t391 topn__t391 topn 1.62055246876
* device instance topn_t392 r0 *1 0,0
Rtopn_t392 topn__t392 topn 1.52232937067
* device instance topn_t393 r0 *1 0,0
Rtopn_t393 topn__t393 topn 1.42730411301
* device instance topn_t394 r0 *1 0,0
Rtopn_t394 topn__t394 topn 1.3361591442
* device instance topn_t395 r0 *1 0,0
Rtopn_t395 topn__t395 topn 1.24974373199
* device instance topn_t396 r0 *1 0,0
Rtopn_t396 topn__t396 topn 1.16910711318
* device instance topn_t397 r0 *1 0,0
Rtopn_t397 topn__t397 topn 1.09552608273
* device instance topn_t398 r0 *1 0,0
Rtopn_t398 topn__t398 topn 1.03051310676
* device instance topn_t399 r0 *1 0,0
Rtopn_t399 topn__t399 topn 0.975782269709
* device instance topn_t400 r0 *1 0,0
Rtopn_t400 topn__t400 topn 0.933144534334
* device instance topn_t401 r0 *1 0,0
Rtopn_t401 topn__t401 topn 0.904312067511
* device instance topn_t402 r0 *1 0,0
Rtopn_t402 topn__t402 topn 0.89062664363
* device instance topn_t403 r0 *1 0,0
Rtopn_t403 topn__t403 topn 0.892785097688
* device instance topn_t404 r0 *1 0,0
Rtopn_t404 topn__t404 topn 0.910674778596
* device instance topn_t405 r0 *1 0,0
Rtopn_t405 topn__t405 topn 0.943401178449
* device instance topn_t406 r0 *1 0,0
Rtopn_t406 topn__t406 topn 1.72142609618
* device instance topn_t407 r0 *1 0,0
Rtopn_t407 topn__t407 topn 1.11754989592
* device instance topn_t408 r0 *1 0,0
Rtopn_t408 topn__t408 topn 1.83962879314
* device instance topn_t409 r0 *1 0,0
Rtopn_t409 topn__t409 topn 1.35569577814
* device instance topn_t410 r0 *1 0,0
Rtopn_t410 topn__t410 topn 1.47479779749
* device instance topn_t411 r0 *1 0,0
Rtopn_t411 topn__t411 topn 1.5939134084
* device instance topn_t412 r0 *1 0,0
Rtopn_t412 topn__t412 topn 1.71303977564
* device instance topn_t413 r0 *1 0,0
Rtopn_t413 topn__t413 topn 1.83217480109
* device instance topn_t414 r0 *1 0,0
Rtopn_t414 topn__t414 topn 0.894957948348
* device instance topn_t415 r0 *1 0,0
Rtopn_t415 topn__t415 topn 1.36575277325
* device instance topn_t416 r0 *1 0,0
Rtopn_t416 topn__t416 topn 0.880127518682
* device instance topn_t417 r0 *1 0,0
Rtopn_t417 topn__t417 topn 0.999042697842
* device instance topn_t418 r0 *1 0,0
Rtopn_t418 topn__t418 topn 1.11801703229
* device instance topn_t419 r0 *1 0,0
Rtopn_t419 topn__t419 topn 1.23703345399
* device instance topn_t420 r0 *1 0,0
Rtopn_t420 topn__t420 topn 1.2204126828
* device instance topn_t421 r0 *1 0,0
Rtopn_t421 topn__t421 topn 0.733072145968
* device instance topn_t422 r0 *1 0,0
Rtopn_t422 topn__t422 topn 1.23661127751
* device instance topn_t423 r0 *1 0,0
Rtopn_t423 topn__t423 topn 1.12972888989
* device instance topn_t424 r0 *1 0,0
Rtopn_t424 topn__t424 topn 1.24762856911
* device instance topn_t425 r0 *1 0,0
Rtopn_t425 topn__t425 topn 1.74561809812
* device instance topn_t426 r0 *1 0,0
Rtopn_t426 topn__t426 topn 1.62651111292
* device instance topn_t427 r0 *1 0,0
Rtopn_t427 topn__t427 topn 0.998519903403
* device instance topn_t428 r0 *1 0,0
Rtopn_t428 topn__t428 topn 1.50741771444
* device instance topn_t429 r0 *1 0,0
Rtopn_t429 topn__t429 topn 1.38834139914
* device instance topn_t430 r0 *1 0,0
Rtopn_t430 topn__t430 topn 1.26928697494
* device instance topn_t431 r0 *1 0,0
Rtopn_t431 topn__t431 topn 1.15026123918
* device instance topn_t432 r0 *1 0,0
Rtopn_t432 topn__t432 topn 1.03127412522
* device instance topn_t433 r0 *1 0,0
Rtopn_t433 topn__t433 topn 0.912340744332
* device instance topn_t434 r0 *1 0,0
Rtopn_t434 topn__t434 topn 0.793485258585
* device instance topn_t435 r0 *1 0,0
Rtopn_t435 topn__t435 topn 0.674748832399
* device instance topn_t436 r0 *1 0,0
Rtopn_t436 topn__t436 topn 0.693982180603
* device instance topn_t437 r0 *1 0,0
Rtopn_t437 topn__t437 topn 1.07034345223
* device instance topn_t438 r0 *1 0,0
Rtopn_t438 topn__t438 topn 0.856856760389
* device instance topn_t439 r0 *1 0,0
Rtopn_t439 topn__t439 topn 0.788411177499
* device instance topn_t440 r0 *1 0,0
Rtopn_t440 topn__t440 topn 1.33319001749
* device instance topn_t441 r0 *1 0,0
Rtopn_t441 topn__t441 topn 1.44699621235
* device instance topn_t442 r0 *1 0,0
Rtopn_t442 topn__t442 topn 0.95317174559
* device instance topn_t443 r0 *1 0,0
Rtopn_t443 topn__t443 topn 1.48539872141
* device instance topn_t444 r0 *1 0,0
Rtopn_t444 topn__t444 topn 1.59725567359
* device instance topn_t445 r0 *1 0,0
Rtopn_t445 topn__t445 topn 1.71010406743
* device instance topn_t446 r0 *1 0,0
Rtopn_t446 topn__t446 topn 1.0541741577
* device instance topn_t447 r0 *1 0,0
Rtopn_t447 topn__t447 topn 1.82375987057
* device instance topn_t448 r0 *1 0,0
Rtopn_t448 topn__t448 topn 1.93808104034
* device instance topn_t449 r0 *1 0,0
Rtopn_t449 topn__t449 topn 1.15863878856
* device instance topn_t450 r0 *1 0,0
Rtopn_t450 topn__t450 topn 1.26570867081
* device instance topn_t451 r0 *1 0,0
Rtopn_t451 topn__t451 topn 1.56160634085
* device instance topn_t452 r0 *1 0,0
Rtopn_t452 topn__t452 topn 0.956281557983
* device instance topn_t453 r0 *1 0,0
Rtopn_t453 topn__t453 topn 1.7926206354
* device instance topn_t454 r0 *1 0,0
Rtopn_t454 topn__t454 topn 1.90880768961
* device instance topn_t455 r0 *1 0,0
Rtopn_t455 topn__t455 topn 1.18541541357
* device instance topn_t456 r0 *1 0,0
Rtopn_t456 topn__t456 topn 1.30122949902
* device instance topn_t457 r0 *1 0,0
Rtopn_t457 topn__t457 topn 1.41760383216
* device instance topn_t458 r0 *1 0,0
Rtopn_t458 topn__t458 topn 1.53441094566
* device instance topn_t459 r0 *1 0,0
Rtopn_t459 topn__t459 topn 1.65155901645
* device instance topn_t460 r0 *1 0,0
Rtopn_t460 topn__t460 topn 1.76898030765
* device instance topn_t461 r0 *1 0,0
Rtopn_t461 topn__t461 topn 1.88662380519
* device instance topn_t462 r0 *1 0,0
Rtopn_t462 topn__t462 topn 1.37477523463
* device instance topn_t463 r0 *1 0,0
Rtopn_t463 topn__t463 topn 0.892146318477
* device instance topn_t464 r0 *1 0,0
Rtopn_t464 topn__t464 topn 0.999335695224
* device instance topn_t465 r0 *1 0,0
Rtopn_t465 topn__t465 topn 1.10897814196
* device instance topn_t466 r0 *1 0,0
Rtopn_t466 topn__t466 topn 0.843639520152
* device instance topn_t467 r0 *1 0,0
Rtopn_t467 topn__t467 topn 1.67685556874
* device instance topn_t468 r0 *1 0,0
Rtopn_t468 topn__t468 topn 1.28565478128
* device instance topn_t469 r0 *1 0,0
Rtopn_t469 topn__t469 topn 1.39779008465
* device instance topn_t470 r0 *1 0,0
Rtopn_t470 topn__t470 topn 1.10408367023
* device instance topn_t471 r0 *1 0,0
Rtopn_t471 topn__t471 topn 1.19237055022
* device instance topn_t472 r0 *1 0,0
Rtopn_t472 topn__t472 topn 1.85613554835
* device instance topn_t473 r0 *1 0,0
Rtopn_t473 topn__t473 topn 0.928415212397
* device instance topn_t474 r0 *1 0,0
Rtopn_t474 topn__t474 topn 0.973776591143
* device instance topn_t475 r0 *1 0,0
Rtopn_t475 topn__t475 topn 1.35608088161
* device instance topn_t476 r0 *1 0,0
Rtopn_t476 topn__t476 topn 1.75314227165
* device instance topn_t477 r0 *1 0,0
Rtopn_t477 topn__t477 topn 1.51612448235
* device instance topn_t478 r0 *1 0,0
Rtopn_t478 topn__t478 topn 1.63458364136
* device instance topn_t479 r0 *1 0,0
Rtopn_t479 topn__t479 topn 1.54865243721
* device instance topn_t480 r0 *1 0,0
Rtopn_t480 topn__t480 topn 1.64764279718
* device instance topn_t481 r0 *1 0,0
Rtopn_t481 topn__t481 topn 1.74915497093
* device instance topn_t482 r0 *1 0,0
Rtopn_t482 topn__t482 topn 1.85277449976
* device instance topn_t483 r0 *1 0,0
Rtopn_t483 topn__t483 topn 0.926549521926
* device instance topn_t484 r0 *1 0,0
Rtopn_t484 topn__t484 topn 2.06506066363
* device instance topn_t485 r0 *1 0,0
Rtopn_t485 topn__t485 topn 1.45269950949
* device instance topn_t486 r0 *1 0,0
Rtopn_t486 topn__t486 topn 1.08245217558
* device instance topn_t487 r0 *1 0,0
Rtopn_t487 topn__t487 topn 1.19313808288
* device instance topn_t488 r0 *1 0,0
Rtopn_t488 topn__t488 topn 1.27961506123
* device instance topn_t489 r0 *1 0,0
Rtopn_t489 topn__t489 topn 1.16164805278
* device instance topn_t490 r0 *1 0,0
Rtopn_t490 topn__t490 topn 0.778396926864
* device instance topn_t491 r0 *1 0,0
Rtopn_t491 topn__t491 topn 1.04395957849
* device instance topn_t492 r0 *1 0,0
Rtopn_t492 topn__t492 topn 0.926655768848
* device instance topn_t493 r0 *1 0,0
Rtopn_t493 topn__t493 topn 0.809903781793
* device instance topn_t494 r0 *1 0,0
Rtopn_t494 topn__t494 topn 1.86473606656
* device instance topn_t495 r0 *1 0,0
Rtopn_t495 topn__t495 topn 0.760613029708
* device instance topn_t496 r0 *1 0,0
Rtopn_t496 topn__t496 topn 0.761299215539
* device instance topn_t497 r0 *1 0,0
Rtopn_t497 topn__t497 topn 0.863645004363
* device instance topn_t498 r0 *1 0,0
Rtopn_t498 topn__t498 topn 0.813440397295
* device instance topn_t499 r0 *1 0,0
Rtopn_t499 topn__t499 topn 0.879534043981
* device instance topn_t500 r0 *1 0,0
Rtopn_t500 topn__t500 topn 1.02208995793
* device instance topn_t501 r0 *1 0,0
Rtopn_t501 topn__t501 topn 1.11468423033
* device instance topn_t502 r0 *1 0,0
Rtopn_t502 topn__t502 topn 1.38292545483
* device instance topn_t503 r0 *1 0,0
Rtopn_t503 topn__t503 topn 1.48339857086
* device instance topn_t504 r0 *1 0,0
Rtopn_t504 topn__t504 topn 1.5864658004
* device instance topn_t505 r0 *1 0,0
Rtopn_t505 topn__t505 topn 1.69165305576
* device instance topn_t506 r0 *1 0,0
Rtopn_t506 topn__t506 topn 1.79858841754
* device instance topn_t507 r0 *1 0,0
Rtopn_t507 topn__t507 topn 1.90697782886
* device instance topn_t508 r0 *1 0,0
Rtopn_t508 topn__t508 topn 2.01658684247
* device instance topn_t509 r0 *1 0,0
Rtopn_t509 topn__t509 topn 1.36042686973
* device instance topn_t510 r0 *1 0,0
Rtopn_t510 topn__t510 topn 1.19031668144
* device instance topn_t511 r0 *1 0,0
Rtopn_t511 topn__t511 topn 1.27263528958
* device instance topn_t512 r0 *1 0,0
Rtopn_t512 topn__t512 topn 1.95816687006
* device instance topn_t513 r0 *1 0,0
Rtopn_t513 topn__t513 topn 2.76930699617
* device instance topn_t514 r0 *1 0,0
Rtopn_t514 topn__t514 topn 2.67680986366
* device instance topn r0 *1 0,0
Ctopn topn vsubs 2.25729953e-13
* device instance topp_t0 r0 *1 0,0
Rtopp_t0 topp__t0 topp 2.03996167827
* device instance topp_t1 r0 *1 0,0
Rtopp_t1 topp__t1 topp 7.28287444016
* device instance topp_t2 r0 *1 0,0
Rtopp_t2 topp__t2 topp 1.00249547688
* device instance topp_t3 r0 *1 0,0
Rtopp_t3 topp__t3 topp 0.887392925394
* device instance topp_t4 r0 *1 0,0
Rtopp_t4 topp__t4 topp 0.774352122821
* device instance topp_t5 r0 *1 0,0
Rtopp_t5 topp__t5 topp 1.95293123124
* device instance topp_t6 r0 *1 0,0
Rtopp_t6 topp__t6 topp 1.97587687156
* device instance topp_t7 r0 *1 0,0
Rtopp_t7 topp__t7 topp 1.85716735076
* device instance topp_t8 r0 *1 0,0
Rtopp_t8 topp__t8 topp 1.7388897921
* device instance topp_t9 r0 *1 0,0
Rtopp_t9 topp__t9 topp 1.50403787833
* device instance topp_t10 r0 *1 0,0
Rtopp_t10 topp__t10 topp 1.38775178958
* device instance topp_t11 r0 *1 0,0
Rtopp_t11 topp__t11 topp 1.27250387139
* device instance topp_t12 r0 *1 0,0
Rtopp_t12 topp__t12 topp 1.15860396993
* device instance topp_t13 r0 *1 0,0
Rtopp_t13 topp__t13 topp 1.04649233097
* device instance topp_t14 r0 *1 0,0
Rtopp_t14 topp__t14 topp 0.936811198505
* device instance topp_t15 r0 *1 0,0
Rtopp_t15 topp__t15 topp 0.830524068117
* device instance topp_t16 r0 *1 0,0
Rtopp_t16 topp__t16 topp 1.71277222405
* device instance topp_t17 r0 *1 0,0
Rtopp_t17 topp__t17 topp 1.62113874566
* device instance topp_t18 r0 *1 0,0
Rtopp_t18 topp__t18 topp 1.97424251824
* device instance topp_t19 r0 *1 0,0
Rtopp_t19 topp__t19 topp 1.86341102851
* device instance topp_t20 r0 *1 0,0
Rtopp_t20 topp__t20 topp 1.75403927686
* device instance topp_t21 r0 *1 0,0
Rtopp_t21 topp__t21 topp 1.64641820069
* device instance topp_t22 r0 *1 0,0
Rtopp_t22 topp__t22 topp 1.54091465746
* device instance topp_t23 r0 *1 0,0
Rtopp_t23 topp__t23 topp 1.43799480346
* device instance topp_t24 r0 *1 0,0
Rtopp_t24 topp__t24 topp 1.33825487529
* device instance topp_t25 r0 *1 0,0
Rtopp_t25 topp__t25 topp 1.24246092529
* device instance topp_t26 r0 *1 0,0
Rtopp_t26 topp__t26 topp 1.83273608332
* device instance topp_t27 r0 *1 0,0
Rtopp_t27 topp__t27 topp 1.06692697961
* device instance topp_t28 r0 *1 0,0
Rtopp_t28 topp__t28 topp 1.92832221207
* device instance topp_t29 r0 *1 0,0
Rtopp_t29 topp__t29 topp 1.81468831867
* device instance topp_t30 r0 *1 0,0
Rtopp_t30 topp__t30 topp 1.59309190415
* device instance topp_t31 r0 *1 0,0
Rtopp_t31 topp__t31 topp 1.47376420158
* device instance topp_t32 r0 *1 0,0
Rtopp_t32 topp__t32 topp 1.35488228709
* device instance topp_t33 r0 *1 0,0
Rtopp_t33 topp__t33 topp 1.23657473898
* device instance topp_t34 r0 *1 0,0
Rtopp_t34 topp__t34 topp 1.11902374484
* device instance topp_t35 r0 *1 0,0
Rtopp_t35 topp__t35 topp 1.15159809558
* device instance topp_t36 r0 *1 0,0
Rtopp_t36 topp__t36 topp 0.551680292598
* device instance topp_t37 r0 *1 0,0
Rtopp_t37 topp__t37 topp 0.485025859284
* device instance topp_t38 r0 *1 0,0
Rtopp_t38 topp__t38 topp 0.813011668884
* device instance topp_t39 r0 *1 0,0
Rtopp_t39 topp__t39 topp 0.866681597443
* device instance topp_t40 r0 *1 0,0
Rtopp_t40 topp__t40 topp 0.55945435195
* device instance topp_t41 r0 *1 0,0
Rtopp_t41 topp__t41 topp 0.591795668995
* device instance topp_t42 r0 *1 0,0
Rtopp_t42 topp__t42 topp 0.614594143422
* device instance topp_t43 r0 *1 0,0
Rtopp_t43 topp__t43 topp 0.325093815256
* device instance topp_t44 r0 *1 0,0
Rtopp_t44 topp__t44 topp 0.660308155026
* device instance topp_t45 r0 *1 0,0
Rtopp_t45 topp__t45 topp 0.801015983714
* device instance topp_t46 r0 *1 0,0
Rtopp_t46 topp__t46 topp 0.590873121641
* device instance topp_t47 r0 *1 0,0
Rtopp_t47 topp__t47 topp 0.754093376321
* device instance topp_t48 r0 *1 0,0
Rtopp_t48 topp__t48 topp 0.633530649242
* device instance topp_t49 r0 *1 0,0
Rtopp_t49 topp__t49 topp 0.120191110943
* device instance topp_t50 r0 *1 0,0
Rtopp_t50 topp__t50 topp 0.470902417012
* device instance topp_t51 r0 *1 0,0
Rtopp_t51 topp__t51 topp 0.350659438869
* device instance topp_t52 r0 *1 0,0
Rtopp_t52 topp__t52 topp 0.723860305081
* device instance topp_t53 r0 *1 0,0
Rtopp_t53 topp__t53 topp 0.23207968675
* device instance topp_t54 r0 *1 0,0
Rtopp_t54 topp__t54 topp 0.309769098006
* device instance topp_t55 r0 *1 0,0
Rtopp_t55 topp__t55 topp 0.406886537557
* device instance topp_t56 r0 *1 0,0
Rtopp_t56 topp__t56 topp 0.494859080394
* device instance topp_t57 r0 *1 0,0
Rtopp_t57 topp__t57 topp 0.340461132371
* device instance topp_t58 r0 *1 0,0
Rtopp_t58 topp__t58 topp 0.46281975718
* device instance topp_t59 r0 *1 0,0
Rtopp_t59 topp__t59 topp 0.380921339084
* device instance topp_t60 r0 *1 0,0
Rtopp_t60 topp__t60 topp 0.634931641612
* device instance topp_t61 r0 *1 0,0
Rtopp_t61 topp__t61 topp 0.578821671202
* device instance topp_t62 r0 *1 0,0
Rtopp_t62 topp__t62 topp 0.666370291408
* device instance topp_t63 r0 *1 0,0
Rtopp_t63 topp__t63 topp 0.763380761286
* device instance topp_t64 r0 *1 0,0
Rtopp_t64 topp__t64 topp 0.594895240917
* device instance topp_t65 r0 *1 0,0
Rtopp_t65 topp__t65 topp 0.701855518677
* device instance topp_t66 r0 *1 0,0
Rtopp_t66 topp__t66 topp 0.453941406197
* device instance topp_t67 r0 *1 0,0
Rtopp_t67 topp__t67 topp 0.505673483633
* device instance topp_t68 r0 *1 0,0
Rtopp_t68 topp__t68 topp 0.442532491827
* device instance topp_t69 r0 *1 0,0
Rtopp_t69 topp__t69 topp 0.431399944001
* device instance topp_t70 r0 *1 0,0
Rtopp_t70 topp__t70 topp 0.724611383364
* device instance topp_t71 r0 *1 0,0
Rtopp_t71 topp__t71 topp 0.777425566794
* device instance topp_t72 r0 *1 0,0
Rtopp_t72 topp__t72 topp 0.844633263684
* device instance topp_t73 r0 *1 0,0
Rtopp_t73 topp__t73 topp 0.923095970933
* device instance topp_t74 r0 *1 0,0
Rtopp_t74 topp__t74 topp 0.820057421387
* device instance topp_t75 r0 *1 0,0
Rtopp_t75 topp__t75 topp 0.757434571492
* device instance topp_t76 r0 *1 0,0
Rtopp_t76 topp__t76 topp 0.922876558169
* device instance topp_t77 r0 *1 0,0
Rtopp_t77 topp__t77 topp 2.08630112008
* device instance topp_t78 r0 *1 0,0
Rtopp_t78 topp__t78 topp 0.826929885947
* device instance topp_t79 r0 *1 0,0
Rtopp_t79 topp__t79 topp 0.802744017991
* device instance topp_t80 r0 *1 0,0
Rtopp_t80 topp__t80 topp 0.796661072089
* device instance topp_t81 r0 *1 0,0
Rtopp_t81 topp__t81 topp 0.80908945881
* device instance topp_t82 r0 *1 0,0
Rtopp_t82 topp__t82 topp 0.839207140191
* device instance topp_t83 r0 *1 0,0
Rtopp_t83 topp__t83 topp 0.885210415184
* device instance topp_t84 r0 *1 0,0
Rtopp_t84 topp__t84 topp 0.94478162417
* device instance topp_t85 r0 *1 0,0
Rtopp_t85 topp__t85 topp 1.0298514903
* device instance topp_t86 r0 *1 0,0
Rtopp_t86 topp__t86 topp 0.867706227555
* device instance topp_t87 r0 *1 0,0
Rtopp_t87 topp__t87 topp 0.998724297523
* device instance topp_t88 r0 *1 0,0
Rtopp_t88 topp__t88 topp 0.899780655794
* device instance topp_t89 r0 *1 0,0
Rtopp_t89 topp__t89 topp 0.807122182716
* device instance topp_t90 r0 *1 0,0
Rtopp_t90 topp__t90 topp 0.72316885327
* device instance topp_t91 r0 *1 0,0
Rtopp_t91 topp__t91 topp 0.651295743928
* device instance topp_t92 r0 *1 0,0
Rtopp_t92 topp__t92 topp 0.595890161853
* device instance topp_t93 r0 *1 0,0
Rtopp_t93 topp__t93 topp 0.561845180758
* device instance topp_t94 r0 *1 0,0
Rtopp_t94 topp__t94 topp 0.553119257035
* device instance topp_t95 r0 *1 0,0
Rtopp_t95 topp__t95 topp 1.18684156226
* device instance topp_t96 r0 *1 0,0
Rtopp_t96 topp__t96 topp 1.09044354259
* device instance topp_t97 r0 *1 0,0
Rtopp_t97 topp__t97 topp 0.612813734236
* device instance topp_t98 r0 *1 0,0
Rtopp_t98 topp__t98 topp 0.674440158852
* device instance topp_t99 r0 *1 0,0
Rtopp_t99 topp__t99 topp 0.750922343581
* device instance topp_t100 r0 *1 0,0
Rtopp_t100 topp__t100 topp 0.838203547786
* device instance topp_t101 r0 *1 0,0
Rtopp_t101 topp__t101 topp 0.729116737577
* device instance topp_t102 r0 *1 0,0
Rtopp_t102 topp__t102 topp 0.933258802351
* device instance topp_t103 r0 *1 0,0
Rtopp_t103 topp__t103 topp 1.09530814999
* device instance topp_t104 r0 *1 0,0
Rtopp_t104 topp__t104 topp 0.570874593128
* device instance topp_t105 r0 *1 0,0
Rtopp_t105 topp__t105 topp 1.26953501093
* device instance topp_t106 r0 *1 0,0
Rtopp_t106 topp__t106 topp 2.13577744958
* device instance topp_t107 r0 *1 0,0
Rtopp_t107 topp__t107 topp 2.02645662951
* device instance topp_t108 r0 *1 0,0
Rtopp_t108 topp__t108 topp 1.91864369064
* device instance topp_t109 r0 *1 0,0
Rtopp_t109 topp__t109 topp 1.81260771686
* device instance topp_t110 r0 *1 0,0
Rtopp_t110 topp__t110 topp 1.70867956095
* device instance topp_t111 r0 *1 0,0
Rtopp_t111 topp__t111 topp 1.6072681581
* device instance topp_t112 r0 *1 0,0
Rtopp_t112 topp__t112 topp 0.980717618787
* device instance topp_t113 r0 *1 0,0
Rtopp_t113 topp__t113 topp 1.41414958957
* device instance topp_t114 r0 *1 0,0
Rtopp_t114 topp__t114 topp 1.32385879207
* device instance topp_t115 r0 *1 0,0
Rtopp_t115 topp__t115 topp 1.2389798724
* device instance topp_t116 r0 *1 0,0
Rtopp_t116 topp__t116 topp 1.16070070659
* device instance topp_t117 r0 *1 0,0
Rtopp_t117 topp__t117 topp 1.16811907939
* device instance topp_t118 r0 *1 0,0
Rtopp_t118 topp__t118 topp 1.07096741617
* device instance topp_t119 r0 *1 0,0
Rtopp_t119 topp__t119 topp 0.979349892823
* device instance topp_t120 r0 *1 0,0
Rtopp_t120 topp__t120 topp 2.04290122043
* device instance topp_t121 r0 *1 0,0
Rtopp_t121 topp__t121 topp 1.5088810441
* device instance topp_t122 r0 *1 0,0
Rtopp_t122 topp__t122 topp 0.944831194835
* device instance topp_t123 r0 *1 0,0
Rtopp_t123 topp__t123 topp 0.92373746751
* device instance topp_t124 r0 *1 0,0
Rtopp_t124 topp__t124 topp 0.91845621248
* device instance topp_t125 r0 *1 0,0
Rtopp_t125 topp__t125 topp 0.929257070362
* device instance topp_t126 r0 *1 0,0
Rtopp_t126 topp__t126 topp 0.955594879961
* device instance topp_t127 r0 *1 0,0
Rtopp_t127 topp__t127 topp 0.996238139007
* device instance topp_t128 r0 *1 0,0
Rtopp_t128 topp__t128 topp 1.04952621112
* device instance topp_t129 r0 *1 0,0
Rtopp_t129 topp__t129 topp 1.11364540553
* device instance topp_t130 r0 *1 0,0
Rtopp_t130 topp__t130 topp 1.3742714752
* device instance topp_t131 r0 *1 0,0
Rtopp_t131 topp__t131 topp 0.710356297238
* device instance topp_t132 r0 *1 0,0
Rtopp_t132 topp__t132 topp 0.682049111996
* device instance topp_t133 r0 *1 0,0
Rtopp_t133 topp__t133 topp 0.674879171805
* device instance topp_t134 r0 *1 0,0
Rtopp_t134 topp__t134 topp 0.689506189321
* device instance topp_t135 r0 *1 0,0
Rtopp_t135 topp__t135 topp 1.01019452394
* device instance topp_t136 r0 *1 0,0
Rtopp_t136 topp__t136 topp 1.70218883133
* device instance topp_t137 r0 *1 0,0
Rtopp_t137 topp__t137 topp 1.5910643998
* device instance topp_t138 r0 *1 0,0
Rtopp_t138 topp__t138 topp 1.48162445118
* device instance topp_t139 r0 *1 0,0
Rtopp_t139 topp__t139 topp 1.0155358875
* device instance topp_t140 r0 *1 0,0
Rtopp_t140 topp__t140 topp 1.42683931072
* device instance topp_t141 r0 *1 0,0
Rtopp_t141 topp__t141 topp 1.35286757373
* device instance topp_t142 r0 *1 0,0
Rtopp_t142 topp__t142 topp 1.2343669411
* device instance topp_t143 r0 *1 0,0
Rtopp_t143 topp__t143 topp 1.11658353996
* device instance topp_t144 r0 *1 0,0
Rtopp_t144 topp__t144 topp 1.54017704457
* device instance topp_t145 r0 *1 0,0
Rtopp_t145 topp__t145 topp 0.999770894435
* device instance topp_t146 r0 *1 0,0
Rtopp_t146 topp__t146 topp 0.884313781541
* device instance topp_t147 r0 *1 0,0
Rtopp_t147 topp__t147 topp 0.068679025266
* device instance topp_t148 r0 *1 0,0
Rtopp_t148 topp__t148 topp 0.660614781494
* device instance topp_t149 r0 *1 0,0
Rtopp_t149 topp__t149 topp 0.75836186017
* device instance topp_t150 r0 *1 0,0
Rtopp_t150 topp__t150 topp 0.489316022252
* device instance topp_t151 r0 *1 0,0
Rtopp_t151 topp__t151 topp 0.590292307124
* device instance topp_t152 r0 *1 0,0
Rtopp_t152 topp__t152 topp 0.697958329187
* device instance topp_t153 r0 *1 0,0
Rtopp_t153 topp__t153 topp 0.628888474834
* device instance topp_t154 r0 *1 0,0
Rtopp_t154 topp__t154 topp 0.544714300802
* device instance topp_t155 r0 *1 0,0
Rtopp_t155 topp__t155 topp 0.477087631817
* device instance topp_t156 r0 *1 0,0
Rtopp_t156 topp__t156 topp 0.832325402623
* device instance topp_t157 r0 *1 0,0
Rtopp_t157 topp__t157 topp 1.61878144199
* device instance topp_t158 r0 *1 0,0
Rtopp_t158 topp__t158 topp 0.825913283572
* device instance topp_t159 r0 *1 0,0
Rtopp_t159 topp__t159 topp 1.50149674116
* device instance topp_t160 r0 *1 0,0
Rtopp_t160 topp__t160 topp 1.38499731181
* device instance topp_t161 r0 *1 0,0
Rtopp_t161 topp__t161 topp 1.26949936075
* device instance topp_t162 r0 *1 0,0
Rtopp_t162 topp__t162 topp 1.7702409718
* device instance topp_t163 r0 *1 0,0
Rtopp_t163 topp__t163 topp 1.65472240023
* device instance topp_t164 r0 *1 0,0
Rtopp_t164 topp__t164 topp 0.932725975784
* device instance topp_t165 r0 *1 0,0
Rtopp_t165 topp__t165 topp 1.88655399018
* device instance topp_t166 r0 *1 0,0
Rtopp_t166 topp__t166 topp 1.95153402587
* device instance topp_t167 r0 *1 0,0
Rtopp_t167 topp__t167 topp 1.47191221954
* device instance topp_t168 r0 *1 0,0
Rtopp_t168 topp__t168 topp 1.83124717373
* device instance topp_t169 r0 *1 0,0
Rtopp_t169 topp__t169 topp 1.71117893619
* device instance topp_t170 r0 *1 0,0
Rtopp_t170 topp__t170 topp 1.59137879691
* device instance topp_t171 r0 *1 0,0
Rtopp_t171 topp__t171 topp 1.15530328632
* device instance topp_t172 r0 *1 0,0
Rtopp_t172 topp__t172 topp 1.0428368631
* device instance topp_t173 r0 *1 0,0
Rtopp_t173 topp__t173 topp 2.00352309713
* device instance topp_t174 r0 *1 0,0
Rtopp_t174 topp__t174 topp 0.667120615934
* device instance topp_t175 r0 *1 0,0
Rtopp_t175 topp__t175 topp 0.744355260894
* device instance topp_t176 r0 *1 0,0
Rtopp_t176 topp__t176 topp 0.809649698281
* device instance topp_t177 r0 *1 0,0
Rtopp_t177 topp__t177 topp 0.927982963474
* device instance topp_t178 r0 *1 0,0
Rtopp_t178 topp__t178 topp 0.862264179707
* device instance topp_t179 r0 *1 0,0
Rtopp_t179 topp__t179 topp 0.316592243907
* device instance topp_t180 r0 *1 0,0
Rtopp_t180 topp__t180 topp 0.300834762392
* device instance topp_t181 r0 *1 0,0
Rtopp_t181 topp__t181 topp 0.332352889019
* device instance topp_t182 r0 *1 0,0
Rtopp_t182 topp__t182 topp 0.400126623245
* device instance topp_t183 r0 *1 0,0
Rtopp_t183 topp__t183 topp 0.433817393128
* device instance topp_t184 r0 *1 0,0
Rtopp_t184 topp__t184 topp 0.554557329859
* device instance topp_t185 r0 *1 0,0
Rtopp_t185 topp__t185 topp 0.456888156796
* device instance topp_t186 r0 *1 0,0
Rtopp_t186 topp__t186 topp 0.373692021261
* device instance topp_t187 r0 *1 0,0
Rtopp_t187 topp__t187 topp 0.422455247266
* device instance topp_t188 r0 *1 0,0
Rtopp_t188 topp__t188 topp 0.604748758742
* device instance topp_t189 r0 *1 0,0
Rtopp_t189 topp__t189 topp 0.498064449954
* device instance topp_t190 r0 *1 0,0
Rtopp_t190 topp__t190 topp 0.572186203356
* device instance topp_t191 r0 *1 0,0
Rtopp_t191 topp__t191 topp 0.716347386867
* device instance topp_t192 r0 *1 0,0
Rtopp_t192 topp__t192 topp 0.643713083905
* device instance topp_t193 r0 *1 0,0
Rtopp_t193 topp__t193 topp 0.587592948669
* device instance topp_t194 r0 *1 0,0
Rtopp_t194 topp__t194 topp 0.553037426828
* device instance topp_t195 r0 *1 0,0
Rtopp_t195 topp__t195 topp 0.544170286615
* device instance topp_t196 r0 *1 0,0
Rtopp_t196 topp__t196 topp 0.56220831496
* device instance topp_t197 r0 *1 0,0
Rtopp_t197 topp__t197 topp 0.44544957573
* device instance topp_t198 r0 *1 0,0
Rtopp_t198 topp__t198 topp 0.229717028186
* device instance topp_t199 r0 *1 0,0
Rtopp_t199 topp__t199 topp 0.115563122087
* device instance topp_t200 r0 *1 0,0
Rtopp_t200 topp__t200 topp 0.0602141224991
* device instance topp_t201 r0 *1 0,0
Rtopp_t201 topp__t201 topp 0.153566367164
* device instance topp_t202 r0 *1 0,0
Rtopp_t202 topp__t202 topp 0.27060210811
* device instance topp_t203 r0 *1 0,0
Rtopp_t203 topp__t203 topp 0.390582073215
* device instance topp_t204 r0 *1 0,0
Rtopp_t204 topp__t204 topp 0.511438358099
* device instance topp_t205 r0 *1 0,0
Rtopp_t205 topp__t205 topp 1.73669232547
* device instance topp_t206 r0 *1 0,0
Rtopp_t206 topp__t206 topp 0.772820636022
* device instance topp_t207 r0 *1 0,0
Rtopp_t207 topp__t207 topp 0.754816459925
* device instance topp_t208 r0 *1 0,0
Rtopp_t208 topp__t208 topp 1.56384483295
* device instance topp_t209 r0 *1 0,0
Rtopp_t209 topp__t209 topp 1.44209908409
* device instance topp_t210 r0 *1 0,0
Rtopp_t210 topp__t210 topp 1.32036921288
* device instance topp_t211 r0 *1 0,0
Rtopp_t211 topp__t211 topp 1.19866005671
* device instance topp_t212 r0 *1 0,0
Rtopp_t212 topp__t212 topp 1.0769786386
* device instance topp_t213 r0 *1 0,0
Rtopp_t213 topp__t213 topp 1.80767294208
* device instance topp_t214 r0 *1 0,0
Rtopp_t214 topp__t214 topp 0.632668962069
* device instance topp_t215 r0 *1 0,0
Rtopp_t215 topp__t215 topp 1.10226185618
* device instance topp_t216 r0 *1 0,0
Rtopp_t216 topp__t216 topp 0.499252374692
* device instance topp_t217 r0 *1 0,0
Rtopp_t217 topp__t217 topp 0.387899328893
* device instance topp_t218 r0 *1 0,0
Rtopp_t218 topp__t218 topp 0.285245207303
* device instance topp_t219 r0 *1 0,0
Rtopp_t219 topp__t219 topp 0.204816382248
* device instance topp_t220 r0 *1 0,0
Rtopp_t220 topp__t220 topp 0.179501130356
* device instance topp_t221 r0 *1 0,0
Rtopp_t221 topp__t221 topp 0.157078633452
* device instance topp_t222 r0 *1 0,0
Rtopp_t222 topp__t222 topp 0.349100235039
* device instance topp_t223 r0 *1 0,0
Rtopp_t223 topp__t223 topp 0.319093115194
* device instance topp_t224 r0 *1 0,0
Rtopp_t224 topp__t224 topp 0.425616342694
* device instance topp_t225 r0 *1 0,0
Rtopp_t225 topp__t225 topp 0.538668830902
* device instance topp_t226 r0 *1 0,0
Rtopp_t226 topp__t226 topp 0.654877798384
* device instance topp_t227 r0 *1 0,0
Rtopp_t227 topp__t227 topp 0.272610654371
* device instance topp_t228 r0 *1 0,0
Rtopp_t228 topp__t228 topp 0.391976305254
* device instance topp_t229 r0 *1 0,0
Rtopp_t229 topp__t229 topp 0.512503914227
* device instance topp_t230 r0 *1 0,0
Rtopp_t230 topp__t230 topp 0.469742502212
* device instance topp_t231 r0 *1 0,0
Rtopp_t231 topp__t231 topp 0.228424045089
* device instance topp_t232 r0 *1 0,0
Rtopp_t232 topp__t232 topp 1.07748506066
* device instance topp_t233 r0 *1 0,0
Rtopp_t233 topp__t233 topp 0.955906426177
* device instance topp_t234 r0 *1 0,0
Rtopp_t234 topp__t234 topp 0.834401652965
* device instance topp_t235 r0 *1 0,0
Rtopp_t235 topp__t235 topp 0.713008502438
* device instance topp_t236 r0 *1 0,0
Rtopp_t236 topp__t236 topp 1.92943004755
* device instance topp_t237 r0 *1 0,0
Rtopp_t237 topp__t237 topp 1.92914728324
* device instance topp_t238 r0 *1 0,0
Rtopp_t238 topp__t238 topp 1.8073711289
* device instance topp_t239 r0 *1 0,0
Rtopp_t239 topp__t239 topp 1.68592663124
* device instance topp_t240 r0 *1 0,0
Rtopp_t240 topp__t240 topp 0.770821555421
* device instance topp_t241 r0 *1 0,0
Rtopp_t241 topp__t241 topp 1.31502147961
* device instance topp_t242 r0 *1 0,0
Rtopp_t242 topp__t242 topp 1.09779851882
* device instance topp_t243 r0 *1 0,0
Rtopp_t243 topp__t243 topp 0.993796060967
* device instance topp_t244 r0 *1 0,0
Rtopp_t244 topp__t244 topp 0.894307339158
* device instance topp_t245 r0 *1 0,0
Rtopp_t245 topp__t245 topp 1.2051466916
* device instance topp_t246 r0 *1 0,0
Rtopp_t246 topp__t246 topp 1.97394324534
* device instance topp_t247 r0 *1 0,0
Rtopp_t247 topp__t247 topp 1.85510999485
* device instance topp_t248 r0 *1 0,0
Rtopp_t248 topp__t248 topp 1.68560301908
* device instance topp_t249 r0 *1 0,0
Rtopp_t249 topp__t249 topp 1.56419363555
* device instance topp_t250 r0 *1 0,0
Rtopp_t250 topp__t250 topp 1.21052915983
* device instance topp_t251 r0 *1 0,0
Rtopp_t251 topp__t251 topp 1.09017333633
* device instance topp_t252 r0 *1 0,0
Rtopp_t252 topp__t252 topp 0.970186035198
* device instance topp_t253 r0 *1 0,0
Rtopp_t253 topp__t253 topp 1.93654438516
* device instance topp_t254 r0 *1 0,0
Rtopp_t254 topp__t254 topp 1.81526452971
* device instance topp_t255 r0 *1 0,0
Rtopp_t255 topp__t255 topp 1.69406388699
* device instance topp_t256 r0 *1 0,0
Rtopp_t256 topp__t256 topp 1.57296076772
* device instance topp_t257 r0 *1 0,0
Rtopp_t257 topp__t257 topp 1.19911509019
* device instance topp_t258 r0 *1 0,0
Rtopp_t258 topp__t258 topp 1.33115354996
* device instance topp_t259 r0 *1 0,0
Rtopp_t259 topp__t259 topp 0.955335557615
* device instance topp_t260 r0 *1 0,0
Rtopp_t260 topp__t260 topp 0.833747594004
* device instance topp_t261 r0 *1 0,0
Rtopp_t261 topp__t261 topp 0.712242975807
* device instance topp_t262 r0 *1 0,0
Rtopp_t262 topp__t262 topp 0.85072320161
* device instance topp_t263 r0 *1 0,0
Rtopp_t263 topp__t263 topp 0.732041646245
* device instance topp_t264 r0 *1 0,0
Rtopp_t264 topp__t264 topp 1.44247732609
* device instance topp_t265 r0 *1 0,0
Rtopp_t265 topp__t265 topp 1.32078231601
* device instance topp_t266 r0 *1 0,0
Rtopp_t266 topp__t266 topp 1.45197957409
* device instance topp_t267 r0 *1 0,0
Rtopp_t267 topp__t267 topp 1.2092138603
* device instance topp_t268 r0 *1 0,0
Rtopp_t268 topp__t268 topp 0.429444379469
* device instance topp_t269 r0 *1 0,0
Rtopp_t269 topp__t269 topp 0.541698544649
* device instance topp_t270 r0 *1 0,0
Rtopp_t270 topp__t270 topp 0.657372143239
* device instance topp_t271 r0 *1 0,0
Rtopp_t271 topp__t271 topp 0.774935442054
* device instance topp_t272 r0 *1 0,0
Rtopp_t272 topp__t272 topp 0.893642952868
* device instance topp_t273 r0 *1 0,0
Rtopp_t273 topp__t273 topp 1.01309254182
* device instance topp_t274 r0 *1 0,0
Rtopp_t274 topp__t274 topp 1.13304953668
* device instance topp_t275 r0 *1 0,0
Rtopp_t275 topp__t275 topp 1.93738931544
* device instance topp_t276 r0 *1 0,0
Rtopp_t276 topp__t276 topp 1.37395367854
* device instance topp_t277 r0 *1 0,0
Rtopp_t277 topp__t277 topp 1.49474125343
* device instance topp_t278 r0 *1 0,0
Rtopp_t278 topp__t278 topp 1.6156856445
* device instance topp_t279 r0 *1 0,0
Rtopp_t279 topp__t279 topp 1.73675409089
* device instance topp_t280 r0 *1 0,0
Rtopp_t280 topp__t280 topp 1.85792234116
* device instance topp_t281 r0 *1 0,0
Rtopp_t281 topp__t281 topp 1.25336825796
* device instance topp_t282 r0 *1 0,0
Rtopp_t282 topp__t282 topp 1.81616588359
* device instance topp_t283 r0 *1 0,0
Rtopp_t283 topp__t283 topp 1.6950296921
* device instance topp_t284 r0 *1 0,0
Rtopp_t284 topp__t284 topp 1.57400088331
* device instance topp_t285 r0 *1 0,0
Rtopp_t285 topp__t285 topp 1.45310628911
* device instance topp_t286 r0 *1 0,0
Rtopp_t286 topp__t286 topp 1.33238244415
* device instance topp_t287 r0 *1 0,0
Rtopp_t287 topp__t287 topp 1.21188037805
* device instance topp_t288 r0 *1 0,0
Rtopp_t288 topp__t288 topp 1.09167353505
* device instance topp_t289 r0 *1 0,0
Rtopp_t289 topp__t289 topp 0.971871466184
* device instance topp_t290 r0 *1 0,0
Rtopp_t290 topp__t290 topp 0.324181461613
* device instance topp_t291 r0 *1 0,0
Rtopp_t291 topp__t291 topp 0.734273910558
* device instance topp_t292 r0 *1 0,0
Rtopp_t292 topp__t292 topp 0.61725129811
* device instance topp_t293 r0 *1 0,0
Rtopp_t293 topp__t293 topp 0.502519788192
* device instance topp_t294 r0 *1 0,0
Rtopp_t294 topp__t294 topp 0.392095770501
* device instance topp_t295 r0 *1 0,0
Rtopp_t295 topp__t295 topp 0.290926162761
* device instance topp_t296 r0 *1 0,0
Rtopp_t296 topp__t296 topp 0.212656893438
* device instance topp_t297 r0 *1 0,0
Rtopp_t297 topp__t297 topp 0.188398141415
* device instance topp_t298 r0 *1 0,0
Rtopp_t298 topp__t298 topp 0.235479825599
* device instance topp_t299 r0 *1 0,0
Rtopp_t299 topp__t299 topp 0.852644808609
* device instance topp_t300 r0 *1 0,0
Rtopp_t300 topp__t300 topp 1.27726075038
* device instance topp_t301 r0 *1 0,0
Rtopp_t301 topp__t301 topp 1.54430031623
* device instance topp_t302 r0 *1 0,0
Rtopp_t302 topp__t302 topp 1.66164140351
* device instance topp_t303 r0 *1 0,0
Rtopp_t303 topp__t303 topp 1.77958613846
* device instance topp_t304 r0 *1 0,0
Rtopp_t304 topp__t304 topp 1.89802199086
* device instance topp_t305 r0 *1 0,0
Rtopp_t305 topp__t305 topp 1.04250637057
* device instance topp_t306 r0 *1 0,0
Rtopp_t306 topp__t306 topp 1.39578355957
* device instance topp_t307 r0 *1 0,0
Rtopp_t307 topp__t307 topp 0.926855307802
* device instance topp_t308 r0 *1 0,0
Rtopp_t308 topp__t308 topp 0.974273975433
* device instance topp_t309 r0 *1 0,0
Rtopp_t309 topp__t309 topp 1.08488181397
* device instance topp_t310 r0 *1 0,0
Rtopp_t310 topp__t310 topp 1.51483149198
* device instance topp_t311 r0 *1 0,0
Rtopp_t311 topp__t311 topp 1.63428979568
* device instance topp_t312 r0 *1 0,0
Rtopp_t312 topp__t312 topp 1.19766994809
* device instance topp_t313 r0 *1 0,0
Rtopp_t313 topp__t313 topp 1.31207623333
* device instance topp_t314 r0 *1 0,0
Rtopp_t314 topp__t314 topp 1.75407462971
* device instance topp_t315 r0 *1 0,0
Rtopp_t315 topp__t315 topp 1.87412338446
* device instance topp_t316 r0 *1 0,0
Rtopp_t316 topp__t316 topp 1.64189423086
* device instance topp_t317 r0 *1 0,0
Rtopp_t317 topp__t317 topp 1.74422457535
* device instance topp_t318 r0 *1 0,0
Rtopp_t318 topp__t318 topp 1.84892078154
* device instance topp_t319 r0 *1 0,0
Rtopp_t319 topp__t319 topp 1.95560290621
* device instance topp_t320 r0 *1 0,0
Rtopp_t320 topp__t320 topp 2.06396302785
* device instance topp_t321 r0 *1 0,0
Rtopp_t321 topp__t321 topp 1.27496333374
* device instance topp_t322 r0 *1 0,0
Rtopp_t322 topp__t322 topp 1.37221582
* device instance topp_t323 r0 *1 0,0
Rtopp_t323 topp__t323 topp 1.51911709477
* device instance topp_t324 r0 *1 0,0
Rtopp_t324 topp__t324 topp 1.57699832431
* device instance topp_t325 r0 *1 0,0
Rtopp_t325 topp__t325 topp 1.68327847334
* device instance topp_t326 r0 *1 0,0
Rtopp_t326 topp__t326 topp 1.79153987004
* device instance topp_t327 r0 *1 0,0
Rtopp_t327 topp__t327 topp 1.90144412916
* device instance topp_t328 r0 *1 0,0
Rtopp_t328 topp__t328 topp 2.01272214423
* device instance topp_t329 r0 *1 0,0
Rtopp_t329 topp__t329 topp 1.20263233581
* device instance topp_t330 r0 *1 0,0
Rtopp_t330 topp__t330 topp 1.30528513721
* device instance topp_t331 r0 *1 0,0
Rtopp_t331 topp__t331 topp 1.41099256799
* device instance topp_t332 r0 *1 0,0
Rtopp_t332 topp__t332 topp 1.473128302
* device instance topp_t333 r0 *1 0,0
Rtopp_t333 topp__t333 topp 0.894967709957
* device instance topp_t334 r0 *1 0,0
Rtopp_t334 topp__t334 topp 0.664426218183
* device instance topp_t335 r0 *1 0,0
Rtopp_t335 topp__t335 topp 1.42771172258
* device instance topp_t336 r0 *1 0,0
Rtopp_t336 topp__t336 topp 2.00597218634
* device instance topp_t337 r0 *1 0,0
Rtopp_t337 topp__t337 topp 1.88915472356
* device instance topp_t338 r0 *1 0,0
Rtopp_t338 topp__t338 topp 1.77301232649
* device instance topp_t339 r0 *1 0,0
Rtopp_t339 topp__t339 topp 1.65768689248
* device instance topp_t340 r0 *1 0,0
Rtopp_t340 topp__t340 topp 1.54336157147
* device instance topp_t341 r0 *1 0,0
Rtopp_t341 topp__t341 topp 1.43027620769
* device instance topp_t342 r0 *1 0,0
Rtopp_t342 topp__t342 topp 1.31874982598
* device instance topp_t343 r0 *1 0,0
Rtopp_t343 topp__t343 topp 0.990037458439
* device instance topp_t344 r0 *1 0,0
Rtopp_t344 topp__t344 topp 1.15942411867
* device instance topp_t345 r0 *1 0,0
Rtopp_t345 topp__t345 topp 1.54240070819
* device instance topp_t346 r0 *1 0,0
Rtopp_t346 topp__t346 topp 1.03394621718
* device instance topp_t347 r0 *1 0,0
Rtopp_t347 topp__t347 topp 1.24669495282
* device instance topp_t348 r0 *1 0,0
Rtopp_t348 topp__t348 topp 1.35697422337
* device instance topp_t349 r0 *1 0,0
Rtopp_t349 topp__t349 topp 1.46907990375
* device instance topp_t350 r0 *1 0,0
Rtopp_t350 topp__t350 topp 1.58262391854
* device instance topp_t351 r0 *1 0,0
Rtopp_t351 topp__t351 topp 1.69731763517
* device instance topp_t352 r0 *1 0,0
Rtopp_t352 topp__t352 topp 1.81294286314
* device instance topp_t353 r0 *1 0,0
Rtopp_t353 topp__t353 topp 1.92933213279
* device instance topp_t354 r0 *1 0,0
Rtopp_t354 topp__t354 topp 1.13877282682
* device instance topp_t355 r0 *1 0,0
Rtopp_t355 topp__t355 topp 1.74080674938
* device instance topp_t356 r0 *1 0,0
Rtopp_t356 topp__t356 topp 1.85372134073
* device instance topp_t357 r0 *1 0,0
Rtopp_t357 topp__t357 topp 1.96770004387
* device instance topp_t358 r0 *1 0,0
Rtopp_t358 topp__t358 topp 1.10388666269
* device instance topp_t359 r0 *1 0,0
Rtopp_t359 topp__t359 topp 1.18227438918
* device instance topp_t360 r0 *1 0,0
Rtopp_t360 topp__t360 topp 1.26754316761
* device instance topp_t361 r0 *1 0,0
Rtopp_t361 topp__t361 topp 1.35440926342
* device instance topp_t362 r0 *1 0,0
Rtopp_t362 topp__t362 topp 1.4463295638
* device instance topp_t363 r0 *1 0,0
Rtopp_t363 topp__t363 topp 1.62917753838
* device instance topp_t364 r0 *1 0,0
Rtopp_t364 topp__t364 topp 1.96464798756
* device instance topp_t365 r0 *1 0,0
Rtopp_t365 topp__t365 topp 1.9252077306
* device instance topp_t366 r0 *1 0,0
Rtopp_t366 topp__t366 topp 1.81137846579
* device instance topp_t367 r0 *1 0,0
Rtopp_t367 topp__t367 topp 1.6986597864
* device instance topp_t368 r0 *1 0,0
Rtopp_t368 topp__t368 topp 1.58728830926
* device instance topp_t369 r0 *1 0,0
Rtopp_t369 topp__t369 topp 1.47756870119
* device instance topp_t370 r0 *1 0,0
Rtopp_t370 topp__t370 topp 1.36989793049
* device instance topp_t371 r0 *1 0,0
Rtopp_t371 topp__t371 topp 1.26479935025
* device instance topp_t372 r0 *1 0,0
Rtopp_t372 topp__t372 topp 1.16297052243
* device instance topp_t373 r0 *1 0,0
Rtopp_t373 topp__t373 topp 1.06534945389
* device instance topp_t374 r0 *1 0,0
Rtopp_t374 topp__t374 topp 0.973203198196
* device instance topp_t375 r0 *1 0,0
Rtopp_t375 topp__t375 topp 0.888237273633
* device instance topp_t376 r0 *1 0,0
Rtopp_t376 topp__t376 topp 0.812706851686
* device instance topp_t377 r0 *1 0,0
Rtopp_t377 topp__t377 topp 0.749470067779
* device instance topp_t378 r0 *1 0,0
Rtopp_t378 topp__t378 topp 1.85048130535
* device instance topp_t379 r0 *1 0,0
Rtopp_t379 topp__t379 topp 0.673193318133
* device instance topp_t380 r0 *1 0,0
Rtopp_t380 topp__t380 topp 0.665928035858
* device instance topp_t381 r0 *1 0,0
Rtopp_t381 topp__t381 topp 0.680747410951
* device instance topp_t382 r0 *1 0,0
Rtopp_t382 topp__t382 topp 0.716282004036
* device instance topp_t383 r0 *1 0,0
Rtopp_t383 topp__t383 topp 0.76966795718
* device instance topp_t384 r0 *1 0,0
Rtopp_t384 topp__t384 topp 0.837498419418
* device instance topp_t385 r0 *1 0,0
Rtopp_t385 topp__t385 topp 0.916572105161
* device instance topp_t386 r0 *1 0,0
Rtopp_t386 topp__t386 topp 1.00423663974
* device instance topp_t387 r0 *1 0,0
Rtopp_t387 topp__t387 topp 1.09843707897
* device instance topp_t388 r0 *1 0,0
Rtopp_t388 topp__t388 topp 1.19763215869
* device instance topp_t389 r0 *1 0,0
Rtopp_t389 topp__t389 topp 1.30067964612
* device instance topp_t390 r0 *1 0,0
Rtopp_t390 topp__t390 topp 1.40673319408
* device instance topp_t391 r0 *1 0,0
Rtopp_t391 topp__t391 topp 1.51516170755
* device instance topp_t392 r0 *1 0,0
Rtopp_t392 topp__t392 topp 1.62548998889
* device instance topp_t393 r0 *1 0,0
Rtopp_t393 topp__t393 topp 1.73735614976
* device instance topp_t394 r0 *1 0,0
Rtopp_t394 topp__t394 topp 0.701857764388
* device instance topp_t395 r0 *1 0,0
Rtopp_t395 topp__t395 topp 1.614672381
* device instance topp_t396 r0 *1 0,0
Rtopp_t396 topp__t396 topp 1.73581150138
* device instance topp_t397 r0 *1 0,0
Rtopp_t397 topp__t397 topp 1.85704125476
* device instance topp_t398 r0 *1 0,0
Rtopp_t398 topp__t398 topp 0.89180969008
* device instance topp_t399 r0 *1 0,0
Rtopp_t399 topp__t399 topp 0.875630977107
* device instance topp_t400 r0 *1 0,0
Rtopp_t400 topp__t400 topp 0.997240381825
* device instance topp_t401 r0 *1 0,0
Rtopp_t401 topp__t401 topp 1.11889817831
* device instance topp_t402 r0 *1 0,0
Rtopp_t402 topp__t402 topp 1.24059013011
* device instance topp_t403 r0 *1 0,0
Rtopp_t403 topp__t403 topp 1.36230708419
* device instance topp_t404 r0 *1 0,0
Rtopp_t404 topp__t404 topp 1.48404288872
* device instance topp_t405 r0 *1 0,0
Rtopp_t405 topp__t405 topp 1.60579325653
* device instance topp_t406 r0 *1 0,0
Rtopp_t406 topp__t406 topp 1.0114758002
* device instance topp_t407 r0 *1 0,0
Rtopp_t407 topp__t407 topp 1.08135612753
* device instance topp_t408 r0 *1 0,0
Rtopp_t408 topp__t408 topp 1.49364594561
* device instance topp_t409 r0 *1 0,0
Rtopp_t409 topp__t409 topp 1.25206181404
* device instance topp_t410 r0 *1 0,0
Rtopp_t410 topp__t410 topp 1.37276199936
* device instance topp_t411 r0 *1 0,0
Rtopp_t411 topp__t411 topp 1.84932617638
* device instance topp_t412 r0 *1 0,0
Rtopp_t412 topp__t412 topp 1.72755510855
* device instance topp_t413 r0 *1 0,0
Rtopp_t413 topp__t413 topp 0.876253773763
* device instance topp_t414 r0 *1 0,0
Rtopp_t414 topp__t414 topp 0.997787275478
* device instance topp_t415 r0 *1 0,0
Rtopp_t415 topp__t415 topp 1.11938563569
* device instance topp_t416 r0 *1 0,0
Rtopp_t416 topp__t416 topp 1.84962114353
* device instance topp_t417 r0 *1 0,0
Rtopp_t417 topp__t417 topp 1.24102978969
* device instance topp_t418 r0 *1 0,0
Rtopp_t418 topp__t418 topp 1.36270747397
* device instance topp_t419 r0 *1 0,0
Rtopp_t419 topp__t419 topp 1.48441044308
* device instance topp_t420 r0 *1 0,0
Rtopp_t420 topp__t420 topp 1.60613294925
* device instance topp_t421 r0 *1 0,0
Rtopp_t421 topp__t421 topp 1.72787086353
* device instance topp_t422 r0 *1 0,0
Rtopp_t422 topp__t422 topp 1.0291866538
* device instance topp_t423 r0 *1 0,0
Rtopp_t423 topp__t423 topp 0.923907691161
* device instance topp_t424 r0 *1 0,0
Rtopp_t424 topp__t424 topp 1.15706911943
* device instance topp_t425 r0 *1 0,0
Rtopp_t425 topp__t425 topp 1.039886625
* device instance topp_t426 r0 *1 0,0
Rtopp_t426 topp__t426 topp 1.24275045513
* device instance topp_t427 r0 *1 0,0
Rtopp_t427 topp__t427 topp 1.13445314554
* device instance topp_t428 r0 *1 0,0
Rtopp_t428 topp__t428 topp 1.89600896676
* device instance topp_t429 r0 *1 0,0
Rtopp_t429 topp__t429 topp 1.77743898586
* device instance topp_t430 r0 *1 0,0
Rtopp_t430 topp__t430 topp 1.65934163996
* device instance topp_t431 r0 *1 0,0
Rtopp_t431 topp__t431 topp 1.92678563077
* device instance topp_t432 r0 *1 0,0
Rtopp_t432 topp__t432 topp 1.81023264067
* device instance topp_t433 r0 *1 0,0
Rtopp_t433 topp__t433 topp 1.69442248067
* device instance topp_t434 r0 *1 0,0
Rtopp_t434 topp__t434 topp 1.46573399767
* device instance topp_t435 r0 *1 0,0
Rtopp_t435 topp__t435 topp 1.35335118547
* device instance topp_t436 r0 *1 0,0
Rtopp_t436 topp__t436 topp 1.54182553843
* device instance topp_t437 r0 *1 0,0
Rtopp_t437 topp__t437 topp 0.970346486295
* device instance topp_t438 r0 *1 0,0
Rtopp_t438 topp__t438 topp 1.42503448626
* device instance topp_t439 r0 *1 0,0
Rtopp_t439 topp__t439 topp 1.30916254389
* device instance topp_t440 r0 *1 0,0
Rtopp_t440 topp__t440 topp 1.87266738113
* device instance topp_t441 r0 *1 0,0
Rtopp_t441 topp__t441 topp 1.75251889199
* device instance topp_t442 r0 *1 0,0
Rtopp_t442 topp__t442 topp 1.63261991793
* device instance topp_t443 r0 *1 0,0
Rtopp_t443 topp__t443 topp 1.13160419259
* device instance topp_t444 r0 *1 0,0
Rtopp_t444 topp__t444 topp 1.51302977806
* device instance topp_t445 r0 *1 0,0
Rtopp_t445 topp__t445 topp 1.39382796835
* device instance topp_t446 r0 *1 0,0
Rtopp_t446 topp__t446 topp 1.27512339977
* device instance topp_t447 r0 *1 0,0
Rtopp_t447 topp__t447 topp 1.19447721988
* device instance topp_t448 r0 *1 0,0
Rtopp_t448 topp__t448 topp 1.57951855192
* device instance topp_t449 r0 *1 0,0
Rtopp_t449 topp__t449 topp 0.793860236376
* device instance topp_t450 r0 *1 0,0
Rtopp_t450 topp__t450 topp 0.818308714821
* device instance topp_t451 r0 *1 0,0
Rtopp_t451 topp__t451 topp 0.859494161596
* device instance topp_t452 r0 *1 0,0
Rtopp_t452 topp__t452 topp 0.915159689944
* device instance topp_t453 r0 *1 0,0
Rtopp_t453 topp__t453 topp 0.982848048068
* device instance topp_t454 r0 *1 0,0
Rtopp_t454 topp__t454 topp 1.06025907037
* device instance topp_t455 r0 *1 0,0
Rtopp_t455 topp__t455 topp 1.14542319263
* device instance topp_t456 r0 *1 0,0
Rtopp_t456 topp__t456 topp 1.2367397735
* device instance topp_t457 r0 *1 0,0
Rtopp_t457 topp__t457 topp 1.33294494549
* device instance topp_t458 r0 *1 0,0
Rtopp_t458 topp__t458 topp 1.43305448999
* device instance topp_t459 r0 *1 0,0
Rtopp_t459 topp__t459 topp 1.53630534011
* device instance topp_t460 r0 *1 0,0
Rtopp_t460 topp__t460 topp 1.6421050539
* device instance topp_t461 r0 *1 0,0
Rtopp_t461 topp__t461 topp 1.74999140033
* device instance topp_t462 r0 *1 0,0
Rtopp_t462 topp__t462 topp 1.97064700982
* device instance topp_t463 r0 *1 0,0
Rtopp_t463 topp__t463 topp 2.08289905664
* device instance topp_t464 r0 *1 0,0
Rtopp_t464 topp__t464 topp 0.987990086066
* device instance topp_t465 r0 *1 0,0
Rtopp_t465 topp__t465 topp 0.946992901325
* device instance topp_t466 r0 *1 0,0
Rtopp_t466 topp__t466 topp 0.920408976147
* device instance topp_t467 r0 *1 0,0
Rtopp_t467 topp__t467 topp 0.909503048261
* device instance topp_t468 r0 *1 0,0
Rtopp_t468 topp__t468 topp 0.914835990456
* device instance topp_t469 r0 *1 0,0
Rtopp_t469 topp__t469 topp 0.936130315333
* device instance topp_t470 r0 *1 0,0
Rtopp_t470 topp__t470 topp 0.972337918808
* device instance topp_t471 r0 *1 0,0
Rtopp_t471 topp__t471 topp 1.02187478324
* device instance topp_t472 r0 *1 0,0
Rtopp_t472 topp__t472 topp 1.85960124157
* device instance topp_t473 r0 *1 0,0
Rtopp_t473 topp__t473 topp 1.08291324681
* device instance topp_t474 r0 *1 0,0
Rtopp_t474 topp__t474 topp 1.15362910454
* device instance topp_t475 r0 *1 0,0
Rtopp_t475 topp__t475 topp 1.23235753933
* device instance topp_t476 r0 *1 0,0
Rtopp_t476 topp__t476 topp 1.31766311396
* device instance topp_t477 r0 *1 0,0
Rtopp_t477 topp__t477 topp 1.40835117859
* device instance topp_t478 r0 *1 0,0
Rtopp_t478 topp__t478 topp 1.50344803229
* device instance topp_t479 r0 *1 0,0
Rtopp_t479 topp__t479 topp 1.17992663944
* device instance topp_t480 r0 *1 0,0
Rtopp_t480 topp__t480 topp 1.08881406123
* device instance topp_t481 r0 *1 0,0
Rtopp_t481 topp__t481 topp 0.787708689974
* device instance topp_t482 r0 *1 0,0
Rtopp_t482 topp__t482 topp 1.60216881526
* device instance topp_t483 r0 *1 0,0
Rtopp_t483 topp__t483 topp 1.70388374679
* device instance topp_t484 r0 *1 0,0
Rtopp_t484 topp__t484 topp 1.80808758521
* device instance topp_t485 r0 *1 0,0
Rtopp_t485 topp__t485 topp 1.91437394262
* device instance topp_t486 r0 *1 0,0
Rtopp_t486 topp__t486 topp 2.02241451039
* device instance topp_t487 r0 *1 0,0
Rtopp_t487 topp__t487 topp 2.13194261055
* device instance topp_t488 r0 *1 0,0
Rtopp_t488 topp__t488 topp 1.10627305391
* device instance topp_t489 r0 *1 0,0
Rtopp_t489 topp__t489 topp 1.04170017202
* device instance topp_t490 r0 *1 0,0
Rtopp_t490 topp__t490 topp 1.00852826201
* device instance topp_t491 r0 *1 0,0
Rtopp_t491 topp__t491 topp 0.937245130074
* device instance topp_t492 r0 *1 0,0
Rtopp_t492 topp__t492 topp 0.877162240199
* device instance topp_t493 r0 *1 0,0
Rtopp_t493 topp__t493 topp 0.830713392589
* device instance topp_t494 r0 *1 0,0
Rtopp_t494 topp__t494 topp 0.800276120372
* device instance topp_t495 r0 *1 0,0
Rtopp_t495 topp__t495 topp 2.05999450506
* device instance topp_t496 r0 *1 0,0
Rtopp_t496 topp__t496 topp 1.95141402765
* device instance topp_t497 r0 *1 0,0
Rtopp_t497 topp__t497 topp 1.84448964133
* device instance topp_t498 r0 *1 0,0
Rtopp_t498 topp__t498 topp 1.73952676031
* device instance topp_t499 r0 *1 0,0
Rtopp_t499 topp__t499 topp 1.63690276006
* device instance topp_t500 r0 *1 0,0
Rtopp_t500 topp__t500 topp 1.53708618014
* device instance topp_t501 r0 *1 0,0
Rtopp_t501 topp__t501 topp 1.44066067749
* device instance topp_t502 r0 *1 0,0
Rtopp_t502 topp__t502 topp 1.34835397185
* device instance topp_t503 r0 *1 0,0
Rtopp_t503 topp__t503 topp 2.0091954973
* device instance topp_t504 r0 *1 0,0
Rtopp_t504 topp__t504 topp 1.89771069786
* device instance topp_t505 r0 *1 0,0
Rtopp_t505 topp__t505 topp 1.17626053567
* device instance topp_t506 r0 *1 0,0
Rtopp_t506 topp__t506 topp 1.26107083953
* device instance topp_t507 r0 *1 0,0
Rtopp_t507 topp__t507 topp 1.26938867919
* device instance topp_t508 r0 *1 0,0
Rtopp_t508 topp__t508 topp 1.3670378097
* device instance topp_t509 r0 *1 0,0
Rtopp_t509 topp__t509 topp 1.46830620466
* device instance topp_t510 r0 *1 0,0
Rtopp_t510 topp__t510 topp 1.57249477944
* device instance topp_t511 r0 *1 0,0
Rtopp_t511 topp__t511 topp 1.67906001539
* device instance topp_t512 r0 *1 0,0
Rtopp_t512 topp__t512 topp 1.78757691371
* device instance topp_t513 r0 *1 0,0
Rtopp_t513 topp__t513 topp 6.70348312711
* device instance topp_t514 r0 *1 0,0
Rtopp_t514 topp__t514 topp 6.5880297408
* device instance topp r0 *1 0,0
Ctopp topp vsubs 2.39393778e-13
* device instance tp_gn_t0 r0 *1 0,0
Rtp_gn_t0 tp_gn__t0 tp_gn 100.696431059
* device instance tp_gn_t1 r0 *1 0,0
Rtp_gn_t1 tp_gn__t1 tp_gn 31.7522969677
* device instance tp_gn_t2 r0 *1 0,0
Rtp_gn_t2 tp_gn__t2 tp_gn 64.5097300968
* device instance tp_gn_t3 r0 *1 0,0
Rtp_gn_t3 tp_gn__t3 tp_gn 70.2913261279
* device instance tp_gn_t4 r0 *1 0,0
Rtp_gn_t4 tp_gn__t4 tp_gn 38.2150929367
* device instance tp_gn_t5 r0 *1 0,0
Rtp_gn_t5 tp_gn__t5 tp_gn 99.0585228122
* device instance tp_gn r0 *1 0,0
Ctp_gn tp_gn vsubs 4.986478e-15
* device instance vcm_t0 r0 *1 0,0
Rvcm_t0 vcm__t0 vcm 412.602375568
* device instance vcm_t1 r0 *1 0,0
Rvcm_t1 vcm__t1 vcm 147.734301397
* device instance vcm_t2 r0 *1 0,0
Rvcm_t2 vcm__t2 vcm 388.410016513
* device instance vcm_t3 r0 *1 0,0
Rvcm_t3 vcm__t3 vcm 237.552531151
* device instance vcm_t4 r0 *1 0,0
Rvcm_t4 vcm__t4 vcm 158.235399068
* device instance vcm_t5 r0 *1 0,0
Rvcm_t5 vcm__t5 vcm 317.760002863
* device instance vcm_t6 r0 *1 0,0
Rvcm_t6 vcm__t6 vcm 19.0664204109
* device instance vcm_t7 r0 *1 0,0
Rvcm_t7 vcm__t7 vcm 73.9012197258
* device instance vcm_t8 r0 *1 0,0
Rvcm_t8 vcm__t8 vcm 41.1736191558
* device instance vcm_t9 r0 *1 0,0
Rvcm_t9 vcm__t9 vcm 366.314563362
* device instance vcm_t10 r0 *1 0,0
Rvcm_t10 vcm__t10 vcm 175.90308584
* device instance vcm_t11 r0 *1 0,0
Rvcm_t11 vcm__t11 vcm 255.51200792
* device instance vcm_t12 r0 *1 0,0
Rvcm_t12 vcm__t12 vcm 335.824846608
* device instance vcm_t13 r0 *1 0,0
Rvcm_t13 vcm__t13 vcm 98.7160364331
* device instance vcm_t14 r0 *1 0,0
Rvcm_t14 vcm__t14 vcm 333.836171006
* device instance vcm_t15 r0 *1 0,0
Rvcm_t15 vcm__t15 vcm 252.892561505
* device instance vcm_t16 r0 *1 0,0
Rvcm_t16 vcm__t16 vcm 153.969811947
* device instance vcm_t17 r0 *1 0,0
Rvcm_t17 vcm__t17 vcm 315.65753736
* device instance vcm_t18 r0 *1 0,0
Rvcm_t18 vcm__t18 vcm 234.732755553
* device instance vcm_t19 r0 *1 0,0
Rvcm_t19 vcm__t19 vcm 172.076021226
* device instance vcm_t20 r0 *1 0,0
Rvcm_t20 vcm__t20 vcm 91.7230468419
* device instance vcm_t21 r0 *1 0,0
Rvcm_t21 vcm__t21 vcm 82.4204392372
* device instance vcm_t22 r0 *1 0,0
Rvcm_t22 vcm__t22 vcm 122.533693892
* device instance vcm_t23 r0 *1 0,0
Rvcm_t23 vcm__t23 vcm 199.583426829
* device instance vcm_t24 r0 *1 0,0
Rvcm_t24 vcm__t24 vcm 278.926573161
* device instance vcm_t25 r0 *1 0,0
Rvcm_t25 vcm__t25 vcm 375.811834767
* device instance vcm_t26 r0 *1 0,0
Rvcm_t26 vcm__t26 vcm 353.64688687
* device instance vcm_t27 r0 *1 0,0
Rvcm_t27 vcm__t27 vcm 193.776334889
* device instance vcm_t28 r0 *1 0,0
Rvcm_t28 vcm__t28 vcm 112.82832019
* device instance vcm_t29 r0 *1 0,0
Rvcm_t29 vcm__t29 vcm 274.801304425
* device instance vcm_t30 r0 *1 0,0
Rvcm_t30 vcm__t30 vcm 69.4174499633
* device instance vcm_t31 r0 *1 0,0
Rvcm_t31 vcm__t31 vcm 374.048751356
* device instance vcm_t32 r0 *1 0,0
Rvcm_t32 vcm__t32 vcm 292.996248391
* device instance vcm_t33 r0 *1 0,0
Rvcm_t33 vcm__t33 vcm 296.868788984
* device instance vcm_t34 r0 *1 0,0
Rvcm_t34 vcm__t34 vcm 211.963642108
* device instance vcm_t35 r0 *1 0,0
Rvcm_t35 vcm__t35 vcm 377.089836369
* device instance vcm_t36 r0 *1 0,0
Rvcm_t36 vcm__t36 vcm 217.285208603
* device instance vcm_t37 r0 *1 0,0
Rvcm_t37 vcm__t37 vcm 130.987863576
* device instance vcm_t38 r0 *1 0,0
Rvcm_t38 vcm__t38 vcm 139.43491925
* device instance vcm_t39 r0 *1 0,0
Rvcm_t39 vcm__t39 vcm 50.3438780536
* device instance vcm_t40 r0 *1 0,0
Rvcm_t40 vcm__t40 vcm 57.8179802216
* device instance vcm_t41 r0 *1 0,0
Rvcm_t41 vcm__t41 vcm 32.5367874101
* device instance vcm r0 *1 0,0
Cvcm vcm vsubs 2.71382523e-13
* device instance vdd_t0 r0 *1 0,0
Rvdd_t0 vdd__t0 vdd 214.659329175
* device instance vdd_t1 r0 *1 0,0
Rvdd_t1 vdd__t1 vdd 214.659329175
* device instance vdd_t2 r0 *1 0,0
Rvdd_t2 vdd__t2 vdd 203.655411352
* device instance vdd_t3 r0 *1 0,0
Rvdd_t3 vdd__t3 vdd 231.591966248
* device instance vdd_t4 r0 *1 0,0
Rvdd_t4 vdd__t4 vdd 231.591966248
* device instance vdd_t5 r0 *1 0,0
Rvdd_t5 vdd__t5 vdd 236.705639534
* device instance vdd_t6 r0 *1 0,0
Rvdd_t6 vdd__t6 vdd 236.705639534
* device instance vdd_t7 r0 *1 0,0
Rvdd_t7 vdd__t7 vdd 284.092425953
* device instance vdd_t8 r0 *1 0,0
Rvdd_t8 vdd__t8 vdd 289.572244968
* device instance vdd_t9 r0 *1 0,0
Rvdd_t9 vdd__t9 vdd 253.018629036
* device instance vdd_t10 r0 *1 0,0
Rvdd_t10 vdd__t10 vdd 246.171055951
* device instance vdd_t11 r0 *1 0,0
Rvdd_t11 vdd__t11 vdd 239.326830072
* device instance vdd_t12 r0 *1 0,0
Rvdd_t12 vdd__t12 vdd 253.018629036
* device instance vdd_t13 r0 *1 0,0
Rvdd_t13 vdd__t13 vdd 246.171055951
* device instance vdd_t14 r0 *1 0,0
Rvdd_t14 vdd__t14 vdd 239.326830072
* device instance vdd_t15 r0 *1 0,0
Rvdd_t15 vdd__t15 vdd 234.210612415
* device instance vdd_t16 r0 *1 0,0
Rvdd_t16 vdd__t16 vdd 234.210612415
* device instance vdd_t17 r0 *1 0,0
Rvdd_t17 vdd__t17 vdd 187.905402595
* device instance vdd_t18 r0 *1 0,0
Rvdd_t18 vdd__t18 vdd 150.67123182
* device instance vdd_t19 r0 *1 0,0
Rvdd_t19 vdd__t19 vdd 153.238583535
* device instance vdd_t20 r0 *1 0,0
Rvdd_t20 vdd__t20 vdd 67.5321930276
* device instance vdd_t21 r0 *1 0,0
Rvdd_t21 vdd__t21 vdd 110.154255255
* device instance vdd_t22 r0 *1 0,0
Rvdd_t22 vdd__t22 vdd 107.601783241
* device instance vdd_t23 r0 *1 0,0
Rvdd_t23 vdd__t23 vdd 105.050801426
* device instance vdd_t24 r0 *1 0,0
Rvdd_t24 vdd__t24 vdd 65.0323618851
* device instance vdd_t25 r0 *1 0,0
Rvdd_t25 vdd__t25 vdd 62.539286911
* device instance vdd_t26 r0 *1 0,0
Rvdd_t26 vdd__t26 vdd 60.0538095382
* device instance vdd_t27 r0 *1 0,0
Rvdd_t27 vdd__t27 vdd 148.104422724
* device instance vdd_t28 r0 *1 0,0
Rvdd_t28 vdd__t28 vdd 102.501421071
* device instance vdd_t29 r0 *1 0,0
Rvdd_t29 vdd__t29 vdd 68.8739601587
* device instance vdd_t30 r0 *1 0,0
Rvdd_t30 vdd__t30 vdd 66.3455335087
* device instance vdd_t31 r0 *1 0,0
Rvdd_t31 vdd__t31 vdd 32.3001042369
* device instance vdd_t32 r0 *1 0,0
Rvdd_t32 vdd__t32 vdd 29.9857419157
* device instance vdd_t33 r0 *1 0,0
Rvdd_t33 vdd__t33 vdd 27.7188748057
* device instance vdd_t34 r0 *1 0,0
Rvdd_t34 vdd__t34 vdd 25.5121665189
* device instance vdd_t35 r0 *1 0,0
Rvdd_t35 vdd__t35 vdd 27.1678746959
* device instance vdd_t36 r0 *1 0,0
Rvdd_t36 vdd__t36 vdd 29.2499366751
* device instance vdd_t37 r0 *1 0,0
Rvdd_t37 vdd__t37 vdd 19.8468299926
* device instance vdd_t38 r0 *1 0,0
Rvdd_t38 vdd__t38 vdd 21.775487059
* device instance vdd_t39 r0 *1 0,0
Rvdd_t39 vdd__t39 vdd 31.4064880756
* device instance vdd_t40 r0 *1 0,0
Rvdd_t40 vdd__t40 vdd 33.6231989662
* device instance vdd_t41 r0 *1 0,0
Rvdd_t41 vdd__t41 vdd 66.9996462048
* device instance vdd_t42 r0 *1 0,0
Rvdd_t42 vdd__t42 vdd 69.504281616
* device instance vdd_t43 r0 *1 0,0
Rvdd_t43 vdd__t43 vdd 176.197096952
* device instance vdd_t44 r0 *1 0,0
Rvdd_t44 vdd__t44 vdd 74.5295931757
* device instance vdd_t45 r0 *1 0,0
Rvdd_t45 vdd__t45 vdd 25.9759916398
* device instance vdd_t46 r0 *1 0,0
Rvdd_t46 vdd__t46 vdd 23.8283513969
* device instance vdd_t47 r0 *1 0,0
Rvdd_t47 vdd__t47 vdd 109.610913895
* device instance vdd_t48 r0 *1 0,0
Rvdd_t48 vdd__t48 vdd 112.164487284
* device instance vdd_t49 r0 *1 0,0
Rvdd_t49 vdd__t49 vdd 114.719376254
* device instance vdd_t50 r0 *1 0,0
Rvdd_t50 vdd__t50 vdd 117.275494825
* device instance vdd_t51 r0 *1 0,0
Rvdd_t51 vdd__t51 vdd 152.692150995
* device instance vdd_t52 r0 *1 0,0
Rvdd_t52 vdd__t52 vdd 155.25991089
* device instance vdd_t53 r0 *1 0,0
Rvdd_t53 vdd__t53 vdd 157.828166692
* device instance vdd_t54 r0 *1 0,0
Rvdd_t54 vdd__t54 vdd 160.396894581
* device instance vdd_t55 r0 *1 0,0
Rvdd_t55 vdd__t55 vdd 195.933596362
* device instance vdd_t56 r0 *1 0,0
Rvdd_t56 vdd__t56 vdd 198.507300442
* device instance vdd_t57 r0 *1 0,0
Rvdd_t57 vdd__t57 vdd 201.081241771
* device instance vdd_t58 r0 *1 0,0
Rvdd_t58 vdd__t58 vdd 72.0144503004
* device instance vdd_t59 r0 *1 0,0
Rvdd_t59 vdd__t59 vdd 145.538184956
* device instance vdd_t60 r0 *1 0,0
Rvdd_t60 vdd__t60 vdd 203.441155615
* device instance vdd_t61 r0 *1 0,0
Rvdd_t61 vdd__t61 vdd 200.864240265
* device instance vdd_t62 r0 *1 0,0
Rvdd_t62 vdd__t62 vdd 198.287482091
* device instance vdd_t63 r0 *1 0,0
Rvdd_t63 vdd__t63 vdd 195.710887301
* device instance vdd_t64 r0 *1 0,0
Rvdd_t64 vdd__t64 vdd 160.124767029
* device instance vdd_t65 r0 *1 0,0
Rvdd_t65 vdd__t65 vdd 157.551602424
* device instance vdd_t66 r0 *1 0,0
Rvdd_t66 vdd__t66 vdd 154.97876356
* device instance vdd_t67 r0 *1 0,0
Rvdd_t67 vdd__t67 vdd 61.8380112255
* device instance vdd_t68 r0 *1 0,0
Rvdd_t68 vdd__t68 vdd 59.323159601
* device instance vdd_t69 r0 *1 0,0
Rvdd_t69 vdd__t69 vdd 152.406266933
* device instance vdd_t70 r0 *1 0,0
Rvdd_t70 vdd__t70 vdd 152.953720807
* device instance vdd_t71 r0 *1 0,0
Rvdd_t71 vdd__t71 vdd 150.381505922
* device instance vdd_t72 r0 *1 0,0
Rvdd_t72 vdd__t72 vdd 147.809665636
* device instance vdd_t73 r0 *1 0,0
Rvdd_t73 vdd__t73 vdd 21.9344349314
* device instance vdd_t74 r0 *1 0,0
Rvdd_t74 vdd__t74 vdd 109.757629237
* device instance vdd_t75 r0 *1 0,0
Rvdd_t75 vdd__t75 vdd 107.195713448
* device instance vdd_t76 r0 *1 0,0
Rvdd_t76 vdd__t76 vdd 104.63483218
* device instance vdd_t77 r0 *1 0,0
Rvdd_t77 vdd__t77 vdd 102.075063295
* device instance vdd_t78 r0 *1 0,0
Rvdd_t78 vdd__t78 vdd 66.8832887955
* device instance vdd_t79 r0 *1 0,0
Rvdd_t79 vdd__t79 vdd 64.3582575693
* device instance vdd_t80 r0 *1 0,0
Rvdd_t80 vdd__t80 vdd 116.903032088
* device instance vdd_t81 r0 *1 0,0
Rvdd_t81 vdd__t81 vdd 114.338587157
* device instance vdd_t82 r0 *1 0,0
Rvdd_t82 vdd__t82 vdd 111.774994666
* device instance vdd_t83 r0 *1 0,0
Rvdd_t83 vdd__t83 vdd 109.212314644
* device instance vdd_t84 r0 *1 0,0
Rvdd_t84 vdd__t84 vdd 73.9421225279
* device instance vdd_t85 r0 *1 0,0
Rvdd_t85 vdd__t85 vdd 71.4062901786
* device instance vdd_t86 r0 *1 0,0
Rvdd_t86 vdd__t86 vdd 27.6038931435
* device instance vdd_t87 r0 *1 0,0
Rvdd_t87 vdd__t87 vdd 23.693767359
* device instance vdd_t88 r0 *1 0,0
Rvdd_t88 vdd__t88 vdd 25.5932238161
* device instance vdd_t89 r0 *1 0,0
Rvdd_t89 vdd__t89 vdd 145.238219851
* device instance vdd_t90 r0 *1 0,0
Rvdd_t90 vdd__t90 vdd 226.626932433
* device instance vdd_t91 r0 *1 0,0
Rvdd_t91 vdd__t91 vdd 229.241224419
* device instance vdd_t92 r0 *1 0,0
Rvdd_t92 vdd__t92 vdd 262.839757651
* device instance vdd_t93 r0 *1 0,0
Rvdd_t93 vdd__t93 vdd 265.46211687
* device instance vdd_t94 r0 *1 0,0
Rvdd_t94 vdd__t94 vdd 274.933005656
* device instance vdd_t95 r0 *1 0,0
Rvdd_t95 vdd__t95 vdd 277.557375145
* device instance vdd_t96 r0 *1 0,0
Rvdd_t96 vdd__t96 vdd 35.4735336692
* device instance vdd_t97 r0 *1 0,0
Rvdd_t97 vdd__t97 vdd 118.99739409
* device instance vdd_t98 r0 *1 0,0
Rvdd_t98 vdd__t98 vdd 121.636618733
* device instance vdd_t99 r0 *1 0,0
Rvdd_t99 vdd__t99 vdd 123.332345539
* device instance vdd_t100 r0 *1 0,0
Rvdd_t100 vdd__t100 vdd 40.6327140398
* device instance vdd_t101 r0 *1 0,0
Rvdd_t101 vdd__t101 vdd 138.442277655
* device instance vdd_t102 r0 *1 0,0
Rvdd_t102 vdd__t102 vdd 141.054845027
* device instance vdd_t103 r0 *1 0,0
Rvdd_t103 vdd__t103 vdd 143.668626368
* device instance vdd_t104 r0 *1 0,0
Rvdd_t104 vdd__t104 vdd 38.7098030415
* device instance vdd_t105 r0 *1 0,0
Rvdd_t105 vdd__t105 vdd 12.3261873224
* device instance vdd_t106 r0 *1 0,0
Rvdd_t106 vdd__t106 vdd 47.8890035138
* device instance vdd_t107 r0 *1 0,0
Rvdd_t107 vdd__t107 vdd 50.4955230575
* device instance vdd_t108 r0 *1 0,0
Rvdd_t108 vdd__t108 vdd 120.730196055
* device instance vdd_t109 r0 *1 0,0
Rvdd_t109 vdd__t109 vdd 38.0485821502
* device instance vdd_t110 r0 *1 0,0
Rvdd_t110 vdd__t110 vdd 206.765747493
* device instance vdd_t111 r0 *1 0,0
Rvdd_t111 vdd__t111 vdd 209.396574927
* device instance vdd_t112 r0 *1 0,0
Rvdd_t112 vdd__t112 vdd 212.027773368
* device instance vdd_t113 r0 *1 0,0
Rvdd_t113 vdd__t113 vdd 24.9378061061
* device instance vdd_t114 r0 *1 0,0
Rvdd_t114 vdd__t114 vdd 23.8188020933
* device instance vdd_t115 r0 *1 0,0
Rvdd_t115 vdd__t115 vdd 10.553477513
* device instance vdd_t116 r0 *1 0,0
Rvdd_t116 vdd__t116 vdd 165.003411315
* device instance vdd_t117 r0 *1 0,0
Rvdd_t117 vdd__t117 vdd 167.645742013
* device instance vdd_t118 r0 *1 0,0
Rvdd_t118 vdd__t118 vdd 184.153645898
* device instance vdd_t119 r0 *1 0,0
Rvdd_t119 vdd__t119 vdd 9.2095990828
* device instance vdd_t120 r0 *1 0,0
Rvdd_t120 vdd__t120 vdd 22.9516083722
* device instance vdd_t121 r0 *1 0,0
Rvdd_t121 vdd__t121 vdd 22.3655349705
* device instance vdd_t122 r0 *1 0,0
Rvdd_t122 vdd__t122 vdd 32.9097008837
* device instance vdd_t123 r0 *1 0,0
Rvdd_t123 vdd__t123 vdd 205.758775991
* device instance vdd_t124 r0 *1 0,0
Rvdd_t124 vdd__t124 vdd 208.40231561
* device instance vdd_t125 r0 *1 0,0
Rvdd_t125 vdd__t125 vdd 211.045910267
* device instance vdd_t126 r0 *1 0,0
Rvdd_t126 vdd__t126 vdd 213.689557917
* device instance vdd_t127 r0 *1 0,0
Rvdd_t127 vdd__t127 vdd 172.373609612
* device instance vdd_t128 r0 *1 0,0
Rvdd_t128 vdd__t128 vdd 170.288178447
* device instance vdd_t129 r0 *1 0,0
Rvdd_t129 vdd__t129 vdd 75.7254499335
* device instance vdd_t130 r0 *1 0,0
Rvdd_t130 vdd__t130 vdd 78.3552740108
* device instance vdd_t131 r0 *1 0,0
Rvdd_t131 vdd__t131 vdd 80.9861345967
* device instance vdd_t132 r0 *1 0,0
Rvdd_t132 vdd__t132 vdd 83.6179338567
* device instance vdd_t133 r0 *1 0,0
Rvdd_t133 vdd__t133 vdd 52.0457212151
* device instance vdd_t134 r0 *1 0,0
Rvdd_t134 vdd__t134 vdd 54.4536342965
* device instance vdd_t135 r0 *1 0,0
Rvdd_t135 vdd__t135 vdd 56.882680258
* device instance vdd_t136 r0 *1 0,0
Rvdd_t136 vdd__t136 vdd 59.3302635466
* device instance vdd_t137 r0 *1 0,0
Rvdd_t137 vdd__t137 vdd 134.293181412
* device instance vdd_t138 r0 *1 0,0
Rvdd_t138 vdd__t138 vdd 40.9117590704
* device instance vdd_t139 r0 *1 0,0
Rvdd_t139 vdd__t139 vdd 139.574599646
* device instance vdd_t140 r0 *1 0,0
Rvdd_t140 vdd__t140 vdd 142.21558903
* device instance vdd_t141 r0 *1 0,0
Rvdd_t141 vdd__t141 vdd 93.23109844
* device instance vdd_t142 r0 *1 0,0
Rvdd_t142 vdd__t142 vdd 95.803762591
* device instance vdd_t143 r0 *1 0,0
Rvdd_t143 vdd__t143 vdd 98.3803027581
* device instance vdd_t144 r0 *1 0,0
Rvdd_t144 vdd__t144 vdd 100.960422191
* device instance vdd_t145 r0 *1 0,0
Rvdd_t145 vdd__t145 vdd 43.1635846854
* device instance vdd_t146 r0 *1 0,0
Rvdd_t146 vdd__t146 vdd 45.4578693901
* device instance vdd_t147 r0 *1 0,0
Rvdd_t147 vdd__t147 vdd 135.830994302
* device instance vdd_t148 r0 *1 0,0
Rvdd_t148 vdd__t148 vdd 136.933793503
* device instance vdd_t149 r0 *1 0,0
Rvdd_t149 vdd__t149 vdd 86.0660171131
* device instance vdd_t150 r0 *1 0,0
Rvdd_t150 vdd__t150 vdd 128.541982991
* device instance vdd_t151 r0 *1 0,0
Rvdd_t151 vdd__t151 vdd 163.635439161
* device instance vdd_t152 r0 *1 0,0
Rvdd_t152 vdd__t152 vdd 166.257409414
* device instance vdd_t153 r0 *1 0,0
Rvdd_t153 vdd__t153 vdd 168.880120957
* device instance vdd_t154 r0 *1 0,0
Rvdd_t154 vdd__t154 vdd 171.503539782
* device instance vdd_t155 r0 *1 0,0
Rvdd_t155 vdd__t155 vdd 124.276120262
* device instance vdd_t156 r0 *1 0,0
Rvdd_t156 vdd__t156 vdd 126.915881402
* device instance vdd_t157 r0 *1 0,0
Rvdd_t157 vdd__t157 vdd 53.1059212714
* device instance vdd_t158 r0 *1 0,0
Rvdd_t158 vdd__t158 vdd 55.7196530253
* device instance vdd_t159 r0 *1 0,0
Rvdd_t159 vdd__t159 vdd 83.5114030308
* device instance vdd_t160 r0 *1 0,0
Rvdd_t160 vdd__t160 vdd 125.936311311
* device instance vdd_t161 r0 *1 0,0
Rvdd_t161 vdd__t161 vdd 162.361191515
* device instance vdd_t162 r0 *1 0,0
Rvdd_t162 vdd__t162 vdd 93.610685754
* device instance vdd_t163 r0 *1 0,0
Rvdd_t163 vdd__t163 vdd 96.2459533254
* device instance vdd_t164 r0 *1 0,0
Rvdd_t164 vdd__t164 vdd 98.881779968
* device instance vdd_t165 r0 *1 0,0
Rvdd_t165 vdd__t165 vdd 80.9626420305
* device instance vdd_t166 r0 *1 0,0
Rvdd_t166 vdd__t166 vdd 78.4203048125
* device instance vdd_t167 r0 *1 0,0
Rvdd_t167 vdd__t167 vdd 14.3698898441
* device instance vdd_t168 r0 *1 0,0
Rvdd_t168 vdd__t168 vdd 90.9760258369
* device instance vdd_t169 r0 *1 0,0
Rvdd_t169 vdd__t169 vdd 226.626932433
* device instance vdd_t170 r0 *1 0,0
Rvdd_t170 vdd__t170 vdd 229.241224419
* device instance vdd_t171 r0 *1 0,0
Rvdd_t171 vdd__t171 vdd 262.839757651
* device instance vdd_t172 r0 *1 0,0
Rvdd_t172 vdd__t172 vdd 274.933005656
* device instance vdd_t173 r0 *1 0,0
Rvdd_t173 vdd__t173 vdd 35.4735336692
* device instance vdd_t174 r0 *1 0,0
Rvdd_t174 vdd__t174 vdd 118.99739409
* device instance vdd_t175 r0 *1 0,0
Rvdd_t175 vdd__t175 vdd 121.636618733
* device instance vdd_t176 r0 *1 0,0
Rvdd_t176 vdd__t176 vdd 123.332345539
* device instance vdd_t177 r0 *1 0,0
Rvdd_t177 vdd__t177 vdd 40.6327140398
* device instance vdd_t178 r0 *1 0,0
Rvdd_t178 vdd__t178 vdd 138.442277655
* device instance vdd_t179 r0 *1 0,0
Rvdd_t179 vdd__t179 vdd 141.054845027
* device instance vdd_t180 r0 *1 0,0
Rvdd_t180 vdd__t180 vdd 143.668626368
* device instance vdd_t181 r0 *1 0,0
Rvdd_t181 vdd__t181 vdd 38.7098030415
* device instance vdd_t182 r0 *1 0,0
Rvdd_t182 vdd__t182 vdd 12.3261873224
* device instance vdd_t183 r0 *1 0,0
Rvdd_t183 vdd__t183 vdd 47.8890035138
* device instance vdd_t184 r0 *1 0,0
Rvdd_t184 vdd__t184 vdd 50.4955230575
* device instance vdd_t185 r0 *1 0,0
Rvdd_t185 vdd__t185 vdd 120.730196055
* device instance vdd_t186 r0 *1 0,0
Rvdd_t186 vdd__t186 vdd 38.0485821502
* device instance vdd_t187 r0 *1 0,0
Rvdd_t187 vdd__t187 vdd 206.765747493
* device instance vdd_t188 r0 *1 0,0
Rvdd_t188 vdd__t188 vdd 209.396574927
* device instance vdd_t189 r0 *1 0,0
Rvdd_t189 vdd__t189 vdd 212.027773368
* device instance vdd_t190 r0 *1 0,0
Rvdd_t190 vdd__t190 vdd 24.9378061061
* device instance vdd_t191 r0 *1 0,0
Rvdd_t191 vdd__t191 vdd 23.8188020933
* device instance vdd_t192 r0 *1 0,0
Rvdd_t192 vdd__t192 vdd 10.553477513
* device instance vdd_t193 r0 *1 0,0
Rvdd_t193 vdd__t193 vdd 165.003411315
* device instance vdd_t194 r0 *1 0,0
Rvdd_t194 vdd__t194 vdd 167.645742013
* device instance vdd_t195 r0 *1 0,0
Rvdd_t195 vdd__t195 vdd 184.153645898
* device instance vdd_t196 r0 *1 0,0
Rvdd_t196 vdd__t196 vdd 9.2095990828
* device instance vdd_t197 r0 *1 0,0
Rvdd_t197 vdd__t197 vdd 22.9516083722
* device instance vdd_t198 r0 *1 0,0
Rvdd_t198 vdd__t198 vdd 22.3655349705
* device instance vdd_t199 r0 *1 0,0
Rvdd_t199 vdd__t199 vdd 32.9097008837
* device instance vdd_t200 r0 *1 0,0
Rvdd_t200 vdd__t200 vdd 205.758775991
* device instance vdd_t201 r0 *1 0,0
Rvdd_t201 vdd__t201 vdd 208.40231561
* device instance vdd_t202 r0 *1 0,0
Rvdd_t202 vdd__t202 vdd 211.045910267
* device instance vdd_t203 r0 *1 0,0
Rvdd_t203 vdd__t203 vdd 213.689557917
* device instance vdd_t204 r0 *1 0,0
Rvdd_t204 vdd__t204 vdd 172.373609612
* device instance vdd_t205 r0 *1 0,0
Rvdd_t205 vdd__t205 vdd 170.288178447
* device instance vdd_t206 r0 *1 0,0
Rvdd_t206 vdd__t206 vdd 75.7254499335
* device instance vdd_t207 r0 *1 0,0
Rvdd_t207 vdd__t207 vdd 78.3552740108
* device instance vdd_t208 r0 *1 0,0
Rvdd_t208 vdd__t208 vdd 80.9861345967
* device instance vdd_t209 r0 *1 0,0
Rvdd_t209 vdd__t209 vdd 83.6179338567
* device instance vdd_t210 r0 *1 0,0
Rvdd_t210 vdd__t210 vdd 52.0457212151
* device instance vdd_t211 r0 *1 0,0
Rvdd_t211 vdd__t211 vdd 54.4536342965
* device instance vdd_t212 r0 *1 0,0
Rvdd_t212 vdd__t212 vdd 56.882680258
* device instance vdd_t213 r0 *1 0,0
Rvdd_t213 vdd__t213 vdd 59.3302635466
* device instance vdd_t214 r0 *1 0,0
Rvdd_t214 vdd__t214 vdd 134.293181412
* device instance vdd_t215 r0 *1 0,0
Rvdd_t215 vdd__t215 vdd 40.9117590704
* device instance vdd_t216 r0 *1 0,0
Rvdd_t216 vdd__t216 vdd 139.574599646
* device instance vdd_t217 r0 *1 0,0
Rvdd_t217 vdd__t217 vdd 142.21558903
* device instance vdd_t218 r0 *1 0,0
Rvdd_t218 vdd__t218 vdd 93.23109844
* device instance vdd_t219 r0 *1 0,0
Rvdd_t219 vdd__t219 vdd 95.803762591
* device instance vdd_t220 r0 *1 0,0
Rvdd_t220 vdd__t220 vdd 98.3803027581
* device instance vdd_t221 r0 *1 0,0
Rvdd_t221 vdd__t221 vdd 100.960422191
* device instance vdd_t222 r0 *1 0,0
Rvdd_t222 vdd__t222 vdd 43.1635846854
* device instance vdd_t223 r0 *1 0,0
Rvdd_t223 vdd__t223 vdd 45.4578693901
* device instance vdd_t224 r0 *1 0,0
Rvdd_t224 vdd__t224 vdd 135.830994302
* device instance vdd_t225 r0 *1 0,0
Rvdd_t225 vdd__t225 vdd 136.933793503
* device instance vdd_t226 r0 *1 0,0
Rvdd_t226 vdd__t226 vdd 86.0660171131
* device instance vdd_t227 r0 *1 0,0
Rvdd_t227 vdd__t227 vdd 128.541982991
* device instance vdd_t228 r0 *1 0,0
Rvdd_t228 vdd__t228 vdd 163.635439161
* device instance vdd_t229 r0 *1 0,0
Rvdd_t229 vdd__t229 vdd 166.257409414
* device instance vdd_t230 r0 *1 0,0
Rvdd_t230 vdd__t230 vdd 168.880120957
* device instance vdd_t231 r0 *1 0,0
Rvdd_t231 vdd__t231 vdd 171.503539782
* device instance vdd_t232 r0 *1 0,0
Rvdd_t232 vdd__t232 vdd 124.276120262
* device instance vdd_t233 r0 *1 0,0
Rvdd_t233 vdd__t233 vdd 126.915881402
* device instance vdd_t234 r0 *1 0,0
Rvdd_t234 vdd__t234 vdd 53.1059212714
* device instance vdd_t235 r0 *1 0,0
Rvdd_t235 vdd__t235 vdd 55.7196530253
* device instance vdd_t236 r0 *1 0,0
Rvdd_t236 vdd__t236 vdd 83.5114030308
* device instance vdd_t237 r0 *1 0,0
Rvdd_t237 vdd__t237 vdd 125.936311311
* device instance vdd_t238 r0 *1 0,0
Rvdd_t238 vdd__t238 vdd 162.361191515
* device instance vdd_t239 r0 *1 0,0
Rvdd_t239 vdd__t239 vdd 93.610685754
* device instance vdd_t240 r0 *1 0,0
Rvdd_t240 vdd__t240 vdd 96.2459533254
* device instance vdd_t241 r0 *1 0,0
Rvdd_t241 vdd__t241 vdd 98.881779968
* device instance vdd_t242 r0 *1 0,0
Rvdd_t242 vdd__t242 vdd 80.9626420305
* device instance vdd_t243 r0 *1 0,0
Rvdd_t243 vdd__t243 vdd 78.4203048125
* device instance vdd_t244 r0 *1 0,0
Rvdd_t244 vdd__t244 vdd 14.3698898441
* device instance vdd_t245 r0 *1 0,0
Rvdd_t245 vdd__t245 vdd 90.9760258369
* device instance vdd r0 *1 0,0
Cvdd vdd vsubs 4.37673342e-13
* device instance vref_t0 r0 *1 0,0
Rvref_t0 vref__t0 vref 376.129957805
* device instance vref_t1 r0 *1 0,0
Rvref_t1 vref__t1 vref 288.132428238
* device instance vref_t2 r0 *1 0,0
Rvref_t2 vref__t2 vref 200.385712152
* device instance vref_t3 r0 *1 0,0
Rvref_t3 vref__t3 vref 75.146706645
* device instance vref_t4 r0 *1 0,0
Rvref_t4 vref__t4 vref 41.8345661207
* device instance vref_t5 r0 *1 0,0
Rvref_t5 vref__t5 vref 34.4306210191
* device instance vref_t6 r0 *1 0,0
Rvref_t6 vref__t6 vref 71.2907024852
* device instance vref_t7 r0 *1 0,0
Rvref_t7 vref__t7 vref 115.93455358
* device instance vref_t8 r0 *1 0,0
Rvref_t8 vref__t8 vref 156.738148663
* device instance vref_t9 r0 *1 0,0
Rvref_t9 vref__t9 vref 244.210803651
* device instance vref_t10 r0 *1 0,0
Rvref_t10 vref__t10 vref 332.112288815
* device instance vref_t11 r0 *1 0,0
Rvref_t11 vref__t11 vref 332.961312528
* device instance vref_t12 r0 *1 0,0
Rvref_t12 vref__t12 vref 245.364178067
* device instance vref_t13 r0 *1 0,0
Rvref_t13 vref__t13 vref 376.879832861
* device instance vref_t14 r0 *1 0,0
Rvref_t14 vref__t14 vref 289.11063533
* device instance vref_t15 r0 *1 0,0
Rvref_t15 vref__t15 vref 201.789734361
* device instance vref_t16 r0 *1 0,0
Rvref_t16 vref__t16 vref 158.529210258
* device instance vref_t17 r0 *1 0,0
Rvref_t17 vref__t17 vref 113.473157421
* device instance vref_t18 r0 *1 0,0
Rvref_t18 vref__t18 vref 332.961312528
* device instance vref_t19 r0 *1 0,0
Rvref_t19 vref__t19 vref 158.529210258
* device instance vref_t20 r0 *1 0,0
Rvref_t20 vref__t20 vref 245.364178067
* device instance vref_t21 r0 *1 0,0
Rvref_t21 vref__t21 vref 41.8345661207
* device instance vref_t22 r0 *1 0,0
Rvref_t22 vref__t22 vref 244.210803651
* device instance vref_t23 r0 *1 0,0
Rvref_t23 vref__t23 vref 156.738148663
* device instance vref_t24 r0 *1 0,0
Rvref_t24 vref__t24 vref 75.146706645
* device instance vref_t25 r0 *1 0,0
Rvref_t25 vref__t25 vref 332.112288815
* device instance vref_t26 r0 *1 0,0
Rvref_t26 vref__t26 vref 71.2907024852
* device instance vref_t27 r0 *1 0,0
Rvref_t27 vref__t27 vref 289.11063533
* device instance vref_t28 r0 *1 0,0
Rvref_t28 vref__t28 vref 288.132428238
* device instance vref_t29 r0 *1 0,0
Rvref_t29 vref__t29 vref 200.385712152
* device instance vref_t30 r0 *1 0,0
Rvref_t30 vref__t30 vref 376.879832861
* device instance vref_t31 r0 *1 0,0
Rvref_t31 vref__t31 vref 201.789734361
* device instance vref_t32 r0 *1 0,0
Rvref_t32 vref__t32 vref 115.93455358
* device instance vref_t33 r0 *1 0,0
Rvref_t33 vref__t33 vref 113.473157421
* device instance vref_t34 r0 *1 0,0
Rvref_t34 vref__t34 vref 376.129957805
* device instance vref_t35 r0 *1 0,0
Rvref_t35 vref__t35 vref 34.4306210191
* device instance vref r0 *1 0,0
Cvref vref vsubs 1.80620176e-13
* device instance vss_t0 r0 *1 0,0
Rvss_t0 vss__t0 vss 42.7824367449
* device instance vss_t1 r0 *1 0,0
Rvss_t1 vss__t1 vss 43.3293604278
* device instance vss_t2 r0 *1 0,0
Rvss_t2 vss__t2 vss 46.1366660966
* device instance vss_t3 r0 *1 0,0
Rvss_t3 vss__t3 vss 51.9939012833
* device instance vss_t4 r0 *1 0,0
Rvss_t4 vss__t4 vss 53.3487302478
* device instance vss_t5 r0 *1 0,0
Rvss_t5 vss__t5 vss 45.3847177856
* device instance vss_t6 r0 *1 0,0
Rvss_t6 vss__t6 vss 34.2204127757
* device instance vss_t7 r0 *1 0,0
Rvss_t7 vss__t7 vss 17.1553710717
* device instance vss_t8 r0 *1 0,0
Rvss_t8 vss__t8 vss 25.6675462616
* device instance vss_t9 r0 *1 0,0
Rvss_t9 vss__t9 vss 9.41218529484
* device instance vss_t10 r0 *1 0,0
Rvss_t10 vss__t10 vss 3.16429638249
* device instance vss_t11 r0 *1 0,0
Rvss_t11 vss__t11 vss 2.89258406192
* device instance vss_t12 r0 *1 0,0
Rvss_t12 vss__t12 vss 9.32435000327
* device instance vss_t13 r0 *1 0,0
Rvss_t13 vss__t13 vss 8.89572122641
* device instance vss_t14 r0 *1 0,0
Rvss_t14 vss__t14 vss 17.6979520957
* device instance vss_t15 r0 *1 0,0
Rvss_t15 vss__t15 vss 26.2142911167
* device instance vss_t16 r0 *1 0,0
Rvss_t16 vss__t16 vss 34.7686375069
* device instance vss_t17 r0 *1 0,0
Rvss_t17 vss__t17 vss 34.7922963187
* device instance vss_t18 r0 *1 0,0
Rvss_t18 vss__t18 vss 26.2456622662
* device instance vss_t19 r0 *1 0,0
Rvss_t19 vss__t19 vss 34.2444503472
* device instance vss_t20 r0 *1 0,0
Rvss_t20 vss__t20 vss 25.6995848241
* device instance vss_t21 r0 *1 0,0
Rvss_t21 vss__t21 vss 17.2032696209
* device instance vss_t22 r0 *1 0,0
Rvss_t22 vss__t22 vss 17.7443860819
* device instance vss_t23 r0 *1 0,0
Rvss_t23 vss__t23 vss 8.80273406942
* device instance vss_t24 r0 *1 0,0
Rvss_t24 vss__t24 vss 30.0393536796
* device instance vss_t25 r0 *1 0,0
Rvss_t25 vss__t25 vss 13.1655011498
* device instance vss_t26 r0 *1 0,0
Rvss_t26 vss__t26 vss 21.540608685
* device instance vss_t27 r0 *1 0,0
Rvss_t27 vss__t27 vss 21.3293883804
* device instance vss_t28 r0 *1 0,0
Rvss_t28 vss__t28 vss 12.8169967888
* device instance vss_t29 r0 *1 0,0
Rvss_t29 vss__t29 vss 29.8882544764
* device instance vss_t30 r0 *1 0,0
Rvss_t30 vss__t30 vss 4.61579350248
* device instance vss_t31 r0 *1 0,0
Rvss_t31 vss__t31 vss 30.5852347562
* device instance vss_t32 r0 *1 0,0
Rvss_t32 vss__t32 vss 39.0117858995
* device instance vss_t33 r0 *1 0,0
Rvss_t33 vss__t33 vss 5.51004205966
* device instance vss_t34 r0 *1 0,0
Rvss_t34 vss__t34 vss 30.4368456192
* device instance vss_t35 r0 *1 0,0
Rvss_t35 vss__t35 vss 39.1276686363
* device instance vss_t36 r0 *1 0,0
Rvss_t36 vss__t36 vss 22.0824876823
* device instance vss_t37 r0 *1 0,0
Rvss_t37 vss__t37 vss 21.8764999119
* device instance vss_t38 r0 *1 0,0
Rvss_t38 vss__t38 vss 13.6935563078
* device instance vss_t39 r0 *1 0,0
Rvss_t39 vss__t39 vss 13.3588349235
* device instance vss_t40 r0 *1 0,0
Rvss_t40 vss__t40 vss 5.10227768754
* device instance vss_t41 r0 *1 0,0
Rvss_t41 vss__t41 vss 5.92353369556
* device instance vss_t42 r0 *1 0,0
Rvss_t42 vss__t42 vss 34.2432840477
* device instance vss_t43 r0 *1 0,0
Rvss_t43 vss__t43 vss 27.8064234872
* device instance vss_t44 r0 *1 0,0
Rvss_t44 vss__t44 vss 11.4063398567
* device instance vss_t45 r0 *1 0,0
Rvss_t45 vss__t45 vss 9.67509342891
* device instance vss_t46 r0 *1 0,0
Rvss_t46 vss__t46 vss 10.1904067288
* device instance vss_t47 r0 *1 0,0
Rvss_t47 vss__t47 vss 10.9233625258
* device instance vss_t48 r0 *1 0,0
Rvss_t48 vss__t48 vss 27.2841137243
* device instance vss_t49 r0 *1 0,0
Rvss_t49 vss__t49 vss 26.7618444789
* device instance vss_t50 r0 *1 0,0
Rvss_t50 vss__t50 vss 17.327041131
* device instance vss_t51 r0 *1 0,0
Rvss_t51 vss__t51 vss 16.8745635435
* device instance vss_t52 r0 *1 0,0
Rvss_t52 vss__t52 vss 26.2396181702
* device instance vss_t53 r0 *1 0,0
Rvss_t53 vss__t53 vss 17.6739678169
* device instance vss_t54 r0 *1 0,0
Rvss_t54 vss__t54 vss 18.106479447
* device instance vss_t55 r0 *1 0,0
Rvss_t55 vss__t55 vss 18.6152776899
* device instance vss_t56 r0 *1 0,0
Rvss_t56 vss__t56 vss 19.1248611131
* device instance vss_t57 r0 *1 0,0
Rvss_t57 vss__t57 vss 19.6351685844
* device instance vss_t58 r0 *1 0,0
Rvss_t58 vss__t58 vss 28.0833161632
* device instance vss_t59 r0 *1 0,0
Rvss_t59 vss__t59 vss 27.5662533053
* device instance vss_t60 r0 *1 0,0
Rvss_t60 vss__t60 vss 27.0494321471
* device instance vss_t61 r0 *1 0,0
Rvss_t61 vss__t61 vss 18.1948647673
* device instance vss_t62 r0 *1 0,0
Rvss_t62 vss__t62 vss 19.2370576172
* device instance vss_t63 r0 *1 0,0
Rvss_t63 vss__t63 vss 18.7158984028
* device instance vss_t64 r0 *1 0,0
Rvss_t64 vss__t64 vss 26.5328668125
* device instance vss_t65 r0 *1 0,0
Rvss_t65 vss__t65 vss 10.7064993978
* device instance vss_t66 r0 *1 0,0
Rvss_t66 vss__t66 vss 25.7403507334
* device instance vss_t67 r0 *1 0,0
Rvss_t67 vss__t67 vss 25.2245051083
* device instance vss_t68 r0 *1 0,0
Rvss_t68 vss__t68 vss 24.7089749618
* device instance vss_t69 r0 *1 0,0
Rvss_t69 vss__t69 vss 16.3540725678
* device instance vss_t70 r0 *1 0,0
Rvss_t70 vss__t70 vss 15.8337698587
* device instance vss_t71 r0 *1 0,0
Rvss_t71 vss__t71 vss 15.313674606
* device instance vss_t72 r0 *1 0,0
Rvss_t72 vss__t72 vss 4.31745135697
* device instance vss_t73 r0 *1 0,0
Rvss_t73 vss__t73 vss 4.39713160566
* device instance vss_t74 r0 *1 0,0
Rvss_t74 vss__t74 vss 8.37311998191
* device instance vss_t75 r0 *1 0,0
Rvss_t75 vss__t75 vss 7.86185256057
* device instance vss_t76 r0 *1 0,0
Rvss_t76 vss__t76 vss 7.35228513825
* device instance vss_t77 r0 *1 0,0
Rvss_t77 vss__t77 vss 6.84479739959
* device instance vss_t78 r0 *1 0,0
Rvss_t78 vss__t78 vss 41.5553853466
* device instance vss_t79 r0 *1 0,0
Rvss_t79 vss__t79 vss 4.72936332764
* device instance vss_t80 r0 *1 0,0
Rvss_t80 vss__t80 vss 1.77902407192
* device instance vss_t81 r0 *1 0,0
Rvss_t81 vss__t81 vss 1.96451184425
* device instance vss_t82 r0 *1 0,0
Rvss_t82 vss__t82 vss 2.25864351795
* device instance vss_t83 r0 *1 0,0
Rvss_t83 vss__t83 vss 2.62515102679
* device instance vss_t84 r0 *1 0,0
Rvss_t84 vss__t84 vss 16.8205573369
* device instance vss_t85 r0 *1 0,0
Rvss_t85 vss__t85 vss 16.3151379862
* device instance vss_t86 r0 *1 0,0
Rvss_t86 vss__t86 vss 15.810885159
* device instance vss_t87 r0 *1 0,0
Rvss_t87 vss__t87 vss 9.25119439871
* device instance vss_t88 r0 *1 0,0
Rvss_t88 vss__t88 vss 8.79114243176
* device instance vss_t89 r0 *1 0,0
Rvss_t89 vss__t89 vss 8.33855840811
* device instance vss_t90 r0 *1 0,0
Rvss_t90 vss__t90 vss 7.89472678519
* device instance vss_t91 r0 *1 0,0
Rvss_t91 vss__t91 vss 4.53618012347
* device instance vss_t92 r0 *1 0,0
Rvss_t92 vss__t92 vss 24.1937804607
* device instance vss_t93 r0 *1 0,0
Rvss_t93 vss__t93 vss 10.4442755818
* device instance vss_t94 r0 *1 0,0
Rvss_t94 vss__t94 vss 42.6011905263
* device instance vss_t95 r0 *1 0,0
Rvss_t95 vss__t95 vss 42.0782824147
* device instance vss_t96 r0 *1 0,0
Rvss_t96 vss__t96 vss 41.0324997441
* device instance vss_t97 r0 *1 0,0
Rvss_t97 vss__t97 vss 39.1548432127
* device instance vss_t98 r0 *1 0,0
Rvss_t98 vss__t98 vss 33.7241413793
* device instance vss_t99 r0 *1 0,0
Rvss_t99 vss__t99 vss 36.8174340251
* device instance vss_t100 r0 *1 0,0
Rvss_t100 vss__t100 vss 57.650698095
* device instance vss_t101 r0 *1 0,0
Rvss_t101 vss__t101 vss 33.2051306997
* device instance vss_t102 r0 *1 0,0
Rvss_t102 vss__t102 vss 9.1606910239
* device instance vss_t103 r0 *1 0,0
Rvss_t103 vss__t103 vss 9.96963989353
* device instance vss_t104 r0 *1 0,0
Rvss_t104 vss__t104 vss 41.220644037
* device instance vss_t105 r0 *1 0,0
Rvss_t105 vss__t105 vss 33.493913659
* device instance vss_t106 r0 *1 0,0
Rvss_t106 vss__t106 vss 32.9712790958
* device instance vss_t107 r0 *1 0,0
Rvss_t107 vss__t107 vss 32.4486674895
* device instance vss_t108 r0 *1 0,0
Rvss_t108 vss__t108 vss 32.6862582964
* device instance vss_t109 r0 *1 0,0
Rvss_t109 vss__t109 vss 57.1312531959
* device instance vss_t110 r0 *1 0,0
Rvss_t110 vss__t110 vss 55.2565818421
* device instance vss_t111 r0 *1 0,0
Rvss_t111 vss__t111 vss 25.4379676135
* device instance vss_t112 r0 *1 0,0
Rvss_t112 vss__t112 vss 24.915862385
* device instance vss_t113 r0 *1 0,0
Rvss_t113 vss__t113 vss 24.3938103643
* device instance vss_t114 r0 *1 0,0
Rvss_t114 vss__t114 vss 23.8718150422
* device instance vss_t115 r0 *1 0,0
Rvss_t115 vss__t115 vss 42.2617712661
* device instance vss_t116 r0 *1 0,0
Rvss_t116 vss__t116 vss 54.7374854473
* device instance vss_t117 r0 *1 0,0
Rvss_t117 vss__t117 vss 41.7411728498
* device instance vss_t118 r0 *1 0,0
Rvss_t118 vss__t118 vss 34.016570121
* device instance vss_t119 r0 *1 0,0
Rvss_t119 vss__t119 vss 60.1767351864
* device instance vss_t120 r0 *1 0,0
Rvss_t120 vss__t120 vss 61.2614758053
* device instance vss_t121 r0 *1 0,0
Rvss_t121 vss__t121 vss 42.7824367449
* device instance vss_t122 r0 *1 0,0
Rvss_t122 vss__t122 vss 42.2617712661
* device instance vss_t123 r0 *1 0,0
Rvss_t123 vss__t123 vss 41.7411728498
* device instance vss_t124 r0 *1 0,0
Rvss_t124 vss__t124 vss 41.220644037
* device instance vss_t125 r0 *1 0,0
Rvss_t125 vss__t125 vss 34.2432840477
* device instance vss_t126 r0 *1 0,0
Rvss_t126 vss__t126 vss 33.7241413793
* device instance vss_t127 r0 *1 0,0
Rvss_t127 vss__t127 vss 33.2051306997
* device instance vss_t128 r0 *1 0,0
Rvss_t128 vss__t128 vss 32.6862582964
* device instance vss_t129 r0 *1 0,0
Rvss_t129 vss__t129 vss 25.7403507334
* device instance vss_t130 r0 *1 0,0
Rvss_t130 vss__t130 vss 25.2245051083
* device instance vss_t131 r0 *1 0,0
Rvss_t131 vss__t131 vss 24.7089749618
* device instance vss_t132 r0 *1 0,0
Rvss_t132 vss__t132 vss 24.1937804607
* device instance vss_t133 r0 *1 0,0
Rvss_t133 vss__t133 vss 17.327041131
* device instance vss_t134 r0 *1 0,0
Rvss_t134 vss__t134 vss 16.8205573369
* device instance vss_t135 r0 *1 0,0
Rvss_t135 vss__t135 vss 16.3151379862
* device instance vss_t136 r0 *1 0,0
Rvss_t136 vss__t136 vss 15.810885159
* device instance vss_t137 r0 *1 0,0
Rvss_t137 vss__t137 vss 9.25119439871
* device instance vss_t138 r0 *1 0,0
Rvss_t138 vss__t138 vss 8.79114243176
* device instance vss_t139 r0 *1 0,0
Rvss_t139 vss__t139 vss 8.33855840811
* device instance vss_t140 r0 *1 0,0
Rvss_t140 vss__t140 vss 7.89472678519
* device instance vss_t141 r0 *1 0,0
Rvss_t141 vss__t141 vss 4.31745135697
* device instance vss_t142 r0 *1 0,0
Rvss_t142 vss__t142 vss 4.39713160566
* device instance vss_t143 r0 *1 0,0
Rvss_t143 vss__t143 vss 4.53618012347
* device instance vss_t144 r0 *1 0,0
Rvss_t144 vss__t144 vss 4.72936332764
* device instance vss_t145 r0 *1 0,0
Rvss_t145 vss__t145 vss 9.96963989353
* device instance vss_t146 r0 *1 0,0
Rvss_t146 vss__t146 vss 10.4442755818
* device instance vss_t147 r0 *1 0,0
Rvss_t147 vss__t147 vss 10.9233625258
* device instance vss_t148 r0 *1 0,0
Rvss_t148 vss__t148 vss 11.4063398567
* device instance vss_t149 r0 *1 0,0
Rvss_t149 vss__t149 vss 18.106479447
* device instance vss_t150 r0 *1 0,0
Rvss_t150 vss__t150 vss 18.6152776899
* device instance vss_t151 r0 *1 0,0
Rvss_t151 vss__t151 vss 19.1248611131
* device instance vss_t152 r0 *1 0,0
Rvss_t152 vss__t152 vss 19.6351685844
* device instance vss_t153 r0 *1 0,0
Rvss_t153 vss__t153 vss 26.5328668125
* device instance vss_t154 r0 *1 0,0
Rvss_t154 vss__t154 vss 27.0494321471
* device instance vss_t155 r0 *1 0,0
Rvss_t155 vss__t155 vss 27.5662533053
* device instance vss_t156 r0 *1 0,0
Rvss_t156 vss__t156 vss 28.0833161632
* device instance vss_t157 r0 *1 0,0
Rvss_t157 vss__t157 vss 42.6011905263
* device instance vss_t158 r0 *1 0,0
Rvss_t158 vss__t158 vss 42.0782824147
* device instance vss_t159 r0 *1 0,0
Rvss_t159 vss__t159 vss 41.5553853466
* device instance vss_t160 r0 *1 0,0
Rvss_t160 vss__t160 vss 41.0324997441
* device instance vss_t161 r0 *1 0,0
Rvss_t161 vss__t161 vss 34.016570121
* device instance vss_t162 r0 *1 0,0
Rvss_t162 vss__t162 vss 33.493913659
* device instance vss_t163 r0 *1 0,0
Rvss_t163 vss__t163 vss 32.9712790958
* device instance vss_t164 r0 *1 0,0
Rvss_t164 vss__t164 vss 32.4486674895
* device instance vss_t165 r0 *1 0,0
Rvss_t165 vss__t165 vss 25.4379676135
* device instance vss_t166 r0 *1 0,0
Rvss_t166 vss__t166 vss 24.915862385
* device instance vss_t167 r0 *1 0,0
Rvss_t167 vss__t167 vss 24.3938103643
* device instance vss_t168 r0 *1 0,0
Rvss_t168 vss__t168 vss 23.8718150422
* device instance vss_t169 r0 *1 0,0
Rvss_t169 vss__t169 vss 16.8745635435
* device instance vss_t170 r0 *1 0,0
Rvss_t170 vss__t170 vss 16.3540725678
* device instance vss_t171 r0 *1 0,0
Rvss_t171 vss__t171 vss 15.8337698587
* device instance vss_t172 r0 *1 0,0
Rvss_t172 vss__t172 vss 15.313674606
* device instance vss_t173 r0 *1 0,0
Rvss_t173 vss__t173 vss 8.37311998191
* device instance vss_t174 r0 *1 0,0
Rvss_t174 vss__t174 vss 7.86185256057
* device instance vss_t175 r0 *1 0,0
Rvss_t175 vss__t175 vss 7.35228513825
* device instance vss_t176 r0 *1 0,0
Rvss_t176 vss__t176 vss 6.84479739959
* device instance vss_t177 r0 *1 0,0
Rvss_t177 vss__t177 vss 1.77902407192
* device instance vss_t178 r0 *1 0,0
Rvss_t178 vss__t178 vss 1.96451184425
* device instance vss_t179 r0 *1 0,0
Rvss_t179 vss__t179 vss 2.25864351795
* device instance vss_t180 r0 *1 0,0
Rvss_t180 vss__t180 vss 2.62515102679
* device instance vss_t181 r0 *1 0,0
Rvss_t181 vss__t181 vss 9.1606910239
* device instance vss_t182 r0 *1 0,0
Rvss_t182 vss__t182 vss 9.67509342891
* device instance vss_t183 r0 *1 0,0
Rvss_t183 vss__t183 vss 10.1904067288
* device instance vss_t184 r0 *1 0,0
Rvss_t184 vss__t184 vss 10.7064993978
* device instance vss_t185 r0 *1 0,0
Rvss_t185 vss__t185 vss 17.6739678169
* device instance vss_t186 r0 *1 0,0
Rvss_t186 vss__t186 vss 18.1948647673
* device instance vss_t187 r0 *1 0,0
Rvss_t187 vss__t187 vss 18.7158984028
* device instance vss_t188 r0 *1 0,0
Rvss_t188 vss__t188 vss 19.2370576172
* device instance vss_t189 r0 *1 0,0
Rvss_t189 vss__t189 vss 26.2396181702
* device instance vss_t190 r0 *1 0,0
Rvss_t190 vss__t190 vss 26.7618444789
* device instance vss_t191 r0 *1 0,0
Rvss_t191 vss__t191 vss 27.2841137243
* device instance vss_t192 r0 *1 0,0
Rvss_t192 vss__t192 vss 27.8064234872
* device instance vss_t193 r0 *1 0,0
Rvss_t193 vss__t193 vss 54.7374854473
* device instance vss_t194 r0 *1 0,0
Rvss_t194 vss__t194 vss 55.2565818421
* device instance vss_t195 r0 *1 0,0
Rvss_t195 vss__t195 vss 57.1312531959
* device instance vss_t196 r0 *1 0,0
Rvss_t196 vss__t196 vss 57.650698095
* device instance vss_t197 r0 *1 0,0
Rvss_t197 vss__t197 vss 36.8174340251
* device instance vss_t198 r0 *1 0,0
Rvss_t198 vss__t198 vss 39.1548432127
* device instance vss_t199 r0 *1 0,0
Rvss_t199 vss__t199 vss 40.6536032271
* device instance vss_t200 r0 *1 0,0
Rvss_t200 vss__t200 vss 40.1449003694
* device instance vss_t201 r0 *1 0,0
Rvss_t201 vss__t201 vss 39.6362547615
* device instance vss_t202 r0 *1 0,0
Rvss_t202 vss__t202 vss 39.1276686363
* device instance vss_t203 r0 *1 0,0
Rvss_t203 vss__t203 vss 32.1069076173
* device instance vss_t204 r0 *1 0,0
Rvss_t204 vss__t204 vss 31.5995639842
* device instance vss_t205 r0 *1 0,0
Rvss_t205 vss__t205 vss 31.0923377502
* device instance vss_t206 r0 *1 0,0
Rvss_t206 vss__t206 vss 30.5852347562
* device instance vss_t207 r0 *1 0,0
Rvss_t207 vss__t207 vss 23.594260385
* device instance vss_t208 r0 *1 0,0
Rvss_t208 vss__t208 vss 23.0900283084
* device instance vss_t209 r0 *1 0,0
Rvss_t209 vss__t209 vss 22.5860972058
* device instance vss_t210 r0 *1 0,0
Rvss_t210 vss__t210 vss 22.0824876823
* device instance vss_t211 r0 *1 0,0
Rvss_t211 vss__t211 vss 15.1730772902
* device instance vss_t212 r0 *1 0,0
Rvss_t212 vss__t212 vss 14.6786891632
* device instance vss_t213 r0 *1 0,0
Rvss_t213 vss__t213 vss 14.1854732802
* device instance vss_t214 r0 *1 0,0
Rvss_t214 vss__t214 vss 13.6935563078
* device instance vss_t215 r0 *1 0,0
Rvss_t215 vss__t215 vss 7.17307261657
* device instance vss_t216 r0 *1 0,0
Rvss_t216 vss__t216 vss 6.74358723401
* device instance vss_t217 r0 *1 0,0
Rvss_t217 vss__t217 vss 6.32622022559
* device instance vss_t218 r0 *1 0,0
Rvss_t218 vss__t218 vss 5.92353369556
* device instance vss_t219 r0 *1 0,0
Rvss_t219 vss__t219 vss 4.51455557505
* device instance vss_t220 r0 *1 0,0
Rvss_t220 vss__t220 vss 4.81513935279
* device instance vss_t221 r0 *1 0,0
Rvss_t221 vss__t221 vss 5.14898217836
* device instance vss_t222 r0 *1 0,0
Rvss_t222 vss__t222 vss 5.51004205966
* device instance vss_t223 r0 *1 0,0
Rvss_t223 vss__t223 vss 11.7049988589
* device instance vss_t224 r0 *1 0,0
Rvss_t224 vss__t224 vss 12.1898609574
* device instance vss_t225 r0 *1 0,0
Rvss_t225 vss__t225 vss 12.6767707865
* device instance vss_t226 r0 *1 0,0
Rvss_t226 vss__t226 vss 13.1655011498
* device instance vss_t227 r0 *1 0,0
Rvss_t227 vss__t227 vss 20.0332306308
* device instance vss_t228 r0 *1 0,0
Rvss_t228 vss__t228 vss 20.5352720533
* device instance vss_t229 r0 *1 0,0
Rvss_t229 vss__t229 vss 21.0377413865
* device instance vss_t230 r0 *1 0,0
Rvss_t230 vss__t230 vss 21.540608685
* device instance vss_t231 r0 *1 0,0
Rvss_t231 vss__t231 vss 28.5193128545
* device instance vss_t232 r0 *1 0,0
Rvss_t232 vss__t232 vss 29.0258441982
* device instance vss_t233 r0 *1 0,0
Rvss_t233 vss__t233 vss 29.5325270284
* device instance vss_t234 r0 *1 0,0
Rvss_t234 vss__t234 vss 30.0393536796
* device instance vss_t235 r0 *1 0,0
Rvss_t235 vss__t235 vss 40.5420823529
* device instance vss_t236 r0 *1 0,0
Rvss_t236 vss__t236 vss 40.0319623779
* device instance vss_t237 r0 *1 0,0
Rvss_t237 vss__t237 vss 39.521863287
* device instance vss_t238 r0 *1 0,0
Rvss_t238 vss__t238 vss 39.0117858995
* device instance vss_t239 r0 *1 0,0
Rvss_t239 vss__t239 vss 31.9655830997
* device instance vss_t240 r0 *1 0,0
Rvss_t240 vss__t240 vss 31.4559601689
* device instance vss_t241 r0 *1 0,0
Rvss_t241 vss__t241 vss 30.946380288
* device instance vss_t242 r0 *1 0,0
Rvss_t242 vss__t242 vss 30.4368456192
* device instance vss_t243 r0 *1 0,0
Rvss_t243 vss__t243 vss 23.4015834779
* device instance vss_t244 r0 *1 0,0
Rvss_t244 vss__t244 vss 22.89310799
* device instance vss_t245 r0 *1 0,0
Rvss_t245 vss__t245 vss 22.3847442056
* device instance vss_t246 r0 *1 0,0
Rvss_t246 vss__t246 vss 21.8764999119
* device instance vss_t247 r0 *1 0,0
Rvss_t247 vss__t247 vss 14.8716932665
* device instance vss_t248 r0 *1 0,0
Rvss_t248 vss__t248 vss 14.3669377985
* device instance vss_t249 r0 *1 0,0
Rvss_t249 vss__t249 vss 13.8626346104
* device instance vss_t250 r0 *1 0,0
Rvss_t250 vss__t250 vss 13.3588349235
* device instance vss_t251 r0 *1 0,0
Rvss_t251 vss__t251 vss 6.51137135485
* device instance vss_t252 r0 *1 0,0
Rvss_t252 vss__t252 vss 6.03497762556
* device instance vss_t253 r0 *1 0,0
Rvss_t253 vss__t253 vss 5.56471459295
* device instance vss_t254 r0 *1 0,0
Rvss_t254 vss__t254 vss 5.10227768754
* device instance vss_t255 r0 *1 0,0
Rvss_t255 vss__t255 vss 3.36544175384
* device instance vss_t256 r0 *1 0,0
Rvss_t256 vss__t256 vss 3.75906280142
* device instance vss_t257 r0 *1 0,0
Rvss_t257 vss__t257 vss 4.17815792322
* device instance vss_t258 r0 *1 0,0
Rvss_t258 vss__t258 vss 4.61579350248
* device instance vss_t259 r0 *1 0,0
Rvss_t259 vss__t259 vss 11.3115862922
* device instance vss_t260 r0 *1 0,0
Rvss_t260 vss__t260 vss 11.8126075157
* device instance vss_t261 r0 *1 0,0
Rvss_t261 vss__t261 vss 12.3144428916
* device instance vss_t262 r0 *1 0,0
Rvss_t262 vss__t262 vss 12.8169967888
* device instance vss_t263 r0 *1 0,0
Rvss_t263 vss__t263 vss 19.8059414233
* device instance vss_t264 r0 *1 0,0
Rvss_t264 vss__t264 vss 20.3136009723
* device instance vss_t265 r0 *1 0,0
Rvss_t265 vss__t265 vss 20.8214204319
* device instance vss_t266 r0 *1 0,0
Rvss_t266 vss__t266 vss 21.3293883804
* device instance vss_t267 r0 *1 0,0
Rvss_t267 vss__t267 vss 28.3601162172
* device instance vss_t268 r0 *1 0,0
Rvss_t268 vss__t268 vss 28.8694408948
* device instance vss_t269 r0 *1 0,0
Rvss_t269 vss__t269 vss 29.3788212637
* device instance vss_t270 r0 *1 0,0
Rvss_t270 vss__t270 vss 29.8882544764
* device instance vss_t271 r0 *1 0,0
Rvss_t271 vss__t271 vss 37.4374433693
* device instance vss_t272 r0 *1 0,0
Rvss_t272 vss__t272 vss 39.769463034
* device instance vss_t273 r0 *1 0,0
Rvss_t273 vss__t273 vss 43.3293604278
* device instance vss_t274 r0 *1 0,0
Rvss_t274 vss__t274 vss 45.3847177856
* device instance vss_t275 r0 *1 0,0
Rvss_t275 vss__t275 vss 44.4161762138
* device instance vss_t276 r0 *1 0,0
Rvss_t276 vss__t276 vss 45.0380461123
* device instance vss_t277 r0 *1 0,0
Rvss_t277 vss__t277 vss 46.1366660966
* device instance vss_t278 r0 *1 0,0
Rvss_t278 vss__t278 vss 46.5478529908
* device instance vss_t279 r0 *1 0,0
Rvss_t279 vss__t279 vss 47.0909918066
* device instance vss_t280 r0 *1 0,0
Rvss_t280 vss__t280 vss 47.5940834358
* device instance vss_t281 r0 *1 0,0
Rvss_t281 vss__t281 vss 48.111518121
* device instance vss_t282 r0 *1 0,0
Rvss_t282 vss__t282 vss 51.9939012833
* device instance vss_t283 r0 *1 0,0
Rvss_t283 vss__t283 vss 53.3487302478
* device instance vss r0 *1 0,0
Cvss vss vsubs 4.49315043e-13
* device instance cc__100__32 r0 *1 0,0
Ccc__100__32 \$100 \$32 1.0837e-17
* device instance cc__100__84 r0 *1 0,0
Ccc__100__84 \$100 \$84 1.0837e-17
* device instance cc__102__32 r0 *1 0,0
Ccc__102__32 \$102 \$32 1.0837e-17
* device instance cc__102__84 r0 *1 0,0
Ccc__102__84 \$102 \$84 1.0837e-17
* device instance cc__104__40 r0 *1 0,0
Ccc__104__40 \$104 \$40 1.0837e-17
* device instance cc__104__85 r0 *1 0,0
Ccc__104__85 \$104 \$85 1.0837e-17
* device instance cc__106__40 r0 *1 0,0
Ccc__106__40 \$106 \$40 1.0837e-17
* device instance cc__106__85 r0 *1 0,0
Ccc__106__85 \$106 \$85 1.0837e-17
* device instance cc__108__48 r0 *1 0,0
Ccc__108__48 \$108 \$48 1.0837e-17
* device instance cc__108__86 r0 *1 0,0
Ccc__108__86 \$108 \$86 1.0837e-17
* device instance cc__108_vcm r0 *1 0,0
Ccc__108_vcm \$108 vcm 2.1675e-17
* device instance cc__11__12 r0 *1 0,0
Ccc__11__12 \$11 \$12 1.0837e-17
* device instance cc__110__48 r0 *1 0,0
Ccc__110__48 \$110 \$48 1.0837e-17
* device instance cc__110__86 r0 *1 0,0
Ccc__110__86 \$110 \$86 1.0837e-17
* device instance cc__110_vcm r0 *1 0,0
Ccc__110_vcm \$110 vcm 2.1675e-17
* device instance cc__112__56 r0 *1 0,0
Ccc__112__56 \$112 \$56 1.0837e-17
* device instance cc__112__87 r0 *1 0,0
Ccc__112__87 \$112 \$87 1.0837e-17
* device instance cc__114__56 r0 *1 0,0
Ccc__114__56 \$114 \$56 1.0837e-17
* device instance cc__114__87 r0 *1 0,0
Ccc__114__87 \$114 \$87 1.0837e-17
* device instance cc__116__64 r0 *1 0,0
Ccc__116__64 \$116 \$64 1.0837e-17
* device instance cc__116__88 r0 *1 0,0
Ccc__116__88 \$116 \$88 1.0837e-17
* device instance cc__118__64 r0 *1 0,0
Ccc__118__64 \$118 \$64 1.0837e-17
* device instance cc__118__88 r0 *1 0,0
Ccc__118__88 \$118 \$88 1.0837e-17
* device instance cc__12__127 r0 *1 0,0
Ccc__12__127 \$12 \$127 1.0837e-17
* device instance cc__12__129 r0 *1 0,0
Ccc__12__129 \$12 \$129 1.0837e-17
* device instance cc__12__24 r0 *1 0,0
Ccc__12__24 \$12 \$24 1.614766e-15
* device instance cc__12__32 r0 *1 0,0
Ccc__12__32 \$12 \$32 8.88663e-16
* device instance cc__12__40 r0 *1 0,0
Ccc__12__40 \$12 \$40 5.52705e-16
* device instance cc__12__48 r0 *1 0,0
Ccc__12__48 \$12 \$48 3.79308e-16
* device instance cc__12__5 r0 *1 0,0
Ccc__12__5 \$12 \$5 1.0837e-17
* device instance cc__12__56 r0 *1 0,0
Ccc__12__56 \$12 \$56 2.92609e-16
* device instance cc__12__64 r0 *1 0,0
Ccc__12__64 \$12 \$64 2.49259e-16
* device instance cc__12__7 r0 *1 0,0
Ccc__12__7 \$12 \$7 1.0837e-17
* device instance cc__12__72 r0 *1 0,0
Ccc__12__72 \$12 \$72 2.0591e-16
* device instance cc__12__80 r0 *1 0,0
Ccc__12__80 \$12 \$80 9.7536e-17
* device instance cc__12__81 r0 *1 0,0
Ccc__12__81 \$12 \$81 1.0837e-17
* device instance cc__12__9 r0 *1 0,0
Ccc__12__9 \$12 \$9 1.0837e-17
* device instance cc__12__92 r0 *1 0,0
Ccc__12__92 \$12 \$92 1.0837e-17
* device instance cc__12__94 r0 *1 0,0
Ccc__12__94 \$12 \$94 1.0837e-17
* device instance cc__12_hi_256_n r0 *1 0,0
Ccc__12_hi_256_n \$12 hi_256_n 1.0837e-17
* device instance cc__12_hi_256_p r0 *1 0,0
Ccc__12_hi_256_p \$12 hi_256_p 1.0837e-17
* device instance cc__12_lo_256_n r0 *1 0,0
Ccc__12_lo_256_n \$12 lo_256_n 1.0837e-17
* device instance cc__12_lo_256_p r0 *1 0,0
Ccc__12_lo_256_p \$12 lo_256_p 1.0837e-17
* device instance cc__12_pinn r0 *1 0,0
Ccc__12_pinn \$12 pinn 1.0837e-17
* device instance cc__12_rel_256_n r0 *1 0,0
Ccc__12_rel_256_n \$12 rel_256_n 1.0837e-17
* device instance cc__12_rel_256_p r0 *1 0,0
Ccc__12_rel_256_p \$12 rel_256_p 1.0837e-17
* device instance cc__12_sel_in r0 *1 0,0
Ccc__12_sel_in \$12 sel_in 2.1675e-17
* device instance cc__12_topp r0 *1 0,0
Ccc__12_topp \$12 topp 4.2159087e-14
* device instance cc__12_vcm r0 *1 0,0
Ccc__12_vcm \$12 vcm 1.19211e-16
* device instance cc__12_vref r0 *1 0,0
Ccc__12_vref \$12 vref 1.0837e-17
* device instance cc__12_vss r0 *1 0,0
Ccc__12_vss \$12 vss 5.20075e-16
* device instance cc__120__72 r0 *1 0,0
Ccc__120__72 \$120 \$72 1.0837e-17
* device instance cc__120__89 r0 *1 0,0
Ccc__120__89 \$120 \$89 1.0837e-17
* device instance cc__122__72 r0 *1 0,0
Ccc__122__72 \$122 \$72 1.0837e-17
* device instance cc__122__89 r0 *1 0,0
Ccc__122__89 \$122 \$89 1.0837e-17
* device instance cc__124__80 r0 *1 0,0
Ccc__124__80 \$124 \$80 1.0837e-17
* device instance cc__124__90 r0 *1 0,0
Ccc__124__90 \$124 \$90 1.0837e-17
* device instance cc__126__80 r0 *1 0,0
Ccc__126__80 \$126 \$80 1.0837e-17
* device instance cc__126__90 r0 *1 0,0
Ccc__126__90 \$126 \$90 1.0837e-17
* device instance cc__127__81 r0 *1 0,0
Ccc__127__81 \$127 \$81 1.0837e-17
* device instance cc__129__81 r0 *1 0,0
Ccc__129__81 \$129 \$81 1.0837e-17
* device instance cc__130__24 r0 *1 0,0
Ccc__130__24 \$130 \$24 1.0837e-17
* device instance cc__130__83 r0 *1 0,0
Ccc__130__83 \$130 \$83 1.0837e-17
* device instance cc__132__24 r0 *1 0,0
Ccc__132__24 \$132 \$24 1.0837e-17
* device instance cc__132__83 r0 *1 0,0
Ccc__132__83 \$132 \$83 1.0837e-17
* device instance cc__133__32 r0 *1 0,0
Ccc__133__32 \$133 \$32 1.0837e-17
* device instance cc__133__84 r0 *1 0,0
Ccc__133__84 \$133 \$84 1.0837e-17
* device instance cc__135__32 r0 *1 0,0
Ccc__135__32 \$135 \$32 1.0837e-17
* device instance cc__135__84 r0 *1 0,0
Ccc__135__84 \$135 \$84 1.0837e-17
* device instance cc__136__40 r0 *1 0,0
Ccc__136__40 \$136 \$40 1.0837e-17
* device instance cc__136__85 r0 *1 0,0
Ccc__136__85 \$136 \$85 1.0837e-17
* device instance cc__138__40 r0 *1 0,0
Ccc__138__40 \$138 \$40 1.0837e-17
* device instance cc__138__85 r0 *1 0,0
Ccc__138__85 \$138 \$85 1.0837e-17
* device instance cc__139__48 r0 *1 0,0
Ccc__139__48 \$139 \$48 1.0837e-17
* device instance cc__139__86 r0 *1 0,0
Ccc__139__86 \$139 \$86 1.0837e-17
* device instance cc__139_vcm r0 *1 0,0
Ccc__139_vcm \$139 vcm 1.0837e-17
* device instance cc__141__48 r0 *1 0,0
Ccc__141__48 \$141 \$48 1.0837e-17
* device instance cc__141__86 r0 *1 0,0
Ccc__141__86 \$141 \$86 1.0837e-17
* device instance cc__141_vcm r0 *1 0,0
Ccc__141_vcm \$141 vcm 3.7724e-17
* device instance cc__142__56 r0 *1 0,0
Ccc__142__56 \$142 \$56 1.0837e-17
* device instance cc__142__87 r0 *1 0,0
Ccc__142__87 \$142 \$87 1.0837e-17
* device instance cc__144__56 r0 *1 0,0
Ccc__144__56 \$144 \$56 1.0837e-17
* device instance cc__144__87 r0 *1 0,0
Ccc__144__87 \$144 \$87 1.0837e-17
* device instance cc__145__64 r0 *1 0,0
Ccc__145__64 \$145 \$64 1.0837e-17
* device instance cc__145__88 r0 *1 0,0
Ccc__145__88 \$145 \$88 1.0837e-17
* device instance cc__147__64 r0 *1 0,0
Ccc__147__64 \$147 \$64 1.0837e-17
* device instance cc__147__88 r0 *1 0,0
Ccc__147__88 \$147 \$88 1.0837e-17
* device instance cc__148__72 r0 *1 0,0
Ccc__148__72 \$148 \$72 1.0837e-17
* device instance cc__148__89 r0 *1 0,0
Ccc__148__89 \$148 \$89 1.0837e-17
* device instance cc__150__72 r0 *1 0,0
Ccc__150__72 \$150 \$72 1.0837e-17
* device instance cc__150__89 r0 *1 0,0
Ccc__150__89 \$150 \$89 1.0837e-17
* device instance cc__151__80 r0 *1 0,0
Ccc__151__80 \$151 \$80 1.0837e-17
* device instance cc__151__90 r0 *1 0,0
Ccc__151__90 \$151 \$90 1.0837e-17
* device instance cc__153__80 r0 *1 0,0
Ccc__153__80 \$153 \$80 1.0837e-17
* device instance cc__153__90 r0 *1 0,0
Ccc__153__90 \$153 \$90 1.0837e-17
* device instance cc__17__24 r0 *1 0,0
Ccc__17__24 \$17 \$24 1.0837e-17
* device instance cc__19__24 r0 *1 0,0
Ccc__19__24 \$19 \$24 1.0837e-17
* device instance cc__21__24 r0 *1 0,0
Ccc__21__24 \$21 \$24 1.0837e-17
* device instance cc__23__24 r0 *1 0,0
Ccc__23__24 \$23 \$24 1.0837e-17
* device instance cc__24__32 r0 *1 0,0
Ccc__24__32 \$24 \$32 1.53635e-16
* device instance cc__24__40 r0 *1 0,0
Ccc__24__40 \$24 \$40 1.53635e-16
* device instance cc__24__48 r0 *1 0,0
Ccc__24__48 \$24 \$48 1.19211e-16
* device instance cc__24__56 r0 *1 0,0
Ccc__24__56 \$24 \$56 1.19211e-16
* device instance cc__24__64 r0 *1 0,0
Ccc__24__64 \$24 \$64 1.19211e-16
* device instance cc__24__72 r0 *1 0,0
Ccc__24__72 \$24 \$72 9.7536e-17
* device instance cc__24__80 r0 *1 0,0
Ccc__24__80 \$24 \$80 5.4187e-17
* device instance cc__24__81 r0 *1 0,0
Ccc__24__81 \$24 \$81 1.7212e-17
* device instance cc__24__83 r0 *1 0,0
Ccc__24__83 \$24 \$83 1.0837e-17
* device instance cc__24__96 r0 *1 0,0
Ccc__24__96 \$24 \$96 1.0837e-17
* device instance cc__24__98 r0 *1 0,0
Ccc__24__98 \$24 \$98 1.0837e-17
* device instance cc__24_hi_128_n r0 *1 0,0
Ccc__24_hi_128_n \$24 hi_128_n 1.0837e-17
* device instance cc__24_hi_128_p r0 *1 0,0
Ccc__24_hi_128_p \$24 hi_128_p 1.0837e-17
* device instance cc__24_lo_128_n r0 *1 0,0
Ccc__24_lo_128_n \$24 lo_128_n 1.0837e-17
* device instance cc__24_lo_128_p r0 *1 0,0
Ccc__24_lo_128_p \$24 lo_128_p 1.0837e-17
* device instance cc__24_pinn r0 *1 0,0
Ccc__24_pinn \$24 pinn 1.0837e-17
* device instance cc__24_rel_128_n r0 *1 0,0
Ccc__24_rel_128_n \$24 rel_128_n 1.0837e-17
* device instance cc__24_rel_128_p r0 *1 0,0
Ccc__24_rel_128_p \$24 rel_128_p 1.0837e-17
* device instance cc__24_sel_in r0 *1 0,0
Ccc__24_sel_in \$24 sel_in 2.1675e-17
* device instance cc__24_topp r0 *1 0,0
Ccc__24_topp \$24 topp 2.1079544e-14
* device instance cc__24_vcm r0 *1 0,0
Ccc__24_vcm \$24 vcm 6.5024e-17
* device instance cc__24_vdd r0 *1 0,0
Ccc__24_vdd \$24 vdd 1.0837e-17
* device instance cc__24_vref r0 *1 0,0
Ccc__24_vref \$24 vref 1.0837e-17
* device instance cc__24_vss r0 *1 0,0
Ccc__24_vss \$24 vss 5.20075e-16
* device instance cc__25__32 r0 *1 0,0
Ccc__25__32 \$25 \$32 1.0837e-17
* device instance cc__27__32 r0 *1 0,0
Ccc__27__32 \$27 \$32 1.0837e-17
* device instance cc__29__32 r0 *1 0,0
Ccc__29__32 \$29 \$32 1.0837e-17
* device instance cc__31__32 r0 *1 0,0
Ccc__31__32 \$31 \$32 1.0837e-17
* device instance cc__32__40 r0 *1 0,0
Ccc__32__40 \$32 \$40 1.10286e-16
* device instance cc__32__48 r0 *1 0,0
Ccc__32__48 \$32 \$48 1.10286e-16
* device instance cc__32__56 r0 *1 0,0
Ccc__32__56 \$32 \$56 1.10286e-16
* device instance cc__32__64 r0 *1 0,0
Ccc__32__64 \$32 \$64 7.5862e-17
* device instance cc__32__72 r0 *1 0,0
Ccc__32__72 \$32 \$72 5.4187e-17
* device instance cc__32__80 r0 *1 0,0
Ccc__32__80 \$32 \$80 3.2512e-17
* device instance cc__32__81 r0 *1 0,0
Ccc__32__81 \$32 \$81 1.7212e-17
* device instance cc__32__83 r0 *1 0,0
Ccc__32__83 \$32 \$83 1.7212e-17
* device instance cc__32__84 r0 *1 0,0
Ccc__32__84 \$32 \$84 1.0837e-17
* device instance cc__32_hi_64_n r0 *1 0,0
Ccc__32_hi_64_n \$32 hi_64_n 1.0837e-17
* device instance cc__32_hi_64_p r0 *1 0,0
Ccc__32_hi_64_p \$32 hi_64_p 1.0837e-17
* device instance cc__32_lo_64_n r0 *1 0,0
Ccc__32_lo_64_n \$32 lo_64_n 1.0837e-17
* device instance cc__32_lo_64_p r0 *1 0,0
Ccc__32_lo_64_p \$32 lo_64_p 1.0837e-17
* device instance cc__32_pinn r0 *1 0,0
Ccc__32_pinn \$32 pinn 1.0837e-17
* device instance cc__32_rel_64_n r0 *1 0,0
Ccc__32_rel_64_n \$32 rel_64_n 1.0837e-17
* device instance cc__32_rel_64_p r0 *1 0,0
Ccc__32_rel_64_p \$32 rel_64_p 1.0837e-17
* device instance cc__32_sel_in r0 *1 0,0
Ccc__32_sel_in \$32 sel_in 2.1675e-17
* device instance cc__32_topp r0 *1 0,0
Ccc__32_topp \$32 topp 1.0556984e-14
* device instance cc__32_vcm r0 *1 0,0
Ccc__32_vcm \$32 vcm 4.3349e-17
* device instance cc__32_vdd r0 *1 0,0
Ccc__32_vdd \$32 vdd 1.0837e-17
* device instance cc__32_vref r0 *1 0,0
Ccc__32_vref \$32 vref 1.0837e-17
* device instance cc__32_vss r0 *1 0,0
Ccc__32_vss \$32 vss 5.20075e-16
* device instance cc__33__40 r0 *1 0,0
Ccc__33__40 \$33 \$40 1.0837e-17
* device instance cc__35__40 r0 *1 0,0
Ccc__35__40 \$35 \$40 1.0837e-17
* device instance cc__37__40 r0 *1 0,0
Ccc__37__40 \$37 \$40 1.0837e-17
* device instance cc__39__40 r0 *1 0,0
Ccc__39__40 \$39 \$40 1.0837e-17
* device instance cc__40__48 r0 *1 0,0
Ccc__40__48 \$40 \$48 2.83684e-16
* device instance cc__40__56 r0 *1 0,0
Ccc__40__56 \$40 \$56 1.96985e-16
* device instance cc__40__64 r0 *1 0,0
Ccc__40__64 \$40 \$64 1.53635e-16
* device instance cc__40__72 r0 *1 0,0
Ccc__40__72 \$40 \$72 1.10286e-16
* device instance cc__40__80 r0 *1 0,0
Ccc__40__80 \$40 \$80 6.6937e-17
* device instance cc__40__81 r0 *1 0,0
Ccc__40__81 \$40 \$81 1.7212e-17
* device instance cc__40__83 r0 *1 0,0
Ccc__40__83 \$40 \$83 1.7212e-17
* device instance cc__40__84 r0 *1 0,0
Ccc__40__84 \$40 \$84 1.7212e-17
* device instance cc__40__85 r0 *1 0,0
Ccc__40__85 \$40 \$85 1.0837e-17
* device instance cc__40_hi_32_n r0 *1 0,0
Ccc__40_hi_32_n \$40 hi_32_n 1.0837e-17
* device instance cc__40_hi_32_p r0 *1 0,0
Ccc__40_hi_32_p \$40 hi_32_p 1.0837e-17
* device instance cc__40_lo_32_n r0 *1 0,0
Ccc__40_lo_32_n \$40 lo_32_n 1.0837e-17
* device instance cc__40_lo_32_p r0 *1 0,0
Ccc__40_lo_32_p \$40 lo_32_p 1.0837e-17
* device instance cc__40_pinn r0 *1 0,0
Ccc__40_pinn \$40 pinn 1.0837e-17
* device instance cc__40_rel_32_n r0 *1 0,0
Ccc__40_rel_32_n \$40 rel_32_n 1.0837e-17
* device instance cc__40_rel_32_p r0 *1 0,0
Ccc__40_rel_32_p \$40 rel_32_p 1.0837e-17
* device instance cc__40_sel_in r0 *1 0,0
Ccc__40_sel_in \$40 sel_in 2.1675e-17
* device instance cc__40_topp r0 *1 0,0
Ccc__40_topp \$40 topp 5.180063e-15
* device instance cc__40_vcm r0 *1 0,0
Ccc__40_vcm \$40 vcm 5.4187e-17
* device instance cc__40_vdd r0 *1 0,0
Ccc__40_vdd \$40 vdd 1.0837e-17
* device instance cc__40_vref r0 *1 0,0
Ccc__40_vref \$40 vref 1.0837e-17
* device instance cc__40_vss r0 *1 0,0
Ccc__40_vss \$40 vss 5.20075e-16
* device instance cc__41__48 r0 *1 0,0
Ccc__41__48 \$41 \$48 1.0837e-17
* device instance cc__41_vcm r0 *1 0,0
Ccc__41_vcm \$41 vcm 1.0837e-17
* device instance cc__43__48 r0 *1 0,0
Ccc__43__48 \$43 \$48 1.0837e-17
* device instance cc__43_vcm r0 *1 0,0
Ccc__43_vcm \$43 vcm 3.7724e-17
* device instance cc__45__48 r0 *1 0,0
Ccc__45__48 \$45 \$48 1.0837e-17
* device instance cc__45_vcm r0 *1 0,0
Ccc__45_vcm \$45 vcm 1.0837e-17
* device instance cc__47__48 r0 *1 0,0
Ccc__47__48 \$47 \$48 1.0837e-17
* device instance cc__47_vcm r0 *1 0,0
Ccc__47_vcm \$47 vcm 1.0837e-17
* device instance cc__48__56 r0 *1 0,0
Ccc__48__56 \$48 \$56 1.96985e-16
* device instance cc__48__64 r0 *1 0,0
Ccc__48__64 \$48 \$64 1.53635e-16
* device instance cc__48__72 r0 *1 0,0
Ccc__48__72 \$48 \$72 1.10286e-16
* device instance cc__48__80 r0 *1 0,0
Ccc__48__80 \$48 \$80 6.6937e-17
* device instance cc__48__81 r0 *1 0,0
Ccc__48__81 \$48 \$81 1.7212e-17
* device instance cc__48__83 r0 *1 0,0
Ccc__48__83 \$48 \$83 1.7212e-17
* device instance cc__48__84 r0 *1 0,0
Ccc__48__84 \$48 \$84 1.7212e-17
* device instance cc__48__85 r0 *1 0,0
Ccc__48__85 \$48 \$85 1.7212e-17
* device instance cc__48__86 r0 *1 0,0
Ccc__48__86 \$48 \$86 1.0837e-17
* device instance cc__48_hi_16_n r0 *1 0,0
Ccc__48_hi_16_n \$48 hi_16_n 1.0837e-17
* device instance cc__48_hi_16_p r0 *1 0,0
Ccc__48_hi_16_p \$48 hi_16_p 1.0837e-17
* device instance cc__48_lo_16_n r0 *1 0,0
Ccc__48_lo_16_n \$48 lo_16_n 1.0837e-17
* device instance cc__48_lo_16_p r0 *1 0,0
Ccc__48_lo_16_p \$48 lo_16_p 1.0837e-17
* device instance cc__48_pinn r0 *1 0,0
Ccc__48_pinn \$48 pinn 1.0837e-17
* device instance cc__48_rel_16_n r0 *1 0,0
Ccc__48_rel_16_n \$48 rel_16_n 1.0837e-17
* device instance cc__48_rel_16_p r0 *1 0,0
Ccc__48_rel_16_p \$48 rel_16_p 1.0837e-17
* device instance cc__48_sel_in r0 *1 0,0
Ccc__48_sel_in \$48 sel_in 2.1675e-17
* device instance cc__48_topp r0 *1 0,0
Ccc__48_topp \$48 topp 2.77493e-15
* device instance cc__48_vcm r0 *1 0,0
Ccc__48_vcm \$48 vcm 9.9449e-17
* device instance cc__48_vdd r0 *1 0,0
Ccc__48_vdd \$48 vdd 1.0837e-17
* device instance cc__48_vref r0 *1 0,0
Ccc__48_vref \$48 vref 1.0837e-17
* device instance cc__48_vss r0 *1 0,0
Ccc__48_vss \$48 vss 5.20075e-16
* device instance cc__49__56 r0 *1 0,0
Ccc__49__56 \$49 \$56 1.0837e-17
* device instance cc__51__56 r0 *1 0,0
Ccc__51__56 \$51 \$56 1.0837e-17
* device instance cc__53__56 r0 *1 0,0
Ccc__53__56 \$53 \$56 1.0837e-17
* device instance cc__55__56 r0 *1 0,0
Ccc__55__56 \$55 \$56 1.0837e-17
* device instance cc__56__64 r0 *1 0,0
Ccc__56__64 \$56 \$64 1.53635e-16
* device instance cc__56__72 r0 *1 0,0
Ccc__56__72 \$56 \$72 1.10286e-16
* device instance cc__56__80 r0 *1 0,0
Ccc__56__80 \$56 \$80 6.6937e-17
* device instance cc__56__81 r0 *1 0,0
Ccc__56__81 \$56 \$81 1.7212e-17
* device instance cc__56__83 r0 *1 0,0
Ccc__56__83 \$56 \$83 1.7212e-17
* device instance cc__56__84 r0 *1 0,0
Ccc__56__84 \$56 \$84 1.7212e-17
* device instance cc__56__85 r0 *1 0,0
Ccc__56__85 \$56 \$85 1.7212e-17
* device instance cc__56__86 r0 *1 0,0
Ccc__56__86 \$56 \$86 1.7212e-17
* device instance cc__56__87 r0 *1 0,0
Ccc__56__87 \$56 \$87 1.0837e-17
* device instance cc__56_hi_8_n r0 *1 0,0
Ccc__56_hi_8_n \$56 hi_8_n 1.0837e-17
* device instance cc__56_hi_8_p r0 *1 0,0
Ccc__56_hi_8_p \$56 hi_8_p 1.0837e-17
* device instance cc__56_lo_8_n r0 *1 0,0
Ccc__56_lo_8_n \$56 lo_8_n 1.0837e-17
* device instance cc__56_lo_8_p r0 *1 0,0
Ccc__56_lo_8_p \$56 lo_8_p 1.0837e-17
* device instance cc__56_pinn r0 *1 0,0
Ccc__56_pinn \$56 pinn 1.0837e-17
* device instance cc__56_rel_8_n r0 *1 0,0
Ccc__56_rel_8_n \$56 rel_8_n 1.0837e-17
* device instance cc__56_rel_8_p r0 *1 0,0
Ccc__56_rel_8_p \$56 rel_8_p 1.0837e-17
* device instance cc__56_sel_in r0 *1 0,0
Ccc__56_sel_in \$56 sel_in 2.1675e-17
* device instance cc__56_topp r0 *1 0,0
Ccc__56_topp \$56 topp 1.326814e-15
* device instance cc__56_vcm r0 *1 0,0
Ccc__56_vcm \$56 vcm 8.8611e-17
* device instance cc__56_vdd r0 *1 0,0
Ccc__56_vdd \$56 vdd 1.0837e-17
* device instance cc__56_vref r0 *1 0,0
Ccc__56_vref \$56 vref 1.0837e-17
* device instance cc__56_vss r0 *1 0,0
Ccc__56_vss \$56 vss 5.20075e-16
* device instance cc__57__64 r0 *1 0,0
Ccc__57__64 \$57 \$64 1.0837e-17
* device instance cc__59__64 r0 *1 0,0
Ccc__59__64 \$59 \$64 1.0837e-17
* device instance cc__61__64 r0 *1 0,0
Ccc__61__64 \$61 \$64 1.0837e-17
* device instance cc__63__64 r0 *1 0,0
Ccc__63__64 \$63 \$64 1.0837e-17
* device instance cc__64__72 r0 *1 0,0
Ccc__64__72 \$64 \$72 1.10286e-16
* device instance cc__64__80 r0 *1 0,0
Ccc__64__80 \$64 \$80 6.6937e-17
* device instance cc__64__81 r0 *1 0,0
Ccc__64__81 \$64 \$81 1.7212e-17
* device instance cc__64__83 r0 *1 0,0
Ccc__64__83 \$64 \$83 1.7212e-17
* device instance cc__64__84 r0 *1 0,0
Ccc__64__84 \$64 \$84 1.7212e-17
* device instance cc__64__85 r0 *1 0,0
Ccc__64__85 \$64 \$85 1.7212e-17
* device instance cc__64__86 r0 *1 0,0
Ccc__64__86 \$64 \$86 1.7212e-17
* device instance cc__64__87 r0 *1 0,0
Ccc__64__87 \$64 \$87 1.7212e-17
* device instance cc__64__88 r0 *1 0,0
Ccc__64__88 \$64 \$88 1.0837e-17
* device instance cc__64_hi_4_n r0 *1 0,0
Ccc__64_hi_4_n \$64 hi_4_n 1.0837e-17
* device instance cc__64_hi_4_p r0 *1 0,0
Ccc__64_hi_4_p \$64 hi_4_p 1.0837e-17
* device instance cc__64_lo_4_n r0 *1 0,0
Ccc__64_lo_4_n \$64 lo_4_n 1.0837e-17
* device instance cc__64_lo_4_p r0 *1 0,0
Ccc__64_lo_4_p \$64 lo_4_p 1.0837e-17
* device instance cc__64_pinn r0 *1 0,0
Ccc__64_pinn \$64 pinn 1.0837e-17
* device instance cc__64_rel_4_n r0 *1 0,0
Ccc__64_rel_4_n \$64 rel_4_n 1.0837e-17
* device instance cc__64_rel_4_p r0 *1 0,0
Ccc__64_rel_4_p \$64 rel_4_p 1.0837e-17
* device instance cc__64_sel_in r0 *1 0,0
Ccc__64_sel_in \$64 sel_in 2.1675e-17
* device instance cc__64_topp r0 *1 0,0
Ccc__64_topp \$64 topp 6.72013e-16
* device instance cc__64_vcm r0 *1 0,0
Ccc__64_vcm \$64 vcm 8.8611e-17
* device instance cc__64_vdd r0 *1 0,0
Ccc__64_vdd \$64 vdd 2.3587e-17
* device instance cc__64_vref r0 *1 0,0
Ccc__64_vref \$64 vref 1.0837e-17
* device instance cc__64_vss r0 *1 0,0
Ccc__64_vss \$64 vss 5.20075e-16
* device instance cc__65__72 r0 *1 0,0
Ccc__65__72 \$65 \$72 1.0837e-17
* device instance cc__67__72 r0 *1 0,0
Ccc__67__72 \$67 \$72 1.0837e-17
* device instance cc__69__72 r0 *1 0,0
Ccc__69__72 \$69 \$72 1.0837e-17
* device instance cc__71__72 r0 *1 0,0
Ccc__71__72 \$71 \$72 1.0837e-17
* device instance cc__72__80 r0 *1 0,0
Ccc__72__80 \$72 \$80 5.6099e-17
* device instance cc__72__81 r0 *1 0,0
Ccc__72__81 \$72 \$81 1.7212e-17
* device instance cc__72__83 r0 *1 0,0
Ccc__72__83 \$72 \$83 1.7212e-17
* device instance cc__72__84 r0 *1 0,0
Ccc__72__84 \$72 \$84 1.7212e-17
* device instance cc__72__85 r0 *1 0,0
Ccc__72__85 \$72 \$85 1.7212e-17
* device instance cc__72__86 r0 *1 0,0
Ccc__72__86 \$72 \$86 1.7212e-17
* device instance cc__72__87 r0 *1 0,0
Ccc__72__87 \$72 \$87 1.7212e-17
* device instance cc__72__88 r0 *1 0,0
Ccc__72__88 \$72 \$88 1.7212e-17
* device instance cc__72__89 r0 *1 0,0
Ccc__72__89 \$72 \$89 1.0837e-17
* device instance cc__72_hi_2_n r0 *1 0,0
Ccc__72_hi_2_n \$72 hi_2_n 1.0837e-17
* device instance cc__72_hi_2_p r0 *1 0,0
Ccc__72_hi_2_p \$72 hi_2_p 1.0837e-17
* device instance cc__72_lo_2_n r0 *1 0,0
Ccc__72_lo_2_n \$72 lo_2_n 1.0837e-17
* device instance cc__72_lo_2_p r0 *1 0,0
Ccc__72_lo_2_p \$72 lo_2_p 1.0837e-17
* device instance cc__72_pinn r0 *1 0,0
Ccc__72_pinn \$72 pinn 1.0837e-17
* device instance cc__72_rel_2_n r0 *1 0,0
Ccc__72_rel_2_n \$72 rel_2_n 1.0837e-17
* device instance cc__72_rel_2_p r0 *1 0,0
Ccc__72_rel_2_p \$72 rel_2_p 1.0837e-17
* device instance cc__72_sel_in r0 *1 0,0
Ccc__72_sel_in \$72 sel_in 2.1675e-17
* device instance cc__72_topn r0 *1 0,0
Ccc__72_topn \$72 topn 1.7212e-17
* device instance cc__72_topp r0 *1 0,0
Ccc__72_topp \$72 topp 3.44613e-16
* device instance cc__72_vcm r0 *1 0,0
Ccc__72_vcm \$72 vcm 6.6937e-17
* device instance cc__72_vdd r0 *1 0,0
Ccc__72_vdd \$72 vdd 1.0837e-17
* device instance cc__72_vref r0 *1 0,0
Ccc__72_vref \$72 vref 1.0837e-17
* device instance cc__72_vss r0 *1 0,0
Ccc__72_vss \$72 vss 5.20075e-16
* device instance cc__73__80 r0 *1 0,0
Ccc__73__80 \$73 \$80 1.0837e-17
* device instance cc__75__80 r0 *1 0,0
Ccc__75__80 \$75 \$80 1.0837e-17
* device instance cc__77__80 r0 *1 0,0
Ccc__77__80 \$77 \$80 1.0837e-17
* device instance cc__79__80 r0 *1 0,0
Ccc__79__80 \$79 \$80 1.0837e-17
* device instance cc__80__81 r0 *1 0,0
Ccc__80__81 \$80 \$81 1.7212e-17
* device instance cc__80__83 r0 *1 0,0
Ccc__80__83 \$80 \$83 1.7212e-17
* device instance cc__80__84 r0 *1 0,0
Ccc__80__84 \$80 \$84 1.7212e-17
* device instance cc__80__85 r0 *1 0,0
Ccc__80__85 \$80 \$85 1.7212e-17
* device instance cc__80__86 r0 *1 0,0
Ccc__80__86 \$80 \$86 1.7212e-17
* device instance cc__80__87 r0 *1 0,0
Ccc__80__87 \$80 \$87 1.7212e-17
* device instance cc__80__88 r0 *1 0,0
Ccc__80__88 \$80 \$88 1.7212e-17
* device instance cc__80__89 r0 *1 0,0
Ccc__80__89 \$80 \$89 1.7212e-17
* device instance cc__80__90 r0 *1 0,0
Ccc__80__90 \$80 \$90 4.5262e-17
* device instance cc__80_hi_1_n r0 *1 0,0
Ccc__80_hi_1_n \$80 hi_1_n 1.0837e-17
* device instance cc__80_hi_1_p r0 *1 0,0
Ccc__80_hi_1_p \$80 hi_1_p 1.0837e-17
* device instance cc__80_lo_1_n r0 *1 0,0
Ccc__80_lo_1_n \$80 lo_1_n 1.0837e-17
* device instance cc__80_lo_1_p r0 *1 0,0
Ccc__80_lo_1_p \$80 lo_1_p 1.0837e-17
* device instance cc__80_pinn r0 *1 0,0
Ccc__80_pinn \$80 pinn 1.0837e-17
* device instance cc__80_rel_1_n r0 *1 0,0
Ccc__80_rel_1_n \$80 rel_1_n 1.0837e-17
* device instance cc__80_rel_1_p r0 *1 0,0
Ccc__80_rel_1_p \$80 rel_1_p 1.0837e-17
* device instance cc__80_sel_in r0 *1 0,0
Ccc__80_sel_in \$80 sel_in 2.1675e-17
* device instance cc__80_topn r0 *1 0,0
Ccc__80_topn \$80 topn 1.7212e-17
* device instance cc__80_topp r0 *1 0,0
Ccc__80_topp \$80 topp 1.80912e-16
* device instance cc__80_vcm r0 *1 0,0
Ccc__80_vcm \$80 vcm 5.6099e-17
* device instance cc__80_vdd r0 *1 0,0
Ccc__80_vdd \$80 vdd 1.0837e-17
* device instance cc__80_vref r0 *1 0,0
Ccc__80_vref \$80 vref 1.0837e-17
* device instance cc__80_vss r0 *1 0,0
Ccc__80_vss \$80 vss 5.20075e-16
* device instance cc__81__83 r0 *1 0,0
Ccc__81__83 \$81 \$83 1.614766e-15
* device instance cc__81__84 r0 *1 0,0
Ccc__81__84 \$81 \$84 8.88663e-16
* device instance cc__81__85 r0 *1 0,0
Ccc__81__85 \$81 \$85 5.52705e-16
* device instance cc__81__86 r0 *1 0,0
Ccc__81__86 \$81 \$86 3.79308e-16
* device instance cc__81__87 r0 *1 0,0
Ccc__81__87 \$81 \$87 2.92609e-16
* device instance cc__81__88 r0 *1 0,0
Ccc__81__88 \$81 \$88 2.49259e-16
* device instance cc__81__89 r0 *1 0,0
Ccc__81__89 \$81 \$89 2.0591e-16
* device instance cc__81__90 r0 *1 0,0
Ccc__81__90 \$81 \$90 9.7536e-17
* device instance cc__81__92 r0 *1 0,0
Ccc__81__92 \$81 \$92 1.0837e-17
* device instance cc__81__94 r0 *1 0,0
Ccc__81__94 \$81 \$94 1.0837e-17
* device instance cc__81_lo_256_n r0 *1 0,0
Ccc__81_lo_256_n \$81 lo_256_n 6.924e-18
* device instance cc__81_sel_in r0 *1 0,0
Ccc__81_sel_in \$81 sel_in 1.0837e-17
* device instance cc__81_topn r0 *1 0,0
Ccc__81_topn \$81 topn 4.2159087e-14
* device instance cc__81_topp r0 *1 0,0
Ccc__81_topp \$81 topp 1.7212e-17
* device instance cc__81_vcm r0 *1 0,0
Ccc__81_vcm \$81 vcm 1.25586e-16
* device instance cc__81_vdd r0 *1 0,0
Ccc__81_vdd \$81 vdd 1.275e-17
* device instance cc__81_vss r0 *1 0,0
Ccc__81_vss \$81 vss 1.0837e-17
* device instance cc__83__84 r0 *1 0,0
Ccc__83__84 \$83 \$84 1.19211e-16
* device instance cc__83__85 r0 *1 0,0
Ccc__83__85 \$83 \$85 1.19211e-16
* device instance cc__83__86 r0 *1 0,0
Ccc__83__86 \$83 \$86 1.19211e-16
* device instance cc__83__87 r0 *1 0,0
Ccc__83__87 \$83 \$87 1.19211e-16
* device instance cc__83__88 r0 *1 0,0
Ccc__83__88 \$83 \$88 1.19211e-16
* device instance cc__83__89 r0 *1 0,0
Ccc__83__89 \$83 \$89 9.7536e-17
* device instance cc__83__90 r0 *1 0,0
Ccc__83__90 \$83 \$90 5.4187e-17
* device instance cc__83__96 r0 *1 0,0
Ccc__83__96 \$83 \$96 1.0837e-17
* device instance cc__83__98 r0 *1 0,0
Ccc__83__98 \$83 \$98 1.0837e-17
* device instance cc__83_lo_128_n r0 *1 0,0
Ccc__83_lo_128_n \$83 lo_128_n 6.924e-18
* device instance cc__83_sel_in r0 *1 0,0
Ccc__83_sel_in \$83 sel_in 1.0837e-17
* device instance cc__83_topn r0 *1 0,0
Ccc__83_topn \$83 topn 2.1079544e-14
* device instance cc__83_topp r0 *1 0,0
Ccc__83_topp \$83 topp 1.7212e-17
* device instance cc__83_vcm r0 *1 0,0
Ccc__83_vcm \$83 vcm 7.1399e-17
* device instance cc__83_vss r0 *1 0,0
Ccc__83_vss \$83 vss 1.0837e-17
* device instance cc__84__85 r0 *1 0,0
Ccc__84__85 \$84 \$85 7.5862e-17
* device instance cc__84__86 r0 *1 0,0
Ccc__84__86 \$84 \$86 7.5862e-17
* device instance cc__84__87 r0 *1 0,0
Ccc__84__87 \$84 \$87 7.5862e-17
* device instance cc__84__88 r0 *1 0,0
Ccc__84__88 \$84 \$88 7.5862e-17
* device instance cc__84__89 r0 *1 0,0
Ccc__84__89 \$84 \$89 5.4187e-17
* device instance cc__84__90 r0 *1 0,0
Ccc__84__90 \$84 \$90 3.2512e-17
* device instance cc__84_lo_64_n r0 *1 0,0
Ccc__84_lo_64_n \$84 lo_64_n 6.924e-18
* device instance cc__84_sel_in r0 *1 0,0
Ccc__84_sel_in \$84 sel_in 1.0837e-17
* device instance cc__84_topn r0 *1 0,0
Ccc__84_topn \$84 topn 1.0539772e-14
* device instance cc__84_topp r0 *1 0,0
Ccc__84_topp \$84 topp 1.7212e-17
* device instance cc__84_vcm r0 *1 0,0
Ccc__84_vcm \$84 vcm 4.9724e-17
* device instance cc__84_vdd r0 *1 0,0
Ccc__84_vdd \$84 vdd 1.275e-17
* device instance cc__84_vss r0 *1 0,0
Ccc__84_vss \$84 vss 1.0837e-17
* device instance cc__85__86 r0 *1 0,0
Ccc__85__86 \$85 \$86 2.49259e-16
* device instance cc__85__87 r0 *1 0,0
Ccc__85__87 \$85 \$87 1.6256e-16
* device instance cc__85__88 r0 *1 0,0
Ccc__85__88 \$85 \$88 1.19211e-16
* device instance cc__85__89 r0 *1 0,0
Ccc__85__89 \$85 \$89 7.5862e-17
* device instance cc__85__90 r0 *1 0,0
Ccc__85__90 \$85 \$90 3.2512e-17
* device instance cc__85_lo_32_n r0 *1 0,0
Ccc__85_lo_32_n \$85 lo_32_n 6.924e-18
* device instance cc__85_sel_in r0 *1 0,0
Ccc__85_sel_in \$85 sel_in 1.0837e-17
* device instance cc__85_topn r0 *1 0,0
Ccc__85_topn \$85 topn 5.162851e-15
* device instance cc__85_topp r0 *1 0,0
Ccc__85_topp \$85 topp 1.7212e-17
* device instance cc__85_vcm r0 *1 0,0
Ccc__85_vcm \$85 vcm 6.0562e-17
* device instance cc__85_vss r0 *1 0,0
Ccc__85_vss \$85 vss 1.0837e-17
* device instance cc__86__87 r0 *1 0,0
Ccc__86__87 \$86 \$87 1.6256e-16
* device instance cc__86__88 r0 *1 0,0
Ccc__86__88 \$86 \$88 1.19211e-16
* device instance cc__86__89 r0 *1 0,0
Ccc__86__89 \$86 \$89 7.5862e-17
* device instance cc__86__90 r0 *1 0,0
Ccc__86__90 \$86 \$90 3.2512e-17
* device instance cc__86_lo_16_n r0 *1 0,0
Ccc__86_lo_16_n \$86 lo_16_n 6.924e-18
* device instance cc__86_sel_in r0 *1 0,0
Ccc__86_sel_in \$86 sel_in 1.0837e-17
* device instance cc__86_topn r0 *1 0,0
Ccc__86_topn \$86 topn 2.757718e-15
* device instance cc__86_topp r0 *1 0,0
Ccc__86_topp \$86 topp 1.7212e-17
* device instance cc__86_vcm r0 *1 0,0
Ccc__86_vcm \$86 vcm 6.5024e-17
* device instance cc__86_vss r0 *1 0,0
Ccc__86_vss \$86 vss 1.0837e-17
* device instance cc__87__88 r0 *1 0,0
Ccc__87__88 \$87 \$88 2.1389e-16
* device instance cc__87__89 r0 *1 0,0
Ccc__87__89 \$87 \$89 7.5862e-17
* device instance cc__87__90 r0 *1 0,0
Ccc__87__90 \$87 \$90 3.2512e-17
* device instance cc__87_lo_8_n r0 *1 0,0
Ccc__87_lo_8_n \$87 lo_8_n 6.924e-18
* device instance cc__87_sel_in r0 *1 0,0
Ccc__87_sel_in \$87 sel_in 1.0837e-17
* device instance cc__87_topn r0 *1 0,0
Ccc__87_topn \$87 topn 1.309601e-15
* device instance cc__87_topp r0 *1 0,0
Ccc__87_topp \$87 topp 1.7212e-17
* device instance cc__87_vcm r0 *1 0,0
Ccc__87_vcm \$87 vcm 6.0562e-17
* device instance cc__87_vdd r0 *1 0,0
Ccc__87_vdd \$87 vdd 1.275e-17
* device instance cc__87_vss r0 *1 0,0
Ccc__87_vss \$87 vss 1.0837e-17
* device instance cc__88__89 r0 *1 0,0
Ccc__88__89 \$88 \$89 7.5862e-17
* device instance cc__88__90 r0 *1 0,0
Ccc__88__90 \$88 \$90 3.2512e-17
* device instance cc__88_lo_4_n r0 *1 0,0
Ccc__88_lo_4_n \$88 lo_4_n 6.924e-18
* device instance cc__88_sel_in r0 *1 0,0
Ccc__88_sel_in \$88 sel_in 1.0837e-17
* device instance cc__88_topn r0 *1 0,0
Ccc__88_topn \$88 topn 6.72013e-16
* device instance cc__88_topp r0 *1 0,0
Ccc__88_topp \$88 topp 1.7212e-17
* device instance cc__88_vcm r0 *1 0,0
Ccc__88_vcm \$88 vcm 6.0562e-17
* device instance cc__88_vss r0 *1 0,0
Ccc__88_vss \$88 vss 1.0837e-17
* device instance cc__89__90 r0 *1 0,0
Ccc__89__90 \$89 \$90 2.1675e-17
* device instance cc__89_lo_2_n r0 *1 0,0
Ccc__89_lo_2_n \$89 lo_2_n 6.924e-18
* device instance cc__89_sel_in r0 *1 0,0
Ccc__89_sel_in \$89 sel_in 1.0837e-17
* device instance cc__89_topn r0 *1 0,0
Ccc__89_topn \$89 topn 3.44613e-16
* device instance cc__89_topp r0 *1 0,0
Ccc__89_topp \$89 topp 1.7212e-17
* device instance cc__89_vcm r0 *1 0,0
Ccc__89_vcm \$89 vcm 3.8887e-17
* device instance cc__89_vdd r0 *1 0,0
Ccc__89_vdd \$89 vdd 1.275e-17
* device instance cc__89_vss r0 *1 0,0
Ccc__89_vss \$89 vss 1.0837e-17
* device instance cc__90_lo_1_n r0 *1 0,0
Ccc__90_lo_1_n \$90 lo_1_n 6.924e-18
* device instance cc__90_sel_in r0 *1 0,0
Ccc__90_sel_in \$90 sel_in 1.0837e-17
* device instance cc__90_topn r0 *1 0,0
Ccc__90_topn \$90 topn 1.80912e-16
* device instance cc__90_topp r0 *1 0,0
Ccc__90_topp \$90 topp 1.7212e-17
* device instance cc__90_vcm r0 *1 0,0
Ccc__90_vcm \$90 vcm 2.805e-17
* device instance cc__90_vdd r0 *1 0,0
Ccc__90_vdd \$90 vdd 5.194e-18
* device instance cc__90_vss r0 *1 0,0
Ccc__90_vss \$90 vss 1.0837e-17
* device instance cc_hi_16_n_vcm r0 *1 0,0
Ccc_hi_16_n_vcm hi_16_n vcm 1.0837e-17
* device instance cc_hi_16_p_vcm r0 *1 0,0
Ccc_hi_16_p_vcm hi_16_p vcm 1.0837e-17
* device instance cc_lo_16_n_vcm r0 *1 0,0
Ccc_lo_16_n_vcm lo_16_n vcm 1.0837e-17
* device instance cc_lo_16_p_vcm r0 *1 0,0
Ccc_lo_16_p_vcm lo_16_p vcm 1.0837e-17
* device instance cc_pinn_vcm r0 *1 0,0
Ccc_pinn_vcm pinn vcm 2.1675e-17
* device instance cc_pinp_vcm r0 *1 0,0
Ccc_pinp_vcm pinp vcm 1.0837e-17
* device instance cc_rel_16_n_vcm r0 *1 0,0
Ccc_rel_16_n_vcm rel_16_n vcm 1e-19
* device instance cc_rel_16_p_vcm r0 *1 0,0
Ccc_rel_16_p_vcm rel_16_p vcm 1e-19
* device instance cc_sel_in_vcm r0 *1 0,0
Ccc_sel_in_vcm sel_in vcm 3.2512e-17
* device instance cc_topn_topp r0 *1 0,0
Ccc_topn_topp topn topp 5.318e-18
* device instance cc_topn_vcm r0 *1 0,0
Ccc_topn_vcm topn vcm 1.74538e-16
* device instance cc_topn_vdd r0 *1 0,0
Ccc_topn_vdd topn vdd 3.1615e-17
* device instance cc_topn_vss r0 *1 0,0
Ccc_topn_vss topn vss 3.1615e-17
* device instance cc_topp_vcm r0 *1 0,0
Ccc_topp_vcm topp vcm 2.19799e-16
* device instance cc_topp_vdd r0 *1 0,0
Ccc_topp_vdd topp vdd 4.2452e-17
* device instance cc_topp_vss r0 *1 0,0
Ccc_topp_vss topp vss 3.1615e-17
* device instance cc_vcm_vdd r0 *1 0,0
Ccc_vcm_vdd vcm vdd 6.042e-17
* device instance cc_vcm_vref r0 *1 0,0
Ccc_vcm_vref vcm vref 1.0837e-17
* device instance cc_vcm_vss r0 *1 0,0
Ccc_vcm_vss vcm vss 5.6595e-17
* device instance cc_vdd_vss r0 *1 0,0
Ccc_vdd_vss vdd vss 6.4221e-17
* device instance vsubs_dctie r0 *1 0,0
Rvsubs_dctie vsubs 0 1e+12
.ENDS ADC_BLOCK
