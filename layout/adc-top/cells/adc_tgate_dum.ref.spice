* Flat LVS reference for ADC_TGATE_DUM.
*
* GENERATED by layout/adc-top/cells/gen_adc_cells.py from
* design/adc-top/adc_top.spice's `.subckt adc_tgate_dum` -- do not
* edit. See layout/adc-top/lib/netlist.py for why the layout and this
* reference are derived from the same parsed design netlist, and what
* that does and does not let LVS prove.
*
* Deliberate, documented choices behind the statements below -- made by
* the generator (`build`) and `klt extract`'s gf180mcu ExtractionDeck,
* and explained in layout/adc-top/README.md:
*   - the substrate: this cell has no `vss` port, so its `Pplus`
*     substrate-tie strip lands on the deck's `vsubs` global, which
*     is why `vsubs` is a pin below;
*
* Runnable by hand:  klt lvs layout/adc-top/cells/adc_tgate_dum.lvs.json --format json
.SUBCKT ADC_TGATE_DUM clk clkb vdd vin vout vsubs
MXDN vout clkb vout vsubs nfet L=0.28U W=17.5U
MXN vin clk vout vsubs nfet L=0.28U W=40U
MXP vin clkb vout vdd pfet L=0.28U W=80U
MXDP vout clk vout vdd pfet L=0.28U W=35U
.ENDS ADC_TGATE_DUM
