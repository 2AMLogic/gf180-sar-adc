* Flat LVS reference for the ADC_TOP block layout.
*
* GENERATED by layout/adc-top/gen_adc_top.py by flattening
* design/adc-top/adc_top.spice's `adc_cdac_side` and `adc_tp_sw`
* into the same composition the ADC-level testbenches use (DR-0014:
* two array sides + two per-side top-plate V_cm switches) -- do not
* edit. See layout/adc-top/lib/netlist.py for why the layout and this
* reference are derived from the same parsed design netlist, and what
* that does and does not let LVS prove.
*
* Deliberate, documented differences from the schematic, each forced by
* `klt extract`'s gf180mcu ExtractionDeck and restated in
* layout/adc-top/README.md:
*   - NMOS bodies are on the deck's `vsubs` global (no tap layer);
*   - PMOS bodies are on their own Nwell island's net -- one island per
*     placed CDAC cell, one per top-plate switch side, and one per
*     comparator group -- not on `vdd`: the deck never connects `nwell`
*     to `contact`;
*   - all 1024 unit MiM capacitors and the two terminating units are
*     absent. The deck DOES model this device (issue #70:
*     `cap_mim_2f0_m4m5_noshield`, proven end-to-end on the
*     cells/adc_cdac_cell case), and issue #85 now draws each REAL
*     unit as a recognised device (CAP_MK/MIM_L_MK + Via4) with its
*     per-weight bottom-plate interconnect wired inside the array
*     cell -- so `klt extract` sees them. They are STILL absent from
*     this reference: their bottom-plate nets stop at the array's
*     per-weight spines and are not routed to the decode switches, nor
*     is this reference extended to include them, until issue #86. So
*     `klt lvs` is not expected to match yet (README.md); the caps are
*     absent here rather than present on one side of the comparison.
*
* Runnable by hand:
*   klt lvs layout/adc-top/adc_top.lvs.json --format json
.SUBCKT ADC_TOP hi_128_n hi_128_p hi_16_n hi_16_p hi_1_n hi_1_p hi_256_n hi_256_p hi_2_n hi_2_p hi_32_n hi_32_p hi_4_n hi_4_p hi_64_n hi_64_p hi_8_n hi_8_p lo_128_n lo_128_p lo_16_n lo_16_p lo_1_n lo_1_p lo_256_n lo_256_p lo_2_n lo_2_p lo_32_n lo_32_p lo_4_n lo_4_p lo_64_n lo_64_p lo_8_n lo_8_p pinn pinp rel_128_n rel_128_p rel_16_n rel_16_p rel_1_n rel_1_p rel_256_n rel_256_p rel_2_n rel_2_p rel_32_n rel_32_p rel_4_n rel_4_p rel_64_n rel_64_p rel_8_n rel_8_p sel_in topn topp tp_gn vcm vdd vref vss vsubs
MXSP_X256_Xdi_Xp XSP.X256.gp_in sel_in vdd nw_p256 pfet L=0.35U W=8U
MXSP_X256_Xdi_Xn XSP.X256.gp_in sel_in vss vsubs nfet L=0.35U W=4U
MXSP_X256_Xdr_Xp XSP.X256.gp_rel rel_256_p vdd nw_p256 pfet L=0.35U W=8U
MXSP_X256_Xdr_Xn XSP.X256.gp_rel rel_256_p vss vsubs nfet L=0.35U W=4U
MXSP_X256_Xdh_Xp XSP.X256.gp_hi hi_256_p vdd nw_p256 pfet L=0.35U W=8U
MXSP_X256_Xdh_Xn XSP.X256.gp_hi hi_256_p vss vsubs nfet L=0.35U W=4U
MXSP_X256_Xdl_Xp XSP.X256.gp_lo lo_256_p vdd nw_p256 pfet L=0.35U W=8U
MXSP_X256_Xdl_Xn XSP.X256.gp_lo lo_256_p vss vsubs nfet L=0.35U W=4U
MXSP_X256_Xsi_XN pinp sel_in XSP.X256.bp vsubs nfet L=0.28U W=10U
MXSP_X256_Xsi_XP pinp XSP.X256.gp_in XSP.X256.bp nw_p256 pfet L=0.28U W=20U
MXSP_X256_Xsr_XN vcm rel_256_p XSP.X256.bp vsubs nfet L=0.28U W=10U
MXSP_X256_Xsr_XP vcm XSP.X256.gp_rel XSP.X256.bp nw_p256 pfet L=0.28U W=20U
MXSP_X256_Xsh_XN vref hi_256_p XSP.X256.bp vsubs nfet L=0.28U W=10U
MXSP_X256_Xsh_XP vref XSP.X256.gp_hi XSP.X256.bp nw_p256 pfet L=0.28U W=20U
MXSP_X256_Xsl_XN vss lo_256_p XSP.X256.bp vsubs nfet L=0.28U W=10U
MXSP_X256_Xsl_XP vss XSP.X256.gp_lo XSP.X256.bp nw_p256 pfet L=0.28U W=20U
MXSP_X128_Xdi_Xp XSP.X128.gp_in sel_in vdd nw_p128 pfet L=0.35U W=8U
MXSP_X128_Xdi_Xn XSP.X128.gp_in sel_in vss vsubs nfet L=0.35U W=4U
MXSP_X128_Xdr_Xp XSP.X128.gp_rel rel_128_p vdd nw_p128 pfet L=0.35U W=8U
MXSP_X128_Xdr_Xn XSP.X128.gp_rel rel_128_p vss vsubs nfet L=0.35U W=4U
MXSP_X128_Xdh_Xp XSP.X128.gp_hi hi_128_p vdd nw_p128 pfet L=0.35U W=8U
MXSP_X128_Xdh_Xn XSP.X128.gp_hi hi_128_p vss vsubs nfet L=0.35U W=4U
MXSP_X128_Xdl_Xp XSP.X128.gp_lo lo_128_p vdd nw_p128 pfet L=0.35U W=8U
MXSP_X128_Xdl_Xn XSP.X128.gp_lo lo_128_p vss vsubs nfet L=0.35U W=4U
MXSP_X128_Xsi_XN pinp sel_in XSP.X128.bp vsubs nfet L=0.28U W=10U
MXSP_X128_Xsi_XP pinp XSP.X128.gp_in XSP.X128.bp nw_p128 pfet L=0.28U W=20U
MXSP_X128_Xsr_XN vcm rel_128_p XSP.X128.bp vsubs nfet L=0.28U W=10U
MXSP_X128_Xsr_XP vcm XSP.X128.gp_rel XSP.X128.bp nw_p128 pfet L=0.28U W=20U
MXSP_X128_Xsh_XN vref hi_128_p XSP.X128.bp vsubs nfet L=0.28U W=10U
MXSP_X128_Xsh_XP vref XSP.X128.gp_hi XSP.X128.bp nw_p128 pfet L=0.28U W=20U
MXSP_X128_Xsl_XN vss lo_128_p XSP.X128.bp vsubs nfet L=0.28U W=10U
MXSP_X128_Xsl_XP vss XSP.X128.gp_lo XSP.X128.bp nw_p128 pfet L=0.28U W=20U
MXSP_X64_Xdi_Xp XSP.X64.gp_in sel_in vdd nw_p64 pfet L=0.35U W=8U
MXSP_X64_Xdi_Xn XSP.X64.gp_in sel_in vss vsubs nfet L=0.35U W=4U
MXSP_X64_Xdr_Xp XSP.X64.gp_rel rel_64_p vdd nw_p64 pfet L=0.35U W=8U
MXSP_X64_Xdr_Xn XSP.X64.gp_rel rel_64_p vss vsubs nfet L=0.35U W=4U
MXSP_X64_Xdh_Xp XSP.X64.gp_hi hi_64_p vdd nw_p64 pfet L=0.35U W=8U
MXSP_X64_Xdh_Xn XSP.X64.gp_hi hi_64_p vss vsubs nfet L=0.35U W=4U
MXSP_X64_Xdl_Xp XSP.X64.gp_lo lo_64_p vdd nw_p64 pfet L=0.35U W=8U
MXSP_X64_Xdl_Xn XSP.X64.gp_lo lo_64_p vss vsubs nfet L=0.35U W=4U
MXSP_X64_Xsi_XN pinp sel_in XSP.X64.bp vsubs nfet L=0.28U W=10U
MXSP_X64_Xsi_XP pinp XSP.X64.gp_in XSP.X64.bp nw_p64 pfet L=0.28U W=20U
MXSP_X64_Xsr_XN vcm rel_64_p XSP.X64.bp vsubs nfet L=0.28U W=10U
MXSP_X64_Xsr_XP vcm XSP.X64.gp_rel XSP.X64.bp nw_p64 pfet L=0.28U W=20U
MXSP_X64_Xsh_XN vref hi_64_p XSP.X64.bp vsubs nfet L=0.28U W=10U
MXSP_X64_Xsh_XP vref XSP.X64.gp_hi XSP.X64.bp nw_p64 pfet L=0.28U W=20U
MXSP_X64_Xsl_XN vss lo_64_p XSP.X64.bp vsubs nfet L=0.28U W=10U
MXSP_X64_Xsl_XP vss XSP.X64.gp_lo XSP.X64.bp nw_p64 pfet L=0.28U W=20U
MXSP_X32_Xdi_Xp XSP.X32.gp_in sel_in vdd nw_p32 pfet L=0.35U W=8U
MXSP_X32_Xdi_Xn XSP.X32.gp_in sel_in vss vsubs nfet L=0.35U W=4U
MXSP_X32_Xdr_Xp XSP.X32.gp_rel rel_32_p vdd nw_p32 pfet L=0.35U W=8U
MXSP_X32_Xdr_Xn XSP.X32.gp_rel rel_32_p vss vsubs nfet L=0.35U W=4U
MXSP_X32_Xdh_Xp XSP.X32.gp_hi hi_32_p vdd nw_p32 pfet L=0.35U W=8U
MXSP_X32_Xdh_Xn XSP.X32.gp_hi hi_32_p vss vsubs nfet L=0.35U W=4U
MXSP_X32_Xdl_Xp XSP.X32.gp_lo lo_32_p vdd nw_p32 pfet L=0.35U W=8U
MXSP_X32_Xdl_Xn XSP.X32.gp_lo lo_32_p vss vsubs nfet L=0.35U W=4U
MXSP_X32_Xsi_XN pinp sel_in XSP.X32.bp vsubs nfet L=0.28U W=10U
MXSP_X32_Xsi_XP pinp XSP.X32.gp_in XSP.X32.bp nw_p32 pfet L=0.28U W=20U
MXSP_X32_Xsr_XN vcm rel_32_p XSP.X32.bp vsubs nfet L=0.28U W=10U
MXSP_X32_Xsr_XP vcm XSP.X32.gp_rel XSP.X32.bp nw_p32 pfet L=0.28U W=20U
MXSP_X32_Xsh_XN vref hi_32_p XSP.X32.bp vsubs nfet L=0.28U W=10U
MXSP_X32_Xsh_XP vref XSP.X32.gp_hi XSP.X32.bp nw_p32 pfet L=0.28U W=20U
MXSP_X32_Xsl_XN vss lo_32_p XSP.X32.bp vsubs nfet L=0.28U W=10U
MXSP_X32_Xsl_XP vss XSP.X32.gp_lo XSP.X32.bp nw_p32 pfet L=0.28U W=20U
MXSP_X16_Xdi_Xp XSP.X16.gp_in sel_in vdd nw_p16 pfet L=0.35U W=8U
MXSP_X16_Xdi_Xn XSP.X16.gp_in sel_in vss vsubs nfet L=0.35U W=4U
MXSP_X16_Xdr_Xp XSP.X16.gp_rel rel_16_p vdd nw_p16 pfet L=0.35U W=8U
MXSP_X16_Xdr_Xn XSP.X16.gp_rel rel_16_p vss vsubs nfet L=0.35U W=4U
MXSP_X16_Xdh_Xp XSP.X16.gp_hi hi_16_p vdd nw_p16 pfet L=0.35U W=8U
MXSP_X16_Xdh_Xn XSP.X16.gp_hi hi_16_p vss vsubs nfet L=0.35U W=4U
MXSP_X16_Xdl_Xp XSP.X16.gp_lo lo_16_p vdd nw_p16 pfet L=0.35U W=8U
MXSP_X16_Xdl_Xn XSP.X16.gp_lo lo_16_p vss vsubs nfet L=0.35U W=4U
MXSP_X16_Xsi_XN pinp sel_in XSP.X16.bp vsubs nfet L=0.28U W=10U
MXSP_X16_Xsi_XP pinp XSP.X16.gp_in XSP.X16.bp nw_p16 pfet L=0.28U W=20U
MXSP_X16_Xsr_XN vcm rel_16_p XSP.X16.bp vsubs nfet L=0.28U W=10U
MXSP_X16_Xsr_XP vcm XSP.X16.gp_rel XSP.X16.bp nw_p16 pfet L=0.28U W=20U
MXSP_X16_Xsh_XN vref hi_16_p XSP.X16.bp vsubs nfet L=0.28U W=10U
MXSP_X16_Xsh_XP vref XSP.X16.gp_hi XSP.X16.bp nw_p16 pfet L=0.28U W=20U
MXSP_X16_Xsl_XN vss lo_16_p XSP.X16.bp vsubs nfet L=0.28U W=10U
MXSP_X16_Xsl_XP vss XSP.X16.gp_lo XSP.X16.bp nw_p16 pfet L=0.28U W=20U
MXSP_X8_Xdi_Xp XSP.X8.gp_in sel_in vdd nw_p8 pfet L=0.35U W=8U
MXSP_X8_Xdi_Xn XSP.X8.gp_in sel_in vss vsubs nfet L=0.35U W=4U
MXSP_X8_Xdr_Xp XSP.X8.gp_rel rel_8_p vdd nw_p8 pfet L=0.35U W=8U
MXSP_X8_Xdr_Xn XSP.X8.gp_rel rel_8_p vss vsubs nfet L=0.35U W=4U
MXSP_X8_Xdh_Xp XSP.X8.gp_hi hi_8_p vdd nw_p8 pfet L=0.35U W=8U
MXSP_X8_Xdh_Xn XSP.X8.gp_hi hi_8_p vss vsubs nfet L=0.35U W=4U
MXSP_X8_Xdl_Xp XSP.X8.gp_lo lo_8_p vdd nw_p8 pfet L=0.35U W=8U
MXSP_X8_Xdl_Xn XSP.X8.gp_lo lo_8_p vss vsubs nfet L=0.35U W=4U
MXSP_X8_Xsi_XN pinp sel_in XSP.X8.bp vsubs nfet L=0.28U W=10U
MXSP_X8_Xsi_XP pinp XSP.X8.gp_in XSP.X8.bp nw_p8 pfet L=0.28U W=20U
MXSP_X8_Xsr_XN vcm rel_8_p XSP.X8.bp vsubs nfet L=0.28U W=10U
MXSP_X8_Xsr_XP vcm XSP.X8.gp_rel XSP.X8.bp nw_p8 pfet L=0.28U W=20U
MXSP_X8_Xsh_XN vref hi_8_p XSP.X8.bp vsubs nfet L=0.28U W=10U
MXSP_X8_Xsh_XP vref XSP.X8.gp_hi XSP.X8.bp nw_p8 pfet L=0.28U W=20U
MXSP_X8_Xsl_XN vss lo_8_p XSP.X8.bp vsubs nfet L=0.28U W=10U
MXSP_X8_Xsl_XP vss XSP.X8.gp_lo XSP.X8.bp nw_p8 pfet L=0.28U W=20U
MXSP_X4_Xdi_Xp XSP.X4.gp_in sel_in vdd nw_p4 pfet L=0.35U W=8U
MXSP_X4_Xdi_Xn XSP.X4.gp_in sel_in vss vsubs nfet L=0.35U W=4U
MXSP_X4_Xdr_Xp XSP.X4.gp_rel rel_4_p vdd nw_p4 pfet L=0.35U W=8U
MXSP_X4_Xdr_Xn XSP.X4.gp_rel rel_4_p vss vsubs nfet L=0.35U W=4U
MXSP_X4_Xdh_Xp XSP.X4.gp_hi hi_4_p vdd nw_p4 pfet L=0.35U W=8U
MXSP_X4_Xdh_Xn XSP.X4.gp_hi hi_4_p vss vsubs nfet L=0.35U W=4U
MXSP_X4_Xdl_Xp XSP.X4.gp_lo lo_4_p vdd nw_p4 pfet L=0.35U W=8U
MXSP_X4_Xdl_Xn XSP.X4.gp_lo lo_4_p vss vsubs nfet L=0.35U W=4U
MXSP_X4_Xsi_XN pinp sel_in XSP.X4.bp vsubs nfet L=0.28U W=10U
MXSP_X4_Xsi_XP pinp XSP.X4.gp_in XSP.X4.bp nw_p4 pfet L=0.28U W=20U
MXSP_X4_Xsr_XN vcm rel_4_p XSP.X4.bp vsubs nfet L=0.28U W=10U
MXSP_X4_Xsr_XP vcm XSP.X4.gp_rel XSP.X4.bp nw_p4 pfet L=0.28U W=20U
MXSP_X4_Xsh_XN vref hi_4_p XSP.X4.bp vsubs nfet L=0.28U W=10U
MXSP_X4_Xsh_XP vref XSP.X4.gp_hi XSP.X4.bp nw_p4 pfet L=0.28U W=20U
MXSP_X4_Xsl_XN vss lo_4_p XSP.X4.bp vsubs nfet L=0.28U W=10U
MXSP_X4_Xsl_XP vss XSP.X4.gp_lo XSP.X4.bp nw_p4 pfet L=0.28U W=20U
MXSP_X2_Xdi_Xp XSP.X2.gp_in sel_in vdd nw_p2 pfet L=0.35U W=8U
MXSP_X2_Xdi_Xn XSP.X2.gp_in sel_in vss vsubs nfet L=0.35U W=4U
MXSP_X2_Xdr_Xp XSP.X2.gp_rel rel_2_p vdd nw_p2 pfet L=0.35U W=8U
MXSP_X2_Xdr_Xn XSP.X2.gp_rel rel_2_p vss vsubs nfet L=0.35U W=4U
MXSP_X2_Xdh_Xp XSP.X2.gp_hi hi_2_p vdd nw_p2 pfet L=0.35U W=8U
MXSP_X2_Xdh_Xn XSP.X2.gp_hi hi_2_p vss vsubs nfet L=0.35U W=4U
MXSP_X2_Xdl_Xp XSP.X2.gp_lo lo_2_p vdd nw_p2 pfet L=0.35U W=8U
MXSP_X2_Xdl_Xn XSP.X2.gp_lo lo_2_p vss vsubs nfet L=0.35U W=4U
MXSP_X2_Xsi_XN pinp sel_in XSP.X2.bp vsubs nfet L=0.28U W=10U
MXSP_X2_Xsi_XP pinp XSP.X2.gp_in XSP.X2.bp nw_p2 pfet L=0.28U W=20U
MXSP_X2_Xsr_XN vcm rel_2_p XSP.X2.bp vsubs nfet L=0.28U W=10U
MXSP_X2_Xsr_XP vcm XSP.X2.gp_rel XSP.X2.bp nw_p2 pfet L=0.28U W=20U
MXSP_X2_Xsh_XN vref hi_2_p XSP.X2.bp vsubs nfet L=0.28U W=10U
MXSP_X2_Xsh_XP vref XSP.X2.gp_hi XSP.X2.bp nw_p2 pfet L=0.28U W=20U
MXSP_X2_Xsl_XN vss lo_2_p XSP.X2.bp vsubs nfet L=0.28U W=10U
MXSP_X2_Xsl_XP vss XSP.X2.gp_lo XSP.X2.bp nw_p2 pfet L=0.28U W=20U
MXSP_X1_Xdi_Xp XSP.X1.gp_in sel_in vdd nw_p1 pfet L=0.35U W=8U
MXSP_X1_Xdi_Xn XSP.X1.gp_in sel_in vss vsubs nfet L=0.35U W=4U
MXSP_X1_Xdr_Xp XSP.X1.gp_rel rel_1_p vdd nw_p1 pfet L=0.35U W=8U
MXSP_X1_Xdr_Xn XSP.X1.gp_rel rel_1_p vss vsubs nfet L=0.35U W=4U
MXSP_X1_Xdh_Xp XSP.X1.gp_hi hi_1_p vdd nw_p1 pfet L=0.35U W=8U
MXSP_X1_Xdh_Xn XSP.X1.gp_hi hi_1_p vss vsubs nfet L=0.35U W=4U
MXSP_X1_Xdl_Xp XSP.X1.gp_lo lo_1_p vdd nw_p1 pfet L=0.35U W=8U
MXSP_X1_Xdl_Xn XSP.X1.gp_lo lo_1_p vss vsubs nfet L=0.35U W=4U
MXSP_X1_Xsi_XN pinp sel_in XSP.X1.bp vsubs nfet L=0.28U W=10U
MXSP_X1_Xsi_XP pinp XSP.X1.gp_in XSP.X1.bp nw_p1 pfet L=0.28U W=20U
MXSP_X1_Xsr_XN vcm rel_1_p XSP.X1.bp vsubs nfet L=0.28U W=10U
MXSP_X1_Xsr_XP vcm XSP.X1.gp_rel XSP.X1.bp nw_p1 pfet L=0.28U W=20U
MXSP_X1_Xsh_XN vref hi_1_p XSP.X1.bp vsubs nfet L=0.28U W=10U
MXSP_X1_Xsh_XP vref XSP.X1.gp_hi XSP.X1.bp nw_p1 pfet L=0.28U W=20U
MXSP_X1_Xsl_XN vss lo_1_p XSP.X1.bp vsubs nfet L=0.28U W=10U
MXSP_X1_Xsl_XP vss XSP.X1.gp_lo XSP.X1.bp nw_p1 pfet L=0.28U W=20U
MXSN_X256_Xdi_Xp XSN.X256.gp_in sel_in vdd nw_n256 pfet L=0.35U W=8U
MXSN_X256_Xdi_Xn XSN.X256.gp_in sel_in vss vsubs nfet L=0.35U W=4U
MXSN_X256_Xdr_Xp XSN.X256.gp_rel rel_256_n vdd nw_n256 pfet L=0.35U W=8U
MXSN_X256_Xdr_Xn XSN.X256.gp_rel rel_256_n vss vsubs nfet L=0.35U W=4U
MXSN_X256_Xdh_Xp XSN.X256.gp_hi hi_256_n vdd nw_n256 pfet L=0.35U W=8U
MXSN_X256_Xdh_Xn XSN.X256.gp_hi hi_256_n vss vsubs nfet L=0.35U W=4U
MXSN_X256_Xdl_Xp XSN.X256.gp_lo lo_256_n vdd nw_n256 pfet L=0.35U W=8U
MXSN_X256_Xdl_Xn XSN.X256.gp_lo lo_256_n vss vsubs nfet L=0.35U W=4U
MXSN_X256_Xsi_XN pinn sel_in XSN.X256.bp vsubs nfet L=0.28U W=10U
MXSN_X256_Xsi_XP pinn XSN.X256.gp_in XSN.X256.bp nw_n256 pfet L=0.28U W=20U
MXSN_X256_Xsr_XN vcm rel_256_n XSN.X256.bp vsubs nfet L=0.28U W=10U
MXSN_X256_Xsr_XP vcm XSN.X256.gp_rel XSN.X256.bp nw_n256 pfet L=0.28U W=20U
MXSN_X256_Xsh_XN vref hi_256_n XSN.X256.bp vsubs nfet L=0.28U W=10U
MXSN_X256_Xsh_XP vref XSN.X256.gp_hi XSN.X256.bp nw_n256 pfet L=0.28U W=20U
MXSN_X256_Xsl_XN vss lo_256_n XSN.X256.bp vsubs nfet L=0.28U W=10U
MXSN_X256_Xsl_XP vss XSN.X256.gp_lo XSN.X256.bp nw_n256 pfet L=0.28U W=20U
MXSN_X128_Xdi_Xp XSN.X128.gp_in sel_in vdd nw_n128 pfet L=0.35U W=8U
MXSN_X128_Xdi_Xn XSN.X128.gp_in sel_in vss vsubs nfet L=0.35U W=4U
MXSN_X128_Xdr_Xp XSN.X128.gp_rel rel_128_n vdd nw_n128 pfet L=0.35U W=8U
MXSN_X128_Xdr_Xn XSN.X128.gp_rel rel_128_n vss vsubs nfet L=0.35U W=4U
MXSN_X128_Xdh_Xp XSN.X128.gp_hi hi_128_n vdd nw_n128 pfet L=0.35U W=8U
MXSN_X128_Xdh_Xn XSN.X128.gp_hi hi_128_n vss vsubs nfet L=0.35U W=4U
MXSN_X128_Xdl_Xp XSN.X128.gp_lo lo_128_n vdd nw_n128 pfet L=0.35U W=8U
MXSN_X128_Xdl_Xn XSN.X128.gp_lo lo_128_n vss vsubs nfet L=0.35U W=4U
MXSN_X128_Xsi_XN pinn sel_in XSN.X128.bp vsubs nfet L=0.28U W=10U
MXSN_X128_Xsi_XP pinn XSN.X128.gp_in XSN.X128.bp nw_n128 pfet L=0.28U W=20U
MXSN_X128_Xsr_XN vcm rel_128_n XSN.X128.bp vsubs nfet L=0.28U W=10U
MXSN_X128_Xsr_XP vcm XSN.X128.gp_rel XSN.X128.bp nw_n128 pfet L=0.28U W=20U
MXSN_X128_Xsh_XN vref hi_128_n XSN.X128.bp vsubs nfet L=0.28U W=10U
MXSN_X128_Xsh_XP vref XSN.X128.gp_hi XSN.X128.bp nw_n128 pfet L=0.28U W=20U
MXSN_X128_Xsl_XN vss lo_128_n XSN.X128.bp vsubs nfet L=0.28U W=10U
MXSN_X128_Xsl_XP vss XSN.X128.gp_lo XSN.X128.bp nw_n128 pfet L=0.28U W=20U
MXSN_X64_Xdi_Xp XSN.X64.gp_in sel_in vdd nw_n64 pfet L=0.35U W=8U
MXSN_X64_Xdi_Xn XSN.X64.gp_in sel_in vss vsubs nfet L=0.35U W=4U
MXSN_X64_Xdr_Xp XSN.X64.gp_rel rel_64_n vdd nw_n64 pfet L=0.35U W=8U
MXSN_X64_Xdr_Xn XSN.X64.gp_rel rel_64_n vss vsubs nfet L=0.35U W=4U
MXSN_X64_Xdh_Xp XSN.X64.gp_hi hi_64_n vdd nw_n64 pfet L=0.35U W=8U
MXSN_X64_Xdh_Xn XSN.X64.gp_hi hi_64_n vss vsubs nfet L=0.35U W=4U
MXSN_X64_Xdl_Xp XSN.X64.gp_lo lo_64_n vdd nw_n64 pfet L=0.35U W=8U
MXSN_X64_Xdl_Xn XSN.X64.gp_lo lo_64_n vss vsubs nfet L=0.35U W=4U
MXSN_X64_Xsi_XN pinn sel_in XSN.X64.bp vsubs nfet L=0.28U W=10U
MXSN_X64_Xsi_XP pinn XSN.X64.gp_in XSN.X64.bp nw_n64 pfet L=0.28U W=20U
MXSN_X64_Xsr_XN vcm rel_64_n XSN.X64.bp vsubs nfet L=0.28U W=10U
MXSN_X64_Xsr_XP vcm XSN.X64.gp_rel XSN.X64.bp nw_n64 pfet L=0.28U W=20U
MXSN_X64_Xsh_XN vref hi_64_n XSN.X64.bp vsubs nfet L=0.28U W=10U
MXSN_X64_Xsh_XP vref XSN.X64.gp_hi XSN.X64.bp nw_n64 pfet L=0.28U W=20U
MXSN_X64_Xsl_XN vss lo_64_n XSN.X64.bp vsubs nfet L=0.28U W=10U
MXSN_X64_Xsl_XP vss XSN.X64.gp_lo XSN.X64.bp nw_n64 pfet L=0.28U W=20U
MXSN_X32_Xdi_Xp XSN.X32.gp_in sel_in vdd nw_n32 pfet L=0.35U W=8U
MXSN_X32_Xdi_Xn XSN.X32.gp_in sel_in vss vsubs nfet L=0.35U W=4U
MXSN_X32_Xdr_Xp XSN.X32.gp_rel rel_32_n vdd nw_n32 pfet L=0.35U W=8U
MXSN_X32_Xdr_Xn XSN.X32.gp_rel rel_32_n vss vsubs nfet L=0.35U W=4U
MXSN_X32_Xdh_Xp XSN.X32.gp_hi hi_32_n vdd nw_n32 pfet L=0.35U W=8U
MXSN_X32_Xdh_Xn XSN.X32.gp_hi hi_32_n vss vsubs nfet L=0.35U W=4U
MXSN_X32_Xdl_Xp XSN.X32.gp_lo lo_32_n vdd nw_n32 pfet L=0.35U W=8U
MXSN_X32_Xdl_Xn XSN.X32.gp_lo lo_32_n vss vsubs nfet L=0.35U W=4U
MXSN_X32_Xsi_XN pinn sel_in XSN.X32.bp vsubs nfet L=0.28U W=10U
MXSN_X32_Xsi_XP pinn XSN.X32.gp_in XSN.X32.bp nw_n32 pfet L=0.28U W=20U
MXSN_X32_Xsr_XN vcm rel_32_n XSN.X32.bp vsubs nfet L=0.28U W=10U
MXSN_X32_Xsr_XP vcm XSN.X32.gp_rel XSN.X32.bp nw_n32 pfet L=0.28U W=20U
MXSN_X32_Xsh_XN vref hi_32_n XSN.X32.bp vsubs nfet L=0.28U W=10U
MXSN_X32_Xsh_XP vref XSN.X32.gp_hi XSN.X32.bp nw_n32 pfet L=0.28U W=20U
MXSN_X32_Xsl_XN vss lo_32_n XSN.X32.bp vsubs nfet L=0.28U W=10U
MXSN_X32_Xsl_XP vss XSN.X32.gp_lo XSN.X32.bp nw_n32 pfet L=0.28U W=20U
MXSN_X16_Xdi_Xp XSN.X16.gp_in sel_in vdd nw_n16 pfet L=0.35U W=8U
MXSN_X16_Xdi_Xn XSN.X16.gp_in sel_in vss vsubs nfet L=0.35U W=4U
MXSN_X16_Xdr_Xp XSN.X16.gp_rel rel_16_n vdd nw_n16 pfet L=0.35U W=8U
MXSN_X16_Xdr_Xn XSN.X16.gp_rel rel_16_n vss vsubs nfet L=0.35U W=4U
MXSN_X16_Xdh_Xp XSN.X16.gp_hi hi_16_n vdd nw_n16 pfet L=0.35U W=8U
MXSN_X16_Xdh_Xn XSN.X16.gp_hi hi_16_n vss vsubs nfet L=0.35U W=4U
MXSN_X16_Xdl_Xp XSN.X16.gp_lo lo_16_n vdd nw_n16 pfet L=0.35U W=8U
MXSN_X16_Xdl_Xn XSN.X16.gp_lo lo_16_n vss vsubs nfet L=0.35U W=4U
MXSN_X16_Xsi_XN pinn sel_in XSN.X16.bp vsubs nfet L=0.28U W=10U
MXSN_X16_Xsi_XP pinn XSN.X16.gp_in XSN.X16.bp nw_n16 pfet L=0.28U W=20U
MXSN_X16_Xsr_XN vcm rel_16_n XSN.X16.bp vsubs nfet L=0.28U W=10U
MXSN_X16_Xsr_XP vcm XSN.X16.gp_rel XSN.X16.bp nw_n16 pfet L=0.28U W=20U
MXSN_X16_Xsh_XN vref hi_16_n XSN.X16.bp vsubs nfet L=0.28U W=10U
MXSN_X16_Xsh_XP vref XSN.X16.gp_hi XSN.X16.bp nw_n16 pfet L=0.28U W=20U
MXSN_X16_Xsl_XN vss lo_16_n XSN.X16.bp vsubs nfet L=0.28U W=10U
MXSN_X16_Xsl_XP vss XSN.X16.gp_lo XSN.X16.bp nw_n16 pfet L=0.28U W=20U
MXSN_X8_Xdi_Xp XSN.X8.gp_in sel_in vdd nw_n8 pfet L=0.35U W=8U
MXSN_X8_Xdi_Xn XSN.X8.gp_in sel_in vss vsubs nfet L=0.35U W=4U
MXSN_X8_Xdr_Xp XSN.X8.gp_rel rel_8_n vdd nw_n8 pfet L=0.35U W=8U
MXSN_X8_Xdr_Xn XSN.X8.gp_rel rel_8_n vss vsubs nfet L=0.35U W=4U
MXSN_X8_Xdh_Xp XSN.X8.gp_hi hi_8_n vdd nw_n8 pfet L=0.35U W=8U
MXSN_X8_Xdh_Xn XSN.X8.gp_hi hi_8_n vss vsubs nfet L=0.35U W=4U
MXSN_X8_Xdl_Xp XSN.X8.gp_lo lo_8_n vdd nw_n8 pfet L=0.35U W=8U
MXSN_X8_Xdl_Xn XSN.X8.gp_lo lo_8_n vss vsubs nfet L=0.35U W=4U
MXSN_X8_Xsi_XN pinn sel_in XSN.X8.bp vsubs nfet L=0.28U W=10U
MXSN_X8_Xsi_XP pinn XSN.X8.gp_in XSN.X8.bp nw_n8 pfet L=0.28U W=20U
MXSN_X8_Xsr_XN vcm rel_8_n XSN.X8.bp vsubs nfet L=0.28U W=10U
MXSN_X8_Xsr_XP vcm XSN.X8.gp_rel XSN.X8.bp nw_n8 pfet L=0.28U W=20U
MXSN_X8_Xsh_XN vref hi_8_n XSN.X8.bp vsubs nfet L=0.28U W=10U
MXSN_X8_Xsh_XP vref XSN.X8.gp_hi XSN.X8.bp nw_n8 pfet L=0.28U W=20U
MXSN_X8_Xsl_XN vss lo_8_n XSN.X8.bp vsubs nfet L=0.28U W=10U
MXSN_X8_Xsl_XP vss XSN.X8.gp_lo XSN.X8.bp nw_n8 pfet L=0.28U W=20U
MXSN_X4_Xdi_Xp XSN.X4.gp_in sel_in vdd nw_n4 pfet L=0.35U W=8U
MXSN_X4_Xdi_Xn XSN.X4.gp_in sel_in vss vsubs nfet L=0.35U W=4U
MXSN_X4_Xdr_Xp XSN.X4.gp_rel rel_4_n vdd nw_n4 pfet L=0.35U W=8U
MXSN_X4_Xdr_Xn XSN.X4.gp_rel rel_4_n vss vsubs nfet L=0.35U W=4U
MXSN_X4_Xdh_Xp XSN.X4.gp_hi hi_4_n vdd nw_n4 pfet L=0.35U W=8U
MXSN_X4_Xdh_Xn XSN.X4.gp_hi hi_4_n vss vsubs nfet L=0.35U W=4U
MXSN_X4_Xdl_Xp XSN.X4.gp_lo lo_4_n vdd nw_n4 pfet L=0.35U W=8U
MXSN_X4_Xdl_Xn XSN.X4.gp_lo lo_4_n vss vsubs nfet L=0.35U W=4U
MXSN_X4_Xsi_XN pinn sel_in XSN.X4.bp vsubs nfet L=0.28U W=10U
MXSN_X4_Xsi_XP pinn XSN.X4.gp_in XSN.X4.bp nw_n4 pfet L=0.28U W=20U
MXSN_X4_Xsr_XN vcm rel_4_n XSN.X4.bp vsubs nfet L=0.28U W=10U
MXSN_X4_Xsr_XP vcm XSN.X4.gp_rel XSN.X4.bp nw_n4 pfet L=0.28U W=20U
MXSN_X4_Xsh_XN vref hi_4_n XSN.X4.bp vsubs nfet L=0.28U W=10U
MXSN_X4_Xsh_XP vref XSN.X4.gp_hi XSN.X4.bp nw_n4 pfet L=0.28U W=20U
MXSN_X4_Xsl_XN vss lo_4_n XSN.X4.bp vsubs nfet L=0.28U W=10U
MXSN_X4_Xsl_XP vss XSN.X4.gp_lo XSN.X4.bp nw_n4 pfet L=0.28U W=20U
MXSN_X2_Xdi_Xp XSN.X2.gp_in sel_in vdd nw_n2 pfet L=0.35U W=8U
MXSN_X2_Xdi_Xn XSN.X2.gp_in sel_in vss vsubs nfet L=0.35U W=4U
MXSN_X2_Xdr_Xp XSN.X2.gp_rel rel_2_n vdd nw_n2 pfet L=0.35U W=8U
MXSN_X2_Xdr_Xn XSN.X2.gp_rel rel_2_n vss vsubs nfet L=0.35U W=4U
MXSN_X2_Xdh_Xp XSN.X2.gp_hi hi_2_n vdd nw_n2 pfet L=0.35U W=8U
MXSN_X2_Xdh_Xn XSN.X2.gp_hi hi_2_n vss vsubs nfet L=0.35U W=4U
MXSN_X2_Xdl_Xp XSN.X2.gp_lo lo_2_n vdd nw_n2 pfet L=0.35U W=8U
MXSN_X2_Xdl_Xn XSN.X2.gp_lo lo_2_n vss vsubs nfet L=0.35U W=4U
MXSN_X2_Xsi_XN pinn sel_in XSN.X2.bp vsubs nfet L=0.28U W=10U
MXSN_X2_Xsi_XP pinn XSN.X2.gp_in XSN.X2.bp nw_n2 pfet L=0.28U W=20U
MXSN_X2_Xsr_XN vcm rel_2_n XSN.X2.bp vsubs nfet L=0.28U W=10U
MXSN_X2_Xsr_XP vcm XSN.X2.gp_rel XSN.X2.bp nw_n2 pfet L=0.28U W=20U
MXSN_X2_Xsh_XN vref hi_2_n XSN.X2.bp vsubs nfet L=0.28U W=10U
MXSN_X2_Xsh_XP vref XSN.X2.gp_hi XSN.X2.bp nw_n2 pfet L=0.28U W=20U
MXSN_X2_Xsl_XN vss lo_2_n XSN.X2.bp vsubs nfet L=0.28U W=10U
MXSN_X2_Xsl_XP vss XSN.X2.gp_lo XSN.X2.bp nw_n2 pfet L=0.28U W=20U
MXSN_X1_Xdi_Xp XSN.X1.gp_in sel_in vdd nw_n1 pfet L=0.35U W=8U
MXSN_X1_Xdi_Xn XSN.X1.gp_in sel_in vss vsubs nfet L=0.35U W=4U
MXSN_X1_Xdr_Xp XSN.X1.gp_rel rel_1_n vdd nw_n1 pfet L=0.35U W=8U
MXSN_X1_Xdr_Xn XSN.X1.gp_rel rel_1_n vss vsubs nfet L=0.35U W=4U
MXSN_X1_Xdh_Xp XSN.X1.gp_hi hi_1_n vdd nw_n1 pfet L=0.35U W=8U
MXSN_X1_Xdh_Xn XSN.X1.gp_hi hi_1_n vss vsubs nfet L=0.35U W=4U
MXSN_X1_Xdl_Xp XSN.X1.gp_lo lo_1_n vdd nw_n1 pfet L=0.35U W=8U
MXSN_X1_Xdl_Xn XSN.X1.gp_lo lo_1_n vss vsubs nfet L=0.35U W=4U
MXSN_X1_Xsi_XN pinn sel_in XSN.X1.bp vsubs nfet L=0.28U W=10U
MXSN_X1_Xsi_XP pinn XSN.X1.gp_in XSN.X1.bp nw_n1 pfet L=0.28U W=20U
MXSN_X1_Xsr_XN vcm rel_1_n XSN.X1.bp vsubs nfet L=0.28U W=10U
MXSN_X1_Xsr_XP vcm XSN.X1.gp_rel XSN.X1.bp nw_n1 pfet L=0.28U W=20U
MXSN_X1_Xsh_XN vref hi_1_n XSN.X1.bp vsubs nfet L=0.28U W=10U
MXSN_X1_Xsh_XP vref XSN.X1.gp_hi XSN.X1.bp nw_n1 pfet L=0.28U W=20U
MXSN_X1_Xsl_XN vss lo_1_n XSN.X1.bp vsubs nfet L=0.28U W=10U
MXSN_X1_Xsl_XP vss XSN.X1.gp_lo XSN.X1.bp nw_n1 pfet L=0.28U W=20U
MXSWP_Xd_Xp XSWP.gp tp_gn vdd nw_swp pfet L=0.35U W=8U
MXSWP_Xd_Xn XSWP.gp tp_gn vss vsubs nfet L=0.35U W=4U
MXSWP_Xs_XN vcm tp_gn topp vsubs nfet L=0.28U W=10U
MXSWP_Xs_XP vcm XSWP.gp topp nw_swp pfet L=0.28U W=20U
MXSWN_Xd_Xp XSWN.gp tp_gn vdd nw_swn pfet L=0.35U W=8U
MXSWN_Xd_Xn XSWN.gp tp_gn vss vsubs nfet L=0.35U W=4U
MXSWN_Xs_XN vcm tp_gn topn vsubs nfet L=0.28U W=10U
MXSWN_Xs_XP vcm XSWN.gp topn nw_swn pfet L=0.28U W=20U
.ENDS ADC_TOP
