* ==================================================================
* tb_adc_power_extracted -- power at 1 MS/s, broken down by block, of
* the extracted, PMOS-body-remediated, MiM-mapped ADC_TOP core over
* the PVT grid (issue #89 Scope item 1). GENERATED by
* layout/adc-top/parasitics/gen_extracted_power_tb.py -- do not edit.
*
* Reuses sim/adc-power/testbench/tb.json UNMODIFIED (via
* `run_corners.py --netlist ... --netlist-provenance extracted`): the
* five-level staircase, the per-block `meas tran ... AVG i(...)`
* expressions and the < 1 mW p_total_* checks are byte-for-byte the
* schematic deck's own, tagged `se_*` to match. The ONLY thing that
* differs is the analog core: one extracted ADC_TOP instance in place
* of two adc_cdac_side + two adc_tp_sw instances. Comparator and
* rung-1 controller stay schematic-level (Scope item 0).
*
* PER-BLOCK ATTRIBUTION POST-LAYOUT, STATED PLAINLY. The drawn layout
* has ONE supply rail: the extracted .SUBCKT ADC_TOP exposes a single
* `vdd` pin, and its parasitic network is a single pin stub with every
* device on the pin node -- there is no internal vdd segmentation to
* tap, and instrumenting inside the extracted subckt would mean
* editing extraction output. So the schematic deck's FIVE-way split
* becomes a FOUR-way split here:
*
*   vddc   comparator          unchanged (schematic-level block)
*   vddd   CDAC + top-plate    MERGED. The extracted core's single vdd
*          V_cm switch         pin is wired here, so this rail carries
*                              BOTH the bottom-plate four-leg T-gate
*                              drivers AND DR-0014's top-plate V_cm
*                              switch and its driver.
*   vddt   (empty)             reads EXACTLY 0 by construction --
*                              nothing but its own source is on this
*                              node. p_trk_* is therefore 0 on the
*                              extracted side and its schematic
*                              counterpart must be compared against
*                              p_cdac_extracted, not against 0.
*   vrefs  reference           unchanged (external to the core)
*   vcms   reference           unchanged (external to the core)
*
* p_total_* -- THE SPEC-LINE ROW -- is unaffected by the merge: the
* manifest's expression already sums all five sources, so every
* microamp the schematic deck attributed to vddt is still measured and
* still inside the < 1 mW check. See gen_extracted_power_tb.py's
* module docstring for the full rationale.
*
* WHAT IS NOT MEASURED HERE, unchanged from the schematic deck: the
* rung-1 SAR sequencer and output register are XSPICE event-driven
* primitives on BOTH sides and draw no supply current on either. That
* is a DR-0010 rung-1 property, not a layout one, so it is neither
* closed nor worsened by this run. The dominant digital term -- the
* array's switch-gate drive -- IS measured, on vddd, on both sides.
* ==================================================================

* ---- retained waveforms --------------------------------------------
* ngspice keeps a transient waveform for EVERY node unless told which
* ones matter. The in-path extraction splits every net into one leg
* node per device terminal, so the full store overruns what ngspice
* will allocate and the point dies before measuring anything. These
* are exactly the vectors this deck's manifest reads, derived from it
* rather than hand-listed. Retention only: no model, tolerance or
* timestep changes, and the measurements are bit-identical with and
* without this line. See gen_extracted_core_tb.saved_vectors_lines.
.save i(vcms) i(vddc) i(vddd) i(vddt) i(vrefs) v(vddc)

* ---- ratiometric rails --------------------------------------------
* V_REF = V_DD. README.md note [c] makes V_REF <= V_DD a hard
* condition of the ratified spec, so a fixed 3.3 V reference is not
* legal at the 2.97 V corner; taking V_REF = V_DD keeps the deck legal
* at every point of the supply axis, and every figure below is in LSB
* of whatever full scale that point has.
.param vref={vdd_val}
.param vcm={vdd_val/2}
.param vth={vdd_val/2}
.param lsb={vdd_val/1024}

* ---- clocks --------------------------------------------------------
* DR-0003: one external clock pin at 16 x f_s. The comparator strobe
* is the same clock shifted half a bit cycle, so the CDAC settles in
* the first 31.25 ns and the comparator decides in the second -- the
* split spec/prior-art-survey.md Sec 1.4 allocates and
* sim/comparator-regeneration/ measured 863 ps of worst-case decision
* delay against.
vclk clk 0 pulse(0 {vdd_val} 0 100p 100p 31.25n 62.5n)
vcmpclk cmpclk 0 pulse(0 {vdd_val} 31.25n 100p 100p 31.25n 62.5n)
vcmpclkb cmpclkb 0 pulse({vdd_val} 0 31.25n 100p 100p 31.25n 62.5n)

* ---- supplies, split per block so power is attributable -----------
vddt vddt 0 dc {vdd_val}
vddd vddd 0 dc {vdd_val}
vddc vddc 0 dc {vdd_val}

* ---- reference network, DR-0002 -----------------------------------
* DR-0002 specifies an EXTERNAL V_REF pin with an effective source
* impedance <= 240 ohm IN THE SWITCHING BAND and >= 40 nF of external
* decoupling. Both halves of that sentence are modelled: the inductor
* in parallel with the 240 ohm makes the network 240 ohm at the
* switching band and DC-accurate below it, which is what an external
* reference buffer behind a decoupling capacitor actually is. A bare
* 240 ohm series resistor would instead assert a DC offset DR-0002
* never specified -- and, with 40 nF, a 9.6 us settling tail that
* would dominate any run shorter than ~50 us.
vrefs vrefs 0 dc {vref}
rref vrefs vrefn 240
lref vrefs vrefn 2.3873u
cref vrefn 0 40n
* V_cm generation is explicitly unbudgeted work (DR-0011
* Consequences: 'a new, currently-unbudgeted deliverable for a future
* issue'), so there is no ratified envelope to model it against and it
* is an IDEAL source here. That is a stated assumption of every record
* this deck produces, not a measured result -- see the known-
* limitations section of spec/testbench-suite-memo.md.
vcms vcmn 0 dc {vcm}

* ---- input: staircase over the code range -------------------------
* Identical to gen_adc_top.power_netlist() -- same PWR_LEVELS, same
* PWR_CONV_PER_LEVEL/PWR_WARMUP_CONV schedule, same tag. Switching
* energy in an MCS array is code-dependent, so both decks convert at
* five input levels rather than reporting one point of a curve.
vseinp se_vinp 0 pwl(
+ 0 0 4990.0n 0 5000.0n {0.25*vref} 7990.0n {0.25*vref} 8000.0n {0.5*vref} 10990.0n {0.5*vref} 11000.0n {0.75*vref} 13990.0n {0.75*vref} 14000.0n {1.0*vref} 17000.0n {1.0*vref})
vsevinn se_vinn 0 dc {vcm}

* ---- library: comparator + SAR controller + extracted core -------
* --- COMPARATOR-NETLIST-BEGIN (verbatim-copied into every testbench) ---
.subckt preamp vinp vinn ibias pop pon vdd vss
* 1:1 NMOS current mirror; ibias is forced into the diode branch.
Xmb  ibias ibias vss vss nfet_03v3 w=20u l=2u
Xmt  ptail ibias vss vss nfet_03v3 w=20u l=2u
* Input pair. The device whose gate is vinp drives the INVERTING node
* pon, so v(pop) - v(pon) = +A_v * (v(vinp) - v(vinn)).
Xmip pon vinp ptail vss nfet_03v3 w=40u l=1u
Xmin pop vinn ptail vss nfet_03v3 w=40u l=1u
* Unsalicided 1 kohm/sq p+ poly loads, 150 squares = 150 kohm nominal.
* Third terminal is the substrate/body contact. `ppolyf_u_1k`, not the
* 2 kohm/sq `ppolyf_u_2k` an earlier revision assumed: issue #118 drew
* SAB(49/0)+RES_MK(110/5)+Resistor(62/0) markers over the load-resistor
* bodies so `klt extract`'s gf180mcu deck recognises them as real devices
* instead of a Poly2 short, and at this repo's pinned klt commit that
* marker geometry can only select `ppolyf_u_1k` (1000 ohm/sq) -- the
* `_2k`/`_3k` flavours share the identical drawn geometry and are chosen by
* a build-time deck option this curated deck does not implement
* (`2AMLogic/klayout-tools#595`, open). `r_length` is doubled (75u -> 150u)
* at the same `r_width=1u` to preserve the 150 kohm target at the new
* sheet-rho -- see layout/adc-top/README.md "Resistors".
Xrlp vdd pop vss ppolyf_u_1k r_width=1u r_length=150u
Xrln vdd pon vss ppolyf_u_1k r_width=1u r_length=150u
.ends preamp

.subckt sarlatch inp inn clk outp outn vdd vss
* clk low  -> tail off; outp/outn/dip/din precharged to vdd
* clk high -> tail on; the input pair discharges dip/din at rates set by
*             v(inp)/v(inn), then the cross-coupled pairs regenerate.
Xmlt ltail clk   vss   vss nfet_03v3 w=16u l=0.35u
Xmlp dip   inp   ltail vss nfet_03v3 w=8u  l=0.5u
Xmln din   inn   ltail vss nfet_03v3 w=8u  l=0.5u
Xmnp outn  outp  dip   vss nfet_03v3 w=6u  l=0.35u
Xmnn outp  outn  din   vss nfet_03v3 w=6u  l=0.35u
Xmpp outn  outp  vdd   vdd pfet_03v3 w=8u  l=0.35u
Xmpn outp  outn  vdd   vdd pfet_03v3 w=8u  l=0.35u
Xmrp outn  clk   vdd   vdd pfet_03v3 w=4u  l=0.35u
Xmrn outp  clk   vdd   vdd pfet_03v3 w=4u  l=0.35u
Xmrd dip   clk   vdd   vdd pfet_03v3 w=2u  l=0.35u
Xmre din   clk   vdd   vdd pfet_03v3 w=2u  l=0.35u
.ends sarlatch

* Minimum-ish isolation inverter. Deliberately small: it is the only
* thing the regeneration nodes drive, so its gate capacitance is added
* directly to the latch's own output nodes and shows up as regeneration
* time.
.subckt inv a y vdd vss
Xp y a vdd vdd pfet_03v3 w=2u   l=0.35u
Xn y a vss vss nfet_03v3 w=1u   l=0.35u
.ends inv

.subckt nor2 a b y vdd vss
Xp1 ps a vdd vdd pfet_03v3 w=8u l=0.35u
Xp2 y  b ps  vdd pfet_03v3 w=8u l=0.35u
Xn1 y  a vss vss nfet_03v3 w=4u l=0.35u
Xn2 y  b vss vss nfet_03v3 w=4u l=0.35u
.ends nor2

.subckt comparator vinp vinn clk ibias dout doutb vdd vss
Xpre preamp_in1 preamp_in2 ibias pop pon vdd vss preamp
Xlat pop pon clk outp outn vdd vss sarlatch
* THE ISOLATION INVERTERS ARE NOT OPTIONAL -- they fix a measured
* hysteresis defect. Both StrongARM outputs precharge HIGH, so the
* decision arrives as an active-low pulse on exactly one of them, and
* the obvious way to hold it is a NAND SR latch wired straight to
* outp/outn. That circuit was built first and MEASURED: after deciding
* one way it would not flip back until the input reached ~10 mV of the
* opposite polarity -- about 3 LSB of hysteresis, which in a SAR (where
* the same comparator makes ten successive decisions on a shrinking
* residue) is a code-dependent error, not an offset.
*
* The cause is that a NAND SR latch's HELD STATE loads the two
* regeneration nodes asymmetrically. Wired directly, the node driving
* the NAND whose output is LOW sees that output swing when it falls
* (Miller-multiplied C_gd, ~26 fF against a regeneration node of a few
* tens of fF), while its twin drives a NAND whose output is already
* HIGH and stays there. The latch is therefore biased toward keeping
* the answer it already holds.
*
* Interposing one small inverter per side removes the coupling: the
* inverters are identical, both of their inputs precharge to V_DD, and
* neither loading depends on what the SR latch is holding. The SR latch
* becomes NOR-type because the inverters make the decision pulses
* active-HIGH. dout goes HIGH when outn falls, i.e. when
* v(vinp) > v(vinn), exactly as before.
Xis outn sset vdd vss inv
Xir outp srst vdd vss inv
Xno1 srst doutb dout  vdd vss nor2
Xno2 sset dout  doutb vdd vss nor2
* Input pass-through (zero-volt sources) so a testbench can probe the
* current the comparator draws from each CDAC top plate directly.
Vpp preamp_in1 vinp dc 0
Vpn preamp_in2 vinn dc 0
.ends comparator
* --- COMPARATOR-NETLIST-END ---

* ------------------------------------------------------------------
* sar_ctrl.spice -- synchronous SAR control logic, rung-1 abstraction
*
* GENERATED by design/sar-logic/gen_sar_logic.py -- do not edit.
*
* Ideal XSPICE event-driven digital primitives (digital.cm: d_dff,
* d_and, d_or, d_inverter) plus adc_bridge/dac_bridge at the analog
* boundary. This is rung 1 of the fidelity ladder in DR-0010: it fixes
* the SEQUENCING and the SWITCH DECODE, and deliberately says nothing
* about gf180mcu gate delay (rung 3 / sim/sar-logic-cell-delay/ owns
* that).
*
* Conversion, M = 16 clocks (DR-0003), with DR-0014's TWO-PHASE
* BOTTOM-PLATE sample laid inside the same 4-clock sample window:
*   ph0..ph2   acquire  samp_tp and samp_bp both asserted: the top
*                       plate is held at Vcm by its own switch and
*                       every bottom plate tracks V_in through the
*                       cell's fourth leg
*   ph2->ph3   THE SAMPLING INSTANT -- samp_tp falls, the top-plate
*                       switch opens and the top node floats
*   ph3        the bottom plates stay on V_in one more clock
*   ph3->ph4   samp_bp falls a full bit cycle after the sampling
*                       instant: the bottom plates leave V_in for Vcm
*                       onto a node that is ALREADY isolated, which
*                       is the whole reason bottom-plate sampling is
*                       worth a fourth leg (DR-0014, README note [d])
*   ph4        trial 1  free MSB -- no array switching at all, the
*                       comparator decides the sign of the sampled
*                       residue (DR-0014 keeps DR-0011's free MSB)
*   ph5..ph13  trials 2..10, weights 256,128,...,1 engaged in turn
*   ph14       output register loads the 10 decisions
*   ph15       drdy asserted; array released back to Vcm
*
* Switch decode per weight w and side s -- FOUR one-hot legs per cell
* now, not three -- from the slice's own engage flag `eng`, the
* direction bit `dir` (= the decision of the PREVIOUS trial, which is
* also that trial's output bit) and the shared sample control `smp`:
*   in  = smp                      bottom plate on V_in (DR-0014)
*   rel = !eng & !smp              bottom plate parked at Vcm
*   p-side:  hi = eng &  dir       -> V_REF      lo = eng & !dir -> GND
*   n-side:  hi = eng & !dir       -> V_REF      lo = eng &  dir -> GND
*   n-side is additionally gated by `mode` (1 = differential): in
*   single-ended mode every n-side cell stays released to Vcm for the
*   whole conversion, per DR-0011 -- driving it too would double every
*   step and cost a bit of resolution. The `in` leg is NOT mode-gated:
*   both sides must acquire their own input pin, and DR-0011's mode
*   rule is about bit trials, not about the sample phase.
*   `eng` is zero for the whole sample window, so exactly one of the
*   four legs conducts at every instant -- the invariant
*   sim/sar-logic-functional/ measures directly as sw_conflict_*.
*
* Sign convention, RE-DERIVED FOR DR-0014 and the one place the
* superseded record's decode could not simply be carried forward.
* Sampling on the bottom plate INVERTS the residue with respect to the
* input: after the sample, top_p - top_n = -k*(V_inp - V_inn). The
* comparator is wired conventionally (cmp = 1 when top_p > top_n), so
* the controller inverts it ONCE at its own boundary --
*
*     dec = !cmp    = 1 when the sampled input is ABOVE the DAC's
*                     current estimate, i.e. 'add this weight'
*
* -- and `dir` therefore still holds the OUTPUT BIT of its position,
* exactly as under DR-0011, at the cost of the hi/lo assignment above
* being the mirror of DR-0011's. Inverting only one of the two would
* either diverge (right code polarity, wrong feedback direction) or
* emit the one's complement of the code (right feedback, wrong bits);
* both were checked against the closed loop before this form was
* chosen, and sim/sar-logic-functional/ falsifies either error on
* every one of the 1024 codes in both modes.
* ------------------------------------------------------------------

* --- ideal digital primitives -------------------------------------
.model sarl_dff d_dff(clk_delay=0.5n set_delay=0.5n
+ reset_delay=0.5n ic=0 rise_delay=0.5n fall_delay=0.5n)
.model sarl_dff1 d_dff(clk_delay=0.5n set_delay=0.5n
+ reset_delay=0.5n ic=1 rise_delay=0.5n fall_delay=0.5n)
.model sarl_and d_and(rise_delay=0.2n fall_delay=0.2n input_load=0)
.model sarl_or d_or(rise_delay=0.2n fall_delay=0.2n input_load=0)
.model sarl_inv d_inverter(rise_delay=0.2n fall_delay=0.2n
+ input_load=0)

* --- enabled bit register -----------------------------------------
* Captures `d` on the clock edge that ENDS the phase in which `en` is
* asserted, and holds otherwise. Written as an explicit D-mux rather
* than a gated clock: gating the clock with a phase signal that itself
* changes one gate delay after the clock edge creates a spurious
* rising edge on the gated clock, which is a real bug in a real
* implementation, not just in this model.
.subckt sar_bitreg clk d en q qb
a_inv en enb sarl_inv
a_sel [en d] dsel sarl_and
a_hold [enb q] dhold sarl_and
a_mux [dsel dhold] dnext sarl_or
a_ff dnext clk NULL NULL q qb sarl_dff
.ends sar_bitreg

* --- one bit slice: engage flag + direction bit + switch decode -----
* `arm`     one-hot phase pulse of the trial BEFORE this slice's own
*           trial: the slice engages on the edge entering its trial,
*           and the direction bit captures the decision made during
*           `arm` (which is also this bit position's output bit).
* `endconv` forces the engage flag low on the edge leaving the last
*           trial, releasing the whole array back to Vcm for the next
*           sample phase.
* `dec`     the comparator decision in OUTPUT-BIT polarity (= !cmp;
*           see the sign-convention note in the header).
* `smpb`    the inverse of the shared bottom-plate sample control,
*           distributed already-inverted so that all four legs of the
*           cell come out at the SAME logic depth. That is not
*           cosmetic: `rel` and the V_in leg are complementary during
*           the sample window, so a one-gate depth difference between
*           them opens a window in which a cell drives V_in and Vcm at
*           once -- which is exactly what the one-hot invariant is
*           there to catch, and it would catch this generator.
.subckt sar_slice clk dec mode arm endconv smpb dir dirb
+ rel_p hi_p lo_p rel_n hi_n lo_n
a_set [arm eng] eng_set sarl_or
a_ninv endconv nend sarl_inv
a_keep [eng_set nend] eng_d sarl_and
a_ff eng_d clk NULL NULL eng engb sarl_dff
xdir clk dec arm dir dirb sar_bitreg
* p side: always driven
a_relp [engb smpb] rel_p sarl_and
a_hip [eng dir] hi_p sarl_and
a_lop [eng dirb] lo_p sarl_and
* n side: driven only in differential mode (DR-0011). `engnb` is built
* as !eng | !mode rather than as an inverter on `engn`, so that it
* lands at the same depth as `engn` and rel_n/hi_n/lo_n switch
* together -- the same delay-balance argument as `smpb` above.
a_engn [eng mode] engn sarl_and
a_modeb mode modeb sarl_inv
a_engnb [engb modeb] engnb sarl_or
a_reln [engnb smpb] rel_n sarl_and
a_hin [engn dirb] hi_n sarl_and
a_lon [engn dir] lo_n sarl_and
.ends sar_slice

* --- 16-phase one-hot sequencer ------------------------------------
* A one-hot ring, seeded by ph15's ic=1 so the very first clock edge
* enters ph0 (sample) with exactly one token in the ring. `start`
* forces a synchronous restart: it sets stage 0 and clears every other
* stage on the same edge, so an asserted `start` cannot inject a
* SECOND token alongside the circulating one.
.subckt sar_seq clk start ph0 ph1 ph2 ph3 ph4 ph5 ph6 ph7 ph8 ph9 ph10 ph11 ph12 ph13 ph14 ph15
a_nstart start nstart sarl_inv
a_d0 [ph15 start] d0 sarl_or
a_ff0 d0 clk NULL NULL ph0 ph0b sarl_dff
a_d1 [ph0 nstart] d1 sarl_and
a_ff1 d1 clk NULL NULL ph1 ph1b sarl_dff
a_d2 [ph1 nstart] d2 sarl_and
a_ff2 d2 clk NULL NULL ph2 ph2b sarl_dff
a_d3 [ph2 nstart] d3 sarl_and
a_ff3 d3 clk NULL NULL ph3 ph3b sarl_dff
a_d4 [ph3 nstart] d4 sarl_and
a_ff4 d4 clk NULL NULL ph4 ph4b sarl_dff
a_d5 [ph4 nstart] d5 sarl_and
a_ff5 d5 clk NULL NULL ph5 ph5b sarl_dff
a_d6 [ph5 nstart] d6 sarl_and
a_ff6 d6 clk NULL NULL ph6 ph6b sarl_dff
a_d7 [ph6 nstart] d7 sarl_and
a_ff7 d7 clk NULL NULL ph7 ph7b sarl_dff
a_d8 [ph7 nstart] d8 sarl_and
a_ff8 d8 clk NULL NULL ph8 ph8b sarl_dff
a_d9 [ph8 nstart] d9 sarl_and
a_ff9 d9 clk NULL NULL ph9 ph9b sarl_dff
a_d10 [ph9 nstart] d10 sarl_and
a_ff10 d10 clk NULL NULL ph10 ph10b sarl_dff
a_d11 [ph10 nstart] d11 sarl_and
a_ff11 d11 clk NULL NULL ph11 ph11b sarl_dff
a_d12 [ph11 nstart] d12 sarl_and
a_ff12 d12 clk NULL NULL ph12 ph12b sarl_dff
a_d13 [ph12 nstart] d13 sarl_and
a_ff13 d13 clk NULL NULL ph13 ph13b sarl_dff
a_d14 [ph13 nstart] d14 sarl_and
a_ff14 d14 clk NULL NULL ph14 ph14b sarl_dff
a_d15 [ph14 nstart] d15 sarl_and
a_ff15 d15 clk NULL NULL ph15 ph15b sarl_dff1
.ends sar_seq

* --- digital top ----------------------------------------------------
.subckt sar_ctrl clk start mode cmp samp_tp samp_bp drdy b9 b8 b7 b6 b5 b4
+ b3 b2 b1 b0 rel_256p hi_256p lo_256p rel_128p hi_128p lo_128p rel_64p
+ hi_64p lo_64p rel_32p hi_32p lo_32p rel_16p hi_16p lo_16p rel_8p hi_8p
+ lo_8p rel_4p hi_4p lo_4p rel_2p hi_2p lo_2p rel_1p hi_1p lo_1p rel_256n
+ hi_256n lo_256n rel_128n hi_128n lo_128n rel_64n hi_64n lo_64n rel_32n
+ hi_32n lo_32n rel_16n hi_16n lo_16n rel_8n hi_8n lo_8n rel_4n hi_4n
+ lo_4n rel_2n hi_2n lo_2n rel_1n hi_1n lo_1n
xseq clk start ph0 ph1 ph2 ph3 ph4 ph5 ph6 ph7 ph8 ph9 ph10 ph11 ph12 ph13 ph14 ph15 sar_seq
* ---- DR-0014's two-phase sample ----------------------------------
* `samp_tp` closes the top-plate switch for ph0..ph2 and opens it on
* the edge into ph3: THAT edge is the sampling instant. `samp_bp`
* keeps every bottom plate on V_in for the whole 4-clock window, so
* the input legs turn off one full clock LATER, onto a top node that
* is already floating. Both are one-hot phase ORs off the same ring:
* one external clock, rising edges only (DR-0008), no gated or
* inverted clock anywhere in the sample path.
* `samp_bp` is emitted through smpb -> inverter rather than straight
* off the OR so that it lands at the SAME logic depth as each cell's
* `rel`, which is AND(engb, smpb). Those two legs are complementary
* across the sample boundary, so a one-gate depth difference would
* leave every cell driving V_in and V_cm together for 0.2 ns.
a_samp4 [ph0 ph1 ph2 ph3] samp4 sarl_or
a_samptp [ph0 ph1 ph2] samp_tp sarl_or
a_smpb samp4 smpb sarl_inv
a_sampbp smpb samp_bp sarl_inv
* The comparator decision, inverted once here into output-bit
* polarity: bottom-plate sampling inverts the residue with respect to
* the input (DR-0014). See the header's sign-convention note.
a_dec cmp dec sarl_inv
a_drdy ph15 drdy_n sarl_inv
a_drdy2 drdy_n drdy sarl_inv
xs256 clk dec mode ph4 ph13 smpb q9 q9b rel_256p hi_256p lo_256p rel_256n hi_256n lo_256n sar_slice
xs128 clk dec mode ph5 ph13 smpb q8 q8b rel_128p hi_128p lo_128p rel_128n hi_128n lo_128n sar_slice
xs64 clk dec mode ph6 ph13 smpb q7 q7b rel_64p hi_64p lo_64p rel_64n hi_64n lo_64n sar_slice
xs32 clk dec mode ph7 ph13 smpb q6 q6b rel_32p hi_32p lo_32p rel_32n hi_32n lo_32n sar_slice
xs16 clk dec mode ph8 ph13 smpb q5 q5b rel_16p hi_16p lo_16p rel_16n hi_16n lo_16n sar_slice
xs8 clk dec mode ph9 ph13 smpb q4 q4b rel_8p hi_8p lo_8p rel_8n hi_8n lo_8n sar_slice
xs4 clk dec mode ph10 ph13 smpb q3 q3b rel_4p hi_4p lo_4p rel_4n hi_4n lo_4n sar_slice
xs2 clk dec mode ph11 ph13 smpb q2 q2b rel_2p hi_2p lo_2p rel_2n hi_2n lo_2n sar_slice
xs1 clk dec mode ph12 ph13 smpb q1 q1b rel_1p hi_1p lo_1p rel_1n hi_1n lo_1n sar_slice
xb0 clk dec ph13 q0 q0b sar_bitreg
* 10-bit parallel output register (DR-0005: in scope, SPI deferred)
xo9 clk q9 ph14 b9 b9b sar_bitreg
xo8 clk q8 ph14 b8 b8b sar_bitreg
xo7 clk q7 ph14 b7 b7b sar_bitreg
xo6 clk q6 ph14 b6 b6b sar_bitreg
xo5 clk q5 ph14 b5 b5b sar_bitreg
xo4 clk q4 ph14 b4 b4b sar_bitreg
xo3 clk q3 ph14 b3 b3b sar_bitreg
xo2 clk q2 ph14 b2 b2b sar_bitreg
xo1 clk q1 ph14 b1 b1b sar_bitreg
xo0 clk q0 ph14 b0 b0b sar_bitreg
.ends sar_ctrl

* --- analog-boundary wrapper ----------------------------------------
* Presents the controller at the analog boundary with the port names
* design/cdac/cdac_array.sch uses, so the two connect directly. Only
* the NMOS-gate (active-high) half of each T-gate leg is routed out of
* the controller; `sar_tgate_drv` below makes the PMOS gate locally at
* the cell. Bridges are VECTOR instances on purpose: 54 scalar
* dac_bridges would put 54 separate sources in the analog matrix.
* DR-0014's two additions ride on the SCALAR bridge group with drdy
* and the code bits, not on the 54-wide array bus: `sel_in_n` is one
* broadcast net feeding every cell's fourth leg and `samp_tp_n` is the
* per-side top-plate switch, so the array control bus grows from 54 to
* 55 wires, not to 72.
.subckt sar_ctrl_a clk start mode cmp samp_tp_n sel_in_n drdy c9 c8 c7 c6
+ c5 c4 c3 c2 c1 c0 rel_n_256p sel_hi_n_256p sel_lo_n_256p rel_n_128p
+ sel_hi_n_128p sel_lo_n_128p rel_n_64p sel_hi_n_64p sel_lo_n_64p
+ rel_n_32p sel_hi_n_32p sel_lo_n_32p rel_n_16p sel_hi_n_16p sel_lo_n_16p
+ rel_n_8p sel_hi_n_8p sel_lo_n_8p rel_n_4p sel_hi_n_4p sel_lo_n_4p
+ rel_n_2p sel_hi_n_2p sel_lo_n_2p rel_n_1p sel_hi_n_1p sel_lo_n_1p
+ rel_n_256n sel_hi_n_256n sel_lo_n_256n rel_n_128n sel_hi_n_128n
+ sel_lo_n_128n rel_n_64n sel_hi_n_64n sel_lo_n_64n rel_n_32n sel_hi_n_32n
+ sel_lo_n_32n rel_n_16n sel_hi_n_16n sel_lo_n_16n rel_n_8n sel_hi_n_8n
+ sel_lo_n_8n rel_n_4n sel_hi_n_4n sel_lo_n_4n rel_n_2n sel_hi_n_2n
+ sel_lo_n_2n rel_n_1n sel_hi_n_1n sel_lo_n_1n
a_in [clk start mode cmp] [dclk dstart dmode dcmp] sarl_adc
xctrl dclk dstart dmode dcmp dsamp_tp dsamp_bp ddrdy db9 db8 db7 db6 db5
+ db4 db3 db2 db1 db0 drel_256p dhi_256p dlo_256p drel_128p dhi_128p
+ dlo_128p drel_64p dhi_64p dlo_64p drel_32p dhi_32p dlo_32p drel_16p
+ dhi_16p dlo_16p drel_8p dhi_8p dlo_8p drel_4p dhi_4p dlo_4p drel_2p
+ dhi_2p dlo_2p drel_1p dhi_1p dlo_1p drel_256n dhi_256n dlo_256n
+ drel_128n dhi_128n dlo_128n drel_64n dhi_64n dlo_64n drel_32n dhi_32n
+ dlo_32n drel_16n dhi_16n dlo_16n drel_8n dhi_8n dlo_8n drel_4n dhi_4n
+ dlo_4n drel_2n dhi_2n dlo_2n drel_1n dhi_1n dlo_1n sar_ctrl
a_dout [dsamp_tp dsamp_bp ddrdy db9 db8 db7 db6 db5 db4 db3 db2 db1 db0]
+ [samp_tp_n sel_in_n drdy c9 c8 c7 c6 c5 c4 c3 c2 c1 c0] sarl_dac
a_gn [drel_256p dhi_256p dlo_256p drel_128p dhi_128p dlo_128p drel_64p dhi_64p dlo_64p drel_32p dhi_32p dlo_32p drel_16p dhi_16p dlo_16p drel_8p dhi_8p dlo_8p drel_4p dhi_4p dlo_4p drel_2p dhi_2p dlo_2p drel_1p dhi_1p dlo_1p drel_256n dhi_256n dlo_256n drel_128n dhi_128n dlo_128n drel_64n dhi_64n dlo_64n drel_32n dhi_32n dlo_32n drel_16n dhi_16n dlo_16n drel_8n dhi_8n dlo_8n drel_4n dhi_4n dlo_4n drel_2n dhi_2n dlo_2n drel_1n dhi_1n dlo_1n]
+ [rel_n_256p sel_hi_n_256p sel_lo_n_256p rel_n_128p sel_hi_n_128p sel_lo_n_128p rel_n_64p sel_hi_n_64p sel_lo_n_64p rel_n_32p sel_hi_n_32p sel_lo_n_32p rel_n_16p sel_hi_n_16p sel_lo_n_16p rel_n_8p sel_hi_n_8p sel_lo_n_8p rel_n_4p sel_hi_n_4p sel_lo_n_4p rel_n_2p sel_hi_n_2p sel_lo_n_2p rel_n_1p sel_hi_n_1p sel_lo_n_1p rel_n_256n sel_hi_n_256n sel_lo_n_256n rel_n_128n sel_hi_n_128n sel_lo_n_128n rel_n_64n sel_hi_n_64n sel_lo_n_64n rel_n_32n sel_hi_n_32n sel_lo_n_32n rel_n_16n sel_hi_n_16n sel_lo_n_16n rel_n_8n sel_hi_n_8n sel_lo_n_8n rel_n_4n sel_hi_n_4n sel_lo_n_4n rel_n_2n sel_hi_n_2n sel_lo_n_2n rel_n_1n sel_hi_n_1n sel_lo_n_1n] sarl_dac
.ends sar_ctrl_a

* --- local T-gate driver -------------------------------------------
* One per T-gate leg, placed with the CDAC cell (#15/#16), not with
* the controller: `gn` is the controller's active-high control and
* `gp` the complementary PMOS gate. Modelled as an ideal inverter at
* rung 1; at rung 3 it is one standard-cell inverter.
.subckt sar_tgate_drv gn gp
a_adc gn dgn sarl_adc
a_inv dgn dgp sarl_inv
a_dac dgp gp sarl_dac
.ends sar_tgate_drv

* Bridge models. Thresholds and rails track the PVT point's supply, so
* the supply axis of the corner grid actually moves something in this
* otherwise PVT-invariant model.
.model sarl_adc adc_bridge(in_low={vdd_val*0.4} in_high={vdd_val*0.6})
.model sarl_dac dac_bridge(out_low=0 out_high={vdd_val}
+ out_undef={vdd_val/2} t_rise=0.3n t_fall=0.3n)

* REMEDIATED extracted core -- NOT raw `klt extract` output.
* Produced by layout/adc-top/parasitics/remediate_extracted.py:
*   - body-tie step NOT APPLIED: all 148 PMOS body terminals already
*     extract on `vdd` because DR-0035 draws an n+ tap in every Nwell and routes
*     it there, closing the klayout-tools#555 body gap in the LAYOUT. Asserted,
*     not assumed -- see _assert_no_unreachable_bodies() (issue #381).
*   - input rails pinp/pinn promoted to pins vinp/vinn (sampled-input port gap).
*   - 1024 MiM caps left as native PDK 'cap_mim_2f0_m4m5_noshield' subckt calls.
* See remediate_extracted.py's module docstring for provenance.
* parasitic model (--parasitics):
* - capacitance: net-to-ground for every net's own (non-coupled) area/perimeter, plus net-to-net for the vertical-overlap coupling `coupling` describes below -- a coupled net pair gets a direct capacitor between their two hub nodes, not just capacitors to the deck's ground/substrate net
* - coupling: vertical overlap (crossover) unconditionally -- where one net's conductor on an adjacent metal level sits directly over another *distinct* net's conductor, that overlap area is charged between the two nets instead of to ground (issue #760) -- plus lateral (same-layer, sidewall) coupling, but only for a net pair naming one of the caller's declared `--critical-net` nets (issue #976): facing-edge length within that layer's own minimum-spacing lookback is charged between the two nets, *additively* (not deducted from either net's substrate fringe term, unlike the vertical case -- a known simplification). Any same-layer pair with neither side named `--critical-net`, and fringe shielding in general, are still not modelled
* - resistance: single lumped series resistance per net, distributed as a star across that net's device terminals (issue #592) -- not a per-segment, distributed RC ladder, *unless* `--distributed-rc` names this net via `--critical-net` (issue #977, Epic #709 Phase 2b): then the net's terminals are ordered along their approximate physical spread and its total R/C is broken into a chain of per-segment resistors (segment length proportional to inter-terminal distance) with a ground capacitor at each terminal node (proportional to its adjacent segment length/2), instead of one star hub -- still an approximation (terminal position is a device-placement proxy, not true per-segment routing geometry), but a strictly finer-grained one than the single-hub star
* - frequency: quasi-static -- one frequency-independent R and C per net; no skin effect, no distributed transmission-line behavior
* cell ADC_TOP
* pin hi_128_n
* pin hi_128_p
* pin hi_16_n
* pin hi_16_p
* pin hi_1_n
* pin hi_1_p
* pin hi_256_n
* pin hi_256_p
* pin hi_2_n
* pin hi_2_p
* pin hi_32_n
* pin hi_32_p
* pin hi_4_n
* pin hi_4_p
* pin hi_64_n
* pin hi_64_p
* pin hi_8_n
* pin hi_8_p
* pin lo_128_n
* pin lo_128_p
* pin lo_16_n
* pin lo_16_p
* pin lo_1_n
* pin lo_1_p
* pin lo_256_n
* pin lo_256_p
* pin lo_2_n
* pin lo_2_p
* pin lo_32_n
* pin lo_32_p
* pin lo_4_n
* pin lo_4_p
* pin lo_64_n
* pin lo_64_p
* pin lo_8_n
* pin lo_8_p
* pin pinn
* pin pinp
* pin rel_128_n
* pin rel_128_p
* pin rel_16_n
* pin rel_16_p
* pin rel_1_n
* pin rel_1_p
* pin rel_256_n
* pin rel_256_p
* pin rel_2_n
* pin rel_2_p
* pin rel_32_n
* pin rel_32_p
* pin rel_4_n
* pin rel_4_p
* pin rel_64_n
* pin rel_64_p
* pin rel_8_n
* pin rel_8_p
* pin sel_in
* pin topn
* pin topp
* pin tp_gn
* pin vcm
* pin vdd
* pin vref
* pin vss
.SUBCKT ADC_TOP hi_128_n hi_128_p hi_16_n hi_16_p hi_1_n hi_1_p hi_256_n hi_256_p hi_2_n hi_2_p hi_32_n hi_32_p hi_4_n hi_4_p hi_64_n hi_64_p hi_8_n hi_8_p lo_128_n lo_128_p lo_16_n lo_16_p lo_1_n lo_1_p lo_256_n lo_256_p lo_2_n lo_2_p lo_32_n lo_32_p lo_4_n lo_4_p lo_64_n lo_64_p lo_8_n lo_8_p rel_128_n rel_128_p rel_16_n rel_16_p rel_1_n rel_1_p rel_256_n rel_256_p rel_2_n rel_2_p rel_32_n rel_32_p rel_4_n rel_4_p rel_64_n rel_64_p rel_8_n rel_8_p sel_in topn topp tp_gn vcm vdd vref vss vinp vinn
* device instance $1 r0 *1 1.275,2 nfet
X$1 \$5__t0 sel_in__t0 vss__t0 vss__t110 nfet_03v3 L=0.35U W=4U AS=4.4P AD=4.4P PS=10.2U PD=10.2U
* device instance $2 r0 *1 4.225,2 nfet
X$2 \$7__t2 rel_256_p__t2 vss__t46 vss__t111 nfet_03v3 L=0.35U W=4U AS=4.4P AD=4.4P PS=10.2U PD=10.2U
* device instance $3 r0 *1 7.175,2 nfet
X$3 \$9__t2 hi_256_p__t2 vss__t45 vss__t112 nfet_03v3 L=0.35U W=4U AS=4.4P AD=4.4P PS=10.2U PD=10.2U
* device instance $4 r0 *1 10.125,2 nfet
X$4 \$11__t2 lo_256_p__t2 vss__t44 vss__t113 nfet_03v3 L=0.35U W=4U AS=4.4P AD=4.4P PS=10.2U PD=10.2U
* device instance $5 r0 *1 13.04,5 nfet
X$5 vinp__t0 sel_in__t1 \$12__t0 vss__t184 nfet_03v3 L=0.28U W=10U AS=11P AD=11P PS=22.2U PD=22.2U
* device instance $6 r0 *1 15.92,5 nfet
X$6 vcm__t27 rel_256_p__t1 \$12__t262 vss__t185 nfet_03v3 L=0.28U W=10U AS=11P AD=11P PS=22.2U PD=22.2U
* device instance $7 r0 *1 18.8,5 nfet
X$7 vref__t21 hi_256_p__t1 \$12__t261 vss__t186 nfet_03v3 L=0.28U W=10U AS=11P AD=11P PS=22.2U PD=22.2U
* device instance $8 r0 *1 21.68,5 nfet
X$8 vss__t24 lo_256_p__t1 \$12__t263 vss__t187 nfet_03v3 L=0.28U W=10U AS=11P AD=11P PS=22.2U PD=22.2U
* device instance $9 r0 *1 49.715,2 nfet
X$9 \$17__t2 sel_in__t50 vss__t94 vss__t114 nfet_03v3 L=0.35U W=4U AS=4.4P AD=4.4P PS=10.2U PD=10.2U
* device instance $10 r0 *1 52.665,2 nfet
X$10 \$19__t2 rel_128_p__t2 vss__t109 vss__t115 nfet_03v3 L=0.35U W=4U AS=4.4P AD=4.4P PS=10.2U PD=10.2U
* device instance $11 r0 *1 55.615,2 nfet
X$11 \$21__t2 hi_128_p__t2 vss__t96 vss__t116 nfet_03v3 L=0.35U W=4U AS=4.4P AD=4.4P PS=10.2U PD=10.2U
* device instance $12 r0 *1 58.565,2 nfet
X$12 \$23__t2 lo_128_p__t2 vss__t99 vss__t117 nfet_03v3 L=0.35U W=4U AS=4.4P AD=4.4P PS=10.2U PD=10.2U
* device instance $13 r0 *1 61.48,5 nfet
X$13 vinp__t12 sel_in__t25 \$24__t132 vss__t188 nfet_03v3 L=0.28U W=10U AS=11P AD=11P PS=22.2U PD=22.2U
* device instance $14 r0 *1 64.36,5 nfet
X$14 vcm__t30 rel_128_p__t1 \$24__t133 vss__t189 nfet_03v3 L=0.28U W=10U AS=11P AD=11P PS=22.2U PD=22.2U
* device instance $15 r0 *1 67.24,5 nfet
X$15 vref__t23 hi_128_p__t1 \$24__t134 vss__t190 nfet_03v3 L=0.28U W=10U AS=11P AD=11P PS=22.2U PD=22.2U
* device instance $16 r0 *1 70.12,5 nfet
X$16 vss__t25 lo_128_p__t1 \$24__t135 vss__t191 nfet_03v3 L=0.28U W=10U AS=11P AD=11P PS=22.2U PD=22.2U
* device instance $17 r0 *1 98.155,2 nfet
X$17 \$25__t2 sel_in__t52 vss__t102 vss__t118 nfet_03v3 L=0.35U W=4U AS=4.4P AD=4.4P PS=10.2U PD=10.2U
* device instance $18 r0 *1 101.105,2 nfet
X$18 \$27__t2 rel_64_p__t2 vss__t103 vss__t119 nfet_03v3 L=0.35U W=4U AS=4.4P AD=4.4P PS=10.2U PD=10.2U
* device instance $19 r0 *1 104.055,2 nfet
X$19 \$29__t2 hi_64_p__t2 vss__t104 vss__t120 nfet_03v3 L=0.35U W=4U AS=4.4P AD=4.4P PS=10.2U PD=10.2U
* device instance $20 r0 *1 107.005,2 nfet
X$20 \$31__t2 lo_64_p__t2 vss__t105 vss__t121 nfet_03v3 L=0.35U W=4U AS=4.4P AD=4.4P PS=10.2U PD=10.2U
* device instance $21 r0 *1 109.92,5 nfet
X$21 vinp__t13 sel_in__t26 \$32__t68 vss__t192 nfet_03v3 L=0.28U W=10U AS=11P AD=11P PS=22.2U PD=22.2U
* device instance $22 r0 *1 112.8,5 nfet
X$22 vcm__t31 rel_64_p__t1 \$32__t69 vss__t193 nfet_03v3 L=0.28U W=10U AS=11P AD=11P PS=22.2U PD=22.2U
* device instance $23 r0 *1 115.68,5 nfet
X$23 vref__t32 hi_64_p__t1 \$32__t71 vss__t194 nfet_03v3 L=0.28U W=10U AS=11P AD=11P PS=22.2U PD=22.2U
* device instance $24 r0 *1 118.56,5 nfet
X$24 vss__t29 lo_64_p__t1 \$32__t70 vss__t195 nfet_03v3 L=0.28U W=10U AS=11P AD=11P PS=22.2U PD=22.2U
* device instance $25 r0 *1 146.595,2 nfet
X$25 \$33__t2 sel_in__t46 vss__t76 vss__t122 nfet_03v3 L=0.35U W=4U AS=4.4P AD=4.4P PS=10.2U PD=10.2U
* device instance $26 r0 *1 149.545,2 nfet
X$26 \$35__t2 rel_32_p__t2 vss__t75 vss__t123 nfet_03v3 L=0.35U W=4U AS=4.4P AD=4.4P PS=10.2U PD=10.2U
* device instance $27 r0 *1 152.495,2 nfet
X$27 \$37__t2 hi_32_p__t2 vss__t65 vss__t124 nfet_03v3 L=0.35U W=4U AS=4.4P AD=4.4P PS=10.2U PD=10.2U
* device instance $28 r0 *1 155.445,2 nfet
X$28 \$39__t2 lo_32_p__t2 vss__t70 vss__t125 nfet_03v3 L=0.35U W=4U AS=4.4P AD=4.4P PS=10.2U PD=10.2U
* device instance $29 r0 *1 158.36,5 nfet
X$29 vinp__t16 sel_in__t31 \$40__t37 vss__t196 nfet_03v3 L=0.28U W=10U AS=11P AD=11P PS=22.2U PD=22.2U
* device instance $30 r0 *1 161.24,5 nfet
X$30 vcm__t35 rel_32_p__t1 \$40__t38 vss__t197 nfet_03v3 L=0.28U W=10U AS=11P AD=11P PS=22.2U PD=22.2U
* device instance $31 r0 *1 164.12,5 nfet
X$31 vref__t30 hi_32_p__t1 \$40__t39 vss__t198 nfet_03v3 L=0.28U W=10U AS=11P AD=11P PS=22.2U PD=22.2U
* device instance $32 r0 *1 167,5 nfet
X$32 vss__t28 lo_32_p__t1 \$40__t36 vss__t199 nfet_03v3 L=0.28U W=10U AS=11P AD=11P PS=22.2U PD=22.2U
* device instance $33 r0 *1 195.035,2 nfet
X$33 \$41__t2 sel_in__t45 vss__t71 vss__t126 nfet_03v3 L=0.35U W=4U AS=4.4P AD=4.4P PS=10.2U PD=10.2U
* device instance $34 r0 *1 197.985,2 nfet
X$34 \$43__t2 rel_16_p__t2 vss__t72 vss__t127 nfet_03v3 L=0.35U W=4U AS=4.4P AD=4.4P PS=10.2U PD=10.2U
* device instance $35 r0 *1 200.935,2 nfet
X$35 \$45__t2 hi_16_p__t2 vss__t73 vss__t128 nfet_03v3 L=0.35U W=4U AS=4.4P AD=4.4P PS=10.2U PD=10.2U
* device instance $36 r0 *1 203.885,2 nfet
X$36 \$47__t2 lo_16_p__t2 vss__t74 vss__t129 nfet_03v3 L=0.35U W=4U AS=4.4P AD=4.4P PS=10.2U PD=10.2U
* device instance $37 r0 *1 206.8,5 nfet
X$37 vinp__t17 sel_in__t32 \$48__t23 vss__t200 nfet_03v3 L=0.28U W=10U AS=11P AD=11P PS=22.2U PD=22.2U
* device instance $38 r0 *1 209.68,5 nfet
X$38 vcm__t33 rel_16_p__t1 \$48__t20 vss__t201 nfet_03v3 L=0.28U W=10U AS=11P AD=11P PS=22.2U PD=22.2U
* device instance $39 r0 *1 212.56,5 nfet
X$39 vref__t29 hi_16_p__t1 \$48__t21 vss__t202 nfet_03v3 L=0.28U W=10U AS=11P AD=11P PS=22.2U PD=22.2U
* device instance $40 r0 *1 215.44,5 nfet
X$40 vss__t32 lo_16_p__t1 \$48__t22 vss__t203 nfet_03v3 L=0.28U W=10U AS=11P AD=11P PS=22.2U PD=22.2U
* device instance $41 r0 *1 243.475,2 nfet
X$41 \$49__t2 sel_in__t38 vss__t41 vss__t130 nfet_03v3 L=0.35U W=4U AS=4.4P AD=4.4P PS=10.2U PD=10.2U
* device instance $42 r0 *1 246.425,2 nfet
X$42 \$51__t2 rel_8_p__t2 vss__t67 vss__t131 nfet_03v3 L=0.35U W=4U AS=4.4P AD=4.4P PS=10.2U PD=10.2U
* device instance $43 r0 *1 249.375,2 nfet
X$43 \$53__t2 hi_8_p__t2 vss__t83 vss__t132 nfet_03v3 L=0.35U W=4U AS=4.4P AD=4.4P PS=10.2U PD=10.2U
* device instance $44 r0 *1 252.325,2 nfet
X$44 \$55__t2 lo_8_p__t2 vss__t38 vss__t133 nfet_03v3 L=0.35U W=4U AS=4.4P AD=4.4P PS=10.2U PD=10.2U
* device instance $45 r0 *1 255.24,5 nfet
X$45 vinp__t11 sel_in__t24 \$56__t12 vss__t204 nfet_03v3 L=0.28U W=10U AS=11P AD=11P PS=22.2U PD=22.2U
* device instance $46 r0 *1 258.12,5 nfet
X$46 vcm__t26 rel_8_p__t1 \$56__t13 vss__t205 nfet_03v3 L=0.28U W=10U AS=11P AD=11P PS=22.2U PD=22.2U
* device instance $47 r0 *1 261,5 nfet
X$47 vref__t20 hi_8_p__t1 \$56__t14 vss__t206 nfet_03v3 L=0.28U W=10U AS=11P AD=11P PS=22.2U PD=22.2U
* device instance $48 r0 *1 263.88,5 nfet
X$48 vss__t22 lo_8_p__t1 \$56__t15 vss__t207 nfet_03v3 L=0.28U W=10U AS=11P AD=11P PS=22.2U PD=22.2U
* device instance $49 r0 *1 291.915,2 nfet
X$49 \$57__t2 sel_in__t51 vss__t101 vss__t134 nfet_03v3 L=0.35U W=4U AS=4.4P AD=4.4P PS=10.2U PD=10.2U
* device instance $50 r0 *1 294.865,2 nfet
X$50 \$59__t2 rel_4_p__t2 vss__t100 vss__t135 nfet_03v3 L=0.35U W=4U AS=4.4P AD=4.4P PS=10.2U PD=10.2U
* device instance $51 r0 *1 297.815,2 nfet
X$51 \$61__t2 hi_4_p__t2 vss__t98 vss__t136 nfet_03v3 L=0.35U W=4U AS=4.4P AD=4.4P PS=10.2U PD=10.2U
* device instance $52 r0 *1 300.765,2 nfet
X$52 \$63__t2 lo_4_p__t2 vss__t97 vss__t137 nfet_03v3 L=0.35U W=4U AS=4.4P AD=4.4P PS=10.2U PD=10.2U
* device instance $53 r0 *1 303.68,5 nfet
X$53 vinp__t14 sel_in__t28 \$64__t11 vss__t208 nfet_03v3 L=0.28U W=10U AS=11P AD=11P PS=22.2U PD=22.2U
* device instance $54 r0 *1 306.56,5 nfet
X$54 vcm__t28 rel_4_p__t1 \$64__t10 vss__t209 nfet_03v3 L=0.28U W=10U AS=11P AD=11P PS=22.2U PD=22.2U
* device instance $55 r0 *1 309.44,5 nfet
X$55 vref__t22 hi_4_p__t1 \$64__t9 vss__t210 nfet_03v3 L=0.28U W=10U AS=11P AD=11P PS=22.2U PD=22.2U
* device instance $56 r0 *1 312.32,5 nfet
X$56 vss__t23 lo_4_p__t1 \$64__t8 vss__t211 nfet_03v3 L=0.28U W=10U AS=11P AD=11P PS=22.2U PD=22.2U
* device instance $57 r0 *1 340.355,2 nfet
X$57 \$65__t2 sel_in__t49 vss__t93 vss__t138 nfet_03v3 L=0.35U W=4U AS=4.4P AD=4.4P PS=10.2U PD=10.2U
* device instance $58 r0 *1 343.305,2 nfet
X$58 \$67__t2 rel_2_p__t2 vss__t92 vss__t139 nfet_03v3 L=0.35U W=4U AS=4.4P AD=4.4P PS=10.2U PD=10.2U
* device instance $59 r0 *1 346.255,2 nfet
X$59 \$69__t2 hi_2_p__t2 vss__t85 vss__t140 nfet_03v3 L=0.35U W=4U AS=4.4P AD=4.4P PS=10.2U PD=10.2U
* device instance $60 r0 *1 349.205,2 nfet
X$60 \$71__t2 lo_2_p__t2 vss__t84 vss__t141 nfet_03v3 L=0.35U W=4U AS=4.4P AD=4.4P PS=10.2U PD=10.2U
* device instance $61 r0 *1 352.12,5 nfet
X$61 vinp__t10 sel_in__t23 \$72__t6 vss__t212 nfet_03v3 L=0.28U W=10U AS=11P AD=11P PS=22.2U PD=22.2U
* device instance $62 r0 *1 355,5 nfet
X$62 vcm__t32 rel_2_p__t1 \$72__t7 vss__t213 nfet_03v3 L=0.28U W=10U AS=11P AD=11P PS=22.2U PD=22.2U
* device instance $63 r0 *1 357.88,5 nfet
X$63 vref__t27 hi_2_p__t1 \$72__t8 vss__t214 nfet_03v3 L=0.28U W=10U AS=11P AD=11P PS=22.2U PD=22.2U
* device instance $64 r0 *1 360.76,5 nfet
X$64 vss__t30 lo_2_p__t1 \$72__t9 vss__t215 nfet_03v3 L=0.28U W=10U AS=11P AD=11P PS=22.2U PD=22.2U
* device instance $65 r0 *1 388.795,2 nfet
X$65 \$73__t2 sel_in__t39 vss__t48 vss__t142 nfet_03v3 L=0.35U W=4U AS=4.4P AD=4.4P PS=10.2U PD=10.2U
* device instance $66 r0 *1 391.745,2 nfet
X$66 \$75__t2 rel_1_p__t2 vss__t47 vss__t143 nfet_03v3 L=0.35U W=4U AS=4.4P AD=4.4P PS=10.2U PD=10.2U
* device instance $67 r0 *1 394.695,2 nfet
X$67 \$77__t2 hi_1_p__t2 vss__t43 vss__t144 nfet_03v3 L=0.35U W=4U AS=4.4P AD=4.4P PS=10.2U PD=10.2U
* device instance $68 r0 *1 397.645,2 nfet
X$68 \$79__t2 lo_1_p__t2 vss__t42 vss__t145 nfet_03v3 L=0.35U W=4U AS=4.4P AD=4.4P PS=10.2U PD=10.2U
* device instance $69 r0 *1 400.56,5 nfet
X$69 vinp__t15 sel_in__t30 \$80__t8 vss__t216 nfet_03v3 L=0.28U W=10U AS=11P AD=11P PS=22.2U PD=22.2U
* device instance $70 r0 *1 403.44,5 nfet
X$70 vcm__t34 rel_1_p__t1 \$80__t7 vss__t217 nfet_03v3 L=0.28U W=10U AS=11P AD=11P PS=22.2U PD=22.2U
* device instance $71 r0 *1 406.32,5 nfet
X$71 vref__t28 hi_1_p__t1 \$80__t6 vss__t218 nfet_03v3 L=0.28U W=10U AS=11P AD=11P PS=22.2U PD=22.2U
* device instance $72 r0 *1 409.2,5 nfet
X$72 vss__t21 lo_1_p__t1 \$80__t5 vss__t219 nfet_03v3 L=0.28U W=10U AS=11P AD=11P PS=22.2U PD=22.2U
* device instance $73 r0 *1 1.275,36 nfet
X$73 \$127__t2 sel_in__t53 vss__t107 vss__t146 nfet_03v3 L=0.35U W=4U AS=4.4P AD=4.4P PS=10.2U PD=10.2U
* device instance $74 r0 *1 4.225,36 nfet
X$74 \$129__t2 rel_256_n__t2 vss__t108 vss__t147 nfet_03v3 L=0.35U W=4U AS=4.4P AD=4.4P PS=10.2U PD=10.2U
* device instance $75 r0 *1 7.175,36 nfet
X$75 \$92__t2 hi_256_n__t2 vss__t95 vss__t148 nfet_03v3 L=0.35U W=4U AS=4.4P AD=4.4P PS=10.2U PD=10.2U
* device instance $76 r0 *1 10.125,36 nfet
X$76 \$94__t2 lo_256_n__t2 vss__t55 vss__t149 nfet_03v3 L=0.35U W=4U AS=4.4P AD=4.4P PS=10.2U PD=10.2U
* device instance $77 r0 *1 13.04,39 nfet
X$77 vinn__t13 sel_in__t29 \$81__t261 vss__t220 nfet_03v3 L=0.28U W=10U AS=11P AD=11P PS=22.2U PD=22.2U
* device instance $78 r0 *1 15.92,39 nfet
X$78 vcm__t41 rel_256_n__t1 \$81__t263 vss__t221 nfet_03v3 L=0.28U W=10U AS=11P AD=11P PS=22.2U PD=22.2U
* device instance $79 r0 *1 18.8,39 nfet
X$79 vref__t26 hi_256_n__t1 \$81__t260 vss__t222 nfet_03v3 L=0.28U W=10U AS=11P AD=11P PS=22.2U PD=22.2U
* device instance $80 r0 *1 21.68,39 nfet
X$80 vss__t31 lo_256_n__t1 \$81__t262 vss__t223 nfet_03v3 L=0.28U W=10U AS=11P AD=11P PS=22.2U PD=22.2U
* device instance $81 r0 *1 49.715,36 nfet
X$81 \$130__t2 sel_in__t43 vss__t62 vss__t150 nfet_03v3 L=0.35U W=4U AS=4.4P AD=4.4P PS=10.2U PD=10.2U
* device instance $82 r0 *1 52.665,36 nfet
X$82 \$132__t2 rel_128_n__t2 vss__t63 vss__t151 nfet_03v3 L=0.35U W=4U AS=4.4P AD=4.4P PS=10.2U PD=10.2U
* device instance $83 r0 *1 55.615,36 nfet
X$83 \$96__t2 hi_128_n__t2 vss__t64 vss__t152 nfet_03v3 L=0.35U W=4U AS=4.4P AD=4.4P PS=10.2U PD=10.2U
* device instance $84 r0 *1 58.565,36 nfet
X$84 \$98__t2 lo_128_n__t2 vss__t106 vss__t153 nfet_03v3 L=0.35U W=4U AS=4.4P AD=4.4P PS=10.2U PD=10.2U
* device instance $85 r0 *1 61.48,39 nfet
X$85 vinn__t17 sel_in__t36 \$83__t135 vss__t224 nfet_03v3 L=0.28U W=10U AS=11P AD=11P PS=22.2U PD=22.2U
* device instance $86 r0 *1 64.36,39 nfet
X$86 vcm__t40 rel_128_n__t1 \$83__t134 vss__t225 nfet_03v3 L=0.28U W=10U AS=11P AD=11P PS=22.2U PD=22.2U
* device instance $87 r0 *1 67.24,39 nfet
X$87 vref__t31 hi_128_n__t1 \$83__t133 vss__t226 nfet_03v3 L=0.28U W=10U AS=11P AD=11P PS=22.2U PD=22.2U
* device instance $88 r0 *1 70.12,39 nfet
X$88 vss__t33 lo_128_n__t1 \$83__t132 vss__t227 nfet_03v3 L=0.28U W=10U AS=11P AD=11P PS=22.2U PD=22.2U
* device instance $89 r0 *1 98.155,36 nfet
X$89 \$133__t2 sel_in__t42 vss__t56 vss__t154 nfet_03v3 L=0.35U W=4U AS=4.4P AD=4.4P PS=10.2U PD=10.2U
* device instance $90 r0 *1 101.105,36 nfet
X$90 \$135__t2 rel_64_n__t2 vss__t59 vss__t155 nfet_03v3 L=0.35U W=4U AS=4.4P AD=4.4P PS=10.2U PD=10.2U
* device instance $91 r0 *1 104.055,36 nfet
X$91 \$100__t2 hi_64_n__t2 vss__t60 vss__t156 nfet_03v3 L=0.35U W=4U AS=4.4P AD=4.4P PS=10.2U PD=10.2U
* device instance $92 r0 *1 107.005,36 nfet
X$92 \$102__t2 lo_64_n__t2 vss__t61 vss__t157 nfet_03v3 L=0.35U W=4U AS=4.4P AD=4.4P PS=10.2U PD=10.2U
* device instance $93 r0 *1 109.92,39 nfet
X$93 vinn__t14 sel_in__t33 \$84__t71 vss__t228 nfet_03v3 L=0.28U W=10U AS=11P AD=11P PS=22.2U PD=22.2U
* device instance $94 r0 *1 112.8,39 nfet
X$94 vcm__t36 rel_64_n__t1 \$84__t70 vss__t229 nfet_03v3 L=0.28U W=10U AS=11P AD=11P PS=22.2U PD=22.2U
* device instance $95 r0 *1 115.68,39 nfet
X$95 vref__t25 hi_64_n__t1 \$84__t68 vss__t230 nfet_03v3 L=0.28U W=10U AS=11P AD=11P PS=22.2U PD=22.2U
* device instance $96 r0 *1 118.56,39 nfet
X$96 vss__t26 lo_64_n__t1 \$84__t69 vss__t231 nfet_03v3 L=0.28U W=10U AS=11P AD=11P PS=22.2U PD=22.2U
* device instance $97 r0 *1 146.595,36 nfet
X$97 \$136__t2 sel_in__t47 vss__t77 vss__t158 nfet_03v3 L=0.35U W=4U AS=4.4P AD=4.4P PS=10.2U PD=10.2U
* device instance $98 r0 *1 149.545,36 nfet
X$98 \$138__t2 rel_32_n__t2 vss__t78 vss__t159 nfet_03v3 L=0.35U W=4U AS=4.4P AD=4.4P PS=10.2U PD=10.2U
* device instance $99 r0 *1 152.495,36 nfet
X$99 \$104__t2 hi_32_n__t2 vss__t79 vss__t160 nfet_03v3 L=0.35U W=4U AS=4.4P AD=4.4P PS=10.2U PD=10.2U
* device instance $100 r0 *1 155.445,36 nfet
X$100 \$106__t2 lo_32_n__t2 vss__t80 vss__t161 nfet_03v3 L=0.35U W=4U AS=4.4P AD=4.4P PS=10.2U PD=10.2U
* device instance $101 r0 *1 158.36,39 nfet
X$101 vinn__t12 sel_in__t27 \$85__t39 vss__t232 nfet_03v3 L=0.28U W=10U AS=11P AD=11P PS=22.2U PD=22.2U
* device instance $102 r0 *1 161.24,39 nfet
X$102 vcm__t29 rel_32_n__t1 \$85__t37 vss__t233 nfet_03v3 L=0.28U W=10U AS=11P AD=11P PS=22.2U PD=22.2U
* device instance $103 r0 *1 164.12,39 nfet
X$103 vref__t24 hi_32_n__t1 \$85__t38 vss__t234 nfet_03v3 L=0.28U W=10U AS=11P AD=11P PS=22.2U PD=22.2U
* device instance $104 r0 *1 167,39 nfet
X$104 vss__t20 lo_32_n__t1 \$85__t36 vss__t235 nfet_03v3 L=0.28U W=10U AS=11P AD=11P PS=22.2U PD=22.2U
* device instance $105 r0 *1 195.035,36 nfet
X$105 \$139__t2 sel_in__t44 vss__t66 vss__t162 nfet_03v3 L=0.35U W=4U AS=4.4P AD=4.4P PS=10.2U PD=10.2U
* device instance $106 r0 *1 197.985,36 nfet
X$106 \$141__t2 rel_16_n__t2 vss__t81 vss__t163 nfet_03v3 L=0.35U W=4U AS=4.4P AD=4.4P PS=10.2U PD=10.2U
* device instance $107 r0 *1 200.935,36 nfet
X$107 \$108__t2 hi_16_n__t2 vss__t68 vss__t164 nfet_03v3 L=0.35U W=4U AS=4.4P AD=4.4P PS=10.2U PD=10.2U
* device instance $108 r0 *1 203.885,36 nfet
X$108 \$110__t2 lo_16_n__t2 vss__t69 vss__t165 nfet_03v3 L=0.35U W=4U AS=4.4P AD=4.4P PS=10.2U PD=10.2U
* device instance $109 r0 *1 206.8,39 nfet
X$109 vinn__t9 sel_in__t20 \$86__t22 vss__t236 nfet_03v3 L=0.28U W=10U AS=11P AD=11P PS=22.2U PD=22.2U
* device instance $110 r0 *1 209.68,39 nfet
X$110 vcm__t23 rel_16_n__t1 \$86__t20 vss__t237 nfet_03v3 L=0.28U W=10U AS=11P AD=11P PS=22.2U PD=22.2U
* device instance $111 r0 *1 212.56,39 nfet
X$111 vref__t18 hi_16_n__t1 \$86__t21 vss__t238 nfet_03v3 L=0.28U W=10U AS=11P AD=11P PS=22.2U PD=22.2U
* device instance $112 r0 *1 215.44,39 nfet
X$112 vss__t27 lo_16_n__t1 \$86__t23 vss__t239 nfet_03v3 L=0.28U W=10U AS=11P AD=11P PS=22.2U PD=22.2U
* device instance $113 r0 *1 243.475,36 nfet
X$113 \$142__t2 sel_in__t48 vss__t82 vss__t166 nfet_03v3 L=0.35U W=4U AS=4.4P AD=4.4P PS=10.2U PD=10.2U
* device instance $114 r0 *1 246.425,36 nfet
X$114 \$144__t2 rel_8_n__t2 vss__t91 vss__t167 nfet_03v3 L=0.35U W=4U AS=4.4P AD=4.4P PS=10.2U PD=10.2U
* device instance $115 r0 *1 249.375,36 nfet
X$115 \$112__t2 hi_8_n__t2 vss__t90 vss__t168 nfet_03v3 L=0.35U W=4U AS=4.4P AD=4.4P PS=10.2U PD=10.2U
* device instance $116 r0 *1 252.325,36 nfet
X$116 \$114__t2 lo_8_n__t2 vss__t89 vss__t169 nfet_03v3 L=0.35U W=4U AS=4.4P AD=4.4P PS=10.2U PD=10.2U
* device instance $117 r0 *1 255.24,39 nfet
X$117 vinn__t16 sel_in__t35 \$87__t15 vss__t240 nfet_03v3 L=0.28U W=10U AS=11P AD=11P PS=22.2U PD=22.2U
* device instance $118 r0 *1 258.12,39 nfet
X$118 vcm__t39 rel_8_n__t1 \$87__t14 vss__t241 nfet_03v3 L=0.28U W=10U AS=11P AD=11P PS=22.2U PD=22.2U
* device instance $119 r0 *1 261,39 nfet
X$119 vref__t35 hi_8_n__t1 \$87__t13 vss__t242 nfet_03v3 L=0.28U W=10U AS=11P AD=11P PS=22.2U PD=22.2U
* device instance $120 r0 *1 263.88,39 nfet
X$120 vss__t36 lo_8_n__t1 \$87__t12 vss__t243 nfet_03v3 L=0.28U W=10U AS=11P AD=11P PS=22.2U PD=22.2U
* device instance $121 r0 *1 291.915,36 nfet
X$121 \$145__t2 sel_in__t41 vss__t54 vss__t170 nfet_03v3 L=0.35U W=4U AS=4.4P AD=4.4P PS=10.2U PD=10.2U
* device instance $122 r0 *1 294.865,36 nfet
X$122 \$147__t2 rel_4_n__t2 vss__t88 vss__t171 nfet_03v3 L=0.35U W=4U AS=4.4P AD=4.4P PS=10.2U PD=10.2U
* device instance $123 r0 *1 297.815,36 nfet
X$123 \$116__t2 hi_4_n__t2 vss__t87 vss__t172 nfet_03v3 L=0.35U W=4U AS=4.4P AD=4.4P PS=10.2U PD=10.2U
* device instance $124 r0 *1 300.765,36 nfet
X$124 \$118__t2 lo_4_n__t2 vss__t86 vss__t173 nfet_03v3 L=0.35U W=4U AS=4.4P AD=4.4P PS=10.2U PD=10.2U
* device instance $125 r0 *1 303.68,39 nfet
X$125 vinn__t10 sel_in__t21 \$88__t11 vss__t244 nfet_03v3 L=0.28U W=10U AS=11P AD=11P PS=22.2U PD=22.2U
* device instance $126 r0 *1 306.56,39 nfet
X$126 vcm__t25 rel_4_n__t1 \$88__t10 vss__t245 nfet_03v3 L=0.28U W=10U AS=11P AD=11P PS=22.2U PD=22.2U
* device instance $127 r0 *1 309.44,39 nfet
X$127 vref__t19 hi_4_n__t1 \$88__t9 vss__t246 nfet_03v3 L=0.28U W=10U AS=11P AD=11P PS=22.2U PD=22.2U
* device instance $128 r0 *1 312.32,39 nfet
X$128 vss__t19 lo_4_n__t1 \$88__t8 vss__t247 nfet_03v3 L=0.28U W=10U AS=11P AD=11P PS=22.2U PD=22.2U
* device instance $129 r0 *1 340.355,36 nfet
X$129 \$148__t2 sel_in__t37 vss__t37 vss__t174 nfet_03v3 L=0.35U W=4U AS=4.4P AD=4.4P PS=10.2U PD=10.2U
* device instance $130 r0 *1 343.305,36 nfet
X$130 \$150__t2 rel_2_n__t2 vss__t53 vss__t175 nfet_03v3 L=0.35U W=4U AS=4.4P AD=4.4P PS=10.2U PD=10.2U
* device instance $131 r0 *1 346.255,36 nfet
X$131 \$120__t2 hi_2_n__t2 vss__t40 vss__t176 nfet_03v3 L=0.35U W=4U AS=4.4P AD=4.4P PS=10.2U PD=10.2U
* device instance $132 r0 *1 349.205,36 nfet
X$132 \$122__t2 lo_2_n__t2 vss__t39 vss__t177 nfet_03v3 L=0.35U W=4U AS=4.4P AD=4.4P PS=10.2U PD=10.2U
* device instance $133 r0 *1 352.12,39 nfet
X$133 vinn__t11 sel_in__t22 \$89__t6 vss__t248 nfet_03v3 L=0.28U W=10U AS=11P AD=11P PS=22.2U PD=22.2U
* device instance $134 r0 *1 355,39 nfet
X$134 vcm__t38 rel_2_n__t1 \$89__t9 vss__t249 nfet_03v3 L=0.28U W=10U AS=11P AD=11P PS=22.2U PD=22.2U
* device instance $135 r0 *1 357.88,39 nfet
X$135 vref__t34 hi_2_n__t1 \$89__t8 vss__t250 nfet_03v3 L=0.28U W=10U AS=11P AD=11P PS=22.2U PD=22.2U
* device instance $136 r0 *1 360.76,39 nfet
X$136 vss__t35 lo_2_n__t1 \$89__t7 vss__t251 nfet_03v3 L=0.28U W=10U AS=11P AD=11P PS=22.2U PD=22.2U
* device instance $137 r0 *1 388.795,36 nfet
X$137 \$151__t2 sel_in__t40 vss__t49 vss__t178 nfet_03v3 L=0.35U W=4U AS=4.4P AD=4.4P PS=10.2U PD=10.2U
* device instance $138 r0 *1 391.745,36 nfet
X$138 \$153__t2 rel_1_n__t2 vss__t50 vss__t179 nfet_03v3 L=0.35U W=4U AS=4.4P AD=4.4P PS=10.2U PD=10.2U
* device instance $139 r0 *1 394.695,36 nfet
X$139 \$124__t2 hi_1_n__t2 vss__t51 vss__t180 nfet_03v3 L=0.35U W=4U AS=4.4P AD=4.4P PS=10.2U PD=10.2U
* device instance $140 r0 *1 397.645,36 nfet
X$140 \$126__t2 lo_1_n__t2 vss__t52 vss__t181 nfet_03v3 L=0.35U W=4U AS=4.4P AD=4.4P PS=10.2U PD=10.2U
* device instance $141 r0 *1 400.56,39 nfet
X$141 vinn__t15 sel_in__t34 \$90__t8 vss__t252 nfet_03v3 L=0.28U W=10U AS=11P AD=11P PS=22.2U PD=22.2U
* device instance $142 r0 *1 403.44,39 nfet
X$142 vcm__t37 rel_1_n__t1 \$90__t7 vss__t253 nfet_03v3 L=0.28U W=10U AS=11P AD=11P PS=22.2U PD=22.2U
* device instance $143 r0 *1 406.32,39 nfet
X$143 vref__t33 hi_1_n__t1 \$90__t6 vss__t254 nfet_03v3 L=0.28U W=10U AS=11P AD=11P PS=22.2U PD=22.2U
* device instance $144 r0 *1 409.2,39 nfet
X$144 vss__t34 lo_1_n__t1 \$90__t5 vss__t255 nfet_03v3 L=0.28U W=10U AS=11P AD=11P PS=22.2U PD=22.2U
* device instance $145 r0 *1 444.075,70 nfet
X$145 \$157__t2 tp_gn__t4 vss__t57 vss__t182 nfet_03v3 L=0.35U W=4U AS=4.4P AD=4.4P PS=10.2U PD=10.2U
* device instance $146 r0 *1 446.99,73 nfet
X$146 vcm__t24 tp_gn__t3 topp__t513 vss__t256 nfet_03v3 L=0.28U W=10U AS=11P AD=11P PS=22.2U PD=22.2U
* device instance $147 r0 *1 457.535,70 nfet
X$147 \$158__t2 tp_gn__t5 vss__t58 vss__t183 nfet_03v3 L=0.35U W=4U AS=4.4P AD=4.4P PS=10.2U PD=10.2U
* device instance $148 r0 *1 460.45,73 nfet
X$148 vcm__t22 tp_gn__t2 topn__t513 vss__t257 nfet_03v3 L=0.28U W=10U AS=11P AD=11P PS=22.2U PD=22.2U
* device instance $149 r0 *1 25.495,4 pfet
X$149 \$5__t1 sel_in__t2 vdd__t0 vdd__t1 pfet_03v3 L=0.35U W=8U AS=8.8P AD=8.8P PS=18.2U PD=18.2U
* device instance $150 r0 *1 28.445,4 pfet
X$150 \$7__t1 rel_256_p__t0 vdd__t209 vdd__t136 pfet_03v3 L=0.35U W=8U AS=8.8P AD=8.8P PS=18.2U PD=18.2U
* device instance $151 r0 *1 31.395,4 pfet
X$151 \$9__t1 hi_256_p__t0 vdd__t208 vdd__t135 pfet_03v3 L=0.35U W=8U AS=8.8P AD=8.8P PS=18.2U PD=18.2U
* device instance $152 r0 *1 34.345,4 pfet
X$152 \$11__t1 lo_256_p__t0 vdd__t218 vdd__t145 pfet_03v3 L=0.35U W=8U AS=8.8P AD=8.8P PS=18.2U PD=18.2U
* device instance $153 r0 *1 37.26,10 pfet
X$153 vinp__t1 \$5__t2 \$12__t1 vdd__t2 pfet_03v3 L=0.28U W=20U AS=22P AD=22P PS=42.2U PD=42.2U
* device instance $154 r0 *1 40.14,10 pfet
X$154 vcm__t21 \$7__t0 \$12__t260 vdd__t74 pfet_03v3 L=0.28U W=20U AS=22P AD=22P PS=42.2U PD=42.2U
* device instance $155 r0 *1 43.02,10 pfet
X$155 vref__t3 \$9__t0 \$12__t258 vdd__t13 pfet_03v3 L=0.28U W=20U AS=22P AD=22P PS=42.2U PD=42.2U
* device instance $156 r0 *1 45.9,10 pfet
X$156 vss__t5 \$11__t0 \$12__t259 vdd__t22 pfet_03v3 L=0.28U W=20U AS=22P AD=22P PS=42.2U PD=42.2U
* device instance $157 r0 *1 73.935,4 pfet
X$157 \$17__t1 sel_in__t19 vdd__t220 vdd__t147 pfet_03v3 L=0.35U W=8U AS=8.8P AD=8.8P PS=18.2U PD=18.2U
* device instance $158 r0 *1 76.885,4 pfet
X$158 \$19__t1 rel_128_p__t0 vdd__t219 vdd__t146 pfet_03v3 L=0.35U W=8U AS=8.8P AD=8.8P PS=18.2U PD=18.2U
* device instance $159 r0 *1 79.835,4 pfet
X$159 \$21__t1 hi_128_p__t0 vdd__t206 vdd__t133 pfet_03v3 L=0.35U W=8U AS=8.8P AD=8.8P PS=18.2U PD=18.2U
* device instance $160 r0 *1 82.785,4 pfet
X$160 \$23__t1 lo_128_p__t0 vdd__t207 vdd__t134 pfet_03v3 L=0.35U W=8U AS=8.8P AD=8.8P PS=18.2U PD=18.2U
* device instance $161 r0 *1 85.7,10 pfet
X$161 vinp__t6 \$17__t0 \$24__t131 vdd__t43 pfet_03v3 L=0.28U W=20U AS=22P AD=22P PS=42.2U PD=42.2U
* device instance $162 r0 *1 88.58,10 pfet
X$162 vcm__t6 \$19__t0 \$24__t130 vdd__t17 pfet_03v3 L=0.28U W=20U AS=22P AD=22P PS=42.2U PD=42.2U
* device instance $163 r0 *1 91.46,10 pfet
X$163 vref__t4 \$21__t0 \$24__t129 vdd__t16 pfet_03v3 L=0.28U W=20U AS=22P AD=22P PS=42.2U PD=42.2U
* device instance $164 r0 *1 94.34,10 pfet
X$164 vss__t2 \$23__t0 \$24__t128 vdd__t15 pfet_03v3 L=0.28U W=20U AS=22P AD=22P PS=42.2U PD=42.2U
* device instance $165 r0 *1 122.375,4 pfet
X$165 \$25__t1 sel_in__t16 vdd__t210 vdd__t137 pfet_03v3 L=0.35U W=8U AS=8.8P AD=8.8P PS=18.2U PD=18.2U
* device instance $166 r0 *1 125.325,4 pfet
X$166 \$27__t1 rel_64_p__t0 vdd__t201 vdd__t128 pfet_03v3 L=0.35U W=8U AS=8.8P AD=8.8P PS=18.2U PD=18.2U
* device instance $167 r0 *1 128.275,4 pfet
X$167 \$29__t1 hi_64_p__t0 vdd__t217 vdd__t144 pfet_03v3 L=0.35U W=8U AS=8.8P AD=8.8P PS=18.2U PD=18.2U
* device instance $168 r0 *1 131.225,4 pfet
X$168 \$31__t1 lo_64_p__t0 vdd__t151 vdd__t78 pfet_03v3 L=0.35U W=8U AS=8.8P AD=8.8P PS=18.2U PD=18.2U
* device instance $169 r0 *1 134.14,10 pfet
X$169 vinp__t9 \$25__t0 \$32__t67 vdd__t75 pfet_03v3 L=0.28U W=20U AS=22P AD=22P PS=42.2U PD=42.2U
* device instance $170 r0 *1 137.02,10 pfet
X$170 vcm__t18 \$27__t0 \$32__t66 vdd__t66 pfet_03v3 L=0.28U W=20U AS=22P AD=22P PS=42.2U PD=42.2U
* device instance $171 r0 *1 139.9,10 pfet
X$171 vref__t15 \$29__t0 \$32__t65 vdd__t64 pfet_03v3 L=0.28U W=20U AS=22P AD=22P PS=42.2U PD=42.2U
* device instance $172 r0 *1 142.78,10 pfet
X$172 vss__t4 \$31__t0 \$32__t64 vdd__t19 pfet_03v3 L=0.28U W=20U AS=22P AD=22P PS=42.2U PD=42.2U
* device instance $173 r0 *1 170.815,4 pfet
X$173 \$33__t1 sel_in__t4 vdd__t156 vdd__t83 pfet_03v3 L=0.35U W=8U AS=8.8P AD=8.8P PS=18.2U PD=18.2U
* device instance $174 r0 *1 173.765,4 pfet
X$174 \$35__t1 rel_32_p__t0 vdd__t158 vdd__t85 pfet_03v3 L=0.35U W=8U AS=8.8P AD=8.8P PS=18.2U PD=18.2U
* device instance $175 r0 *1 176.715,4 pfet
X$175 \$37__t1 hi_32_p__t0 vdd__t160 vdd__t87 pfet_03v3 L=0.35U W=8U AS=8.8P AD=8.8P PS=18.2U PD=18.2U
* device instance $176 r0 *1 179.665,4 pfet
X$176 \$39__t1 lo_32_p__t0 vdd__t161 vdd__t88 pfet_03v3 L=0.35U W=8U AS=8.8P AD=8.8P PS=18.2U PD=18.2U
* device instance $177 r0 *1 182.58,10 pfet
X$177 vinp__t3 \$33__t0 \$40__t32 vdd__t11 pfet_03v3 L=0.28U W=20U AS=22P AD=22P PS=42.2U PD=42.2U
* device instance $178 r0 *1 185.46,10 pfet
X$178 vcm__t13 \$35__t0 \$40__t33 vdd__t44 pfet_03v3 L=0.28U W=20U AS=22P AD=22P PS=42.2U PD=42.2U
* device instance $179 r0 *1 188.34,10 pfet
X$179 vref__t10 \$37__t0 \$40__t34 vdd__t45 pfet_03v3 L=0.28U W=20U AS=22P AD=22P PS=42.2U PD=42.2U
* device instance $180 r0 *1 191.22,10 pfet
X$180 vss__t12 \$39__t0 \$40__t35 vdd__t46 pfet_03v3 L=0.28U W=20U AS=22P AD=22P PS=42.2U PD=42.2U
* device instance $181 r0 *1 219.255,4 pfet
X$181 \$41__t1 sel_in__t18 vdd__t215 vdd__t142 pfet_03v3 L=0.35U W=8U AS=8.8P AD=8.8P PS=18.2U PD=18.2U
* device instance $182 r0 *1 222.205,4 pfet
X$182 \$43__t1 rel_16_p__t0 vdd__t216 vdd__t143 pfet_03v3 L=0.35U W=8U AS=8.8P AD=8.8P PS=18.2U PD=18.2U
* device instance $183 r0 *1 225.155,4 pfet
X$183 \$45__t1 hi_16_p__t0 vdd__t154 vdd__t81 pfet_03v3 L=0.35U W=8U AS=8.8P AD=8.8P PS=18.2U PD=18.2U
* device instance $184 r0 *1 228.105,4 pfet
X$184 \$47__t1 lo_16_p__t0 vdd__t155 vdd__t82 pfet_03v3 L=0.35U W=8U AS=8.8P AD=8.8P PS=18.2U PD=18.2U
* device instance $185 r0 *1 231.02,10 pfet
X$185 vinp__t7 \$41__t0 \$48__t19 vdd__t47 pfet_03v3 L=0.28U W=20U AS=22P AD=22P PS=42.2U PD=42.2U
* device instance $186 r0 *1 233.9,10 pfet
X$186 vcm__t4 \$43__t0 \$48__t16 vdd__t5 pfet_03v3 L=0.28U W=20U AS=22P AD=22P PS=42.2U PD=42.2U
* device instance $187 r0 *1 236.78,10 pfet
X$187 vref__t2 \$45__t0 \$48__t17 vdd__t12 pfet_03v3 L=0.28U W=20U AS=22P AD=22P PS=42.2U PD=42.2U
* device instance $188 r0 *1 239.66,10 pfet
X$188 vss__t6 \$47__t0 \$48__t18 vdd__t23 pfet_03v3 L=0.28U W=20U AS=22P AD=22P PS=42.2U PD=42.2U
* device instance $189 r0 *1 267.695,4 pfet
X$189 \$49__t1 sel_in__t14 vdd__t198 vdd__t125 pfet_03v3 L=0.35U W=8U AS=8.8P AD=8.8P PS=18.2U PD=18.2U
* device instance $190 r0 *1 270.645,4 pfet
X$190 \$51__t1 rel_8_p__t0 vdd__t199 vdd__t126 pfet_03v3 L=0.35U W=8U AS=8.8P AD=8.8P PS=18.2U PD=18.2U
* device instance $191 r0 *1 273.595,4 pfet
X$191 \$53__t1 hi_8_p__t0 vdd__t191 vdd__t118 pfet_03v3 L=0.35U W=8U AS=8.8P AD=8.8P PS=18.2U PD=18.2U
* device instance $192 r0 *1 276.545,4 pfet
X$192 \$55__t1 lo_8_p__t0 vdd__t167 vdd__t94 pfet_03v3 L=0.35U W=8U AS=8.8P AD=8.8P PS=18.2U PD=18.2U
* device instance $193 r0 *1 279.46,10 pfet
X$193 vinp__t4 \$49__t0 \$56__t8 vdd__t14 pfet_03v3 L=0.28U W=20U AS=22P AD=22P PS=42.2U PD=42.2U
* device instance $194 r0 *1 282.34,10 pfet
X$194 vcm__t12 \$51__t0 \$56__t9 vdd__t38 pfet_03v3 L=0.28U W=20U AS=22P AD=22P PS=42.2U PD=42.2U
* device instance $195 r0 *1 285.22,10 pfet
X$195 vref__t9 \$53__t0 \$56__t10 vdd__t39 pfet_03v3 L=0.28U W=20U AS=22P AD=22P PS=42.2U PD=42.2U
* device instance $196 r0 *1 288.1,10 pfet
X$196 vss__t11 \$55__t0 \$56__t11 vdd__t40 pfet_03v3 L=0.28U W=20U AS=22P AD=22P PS=42.2U PD=42.2U
* device instance $197 r0 *1 316.135,4 pfet
X$197 \$57__t1 sel_in__t11 vdd__t186 vdd__t113 pfet_03v3 L=0.35U W=8U AS=8.8P AD=8.8P PS=18.2U PD=18.2U
* device instance $198 r0 *1 319.085,4 pfet
X$198 \$59__t1 rel_4_p__t0 vdd__t187 vdd__t114 pfet_03v3 L=0.35U W=8U AS=8.8P AD=8.8P PS=18.2U PD=18.2U
* device instance $199 r0 *1 322.035,4 pfet
X$199 \$61__t1 hi_4_p__t0 vdd__t188 vdd__t115 pfet_03v3 L=0.35U W=8U AS=8.8P AD=8.8P PS=18.2U PD=18.2U
* device instance $200 r0 *1 324.985,4 pfet
X$200 \$63__t1 lo_4_p__t0 vdd__t189 vdd__t116 pfet_03v3 L=0.35U W=8U AS=8.8P AD=8.8P PS=18.2U PD=18.2U
* device instance $201 r0 *1 327.9,10 pfet
X$201 vinp__t2 \$57__t0 \$64__t4 vdd__t7 pfet_03v3 L=0.28U W=20U AS=22P AD=22P PS=42.2U PD=42.2U
* device instance $202 r0 *1 330.78,10 pfet
X$202 vcm__t5 \$59__t0 \$64__t5 vdd__t8 pfet_03v3 L=0.28U W=20U AS=22P AD=22P PS=42.2U PD=42.2U
* device instance $203 r0 *1 333.66,10 pfet
X$203 vref__t1 \$61__t0 \$64__t6 vdd__t9 pfet_03v3 L=0.28U W=20U AS=22P AD=22P PS=42.2U PD=42.2U
* device instance $204 r0 *1 336.54,10 pfet
X$204 vss__t1 \$63__t0 \$64__t7 vdd__t10 pfet_03v3 L=0.28U W=20U AS=22P AD=22P PS=42.2U PD=42.2U
* device instance $205 r0 *1 364.575,4 pfet
X$205 \$65__t1 sel_in__t10 vdd__t183 vdd__t110 pfet_03v3 L=0.35U W=8U AS=8.8P AD=8.8P PS=18.2U PD=18.2U
* device instance $206 r0 *1 367.525,4 pfet
X$206 \$67__t1 rel_2_p__t0 vdd__t179 vdd__t106 pfet_03v3 L=0.35U W=8U AS=8.8P AD=8.8P PS=18.2U PD=18.2U
* device instance $207 r0 *1 370.475,4 pfet
X$207 \$69__t1 hi_2_p__t0 vdd__t180 vdd__t107 pfet_03v3 L=0.35U W=8U AS=8.8P AD=8.8P PS=18.2U PD=18.2U
* device instance $208 r0 *1 373.425,4 pfet
X$208 \$71__t1 lo_2_p__t0 vdd__t181 vdd__t108 pfet_03v3 L=0.35U W=8U AS=8.8P AD=8.8P PS=18.2U PD=18.2U
* device instance $209 r0 *1 376.34,10 pfet
X$209 vinp__t8 \$65__t0 \$72__t2 vdd__t48 pfet_03v3 L=0.28U W=20U AS=22P AD=22P PS=42.2U PD=42.2U
* device instance $210 r0 *1 379.22,10 pfet
X$210 vcm__t14 \$67__t0 \$72__t3 vdd__t49 pfet_03v3 L=0.28U W=20U AS=22P AD=22P PS=42.2U PD=42.2U
* device instance $211 r0 *1 382.1,10 pfet
X$211 vref__t11 \$69__t0 \$72__t4 vdd__t50 pfet_03v3 L=0.28U W=20U AS=22P AD=22P PS=42.2U PD=42.2U
* device instance $212 r0 *1 384.98,10 pfet
X$212 vss__t13 \$71__t0 \$72__t5 vdd__t51 pfet_03v3 L=0.28U W=20U AS=22P AD=22P PS=42.2U PD=42.2U
* device instance $213 r0 *1 413.015,4 pfet
X$213 \$73__t1 sel_in__t9 vdd__t182 vdd__t109 pfet_03v3 L=0.35U W=8U AS=8.8P AD=8.8P PS=18.2U PD=18.2U
* device instance $214 r0 *1 415.965,4 pfet
X$214 \$75__t1 rel_1_p__t0 vdd__t202 vdd__t129 pfet_03v3 L=0.35U W=8U AS=8.8P AD=8.8P PS=18.2U PD=18.2U
* device instance $215 r0 *1 418.915,4 pfet
X$215 \$77__t1 hi_1_p__t0 vdd__t168 vdd__t95 pfet_03v3 L=0.35U W=8U AS=8.8P AD=8.8P PS=18.2U PD=18.2U
* device instance $216 r0 *1 421.865,4 pfet
X$216 \$79__t1 lo_1_p__t0 vdd__t169 vdd__t96 pfet_03v3 L=0.35U W=8U AS=8.8P AD=8.8P PS=18.2U PD=18.2U
* device instance $217 r0 *1 424.78,10 pfet
X$217 vinp__t5 \$73__t0 \$80__t1 vdd__t20 pfet_03v3 L=0.28U W=20U AS=22P AD=22P PS=42.2U PD=42.2U
* device instance $218 r0 *1 427.66,10 pfet
X$218 vcm__t7 \$75__t0 \$80__t2 vdd__t21 pfet_03v3 L=0.28U W=20U AS=22P AD=22P PS=42.2U PD=42.2U
* device instance $219 r0 *1 430.54,10 pfet
X$219 vref__t12 \$77__t0 \$80__t3 vdd__t52 pfet_03v3 L=0.28U W=20U AS=22P AD=22P PS=42.2U PD=42.2U
* device instance $220 r0 *1 433.42,10 pfet
X$220 vss__t16 \$79__t0 \$80__t4 vdd__t63 pfet_03v3 L=0.28U W=20U AS=22P AD=22P PS=42.2U PD=42.2U
* device instance $221 r0 *1 25.495,38 pfet
X$221 \$127__t1 sel_in__t17 vdd__t214 vdd__t141 pfet_03v3 L=0.35U W=8U AS=8.8P AD=8.8P PS=18.2U PD=18.2U
* device instance $222 r0 *1 28.445,38 pfet
X$222 \$129__t1 rel_256_n__t0 vdd__t213 vdd__t140 pfet_03v3 L=0.35U W=8U AS=8.8P AD=8.8P PS=18.2U PD=18.2U
* device instance $223 r0 *1 31.395,38 pfet
X$223 \$92__t1 hi_256_n__t0 vdd__t212 vdd__t139 pfet_03v3 L=0.35U W=8U AS=8.8P AD=8.8P PS=18.2U PD=18.2U
* device instance $224 r0 *1 34.345,38 pfet
X$224 \$94__t1 lo_256_n__t0 vdd__t211 vdd__t138 pfet_03v3 L=0.35U W=8U AS=8.8P AD=8.8P PS=18.2U PD=18.2U
* device instance $225 r0 *1 37.26,44 pfet
X$225 vinn__t7 \$127__t0 \$81__t256 vdd__t65 pfet_03v3 L=0.28U W=20U AS=22P AD=22P PS=42.2U PD=42.2U
* device instance $226 r0 *1 40.14,44 pfet
X$226 vcm__t19 \$129__t0 \$81__t257 vdd__t67 pfet_03v3 L=0.28U W=20U AS=22P AD=22P PS=42.2U PD=42.2U
* device instance $227 r0 *1 43.02,44 pfet
X$227 vref__t16 \$92__t0 \$81__t258 vdd__t68 pfet_03v3 L=0.28U W=20U AS=22P AD=22P PS=42.2U PD=42.2U
* device instance $228 r0 *1 45.9,44 pfet
X$228 vss__t17 \$94__t0 \$81__t259 vdd__t69 pfet_03v3 L=0.28U W=20U AS=22P AD=22P PS=42.2U PD=42.2U
* device instance $229 r0 *1 73.935,38 pfet
X$229 \$130__t1 sel_in__t15 vdd__t205 vdd__t132 pfet_03v3 L=0.35U W=8U AS=8.8P AD=8.8P PS=18.2U PD=18.2U
* device instance $230 r0 *1 76.885,38 pfet
X$230 \$132__t1 rel_128_n__t0 vdd__t204 vdd__t131 pfet_03v3 L=0.35U W=8U AS=8.8P AD=8.8P PS=18.2U PD=18.2U
* device instance $231 r0 *1 79.835,38 pfet
X$231 \$96__t1 hi_128_n__t0 vdd__t203 vdd__t130 pfet_03v3 L=0.35U W=8U AS=8.8P AD=8.8P PS=18.2U PD=18.2U
* device instance $232 r0 *1 82.785,38 pfet
X$232 \$98__t1 lo_128_n__t0 vdd__t221 vdd__t148 pfet_03v3 L=0.35U W=8U AS=8.8P AD=8.8P PS=18.2U PD=18.2U
* device instance $233 r0 *1 85.7,44 pfet
X$233 vinn__t8 \$130__t0 \$83__t128 vdd__t70 pfet_03v3 L=0.28U W=20U AS=22P AD=22P PS=42.2U PD=42.2U
* device instance $234 r0 *1 88.58,44 pfet
X$234 vcm__t20 \$132__t0 \$83__t129 vdd__t71 pfet_03v3 L=0.28U W=20U AS=22P AD=22P PS=42.2U PD=42.2U
* device instance $235 r0 *1 91.46,44 pfet
X$235 vref__t17 \$96__t0 \$83__t130 vdd__t72 pfet_03v3 L=0.28U W=20U AS=22P AD=22P PS=42.2U PD=42.2U
* device instance $236 r0 *1 94.34,44 pfet
X$236 vss__t18 \$98__t0 \$83__t131 vdd__t73 pfet_03v3 L=0.28U W=20U AS=22P AD=22P PS=42.2U PD=42.2U
* device instance $237 r0 *1 122.375,38 pfet
X$237 \$133__t1 sel_in__t7 vdd__t174 vdd__t101 pfet_03v3 L=0.35U W=8U AS=8.8P AD=8.8P PS=18.2U PD=18.2U
* device instance $238 r0 *1 125.325,38 pfet
X$238 \$135__t1 rel_64_n__t0 vdd__t153 vdd__t80 pfet_03v3 L=0.35U W=8U AS=8.8P AD=8.8P PS=18.2U PD=18.2U
* device instance $239 r0 *1 128.275,38 pfet
X$239 \$100__t1 hi_64_n__t0 vdd__t159 vdd__t86 pfet_03v3 L=0.35U W=8U AS=8.8P AD=8.8P PS=18.2U PD=18.2U
* device instance $240 r0 *1 131.225,38 pfet
X$240 \$102__t1 lo_64_n__t0 vdd__t162 vdd__t89 pfet_03v3 L=0.35U W=8U AS=8.8P AD=8.8P PS=18.2U PD=18.2U
* device instance $241 r0 *1 134.14,44 pfet
X$241 vinn__t6 \$133__t0 \$84__t67 vdd__t61 pfet_03v3 L=0.28U W=20U AS=22P AD=22P PS=42.2U PD=42.2U
* device instance $242 r0 *1 137.02,44 pfet
X$242 vcm__t16 \$135__t0 \$84__t66 vdd__t60 pfet_03v3 L=0.28U W=20U AS=22P AD=22P PS=42.2U PD=42.2U
* device instance $243 r0 *1 139.9,44 pfet
X$243 vref__t14 \$100__t0 \$84__t65 vdd__t59 pfet_03v3 L=0.28U W=20U AS=22P AD=22P PS=42.2U PD=42.2U
* device instance $244 r0 *1 142.78,44 pfet
X$244 vss__t15 \$102__t0 \$84__t64 vdd__t58 pfet_03v3 L=0.28U W=20U AS=22P AD=22P PS=42.2U PD=42.2U
* device instance $245 r0 *1 170.815,38 pfet
X$245 \$136__t1 sel_in__t3 vdd__t149 vdd__t76 pfet_03v3 L=0.35U W=8U AS=8.8P AD=8.8P PS=18.2U PD=18.2U
* device instance $246 r0 *1 173.765,38 pfet
X$246 \$138__t1 rel_32_n__t0 vdd__t152 vdd__t79 pfet_03v3 L=0.35U W=8U AS=8.8P AD=8.8P PS=18.2U PD=18.2U
* device instance $247 r0 *1 176.715,38 pfet
X$247 \$104__t1 hi_32_n__t0 vdd__t150 vdd__t77 pfet_03v3 L=0.35U W=8U AS=8.8P AD=8.8P PS=18.2U PD=18.2U
* device instance $248 r0 *1 179.665,38 pfet
X$248 \$106__t1 lo_32_n__t0 vdd__t166 vdd__t93 pfet_03v3 L=0.35U W=8U AS=8.8P AD=8.8P PS=18.2U PD=18.2U
* device instance $249 r0 *1 182.58,44 pfet
X$249 vinn__t5 \$136__t0 \$85__t35 vdd__t57 pfet_03v3 L=0.28U W=20U AS=22P AD=22P PS=42.2U PD=42.2U
* device instance $250 r0 *1 185.46,44 pfet
X$250 vcm__t15 \$138__t0 \$85__t34 vdd__t56 pfet_03v3 L=0.28U W=20U AS=22P AD=22P PS=42.2U PD=42.2U
* device instance $251 r0 *1 188.34,44 pfet
X$251 vref__t13 \$104__t0 \$85__t33 vdd__t55 pfet_03v3 L=0.28U W=20U AS=22P AD=22P PS=42.2U PD=42.2U
* device instance $252 r0 *1 191.22,44 pfet
X$252 vss__t14 \$106__t0 \$85__t32 vdd__t54 pfet_03v3 L=0.28U W=20U AS=22P AD=22P PS=42.2U PD=42.2U
* device instance $253 r0 *1 219.255,38 pfet
X$253 \$139__t1 sel_in__t5 vdd__t165 vdd__t92 pfet_03v3 L=0.35U W=8U AS=8.8P AD=8.8P PS=18.2U PD=18.2U
* device instance $254 r0 *1 222.205,38 pfet
X$254 \$141__t1 rel_16_n__t0 vdd__t164 vdd__t91 pfet_03v3 L=0.35U W=8U AS=8.8P AD=8.8P PS=18.2U PD=18.2U
* device instance $255 r0 *1 225.155,38 pfet
X$255 \$108__t1 hi_16_n__t0 vdd__t163 vdd__t90 pfet_03v3 L=0.35U W=8U AS=8.8P AD=8.8P PS=18.2U PD=18.2U
* device instance $256 r0 *1 228.105,38 pfet
X$256 \$110__t1 lo_16_n__t0 vdd__t157 vdd__t84 pfet_03v3 L=0.35U W=8U AS=8.8P AD=8.8P PS=18.2U PD=18.2U
* device instance $257 r0 *1 231.02,44 pfet
X$257 vinn__t4 \$139__t0 \$86__t18 vdd__t53 pfet_03v3 L=0.28U W=20U AS=22P AD=22P PS=42.2U PD=42.2U
* device instance $258 r0 *1 233.9,44 pfet
X$258 vcm__t17 \$141__t0 \$86__t19 vdd__t62 pfet_03v3 L=0.28U W=20U AS=22P AD=22P PS=42.2U PD=42.2U
* device instance $259 r0 *1 236.78,44 pfet
X$259 vref__t0 \$108__t0 \$86__t16 vdd__t6 pfet_03v3 L=0.28U W=20U AS=22P AD=22P PS=42.2U PD=42.2U
* device instance $260 r0 *1 239.66,44 pfet
X$260 vss__t9 \$110__t0 \$86__t17 vdd__t32 pfet_03v3 L=0.28U W=20U AS=22P AD=22P PS=42.2U PD=42.2U
* device instance $261 r0 *1 267.695,38 pfet
X$261 \$142__t1 sel_in__t12 vdd__t190 vdd__t117 pfet_03v3 L=0.35U W=8U AS=8.8P AD=8.8P PS=18.2U PD=18.2U
* device instance $262 r0 *1 270.645,38 pfet
X$262 \$144__t1 rel_8_n__t0 vdd__t200 vdd__t127 pfet_03v3 L=0.35U W=8U AS=8.8P AD=8.8P PS=18.2U PD=18.2U
* device instance $263 r0 *1 273.595,38 pfet
X$263 \$112__t1 hi_8_n__t0 vdd__t192 vdd__t119 pfet_03v3 L=0.35U W=8U AS=8.8P AD=8.8P PS=18.2U PD=18.2U
* device instance $264 r0 *1 276.545,38 pfet
X$264 \$114__t1 lo_8_n__t0 vdd__t193 vdd__t120 pfet_03v3 L=0.35U W=8U AS=8.8P AD=8.8P PS=18.2U PD=18.2U
* device instance $265 r0 *1 279.46,44 pfet
X$265 vinn__t2 \$142__t0 \$87__t11 vdd__t41 pfet_03v3 L=0.28U W=20U AS=22P AD=22P PS=42.2U PD=42.2U
* device instance $266 r0 *1 282.34,44 pfet
X$266 vcm__t11 \$144__t0 \$87__t10 vdd__t37 pfet_03v3 L=0.28U W=20U AS=22P AD=22P PS=42.2U PD=42.2U
* device instance $267 r0 *1 285.22,44 pfet
X$267 vref__t8 \$112__t0 \$87__t9 vdd__t36 pfet_03v3 L=0.28U W=20U AS=22P AD=22P PS=42.2U PD=42.2U
* device instance $268 r0 *1 288.1,44 pfet
X$268 vss__t3 \$114__t0 \$87__t8 vdd__t18 pfet_03v3 L=0.28U W=20U AS=22P AD=22P PS=42.2U PD=42.2U
* device instance $269 r0 *1 316.135,38 pfet
X$269 \$145__t1 sel_in__t13 vdd__t194 vdd__t121 pfet_03v3 L=0.35U W=8U AS=8.8P AD=8.8P PS=18.2U PD=18.2U
* device instance $270 r0 *1 319.085,38 pfet
X$270 \$147__t1 rel_4_n__t0 vdd__t195 vdd__t122 pfet_03v3 L=0.35U W=8U AS=8.8P AD=8.8P PS=18.2U PD=18.2U
* device instance $271 r0 *1 322.035,38 pfet
X$271 \$116__t1 hi_4_n__t0 vdd__t196 vdd__t123 pfet_03v3 L=0.35U W=8U AS=8.8P AD=8.8P PS=18.2U PD=18.2U
* device instance $272 r0 *1 324.985,38 pfet
X$272 \$118__t1 lo_4_n__t0 vdd__t197 vdd__t124 pfet_03v3 L=0.35U W=8U AS=8.8P AD=8.8P PS=18.2U PD=18.2U
* device instance $273 r0 *1 327.9,44 pfet
X$273 vinn__t0 \$145__t0 \$88__t4 vdd__t24 pfet_03v3 L=0.28U W=20U AS=22P AD=22P PS=42.2U PD=42.2U
* device instance $274 r0 *1 330.78,44 pfet
X$274 vcm__t8 \$147__t0 \$88__t5 vdd__t25 pfet_03v3 L=0.28U W=20U AS=22P AD=22P PS=42.2U PD=42.2U
* device instance $275 r0 *1 333.66,44 pfet
X$275 vref__t5 \$116__t0 \$88__t6 vdd__t26 pfet_03v3 L=0.28U W=20U AS=22P AD=22P PS=42.2U PD=42.2U
* device instance $276 r0 *1 336.54,44 pfet
X$276 vss__t7 \$118__t0 \$88__t7 vdd__t27 pfet_03v3 L=0.28U W=20U AS=22P AD=22P PS=42.2U PD=42.2U
* device instance $277 r0 *1 364.575,38 pfet
X$277 \$148__t1 sel_in__t6 vdd__t170 vdd__t97 pfet_03v3 L=0.35U W=8U AS=8.8P AD=8.8P PS=18.2U PD=18.2U
* device instance $278 r0 *1 367.525,38 pfet
X$278 \$150__t1 rel_2_n__t0 vdd__t171 vdd__t98 pfet_03v3 L=0.35U W=8U AS=8.8P AD=8.8P PS=18.2U PD=18.2U
* device instance $279 r0 *1 370.475,38 pfet
X$279 \$120__t1 hi_2_n__t0 vdd__t172 vdd__t99 pfet_03v3 L=0.35U W=8U AS=8.8P AD=8.8P PS=18.2U PD=18.2U
* device instance $280 r0 *1 373.425,38 pfet
X$280 \$122__t1 lo_2_n__t0 vdd__t173 vdd__t100 pfet_03v3 L=0.35U W=8U AS=8.8P AD=8.8P PS=18.2U PD=18.2U
* device instance $281 r0 *1 376.34,44 pfet
X$281 vinn__t1 \$148__t0 \$89__t2 vdd__t28 pfet_03v3 L=0.28U W=20U AS=22P AD=22P PS=42.2U PD=42.2U
* device instance $282 r0 *1 379.22,44 pfet
X$282 vcm__t9 \$150__t0 \$89__t3 vdd__t29 pfet_03v3 L=0.28U W=20U AS=22P AD=22P PS=42.2U PD=42.2U
* device instance $283 r0 *1 382.1,44 pfet
X$283 vref__t6 \$120__t0 \$89__t4 vdd__t30 pfet_03v3 L=0.28U W=20U AS=22P AD=22P PS=42.2U PD=42.2U
* device instance $284 r0 *1 384.98,44 pfet
X$284 vss__t8 \$122__t0 \$89__t5 vdd__t31 pfet_03v3 L=0.28U W=20U AS=22P AD=22P PS=42.2U PD=42.2U
* device instance $285 r0 *1 413.015,38 pfet
X$285 \$151__t1 sel_in__t8 vdd__t175 vdd__t102 pfet_03v3 L=0.35U W=8U AS=8.8P AD=8.8P PS=18.2U PD=18.2U
* device instance $286 r0 *1 415.965,38 pfet
X$286 \$153__t1 rel_1_n__t0 vdd__t176 vdd__t103 pfet_03v3 L=0.35U W=8U AS=8.8P AD=8.8P PS=18.2U PD=18.2U
* device instance $287 r0 *1 418.915,38 pfet
X$287 \$124__t1 hi_1_n__t0 vdd__t177 vdd__t104 pfet_03v3 L=0.35U W=8U AS=8.8P AD=8.8P PS=18.2U PD=18.2U
* device instance $288 r0 *1 421.865,38 pfet
X$288 \$126__t1 lo_1_n__t0 vdd__t178 vdd__t105 pfet_03v3 L=0.35U W=8U AS=8.8P AD=8.8P PS=18.2U PD=18.2U
* device instance $289 r0 *1 424.78,44 pfet
X$289 vinn__t3 \$151__t0 \$90__t4 vdd__t42 pfet_03v3 L=0.28U W=20U AS=22P AD=22P PS=42.2U PD=42.2U
* device instance $290 r0 *1 427.66,44 pfet
X$290 vcm__t10 \$153__t0 \$90__t1 vdd__t33 pfet_03v3 L=0.28U W=20U AS=22P AD=22P PS=42.2U PD=42.2U
* device instance $291 r0 *1 430.54,44 pfet
X$291 vref__t7 \$124__t0 \$90__t2 vdd__t34 pfet_03v3 L=0.28U W=20U AS=22P AD=22P PS=42.2U PD=42.2U
* device instance $292 r0 *1 433.42,44 pfet
X$292 vss__t10 \$126__t0 \$90__t3 vdd__t35 pfet_03v3 L=0.28U W=20U AS=22P AD=22P PS=42.2U PD=42.2U
* device instance $293 r0 *1 450.805,72 pfet
X$293 \$157__t1 tp_gn__t0 vdd__t184 vdd__t111 pfet_03v3 L=0.35U W=8U AS=8.8P AD=8.8P PS=18.2U PD=18.2U
* device instance $294 r0 *1 453.72,78 pfet
X$294 vcm__t3 \$157__t0 topp__t512 vdd__t4 pfet_03v3 L=0.28U W=20U AS=22P AD=22P PS=42.2U PD=42.2U
* device instance $295 r0 *1 464.265,72 pfet
X$295 \$158__t1 tp_gn__t1 vdd__t185 vdd__t112 pfet_03v3 L=0.35U W=8U AS=8.8P AD=8.8P PS=18.2U PD=18.2U
* device instance $296 r0 *1 467.18,78 pfet
X$296 vcm__t2 \$158__t0 topn__t512 vdd__t3 pfet_03v3 L=0.28U W=20U AS=22P AD=22P PS=42.2U PD=42.2U
* device instance $297 r0 *1 2.6,70.6 cap_mim_2f0_m4m5_noshield
X$297 \$12__t248 topp__t0 cap_mim_2f0_m4m5_noshield c_length=4U c_width=4U
* device instance $298 r0 *1 9,70.6 cap_mim_2f0_m4m5_noshield
X$298 \$72__t1 topp__t494 cap_mim_2f0_m4m5_noshield c_length=4U c_width=4U
* device instance $299 r0 *1 15.4,70.6 cap_mim_2f0_m4m5_noshield
X$299 \$12__t247 topp__t493 cap_mim_2f0_m4m5_noshield c_length=4U c_width=4U
* device instance $300 r0 *1 21.8,70.6 cap_mim_2f0_m4m5_noshield
X$300 \$64__t3 topp__t492 cap_mim_2f0_m4m5_noshield c_length=4U c_width=4U
* device instance $301 r0 *1 28.2,70.6 cap_mim_2f0_m4m5_noshield
X$301 \$12__t246 topp__t491 cap_mim_2f0_m4m5_noshield c_length=4U c_width=4U
* device instance $302 r0 *1 34.6,70.6 cap_mim_2f0_m4m5_noshield
X$302 \$56__t7 topp__t490 cap_mim_2f0_m4m5_noshield c_length=4U c_width=4U
* device instance $303 r0 *1 41,70.6 cap_mim_2f0_m4m5_noshield
X$303 \$12__t245 topp__t489 cap_mim_2f0_m4m5_noshield c_length=4U c_width=4U
* device instance $304 r0 *1 47.4,70.6 cap_mim_2f0_m4m5_noshield
X$304 \$56__t6 topp__t488 cap_mim_2f0_m4m5_noshield c_length=4U c_width=4U
* device instance $305 r0 *1 53.8,70.6 cap_mim_2f0_m4m5_noshield
X$305 \$12__t244 topp__t487 cap_mim_2f0_m4m5_noshield c_length=4U c_width=4U
* device instance $306 r0 *1 60.2,70.6 cap_mim_2f0_m4m5_noshield
X$306 \$48__t15 topp__t486 cap_mim_2f0_m4m5_noshield c_length=4U c_width=4U
* device instance $307 r0 *1 66.6,70.6 cap_mim_2f0_m4m5_noshield
X$307 \$12__t243 topp__t485 cap_mim_2f0_m4m5_noshield c_length=4U c_width=4U
* device instance $308 r0 *1 73,70.6 cap_mim_2f0_m4m5_noshield
X$308 \$48__t14 topp__t484 cap_mim_2f0_m4m5_noshield c_length=4U c_width=4U
* device instance $309 r0 *1 79.4,70.6 cap_mim_2f0_m4m5_noshield
X$309 \$12__t242 topp__t483 cap_mim_2f0_m4m5_noshield c_length=4U c_width=4U
* device instance $310 r0 *1 85.8,70.6 cap_mim_2f0_m4m5_noshield
X$310 \$48__t13 topp__t482 cap_mim_2f0_m4m5_noshield c_length=4U c_width=4U
* device instance $311 r0 *1 92.2,70.6 cap_mim_2f0_m4m5_noshield
X$311 \$12__t249 topp__t496 cap_mim_2f0_m4m5_noshield c_length=4U c_width=4U
* device instance $312 r0 *1 98.6,70.6 cap_mim_2f0_m4m5_noshield
X$312 \$48__t12 topp__t450 cap_mim_2f0_m4m5_noshield c_length=4U c_width=4U
* device instance $313 r0 *1 105,70.6 cap_mim_2f0_m4m5_noshield
X$313 \$12__t257 topp__t511 cap_mim_2f0_m4m5_noshield c_length=4U c_width=4U
* device instance $314 r0 *1 111.4,70.6 cap_mim_2f0_m4m5_noshield
X$314 \$40__t30 topp__t495 cap_mim_2f0_m4m5_noshield c_length=4U c_width=4U
* device instance $315 r0 *1 117.8,70.6 cap_mim_2f0_m4m5_noshield
X$315 \$12__t198 topp__t392 cap_mim_2f0_m4m5_noshield c_length=4U c_width=4U
* device instance $316 r0 *1 124.2,70.6 cap_mim_2f0_m4m5_noshield
X$316 \$40__t27 topp__t476 cap_mim_2f0_m4m5_noshield c_length=4U c_width=4U
* device instance $317 r0 *1 130.6,70.6 cap_mim_2f0_m4m5_noshield
X$317 \$12__t233 topp__t462 cap_mim_2f0_m4m5_noshield c_length=4U c_width=4U
* device instance $318 r0 *1 137,70.6 cap_mim_2f0_m4m5_noshield
X$318 \$40__t25 topp__t461 cap_mim_2f0_m4m5_noshield c_length=4U c_width=4U
* device instance $319 r0 *1 143.4,70.6 cap_mim_2f0_m4m5_noshield
X$319 \$12__t232 topp__t460 cap_mim_2f0_m4m5_noshield c_length=4U c_width=4U
* device instance $320 r0 *1 149.8,70.6 cap_mim_2f0_m4m5_noshield
X$320 \$40__t24 topp__t459 cap_mim_2f0_m4m5_noshield c_length=4U c_width=4U
* device instance $321 r0 *1 156.2,70.6 cap_mim_2f0_m4m5_noshield
X$321 \$12__t231 topp__t458 cap_mim_2f0_m4m5_noshield c_length=4U c_width=4U
* device instance $322 r0 *1 162.6,70.6 cap_mim_2f0_m4m5_noshield
X$322 \$40__t26 topp__t471 cap_mim_2f0_m4m5_noshield c_length=4U c_width=4U
* device instance $323 r0 *1 169,70.6 cap_mim_2f0_m4m5_noshield
X$323 \$12__t256 topp__t510 cap_mim_2f0_m4m5_noshield c_length=4U c_width=4U
* device instance $324 r0 *1 175.4,70.6 cap_mim_2f0_m4m5_noshield
X$324 \$40__t31 topp__t497 cap_mim_2f0_m4m5_noshield c_length=4U c_width=4U
* device instance $325 r0 *1 181.8,70.6 cap_mim_2f0_m4m5_noshield
X$325 \$12__t241 topp__t480 cap_mim_2f0_m4m5_noshield c_length=4U c_width=4U
* device instance $326 r0 *1 188.2,70.6 cap_mim_2f0_m4m5_noshield
X$326 \$40__t29 topp__t479 cap_mim_2f0_m4m5_noshield c_length=4U c_width=4U
* device instance $327 r0 *1 194.6,70.6 cap_mim_2f0_m4m5_noshield
X$327 \$12__t240 topp__t478 cap_mim_2f0_m4m5_noshield c_length=4U c_width=4U
* device instance $328 r0 *1 201,70.6 cap_mim_2f0_m4m5_noshield
X$328 \$40__t28 topp__t477 cap_mim_2f0_m4m5_noshield c_length=4U c_width=4U
* device instance $329 r0 *1 224,70.6 cap_mim_2f0_m4m5_noshield
X$329 \$81__t252 topn__t506 cap_mim_2f0_m4m5_noshield c_length=4U c_width=4U
* device instance $330 r0 *1 230.4,70.6 cap_mim_2f0_m4m5_noshield
X$330 \$89__t1 topn__t505 cap_mim_2f0_m4m5_noshield c_length=4U c_width=4U
* device instance $331 r0 *1 236.8,70.6 cap_mim_2f0_m4m5_noshield
X$331 \$81__t173 topn__t346 cap_mim_2f0_m4m5_noshield c_length=4U c_width=4U
* device instance $332 r0 *1 243.2,70.6 cap_mim_2f0_m4m5_noshield
X$332 \$88__t3 topn__t345 cap_mim_2f0_m4m5_noshield c_length=4U c_width=4U
* device instance $333 r0 *1 249.6,70.6 cap_mim_2f0_m4m5_noshield
X$333 \$81__t172 topn__t344 cap_mim_2f0_m4m5_noshield c_length=4U c_width=4U
* device instance $334 r0 *1 256,70.6 cap_mim_2f0_m4m5_noshield
X$334 \$87__t7 topn__t343 cap_mim_2f0_m4m5_noshield c_length=4U c_width=4U
* device instance $335 r0 *1 262.4,70.6 cap_mim_2f0_m4m5_noshield
X$335 \$81__t171 topn__t342 cap_mim_2f0_m4m5_noshield c_length=4U c_width=4U
* device instance $336 r0 *1 268.8,70.6 cap_mim_2f0_m4m5_noshield
X$336 \$87__t6 topn__t341 cap_mim_2f0_m4m5_noshield c_length=4U c_width=4U
* device instance $337 r0 *1 275.2,70.6 cap_mim_2f0_m4m5_noshield
X$337 \$81__t170 topn__t340 cap_mim_2f0_m4m5_noshield c_length=4U c_width=4U
* device instance $338 r0 *1 281.6,70.6 cap_mim_2f0_m4m5_noshield
X$338 \$86__t9 topn__t339 cap_mim_2f0_m4m5_noshield c_length=4U c_width=4U
* device instance $339 r0 *1 288,70.6 cap_mim_2f0_m4m5_noshield
X$339 \$81__t169 topn__t338 cap_mim_2f0_m4m5_noshield c_length=4U c_width=4U
* device instance $340 r0 *1 294.4,70.6 cap_mim_2f0_m4m5_noshield
X$340 \$86__t12 topn__t385 cap_mim_2f0_m4m5_noshield c_length=4U c_width=4U
* device instance $341 r0 *1 300.8,70.6 cap_mim_2f0_m4m5_noshield
X$341 \$81__t199 topn__t400 cap_mim_2f0_m4m5_noshield c_length=4U c_width=4U
* device instance $342 r0 *1 307.2,70.6 cap_mim_2f0_m4m5_noshield
X$342 \$86__t7 topn__t211 cap_mim_2f0_m4m5_noshield c_length=4U c_width=4U
* device instance $343 r0 *1 313.6,70.6 cap_mim_2f0_m4m5_noshield
X$343 \$81__t176 topn__t352 cap_mim_2f0_m4m5_noshield c_length=4U c_width=4U
* device instance $344 r0 *1 320,70.6 cap_mim_2f0_m4m5_noshield
X$344 \$86__t10 topn__t351 cap_mim_2f0_m4m5_noshield c_length=4U c_width=4U
* device instance $345 r0 *1 326.4,70.6 cap_mim_2f0_m4m5_noshield
X$345 \$81__t175 topn__t350 cap_mim_2f0_m4m5_noshield c_length=4U c_width=4U
* device instance $346 r0 *1 332.8,70.6 cap_mim_2f0_m4m5_noshield
X$346 \$85__t22 topn__t349 cap_mim_2f0_m4m5_noshield c_length=4U c_width=4U
* device instance $347 r0 *1 339.2,70.6 cap_mim_2f0_m4m5_noshield
X$347 \$81__t174 topn__t348 cap_mim_2f0_m4m5_noshield c_length=4U c_width=4U
* device instance $348 r0 *1 345.6,70.6 cap_mim_2f0_m4m5_noshield
X$348 \$85__t21 topn__t347 cap_mim_2f0_m4m5_noshield c_length=4U c_width=4U
* device instance $349 r0 *1 352,70.6 cap_mim_2f0_m4m5_noshield
X$349 \$81__t137 topn__t277 cap_mim_2f0_m4m5_noshield c_length=4U c_width=4U
* device instance $350 r0 *1 358.4,70.6 cap_mim_2f0_m4m5_noshield
X$350 \$85__t15 topn__t214 cap_mim_2f0_m4m5_noshield c_length=4U c_width=4U
* device instance $351 r0 *1 364.8,70.6 cap_mim_2f0_m4m5_noshield
X$351 \$81__t113 topn__t230 cap_mim_2f0_m4m5_noshield c_length=4U c_width=4U
* device instance $352 r0 *1 371.2,70.6 cap_mim_2f0_m4m5_noshield
X$352 \$85__t19 topn__t229 cap_mim_2f0_m4m5_noshield c_length=4U c_width=4U
* device instance $353 r0 *1 377.6,70.6 cap_mim_2f0_m4m5_noshield
X$353 \$81__t112 topn__t228 cap_mim_2f0_m4m5_noshield c_length=4U c_width=4U
* device instance $354 r0 *1 384,70.6 cap_mim_2f0_m4m5_noshield
X$354 \$85__t18 topn__t227 cap_mim_2f0_m4m5_noshield c_length=4U c_width=4U
* device instance $355 r0 *1 390.4,70.6 cap_mim_2f0_m4m5_noshield
X$355 \$81__t111 topn__t226 cap_mim_2f0_m4m5_noshield c_length=4U c_width=4U
* device instance $356 r0 *1 396.8,70.6 cap_mim_2f0_m4m5_noshield
X$356 \$85__t20 topn__t241 cap_mim_2f0_m4m5_noshield c_length=4U c_width=4U
* device instance $357 r0 *1 403.2,70.6 cap_mim_2f0_m4m5_noshield
X$357 \$81__t109 topn__t224 cap_mim_2f0_m4m5_noshield c_length=4U c_width=4U
* device instance $358 r0 *1 409.6,70.6 cap_mim_2f0_m4m5_noshield
X$358 \$85__t17 topn__t218 cap_mim_2f0_m4m5_noshield c_length=4U c_width=4U
* device instance $359 r0 *1 416,70.6 cap_mim_2f0_m4m5_noshield
X$359 \$81__t105 topn__t216 cap_mim_2f0_m4m5_noshield c_length=4U c_width=4U
* device instance $360 r0 *1 422.4,70.6 cap_mim_2f0_m4m5_noshield
X$360 \$85__t16 topn__t215 cap_mim_2f0_m4m5_noshield c_length=4U c_width=4U
* device instance $361 r0 *1 2.6,77 cap_mim_2f0_m4m5_noshield
X$361 \$12__t229 topp__t456 cap_mim_2f0_m4m5_noshield c_length=4U c_width=4U
* device instance $362 r0 *1 9,77 cap_mim_2f0_m4m5_noshield
X$362 \$32__t50 topp__t455 cap_mim_2f0_m4m5_noshield c_length=4U c_width=4U
* device instance $363 r0 *1 15.4,77 cap_mim_2f0_m4m5_noshield
X$363 \$12__t228 topp__t454 cap_mim_2f0_m4m5_noshield c_length=4U c_width=4U
* device instance $364 r0 *1 21.8,77 cap_mim_2f0_m4m5_noshield
X$364 \$32__t49 topp__t453 cap_mim_2f0_m4m5_noshield c_length=4U c_width=4U
* device instance $365 r0 *1 28.2,77 cap_mim_2f0_m4m5_noshield
X$365 \$12__t227 topp__t452 cap_mim_2f0_m4m5_noshield c_length=4U c_width=4U
* device instance $366 r0 *1 34.6,77 cap_mim_2f0_m4m5_noshield
X$366 \$32__t48 topp__t451 cap_mim_2f0_m4m5_noshield c_length=4U c_width=4U
* device instance $367 r0 *1 41,77 cap_mim_2f0_m4m5_noshield
X$367 \$12__t250 topp__t498 cap_mim_2f0_m4m5_noshield c_length=4U c_width=4U
* device instance $368 r0 *1 47.4,77 cap_mim_2f0_m4m5_noshield
X$368 \$32__t58 topp__t499 cap_mim_2f0_m4m5_noshield c_length=4U c_width=4U
* device instance $369 r0 *1 53.8,77 cap_mim_2f0_m4m5_noshield
X$369 \$12__t251 topp__t500 cap_mim_2f0_m4m5_noshield c_length=4U c_width=4U
* device instance $370 r0 *1 60.2,77 cap_mim_2f0_m4m5_noshield
X$370 \$32__t59 topp__t501 cap_mim_2f0_m4m5_noshield c_length=4U c_width=4U
* device instance $371 r0 *1 66.6,77 cap_mim_2f0_m4m5_noshield
X$371 \$12__t252 topp__t502 cap_mim_2f0_m4m5_noshield c_length=4U c_width=4U
* device instance $372 r0 *1 73,77 cap_mim_2f0_m4m5_noshield
X$372 \$32__t60 topp__t503 cap_mim_2f0_m4m5_noshield c_length=4U c_width=4U
* device instance $373 r0 *1 79.4,77 cap_mim_2f0_m4m5_noshield
X$373 \$12__t253 topp__t504 cap_mim_2f0_m4m5_noshield c_length=4U c_width=4U
* device instance $374 r0 *1 85.8,77 cap_mim_2f0_m4m5_noshield
X$374 \$32__t61 topp__t505 cap_mim_2f0_m4m5_noshield c_length=4U c_width=4U
* device instance $375 r0 *1 92.2,77 cap_mim_2f0_m4m5_noshield
X$375 \$12__t254 topp__t506 cap_mim_2f0_m4m5_noshield c_length=4U c_width=4U
* device instance $376 r0 *1 98.6,77 cap_mim_2f0_m4m5_noshield
X$376 \$32__t62 topp__t507 cap_mim_2f0_m4m5_noshield c_length=4U c_width=4U
* device instance $377 r0 *1 105,77 cap_mim_2f0_m4m5_noshield
X$377 \$12__t255 topp__t508 cap_mim_2f0_m4m5_noshield c_length=4U c_width=4U
* device instance $378 r0 *1 111.4,77 cap_mim_2f0_m4m5_noshield
X$378 \$32__t63 topp__t509 cap_mim_2f0_m4m5_noshield c_length=4U c_width=4U
* device instance $379 r0 *1 117.8,77 cap_mim_2f0_m4m5_noshield
X$379 \$12__t197 topp__t391 cap_mim_2f0_m4m5_noshield c_length=4U c_width=4U
* device instance $380 r0 *1 124.2,77 cap_mim_2f0_m4m5_noshield
X$380 \$32__t56 topp__t475 cap_mim_2f0_m4m5_noshield c_length=4U c_width=4U
* device instance $381 r0 *1 130.6,77 cap_mim_2f0_m4m5_noshield
X$381 \$12__t239 topp__t474 cap_mim_2f0_m4m5_noshield c_length=4U c_width=4U
* device instance $382 r0 *1 137,77 cap_mim_2f0_m4m5_noshield
X$382 \$32__t55 topp__t473 cap_mim_2f0_m4m5_noshield c_length=4U c_width=4U
* device instance $383 r0 *1 143.4,77 cap_mim_2f0_m4m5_noshield
X$383 \$12__t238 topp__t472 cap_mim_2f0_m4m5_noshield c_length=4U c_width=4U
* device instance $384 r0 *1 149.8,77 cap_mim_2f0_m4m5_noshield
X$384 \$32__t57 topp__t481 cap_mim_2f0_m4m5_noshield c_length=4U c_width=4U
* device instance $385 r0 *1 156.2,77 cap_mim_2f0_m4m5_noshield
X$385 \$12__t237 topp__t470 cap_mim_2f0_m4m5_noshield c_length=4U c_width=4U
* device instance $386 r0 *1 162.6,77 cap_mim_2f0_m4m5_noshield
X$386 \$32__t54 topp__t469 cap_mim_2f0_m4m5_noshield c_length=4U c_width=4U
* device instance $387 r0 *1 169,77 cap_mim_2f0_m4m5_noshield
X$387 \$12__t236 topp__t468 cap_mim_2f0_m4m5_noshield c_length=4U c_width=4U
* device instance $388 r0 *1 175.4,77 cap_mim_2f0_m4m5_noshield
X$388 \$32__t53 topp__t467 cap_mim_2f0_m4m5_noshield c_length=4U c_width=4U
* device instance $389 r0 *1 181.8,77 cap_mim_2f0_m4m5_noshield
X$389 \$12__t235 topp__t466 cap_mim_2f0_m4m5_noshield c_length=4U c_width=4U
* device instance $390 r0 *1 188.2,77 cap_mim_2f0_m4m5_noshield
X$390 \$32__t52 topp__t465 cap_mim_2f0_m4m5_noshield c_length=4U c_width=4U
* device instance $391 r0 *1 194.6,77 cap_mim_2f0_m4m5_noshield
X$391 \$12__t234 topp__t464 cap_mim_2f0_m4m5_noshield c_length=4U c_width=4U
* device instance $392 r0 *1 201,77 cap_mim_2f0_m4m5_noshield
X$392 \$32__t51 topp__t463 cap_mim_2f0_m4m5_noshield c_length=4U c_width=4U
* device instance $393 r0 *1 224,77 cap_mim_2f0_m4m5_noshield
X$393 \$81__t251 topn__t504 cap_mim_2f0_m4m5_noshield c_length=4U c_width=4U
* device instance $394 r0 *1 230.4,77 cap_mim_2f0_m4m5_noshield
X$394 \$84__t63 topn__t503 cap_mim_2f0_m4m5_noshield c_length=4U c_width=4U
* device instance $395 r0 *1 236.8,77 cap_mim_2f0_m4m5_noshield
X$395 \$81__t103 topn__t210 cap_mim_2f0_m4m5_noshield c_length=4U c_width=4U
* device instance $396 r0 *1 243.2,77 cap_mim_2f0_m4m5_noshield
X$396 \$84__t31 topn__t321 cap_mim_2f0_m4m5_noshield c_length=4U c_width=4U
* device instance $397 r0 *1 249.6,77 cap_mim_2f0_m4m5_noshield
X$397 \$81__t184 topn__t368 cap_mim_2f0_m4m5_noshield c_length=4U c_width=4U
* device instance $398 r0 *1 256,77 cap_mim_2f0_m4m5_noshield
X$398 \$84__t38 topn__t367 cap_mim_2f0_m4m5_noshield c_length=4U c_width=4U
* device instance $399 r0 *1 262.4,77 cap_mim_2f0_m4m5_noshield
X$399 \$81__t183 topn__t366 cap_mim_2f0_m4m5_noshield c_length=4U c_width=4U
* device instance $400 r0 *1 268.8,77 cap_mim_2f0_m4m5_noshield
X$400 \$84__t37 topn__t365 cap_mim_2f0_m4m5_noshield c_length=4U c_width=4U
* device instance $401 r0 *1 275.2,77 cap_mim_2f0_m4m5_noshield
X$401 \$81__t182 topn__t364 cap_mim_2f0_m4m5_noshield c_length=4U c_width=4U
* device instance $402 r0 *1 281.6,77 cap_mim_2f0_m4m5_noshield
X$402 \$84__t36 topn__t363 cap_mim_2f0_m4m5_noshield c_length=4U c_width=4U
* device instance $403 r0 *1 288,77 cap_mim_2f0_m4m5_noshield
X$403 \$81__t181 topn__t362 cap_mim_2f0_m4m5_noshield c_length=4U c_width=4U
* device instance $404 r0 *1 294.4,77 cap_mim_2f0_m4m5_noshield
X$404 \$84__t35 topn__t361 cap_mim_2f0_m4m5_noshield c_length=4U c_width=4U
* device instance $405 r0 *1 300.8,77 cap_mim_2f0_m4m5_noshield
X$405 \$81__t180 topn__t360 cap_mim_2f0_m4m5_noshield c_length=4U c_width=4U
* device instance $406 r0 *1 307.2,77 cap_mim_2f0_m4m5_noshield
X$406 \$84__t34 topn__t359 cap_mim_2f0_m4m5_noshield c_length=4U c_width=4U
* device instance $407 r0 *1 313.6,77 cap_mim_2f0_m4m5_noshield
X$407 \$81__t179 topn__t358 cap_mim_2f0_m4m5_noshield c_length=4U c_width=4U
* device instance $408 r0 *1 320,77 cap_mim_2f0_m4m5_noshield
X$408 \$84__t33 topn__t357 cap_mim_2f0_m4m5_noshield c_length=4U c_width=4U
* device instance $409 r0 *1 326.4,77 cap_mim_2f0_m4m5_noshield
X$409 \$81__t178 topn__t356 cap_mim_2f0_m4m5_noshield c_length=4U c_width=4U
* device instance $410 r0 *1 332.8,77 cap_mim_2f0_m4m5_noshield
X$410 \$84__t32 topn__t355 cap_mim_2f0_m4m5_noshield c_length=4U c_width=4U
* device instance $411 r0 *1 339.2,77 cap_mim_2f0_m4m5_noshield
X$411 \$81__t177 topn__t354 cap_mim_2f0_m4m5_noshield c_length=4U c_width=4U
* device instance $412 r0 *1 345.6,77 cap_mim_2f0_m4m5_noshield
X$412 \$84__t39 topn__t369 cap_mim_2f0_m4m5_noshield c_length=4U c_width=4U
* device instance $413 r0 *1 352,77 cap_mim_2f0_m4m5_noshield
X$413 \$81__t136 topn__t276 cap_mim_2f0_m4m5_noshield c_length=4U c_width=4U
* device instance $414 r0 *1 358.4,77 cap_mim_2f0_m4m5_noshield
X$414 \$84__t17 topn__t213 cap_mim_2f0_m4m5_noshield c_length=4U c_width=4U
* device instance $415 r0 *1 364.8,77 cap_mim_2f0_m4m5_noshield
X$415 \$81__t104 topn__t212 cap_mim_2f0_m4m5_noshield c_length=4U c_width=4U
* device instance $416 r0 *1 371.2,77 cap_mim_2f0_m4m5_noshield
X$416 \$84__t25 topn__t239 cap_mim_2f0_m4m5_noshield c_length=4U c_width=4U
* device instance $417 r0 *1 377.6,77 cap_mim_2f0_m4m5_noshield
X$417 \$81__t117 topn__t238 cap_mim_2f0_m4m5_noshield c_length=4U c_width=4U
* device instance $418 r0 *1 384,77 cap_mim_2f0_m4m5_noshield
X$418 \$84__t24 topn__t237 cap_mim_2f0_m4m5_noshield c_length=4U c_width=4U
* device instance $419 r0 *1 390.4,77 cap_mim_2f0_m4m5_noshield
X$419 \$81__t116 topn__t236 cap_mim_2f0_m4m5_noshield c_length=4U c_width=4U
* device instance $420 r0 *1 396.8,77 cap_mim_2f0_m4m5_noshield
X$420 \$84__t23 topn__t235 cap_mim_2f0_m4m5_noshield c_length=4U c_width=4U
* device instance $421 r0 *1 403.2,77 cap_mim_2f0_m4m5_noshield
X$421 \$81__t115 topn__t234 cap_mim_2f0_m4m5_noshield c_length=4U c_width=4U
* device instance $422 r0 *1 409.6,77 cap_mim_2f0_m4m5_noshield
X$422 \$84__t22 topn__t233 cap_mim_2f0_m4m5_noshield c_length=4U c_width=4U
* device instance $423 r0 *1 416,77 cap_mim_2f0_m4m5_noshield
X$423 \$81__t114 topn__t232 cap_mim_2f0_m4m5_noshield c_length=4U c_width=4U
* device instance $424 r0 *1 422.4,77 cap_mim_2f0_m4m5_noshield
X$424 \$84__t21 topn__t231 cap_mim_2f0_m4m5_noshield c_length=4U c_width=4U
* device instance $425 r0 *1 2.6,83.4 cap_mim_2f0_m4m5_noshield
X$425 \$12__t168 topp__t335 cap_mim_2f0_m4m5_noshield c_length=4U c_width=4U
* device instance $426 r0 *1 9,83.4 cap_mim_2f0_m4m5_noshield
X$426 \$24__t91 topp__t336 cap_mim_2f0_m4m5_noshield c_length=4U c_width=4U
* device instance $427 r0 *1 15.4,83.4 cap_mim_2f0_m4m5_noshield
X$427 \$12__t169 topp__t337 cap_mim_2f0_m4m5_noshield c_length=4U c_width=4U
* device instance $428 r0 *1 21.8,83.4 cap_mim_2f0_m4m5_noshield
X$428 \$24__t92 topp__t338 cap_mim_2f0_m4m5_noshield c_length=4U c_width=4U
* device instance $429 r0 *1 28.2,83.4 cap_mim_2f0_m4m5_noshield
X$429 \$12__t170 topp__t339 cap_mim_2f0_m4m5_noshield c_length=4U c_width=4U
* device instance $430 r0 *1 34.6,83.4 cap_mim_2f0_m4m5_noshield
X$430 \$24__t93 topp__t340 cap_mim_2f0_m4m5_noshield c_length=4U c_width=4U
* device instance $431 r0 *1 41,83.4 cap_mim_2f0_m4m5_noshield
X$431 \$12__t171 topp__t341 cap_mim_2f0_m4m5_noshield c_length=4U c_width=4U
* device instance $432 r0 *1 47.4,83.4 cap_mim_2f0_m4m5_noshield
X$432 \$24__t94 topp__t342 cap_mim_2f0_m4m5_noshield c_length=4U c_width=4U
* device instance $433 r0 *1 53.8,83.4 cap_mim_2f0_m4m5_noshield
X$433 \$12__t172 topp__t343 cap_mim_2f0_m4m5_noshield c_length=4U c_width=4U
* device instance $434 r0 *1 60.2,83.4 cap_mim_2f0_m4m5_noshield
X$434 \$24__t95 topp__t344 cap_mim_2f0_m4m5_noshield c_length=4U c_width=4U
* device instance $435 r0 *1 66.6,83.4 cap_mim_2f0_m4m5_noshield
X$435 \$12__t173 topp__t345 cap_mim_2f0_m4m5_noshield c_length=4U c_width=4U
* device instance $436 r0 *1 73,83.4 cap_mim_2f0_m4m5_noshield
X$436 \$24__t96 topp__t346 cap_mim_2f0_m4m5_noshield c_length=4U c_width=4U
* device instance $437 r0 *1 79.4,83.4 cap_mim_2f0_m4m5_noshield
X$437 \$12__t174 topp__t347 cap_mim_2f0_m4m5_noshield c_length=4U c_width=4U
* device instance $438 r0 *1 85.8,83.4 cap_mim_2f0_m4m5_noshield
X$438 \$24__t97 topp__t348 cap_mim_2f0_m4m5_noshield c_length=4U c_width=4U
* device instance $439 r0 *1 92.2,83.4 cap_mim_2f0_m4m5_noshield
X$439 \$12__t175 topp__t349 cap_mim_2f0_m4m5_noshield c_length=4U c_width=4U
* device instance $440 r0 *1 98.6,83.4 cap_mim_2f0_m4m5_noshield
X$440 \$24__t106 topp__t366 cap_mim_2f0_m4m5_noshield c_length=4U c_width=4U
* device instance $441 r0 *1 105,83.4 cap_mim_2f0_m4m5_noshield
X$441 \$12__t176 topp__t351 cap_mim_2f0_m4m5_noshield c_length=4U c_width=4U
* device instance $442 r0 *1 111.4,83.4 cap_mim_2f0_m4m5_noshield
X$442 \$24__t99 topp__t352 cap_mim_2f0_m4m5_noshield c_length=4U c_width=4U
* device instance $443 r0 *1 117.8,83.4 cap_mim_2f0_m4m5_noshield
X$443 \$12__t177 topp__t353 cap_mim_2f0_m4m5_noshield c_length=4U c_width=4U
* device instance $444 r0 *1 124.2,83.4 cap_mim_2f0_m4m5_noshield
X$444 \$24__t100 topp__t354 cap_mim_2f0_m4m5_noshield c_length=4U c_width=4U
* device instance $445 r0 *1 130.6,83.4 cap_mim_2f0_m4m5_noshield
X$445 \$12__t178 topp__t355 cap_mim_2f0_m4m5_noshield c_length=4U c_width=4U
* device instance $446 r0 *1 137,83.4 cap_mim_2f0_m4m5_noshield
X$446 \$24__t101 topp__t356 cap_mim_2f0_m4m5_noshield c_length=4U c_width=4U
* device instance $447 r0 *1 143.4,83.4 cap_mim_2f0_m4m5_noshield
X$447 \$12__t179 topp__t357 cap_mim_2f0_m4m5_noshield c_length=4U c_width=4U
* device instance $448 r0 *1 149.8,83.4 cap_mim_2f0_m4m5_noshield
X$448 \$24__t102 topp__t358 cap_mim_2f0_m4m5_noshield c_length=4U c_width=4U
* device instance $449 r0 *1 156.2,83.4 cap_mim_2f0_m4m5_noshield
X$449 \$12__t180 topp__t359 cap_mim_2f0_m4m5_noshield c_length=4U c_width=4U
* device instance $450 r0 *1 162.6,83.4 cap_mim_2f0_m4m5_noshield
X$450 \$24__t103 topp__t360 cap_mim_2f0_m4m5_noshield c_length=4U c_width=4U
* device instance $451 r0 *1 169,83.4 cap_mim_2f0_m4m5_noshield
X$451 \$12__t181 topp__t361 cap_mim_2f0_m4m5_noshield c_length=4U c_width=4U
* device instance $452 r0 *1 175.4,83.4 cap_mim_2f0_m4m5_noshield
X$452 \$24__t104 topp__t362 cap_mim_2f0_m4m5_noshield c_length=4U c_width=4U
* device instance $453 r0 *1 181.8,83.4 cap_mim_2f0_m4m5_noshield
X$453 \$12__t182 topp__t363 cap_mim_2f0_m4m5_noshield c_length=4U c_width=4U
* device instance $454 r0 *1 188.2,83.4 cap_mim_2f0_m4m5_noshield
X$454 \$24__t105 topp__t364 cap_mim_2f0_m4m5_noshield c_length=4U c_width=4U
* device instance $455 r0 *1 194.6,83.4 cap_mim_2f0_m4m5_noshield
X$455 \$12__t183 topp__t365 cap_mim_2f0_m4m5_noshield c_length=4U c_width=4U
* device instance $456 r0 *1 201,83.4 cap_mim_2f0_m4m5_noshield
X$456 \$24__t98 topp__t350 cap_mim_2f0_m4m5_noshield c_length=4U c_width=4U
* device instance $457 r0 *1 224,83.4 cap_mim_2f0_m4m5_noshield
X$457 \$81__t153 topn__t306 cap_mim_2f0_m4m5_noshield c_length=4U c_width=4U
* device instance $458 r0 *1 230.4,83.4 cap_mim_2f0_m4m5_noshield
X$458 \$83__t81 topn__t307 cap_mim_2f0_m4m5_noshield c_length=4U c_width=4U
* device instance $459 r0 *1 236.8,83.4 cap_mim_2f0_m4m5_noshield
X$459 \$81__t154 topn__t308 cap_mim_2f0_m4m5_noshield c_length=4U c_width=4U
* device instance $460 r0 *1 243.2,83.4 cap_mim_2f0_m4m5_noshield
X$460 \$83__t82 topn__t309 cap_mim_2f0_m4m5_noshield c_length=4U c_width=4U
* device instance $461 r0 *1 249.6,83.4 cap_mim_2f0_m4m5_noshield
X$461 \$81__t155 topn__t310 cap_mim_2f0_m4m5_noshield c_length=4U c_width=4U
* device instance $462 r0 *1 256,83.4 cap_mim_2f0_m4m5_noshield
X$462 \$83__t83 topn__t311 cap_mim_2f0_m4m5_noshield c_length=4U c_width=4U
* device instance $463 r0 *1 262.4,83.4 cap_mim_2f0_m4m5_noshield
X$463 \$81__t156 topn__t312 cap_mim_2f0_m4m5_noshield c_length=4U c_width=4U
* device instance $464 r0 *1 268.8,83.4 cap_mim_2f0_m4m5_noshield
X$464 \$83__t84 topn__t313 cap_mim_2f0_m4m5_noshield c_length=4U c_width=4U
* device instance $465 r0 *1 275.2,83.4 cap_mim_2f0_m4m5_noshield
X$465 \$81__t157 topn__t314 cap_mim_2f0_m4m5_noshield c_length=4U c_width=4U
* device instance $466 r0 *1 281.6,83.4 cap_mim_2f0_m4m5_noshield
X$466 \$83__t85 topn__t315 cap_mim_2f0_m4m5_noshield c_length=4U c_width=4U
* device instance $467 r0 *1 288,83.4 cap_mim_2f0_m4m5_noshield
X$467 \$81__t158 topn__t316 cap_mim_2f0_m4m5_noshield c_length=4U c_width=4U
* device instance $468 r0 *1 294.4,83.4 cap_mim_2f0_m4m5_noshield
X$468 \$83__t86 topn__t317 cap_mim_2f0_m4m5_noshield c_length=4U c_width=4U
* device instance $469 r0 *1 300.8,83.4 cap_mim_2f0_m4m5_noshield
X$469 \$81__t159 topn__t318 cap_mim_2f0_m4m5_noshield c_length=4U c_width=4U
* device instance $470 r0 *1 307.2,83.4 cap_mim_2f0_m4m5_noshield
X$470 \$83__t87 topn__t319 cap_mim_2f0_m4m5_noshield c_length=4U c_width=4U
* device instance $471 r0 *1 313.6,83.4 cap_mim_2f0_m4m5_noshield
X$471 \$81__t160 topn__t320 cap_mim_2f0_m4m5_noshield c_length=4U c_width=4U
* device instance $472 r0 *1 320,83.4 cap_mim_2f0_m4m5_noshield
X$472 \$83__t95 topn__t337 cap_mim_2f0_m4m5_noshield c_length=4U c_width=4U
* device instance $473 r0 *1 326.4,83.4 cap_mim_2f0_m4m5_noshield
X$473 \$81__t161 topn__t322 cap_mim_2f0_m4m5_noshield c_length=4U c_width=4U
* device instance $474 r0 *1 332.8,83.4 cap_mim_2f0_m4m5_noshield
X$474 \$83__t88 topn__t323 cap_mim_2f0_m4m5_noshield c_length=4U c_width=4U
* device instance $475 r0 *1 339.2,83.4 cap_mim_2f0_m4m5_noshield
X$475 \$81__t162 topn__t324 cap_mim_2f0_m4m5_noshield c_length=4U c_width=4U
* device instance $476 r0 *1 345.6,83.4 cap_mim_2f0_m4m5_noshield
X$476 \$83__t89 topn__t325 cap_mim_2f0_m4m5_noshield c_length=4U c_width=4U
* device instance $477 r0 *1 352,83.4 cap_mim_2f0_m4m5_noshield
X$477 \$81__t163 topn__t326 cap_mim_2f0_m4m5_noshield c_length=4U c_width=4U
* device instance $478 r0 *1 358.4,83.4 cap_mim_2f0_m4m5_noshield
X$478 \$83__t90 topn__t327 cap_mim_2f0_m4m5_noshield c_length=4U c_width=4U
* device instance $479 r0 *1 364.8,83.4 cap_mim_2f0_m4m5_noshield
X$479 \$81__t164 topn__t328 cap_mim_2f0_m4m5_noshield c_length=4U c_width=4U
* device instance $480 r0 *1 371.2,83.4 cap_mim_2f0_m4m5_noshield
X$480 \$83__t91 topn__t329 cap_mim_2f0_m4m5_noshield c_length=4U c_width=4U
* device instance $481 r0 *1 377.6,83.4 cap_mim_2f0_m4m5_noshield
X$481 \$81__t165 topn__t330 cap_mim_2f0_m4m5_noshield c_length=4U c_width=4U
* device instance $482 r0 *1 384,83.4 cap_mim_2f0_m4m5_noshield
X$482 \$83__t92 topn__t331 cap_mim_2f0_m4m5_noshield c_length=4U c_width=4U
* device instance $483 r0 *1 390.4,83.4 cap_mim_2f0_m4m5_noshield
X$483 \$81__t166 topn__t332 cap_mim_2f0_m4m5_noshield c_length=4U c_width=4U
* device instance $484 r0 *1 396.8,83.4 cap_mim_2f0_m4m5_noshield
X$484 \$83__t93 topn__t333 cap_mim_2f0_m4m5_noshield c_length=4U c_width=4U
* device instance $485 r0 *1 403.2,83.4 cap_mim_2f0_m4m5_noshield
X$485 \$81__t167 topn__t334 cap_mim_2f0_m4m5_noshield c_length=4U c_width=4U
* device instance $486 r0 *1 409.6,83.4 cap_mim_2f0_m4m5_noshield
X$486 \$83__t94 topn__t335 cap_mim_2f0_m4m5_noshield c_length=4U c_width=4U
* device instance $487 r0 *1 416,83.4 cap_mim_2f0_m4m5_noshield
X$487 \$81__t168 topn__t336 cap_mim_2f0_m4m5_noshield c_length=4U c_width=4U
* device instance $488 r0 *1 422.4,83.4 cap_mim_2f0_m4m5_noshield
X$488 \$83__t96 topn__t353 cap_mim_2f0_m4m5_noshield c_length=4U c_width=4U
* device instance $489 r0 *1 2.6,89.8 cap_mim_2f0_m4m5_noshield
X$489 \$12__t66 topp__t129 cap_mim_2f0_m4m5_noshield c_length=4U c_width=4U
* device instance $490 r0 *1 9,89.8 cap_mim_2f0_m4m5_noshield
X$490 \$24__t34 topp__t128 cap_mim_2f0_m4m5_noshield c_length=4U c_width=4U
* device instance $491 r0 *1 15.4,89.8 cap_mim_2f0_m4m5_noshield
X$491 \$12__t67 topp__t131 cap_mim_2f0_m4m5_noshield c_length=4U c_width=4U
* device instance $492 r0 *1 21.8,89.8 cap_mim_2f0_m4m5_noshield
X$492 \$24__t35 topp__t130 cap_mim_2f0_m4m5_noshield c_length=4U c_width=4U
* device instance $493 r0 *1 28.2,89.8 cap_mim_2f0_m4m5_noshield
X$493 \$12__t65 topp__t127 cap_mim_2f0_m4m5_noshield c_length=4U c_width=4U
* device instance $494 r0 *1 34.6,89.8 cap_mim_2f0_m4m5_noshield
X$494 \$24__t33 topp__t126 cap_mim_2f0_m4m5_noshield c_length=4U c_width=4U
* device instance $495 r0 *1 41,89.8 cap_mim_2f0_m4m5_noshield
X$495 \$12__t92 topp__t182 cap_mim_2f0_m4m5_noshield c_length=4U c_width=4U
* device instance $496 r0 *1 47.4,89.8 cap_mim_2f0_m4m5_noshield
X$496 \$24__t36 topp__t133 cap_mim_2f0_m4m5_noshield c_length=4U c_width=4U
* device instance $497 r0 *1 53.8,89.8 cap_mim_2f0_m4m5_noshield
X$497 \$12__t68 topp__t132 cap_mim_2f0_m4m5_noshield c_length=4U c_width=4U
* device instance $498 r0 *1 60.2,89.8 cap_mim_2f0_m4m5_noshield
X$498 \$24__t53 topp__t190 cap_mim_2f0_m4m5_noshield c_length=4U c_width=4U
* device instance $499 r0 *1 66.6,89.8 cap_mim_2f0_m4m5_noshield
X$499 \$12__t87 topp__t170 cap_mim_2f0_m4m5_noshield c_length=4U c_width=4U
* device instance $500 r0 *1 73,89.8 cap_mim_2f0_m4m5_noshield
X$500 \$24__t42 topp__t164 cap_mim_2f0_m4m5_noshield c_length=4U c_width=4U
* device instance $501 r0 *1 79.4,89.8 cap_mim_2f0_m4m5_noshield
X$501 \$12__t81 topp__t158 cap_mim_2f0_m4m5_noshield c_length=4U c_width=4U
* device instance $502 r0 *1 85.8,89.8 cap_mim_2f0_m4m5_noshield
X$502 \$24__t46 topp__t171 cap_mim_2f0_m4m5_noshield c_length=4U c_width=4U
* device instance $503 r0 *1 92.2,89.8 cap_mim_2f0_m4m5_noshield
X$503 \$12__t84 topp__t163 cap_mim_2f0_m4m5_noshield c_length=4U c_width=4U
* device instance $504 r0 *1 98.6,89.8 cap_mim_2f0_m4m5_noshield
X$504 \$24__t41 topp__t162 cap_mim_2f0_m4m5_noshield c_length=4U c_width=4U
* device instance $505 r0 *1 105,89.8 cap_mim_2f0_m4m5_noshield
X$505 \$12__t83 topp__t161 cap_mim_2f0_m4m5_noshield c_length=4U c_width=4U
* device instance $506 r0 *1 111.4,89.8 cap_mim_2f0_m4m5_noshield
X$506 \$24__t40 topp__t160 cap_mim_2f0_m4m5_noshield c_length=4U c_width=4U
* device instance $507 r0 *1 117.8,89.8 cap_mim_2f0_m4m5_noshield
X$507 \$12__t136 topp__t273 cap_mim_2f0_m4m5_noshield c_length=4U c_width=4U
* device instance $508 r0 *1 124.2,89.8 cap_mim_2f0_m4m5_noshield
X$508 \$24__t117 topp__t414 cap_mim_2f0_m4m5_noshield c_length=4U c_width=4U
* device instance $509 r0 *1 130.6,89.8 cap_mim_2f0_m4m5_noshield
X$509 \$12__t199 topp__t394 cap_mim_2f0_m4m5_noshield c_length=4U c_width=4U
* device instance $510 r0 *1 137,89.8 cap_mim_2f0_m4m5_noshield
X$510 \$24__t112 topp__t393 cap_mim_2f0_m4m5_noshield c_length=4U c_width=4U
* device instance $511 r0 *1 143.4,89.8 cap_mim_2f0_m4m5_noshield
X$511 \$12__t218 topp__t433 cap_mim_2f0_m4m5_noshield c_length=4U c_width=4U
* device instance $512 r0 *1 149.8,89.8 cap_mim_2f0_m4m5_noshield
X$512 \$24__t126 topp__t445 cap_mim_2f0_m4m5_noshield c_length=4U c_width=4U
* device instance $513 r0 *1 156.2,89.8 cap_mim_2f0_m4m5_noshield
X$513 \$12__t223 topp__t444 cap_mim_2f0_m4m5_noshield c_length=4U c_width=4U
* device instance $514 r0 *1 162.6,89.8 cap_mim_2f0_m4m5_noshield
X$514 \$24__t125 topp__t443 cap_mim_2f0_m4m5_noshield c_length=4U c_width=4U
* device instance $515 r0 *1 169,89.8 cap_mim_2f0_m4m5_noshield
X$515 \$12__t194 topp__t386 cap_mim_2f0_m4m5_noshield c_length=4U c_width=4U
* device instance $516 r0 *1 175.4,89.8 cap_mim_2f0_m4m5_noshield
X$516 \$24__t109 topp__t385 cap_mim_2f0_m4m5_noshield c_length=4U c_width=4U
* device instance $517 r0 *1 181.8,89.8 cap_mim_2f0_m4m5_noshield
X$517 \$12__t193 topp__t384 cap_mim_2f0_m4m5_noshield c_length=4U c_width=4U
* device instance $518 r0 *1 188.2,89.8 cap_mim_2f0_m4m5_noshield
X$518 \$24__t108 topp__t383 cap_mim_2f0_m4m5_noshield c_length=4U c_width=4U
* device instance $519 r0 *1 194.6,89.8 cap_mim_2f0_m4m5_noshield
X$519 \$12__t192 topp__t382 cap_mim_2f0_m4m5_noshield c_length=4U c_width=4U
* device instance $520 r0 *1 201,89.8 cap_mim_2f0_m4m5_noshield
X$520 \$24__t107 topp__t381 cap_mim_2f0_m4m5_noshield c_length=4U c_width=4U
* device instance $521 r0 *1 224,89.8 cap_mim_2f0_m4m5_noshield
X$521 \$81__t202 topn__t406 cap_mim_2f0_m4m5_noshield c_length=4U c_width=4U
* device instance $522 r0 *1 230.4,89.8 cap_mim_2f0_m4m5_noshield
X$522 \$83__t99 topn__t405 cap_mim_2f0_m4m5_noshield c_length=4U c_width=4U
* device instance $523 r0 *1 236.8,89.8 cap_mim_2f0_m4m5_noshield
X$523 \$81__t56 topn__t115 cap_mim_2f0_m4m5_noshield c_length=4U c_width=4U
* device instance $524 r0 *1 243.2,89.8 cap_mim_2f0_m4m5_noshield
X$524 \$83__t29 topn__t87 cap_mim_2f0_m4m5_noshield c_length=4U c_width=4U
* device instance $525 r0 *1 249.6,89.8 cap_mim_2f0_m4m5_noshield
X$525 \$81__t58 topn__t118 cap_mim_2f0_m4m5_noshield c_length=4U c_width=4U
* device instance $526 r0 *1 256,89.8 cap_mim_2f0_m4m5_noshield
X$526 \$83__t14 topn__t34 cap_mim_2f0_m4m5_noshield c_length=4U c_width=4U
* device instance $527 r0 *1 262.4,89.8 cap_mim_2f0_m4m5_noshield
X$527 \$81__t51 topn__t106 cap_mim_2f0_m4m5_noshield c_length=4U c_width=4U
* device instance $528 r0 *1 268.8,89.8 cap_mim_2f0_m4m5_noshield
X$528 \$83__t35 topn__t116 cap_mim_2f0_m4m5_noshield c_length=4U c_width=4U
* device instance $529 r0 *1 275.2,89.8 cap_mim_2f0_m4m5_noshield
X$529 \$81__t50 topn__t104 cap_mim_2f0_m4m5_noshield c_length=4U c_width=4U
* device instance $530 r0 *1 281.6,89.8 cap_mim_2f0_m4m5_noshield
X$530 \$83__t36 topn__t135 cap_mim_2f0_m4m5_noshield c_length=4U c_width=4U
* device instance $531 r0 *1 288,89.8 cap_mim_2f0_m4m5_noshield
X$531 \$81__t57 topn__t117 cap_mim_2f0_m4m5_noshield c_length=4U c_width=4U
* device instance $532 r0 *1 294.4,89.8 cap_mim_2f0_m4m5_noshield
X$532 \$83__t112 topn__t433 cap_mim_2f0_m4m5_noshield c_length=4U c_width=4U
* device instance $533 r0 *1 300.8,89.8 cap_mim_2f0_m4m5_noshield
X$533 \$81__t11 topn__t23 cap_mim_2f0_m4m5_noshield c_length=4U c_width=4U
* device instance $534 r0 *1 307.2,89.8 cap_mim_2f0_m4m5_noshield
X$534 \$83__t8 topn__t22 cap_mim_2f0_m4m5_noshield c_length=4U c_width=4U
* device instance $535 r0 *1 313.6,89.8 cap_mim_2f0_m4m5_noshield
X$535 \$81__t10 topn__t21 cap_mim_2f0_m4m5_noshield c_length=4U c_width=4U
* device instance $536 r0 *1 320,89.8 cap_mim_2f0_m4m5_noshield
X$536 \$83__t10 topn__t27 cap_mim_2f0_m4m5_noshield c_length=4U c_width=4U
* device instance $537 r0 *1 326.4,89.8 cap_mim_2f0_m4m5_noshield
X$537 \$81__t13 topn__t26 cap_mim_2f0_m4m5_noshield c_length=4U c_width=4U
* device instance $538 r0 *1 332.8,89.8 cap_mim_2f0_m4m5_noshield
X$538 \$83__t9 topn__t25 cap_mim_2f0_m4m5_noshield c_length=4U c_width=4U
* device instance $539 r0 *1 339.2,89.8 cap_mim_2f0_m4m5_noshield
X$539 \$81__t12 topn__t24 cap_mim_2f0_m4m5_noshield c_length=4U c_width=4U
* device instance $540 r0 *1 345.6,89.8 cap_mim_2f0_m4m5_noshield
X$540 \$83__t17 topn__t39 cap_mim_2f0_m4m5_noshield c_length=4U c_width=4U
* device instance $541 r0 *1 352,89.8 cap_mim_2f0_m4m5_noshield
X$541 \$81__t185 topn__t370 cap_mim_2f0_m4m5_noshield c_length=4U c_width=4U
* device instance $542 r0 *1 358.4,89.8 cap_mim_2f0_m4m5_noshield
X$542 \$83__t19 topn__t43 cap_mim_2f0_m4m5_noshield c_length=4U c_width=4U
* device instance $543 r0 *1 364.8,89.8 cap_mim_2f0_m4m5_noshield
X$543 \$81__t20 topn__t42 cap_mim_2f0_m4m5_noshield c_length=4U c_width=4U
* device instance $544 r0 *1 371.2,89.8 cap_mim_2f0_m4m5_noshield
X$544 \$83__t18 topn__t41 cap_mim_2f0_m4m5_noshield c_length=4U c_width=4U
* device instance $545 r0 *1 377.6,89.8 cap_mim_2f0_m4m5_noshield
X$545 \$81__t19 topn__t40 cap_mim_2f0_m4m5_noshield c_length=4U c_width=4U
* device instance $546 r0 *1 384,89.8 cap_mim_2f0_m4m5_noshield
X$546 \$83__t37 topn__t136 cap_mim_2f0_m4m5_noshield c_length=4U c_width=4U
* device instance $547 r0 *1 390.4,89.8 cap_mim_2f0_m4m5_noshield
X$547 \$81__t84 topn__t170 cap_mim_2f0_m4m5_noshield c_length=4U c_width=4U
* device instance $548 r0 *1 396.8,89.8 cap_mim_2f0_m4m5_noshield
X$548 \$83__t43 topn__t169 cap_mim_2f0_m4m5_noshield c_length=4U c_width=4U
* device instance $549 r0 *1 403.2,89.8 cap_mim_2f0_m4m5_noshield
X$549 \$81__t83 topn__t168 cap_mim_2f0_m4m5_noshield c_length=4U c_width=4U
* device instance $550 r0 *1 409.6,89.8 cap_mim_2f0_m4m5_noshield
X$550 \$83__t22 topn__t57 cap_mim_2f0_m4m5_noshield c_length=4U c_width=4U
* device instance $551 r0 *1 416,89.8 cap_mim_2f0_m4m5_noshield
X$551 \$81__t26 topn__t56 cap_mim_2f0_m4m5_noshield c_length=4U c_width=4U
* device instance $552 r0 *1 422.4,89.8 cap_mim_2f0_m4m5_noshield
X$552 \$83__t20 topn__t44 cap_mim_2f0_m4m5_noshield c_length=4U c_width=4U
* device instance $553 r0 *1 2.6,96.2 cap_mim_2f0_m4m5_noshield
X$553 \$24__t0 topp__t181 cap_mim_2f0_m4m5_noshield c_length=4U c_width=4U
* device instance $554 r0 *1 9,96.2 cap_mim_2f0_m4m5_noshield
X$554 \$12__t91 topp__t180 cap_mim_2f0_m4m5_noshield c_length=4U c_width=4U
* device instance $555 r0 *1 15.4,96.2 cap_mim_2f0_m4m5_noshield
X$555 \$24__t51 topp__t179 cap_mim_2f0_m4m5_noshield c_length=4U c_width=4U
* device instance $556 r0 *1 21.8,96.2 cap_mim_2f0_m4m5_noshield
X$556 \$12__t90 topp__t178 cap_mim_2f0_m4m5_noshield c_length=4U c_width=4U
* device instance $557 r0 *1 28.2,96.2 cap_mim_2f0_m4m5_noshield
X$557 \$24__t50 topp__t177 cap_mim_2f0_m4m5_noshield c_length=4U c_width=4U
* device instance $558 r0 *1 34.6,96.2 cap_mim_2f0_m4m5_noshield
X$558 \$12__t89 topp__t176 cap_mim_2f0_m4m5_noshield c_length=4U c_width=4U
* device instance $559 r0 *1 41,96.2 cap_mim_2f0_m4m5_noshield
X$559 \$24__t49 topp__t175 cap_mim_2f0_m4m5_noshield c_length=4U c_width=4U
* device instance $560 r0 *1 47.4,96.2 cap_mim_2f0_m4m5_noshield
X$560 \$12__t88 topp__t174 cap_mim_2f0_m4m5_noshield c_length=4U c_width=4U
* device instance $561 r0 *1 53.8,96.2 cap_mim_2f0_m4m5_noshield
X$561 \$24__t48 topp__t173 cap_mim_2f0_m4m5_noshield c_length=4U c_width=4U
* device instance $562 r0 *1 60.2,96.2 cap_mim_2f0_m4m5_noshield
X$562 \$12__t94 topp__t186 cap_mim_2f0_m4m5_noshield c_length=4U c_width=4U
* device instance $563 r0 *1 66.6,96.2 cap_mim_2f0_m4m5_noshield
X$563 \$24__t39 topp__t157 cap_mim_2f0_m4m5_noshield c_length=4U c_width=4U
* device instance $564 r0 *1 73,96.2 cap_mim_2f0_m4m5_noshield
X$564 \$12__t80 topp__t156 cap_mim_2f0_m4m5_noshield c_length=4U c_width=4U
* device instance $565 r0 *1 79.4,96.2 cap_mim_2f0_m4m5_noshield
X$565 \$24__t38 topp__t155 cap_mim_2f0_m4m5_noshield c_length=4U c_width=4U
* device instance $566 r0 *1 85.8,96.2 cap_mim_2f0_m4m5_noshield
X$566 \$12__t79 topp__t154 cap_mim_2f0_m4m5_noshield c_length=4U c_width=4U
* device instance $567 r0 *1 92.2,96.2 cap_mim_2f0_m4m5_noshield
X$567 \$24__t43 topp__t165 cap_mim_2f0_m4m5_noshield c_length=4U c_width=4U
* device instance $568 r0 *1 98.6,96.2 cap_mim_2f0_m4m5_noshield
X$568 \$12__t82 topp__t159 cap_mim_2f0_m4m5_noshield c_length=4U c_width=4U
* device instance $569 r0 *1 105,96.2 cap_mim_2f0_m4m5_noshield
X$569 \$24__t52 topp__t183 cap_mim_2f0_m4m5_noshield c_length=4U c_width=4U
* device instance $570 r0 *1 111.4,96.2 cap_mim_2f0_m4m5_noshield
X$570 \$12__t85 topp__t166 cap_mim_2f0_m4m5_noshield c_length=4U c_width=4U
* device instance $571 r0 *1 117.8,96.2 cap_mim_2f0_m4m5_noshield
X$571 \$24__t90 topp__t308 cap_mim_2f0_m4m5_noshield c_length=4U c_width=4U
* device instance $572 r0 *1 124.2,96.2 cap_mim_2f0_m4m5_noshield
X$572 \$12__t208 topp__t415 cap_mim_2f0_m4m5_noshield c_length=4U c_width=4U
* device instance $573 r0 *1 130.6,96.2 cap_mim_2f0_m4m5_noshield
X$573 \$24__t124 topp__t442 cap_mim_2f0_m4m5_noshield c_length=4U c_width=4U
* device instance $574 r0 *1 137,96.2 cap_mim_2f0_m4m5_noshield
X$574 \$12__t222 topp__t441 cap_mim_2f0_m4m5_noshield c_length=4U c_width=4U
* device instance $575 r0 *1 143.4,96.2 cap_mim_2f0_m4m5_noshield
X$575 \$24__t123 topp__t440 cap_mim_2f0_m4m5_noshield c_length=4U c_width=4U
* device instance $576 r0 *1 149.8,96.2 cap_mim_2f0_m4m5_noshield
X$576 \$12__t191 topp__t380 cap_mim_2f0_m4m5_noshield c_length=4U c_width=4U
* device instance $577 r0 *1 156.2,96.2 cap_mim_2f0_m4m5_noshield
X$577 \$24__t111 topp__t390 cap_mim_2f0_m4m5_noshield c_length=4U c_width=4U
* device instance $578 r0 *1 162.6,96.2 cap_mim_2f0_m4m5_noshield
X$578 \$12__t190 topp__t379 cap_mim_2f0_m4m5_noshield c_length=4U c_width=4U
* device instance $579 r0 *1 169,96.2 cap_mim_2f0_m4m5_noshield
X$579 \$24__t122 topp__t426 cap_mim_2f0_m4m5_noshield c_length=4U c_width=4U
* device instance $580 r0 *1 175.4,96.2 cap_mim_2f0_m4m5_noshield
X$580 \$12__t214 topp__t425 cap_mim_2f0_m4m5_noshield c_length=4U c_width=4U
* device instance $581 r0 *1 181.8,96.2 cap_mim_2f0_m4m5_noshield
X$581 \$24__t121 topp__t424 cap_mim_2f0_m4m5_noshield c_length=4U c_width=4U
* device instance $582 r0 *1 188.2,96.2 cap_mim_2f0_m4m5_noshield
X$582 \$12__t213 topp__t423 cap_mim_2f0_m4m5_noshield c_length=4U c_width=4U
* device instance $583 r0 *1 194.6,96.2 cap_mim_2f0_m4m5_noshield
X$583 \$24__t120 topp__t422 cap_mim_2f0_m4m5_noshield c_length=4U c_width=4U
* device instance $584 r0 *1 201,96.2 cap_mim_2f0_m4m5_noshield
X$584 \$12__t212 topp__t421 cap_mim_2f0_m4m5_noshield c_length=4U c_width=4U
* device instance $585 r0 *1 224,96.2 cap_mim_2f0_m4m5_noshield
X$585 \$83__t113 topn__t444 cap_mim_2f0_m4m5_noshield c_length=4U c_width=4U
* device instance $586 r0 *1 230.4,96.2 cap_mim_2f0_m4m5_noshield
X$586 \$81__t203 topn__t407 cap_mim_2f0_m4m5_noshield c_length=4U c_width=4U
* device instance $587 r0 *1 236.8,96.2 cap_mim_2f0_m4m5_noshield
X$587 \$83__t34 topn__t114 cap_mim_2f0_m4m5_noshield c_length=4U c_width=4U
* device instance $588 r0 *1 243.2,96.2 cap_mim_2f0_m4m5_noshield
X$588 \$81__t55 topn__t113 cap_mim_2f0_m4m5_noshield c_length=4U c_width=4U
* device instance $589 r0 *1 249.6,96.2 cap_mim_2f0_m4m5_noshield
X$589 \$83__t33 topn__t112 cap_mim_2f0_m4m5_noshield c_length=4U c_width=4U
* device instance $590 r0 *1 256,96.2 cap_mim_2f0_m4m5_noshield
X$590 \$81__t54 topn__t111 cap_mim_2f0_m4m5_noshield c_length=4U c_width=4U
* device instance $591 r0 *1 262.4,96.2 cap_mim_2f0_m4m5_noshield
X$591 \$83__t32 topn__t110 cap_mim_2f0_m4m5_noshield c_length=4U c_width=4U
* device instance $592 r0 *1 268.8,96.2 cap_mim_2f0_m4m5_noshield
X$592 \$81__t53 topn__t109 cap_mim_2f0_m4m5_noshield c_length=4U c_width=4U
* device instance $593 r0 *1 275.2,96.2 cap_mim_2f0_m4m5_noshield
X$593 \$83__t31 topn__t108 cap_mim_2f0_m4m5_noshield c_length=4U c_width=4U
* device instance $594 r0 *1 281.6,96.2 cap_mim_2f0_m4m5_noshield
X$594 \$81__t52 topn__t107 cap_mim_2f0_m4m5_noshield c_length=4U c_width=4U
* device instance $595 r0 *1 288,96.2 cap_mim_2f0_m4m5_noshield
X$595 \$83__t30 topn__t105 cap_mim_2f0_m4m5_noshield c_length=4U c_width=4U
* device instance $596 r0 *1 294.4,96.2 cap_mim_2f0_m4m5_noshield
X$596 \$81__t217 topn__t434 cap_mim_2f0_m4m5_noshield c_length=4U c_width=4U
* device instance $597 r0 *1 300.8,96.2 cap_mim_2f0_m4m5_noshield
X$597 \$83__t7 topn__t20 cap_mim_2f0_m4m5_noshield c_length=4U c_width=4U
* device instance $598 r0 *1 307.2,96.2 cap_mim_2f0_m4m5_noshield
X$598 \$81__t9 topn__t19 cap_mim_2f0_m4m5_noshield c_length=4U c_width=4U
* device instance $599 r0 *1 313.6,96.2 cap_mim_2f0_m4m5_noshield
X$599 \$83__t6 topn__t18 cap_mim_2f0_m4m5_noshield c_length=4U c_width=4U
* device instance $600 r0 *1 320,96.2 cap_mim_2f0_m4m5_noshield
X$600 \$81__t4 topn__t9 cap_mim_2f0_m4m5_noshield c_length=4U c_width=4U
* device instance $601 r0 *1 326.4,96.2 cap_mim_2f0_m4m5_noshield
X$601 \$83__t21 topn__t55 cap_mim_2f0_m4m5_noshield c_length=4U c_width=4U
* device instance $602 r0 *1 332.8,96.2 cap_mim_2f0_m4m5_noshield
X$602 \$81__t33 topn__t70 cap_mim_2f0_m4m5_noshield c_length=4U c_width=4U
* device instance $603 r0 *1 339.2,96.2 cap_mim_2f0_m4m5_noshield
X$603 \$83__t28 topn__t69 cap_mim_2f0_m4m5_noshield c_length=4U c_width=4U
* device instance $604 r0 *1 345.6,96.2 cap_mim_2f0_m4m5_noshield
X$604 \$81__t14 topn__t28 cap_mim_2f0_m4m5_noshield c_length=4U c_width=4U
* device instance $605 r0 *1 352,96.2 cap_mim_2f0_m4m5_noshield
X$605 \$83__t97 topn__t371 cap_mim_2f0_m4m5_noshield c_length=4U c_width=4U
* device instance $606 r0 *1 358.4,96.2 cap_mim_2f0_m4m5_noshield
X$606 \$81__t82 topn__t167 cap_mim_2f0_m4m5_noshield c_length=4U c_width=4U
* device instance $607 r0 *1 364.8,96.2 cap_mim_2f0_m4m5_noshield
X$607 \$83__t42 topn__t166 cap_mim_2f0_m4m5_noshield c_length=4U c_width=4U
* device instance $608 r0 *1 371.2,96.2 cap_mim_2f0_m4m5_noshield
X$608 \$81__t81 topn__t165 cap_mim_2f0_m4m5_noshield c_length=4U c_width=4U
* device instance $609 r0 *1 377.6,96.2 cap_mim_2f0_m4m5_noshield
X$609 \$83__t41 topn__t164 cap_mim_2f0_m4m5_noshield c_length=4U c_width=4U
* device instance $610 r0 *1 384,96.2 cap_mim_2f0_m4m5_noshield
X$610 \$81__t80 topn__t163 cap_mim_2f0_m4m5_noshield c_length=4U c_width=4U
* device instance $611 r0 *1 390.4,96.2 cap_mim_2f0_m4m5_noshield
X$611 \$83__t40 topn__t141 cap_mim_2f0_m4m5_noshield c_length=4U c_width=4U
* device instance $612 r0 *1 396.8,96.2 cap_mim_2f0_m4m5_noshield
X$612 \$81__t86 topn__t174 cap_mim_2f0_m4m5_noshield c_length=4U c_width=4U
* device instance $613 r0 *1 403.2,96.2 cap_mim_2f0_m4m5_noshield
X$613 \$83__t44 topn__t175 cap_mim_2f0_m4m5_noshield c_length=4U c_width=4U
* device instance $614 r0 *1 409.6,96.2 cap_mim_2f0_m4m5_noshield
X$614 \$81__t28 topn__t60 cap_mim_2f0_m4m5_noshield c_length=4U c_width=4U
* device instance $615 r0 *1 416,96.2 cap_mim_2f0_m4m5_noshield
X$615 \$83__t23 topn__t59 cap_mim_2f0_m4m5_noshield c_length=4U c_width=4U
* device instance $616 r0 *1 422.4,96.2 cap_mim_2f0_m4m5_noshield
X$616 \$81__t27 topn__t58 cap_mim_2f0_m4m5_noshield c_length=4U c_width=4U
* device instance $617 r0 *1 2.6,102.6 cap_mim_2f0_m4m5_noshield
X$617 \$24__t47 topp__t172 cap_mim_2f0_m4m5_noshield c_length=4U c_width=4U
* device instance $618 r0 *1 9,102.6 cap_mim_2f0_m4m5_noshield
X$618 \$12__t69 topp__t134 cap_mim_2f0_m4m5_noshield c_length=4U c_width=4U
* device instance $619 r0 *1 15.4,102.6 cap_mim_2f0_m4m5_noshield
X$619 \$24__t32 topp__t125 cap_mim_2f0_m4m5_noshield c_length=4U c_width=4U
* device instance $620 r0 *1 21.8,102.6 cap_mim_2f0_m4m5_noshield
X$620 \$12__t64 topp__t124 cap_mim_2f0_m4m5_noshield c_length=4U c_width=4U
* device instance $621 r0 *1 28.2,102.6 cap_mim_2f0_m4m5_noshield
X$621 \$24__t31 topp__t123 cap_mim_2f0_m4m5_noshield c_length=4U c_width=4U
* device instance $622 r0 *1 34.6,102.6 cap_mim_2f0_m4m5_noshield
X$622 \$12__t63 topp__t122 cap_mim_2f0_m4m5_noshield c_length=4U c_width=4U
* device instance $623 r0 *1 41,102.6 cap_mim_2f0_m4m5_noshield
X$623 \$24__t30 topp__t121 cap_mim_2f0_m4m5_noshield c_length=4U c_width=4U
* device instance $624 r0 *1 47.4,102.6 cap_mim_2f0_m4m5_noshield
X$624 \$12__t62 topp__t120 cap_mim_2f0_m4m5_noshield c_length=4U c_width=4U
* device instance $625 r0 *1 53.8,102.6 cap_mim_2f0_m4m5_noshield
X$625 \$24__t44 topp__t167 cap_mim_2f0_m4m5_noshield c_length=4U c_width=4U
* device instance $626 r0 *1 60.2,102.6 cap_mim_2f0_m4m5_noshield
X$626 \$12__t95 topp__t187 cap_mim_2f0_m4m5_noshield c_length=4U c_width=4U
* device instance $627 r0 *1 66.6,102.6 cap_mim_2f0_m4m5_noshield
X$627 \$24__t45 topp__t169 cap_mim_2f0_m4m5_noshield c_length=4U c_width=4U
* device instance $628 r0 *1 73,102.6 cap_mim_2f0_m4m5_noshield
X$628 \$12__t86 topp__t168 cap_mim_2f0_m4m5_noshield c_length=4U c_width=4U
* device instance $629 r0 *1 79.4,102.6 cap_mim_2f0_m4m5_noshield
X$629 \$24__t37 topp__t153 cap_mim_2f0_m4m5_noshield c_length=4U c_width=4U
* device instance $630 r0 *1 85.8,102.6 cap_mim_2f0_m4m5_noshield
X$630 \$12__t78 topp__t152 cap_mim_2f0_m4m5_noshield c_length=4U c_width=4U
* device instance $631 r0 *1 92.2,102.6 cap_mim_2f0_m4m5_noshield
X$631 \$24__t119 topp__t419 cap_mim_2f0_m4m5_noshield c_length=4U c_width=4U
* device instance $632 r0 *1 98.6,102.6 cap_mim_2f0_m4m5_noshield
X$632 \$12__t230 topp__t457 cap_mim_2f0_m4m5_noshield c_length=4U c_width=4U
* device instance $633 r0 *1 105,102.6 cap_mim_2f0_m4m5_noshield
X$633 \$24__t118 topp__t418 cap_mim_2f0_m4m5_noshield c_length=4U c_width=4U
* device instance $634 r0 *1 111.4,102.6 cap_mim_2f0_m4m5_noshield
X$634 \$12__t210 topp__t417 cap_mim_2f0_m4m5_noshield c_length=4U c_width=4U
* device instance $635 r0 *1 117.8,102.6 cap_mim_2f0_m4m5_noshield
X$635 \$24__t74 topp__t271 cap_mim_2f0_m4m5_noshield c_length=4U c_width=4U
* device instance $636 r0 *1 124.2,102.6 cap_mim_2f0_m4m5_noshield
X$636 \$12__t225 topp__t448 cap_mim_2f0_m4m5_noshield c_length=4U c_width=4U
* device instance $637 r0 *1 130.6,102.6 cap_mim_2f0_m4m5_noshield
X$637 \$24__t127 topp__t447 cap_mim_2f0_m4m5_noshield c_length=4U c_width=4U
* device instance $638 r0 *1 137,102.6 cap_mim_2f0_m4m5_noshield
X$638 \$12__t224 topp__t446 cap_mim_2f0_m4m5_noshield c_length=4U c_width=4U
* device instance $639 r0 *1 143.4,102.6 cap_mim_2f0_m4m5_noshield
X$639 \$24__t115 topp__t400 cap_mim_2f0_m4m5_noshield c_length=4U c_width=4U
* device instance $640 r0 *1 149.8,102.6 cap_mim_2f0_m4m5_noshield
X$640 \$12__t202 topp__t399 cap_mim_2f0_m4m5_noshield c_length=4U c_width=4U
* device instance $641 r0 *1 156.2,102.6 cap_mim_2f0_m4m5_noshield
X$641 \$24__t114 topp__t398 cap_mim_2f0_m4m5_noshield c_length=4U c_width=4U
* device instance $642 r0 *1 162.6,102.6 cap_mim_2f0_m4m5_noshield
X$642 \$12__t201 topp__t397 cap_mim_2f0_m4m5_noshield c_length=4U c_width=4U
* device instance $643 r0 *1 169,102.6 cap_mim_2f0_m4m5_noshield
X$643 \$24__t113 topp__t396 cap_mim_2f0_m4m5_noshield c_length=4U c_width=4U
* device instance $644 r0 *1 175.4,102.6 cap_mim_2f0_m4m5_noshield
X$644 \$12__t200 topp__t395 cap_mim_2f0_m4m5_noshield c_length=4U c_width=4U
* device instance $645 r0 *1 181.8,102.6 cap_mim_2f0_m4m5_noshield
X$645 \$24__t116 topp__t406 cap_mim_2f0_m4m5_noshield c_length=4U c_width=4U
* device instance $646 r0 *1 188.2,102.6 cap_mim_2f0_m4m5_noshield
X$646 \$12__t196 topp__t389 cap_mim_2f0_m4m5_noshield c_length=4U c_width=4U
* device instance $647 r0 *1 194.6,102.6 cap_mim_2f0_m4m5_noshield
X$647 \$24__t110 topp__t388 cap_mim_2f0_m4m5_noshield c_length=4U c_width=4U
* device instance $648 r0 *1 201,102.6 cap_mim_2f0_m4m5_noshield
X$648 \$12__t195 topp__t387 cap_mim_2f0_m4m5_noshield c_length=4U c_width=4U
* device instance $649 r0 *1 224,102.6 cap_mim_2f0_m4m5_noshield
X$649 \$83__t100 topn__t409 cap_mim_2f0_m4m5_noshield c_length=4U c_width=4U
* device instance $650 r0 *1 230.4,102.6 cap_mim_2f0_m4m5_noshield
X$650 \$81__t204 topn__t408 cap_mim_2f0_m4m5_noshield c_length=4U c_width=4U
* device instance $651 r0 *1 236.8,102.6 cap_mim_2f0_m4m5_noshield
X$651 \$83__t16 topn__t38 cap_mim_2f0_m4m5_noshield c_length=4U c_width=4U
* device instance $652 r0 *1 243.2,102.6 cap_mim_2f0_m4m5_noshield
X$652 \$81__t18 topn__t37 cap_mim_2f0_m4m5_noshield c_length=4U c_width=4U
* device instance $653 r0 *1 249.6,102.6 cap_mim_2f0_m4m5_noshield
X$653 \$83__t15 topn__t36 cap_mim_2f0_m4m5_noshield c_length=4U c_width=4U
* device instance $654 r0 *1 256,102.6 cap_mim_2f0_m4m5_noshield
X$654 \$81__t17 topn__t35 cap_mim_2f0_m4m5_noshield c_length=4U c_width=4U
* device instance $655 r0 *1 262.4,102.6 cap_mim_2f0_m4m5_noshield
X$655 \$83__t13 topn__t33 cap_mim_2f0_m4m5_noshield c_length=4U c_width=4U
* device instance $656 r0 *1 268.8,102.6 cap_mim_2f0_m4m5_noshield
X$656 \$81__t16 topn__t32 cap_mim_2f0_m4m5_noshield c_length=4U c_width=4U
* device instance $657 r0 *1 275.2,102.6 cap_mim_2f0_m4m5_noshield
X$657 \$83__t12 topn__t31 cap_mim_2f0_m4m5_noshield c_length=4U c_width=4U
* device instance $658 r0 *1 281.6,102.6 cap_mim_2f0_m4m5_noshield
X$658 \$81__t15 topn__t30 cap_mim_2f0_m4m5_noshield c_length=4U c_width=4U
* device instance $659 r0 *1 288,102.6 cap_mim_2f0_m4m5_noshield
X$659 \$83__t11 topn__t29 cap_mim_2f0_m4m5_noshield c_length=4U c_width=4U
* device instance $660 r0 *1 294.4,102.6 cap_mim_2f0_m4m5_noshield
X$660 \$81__t218 topn__t435 cap_mim_2f0_m4m5_noshield c_length=4U c_width=4U
* device instance $661 r0 *1 300.8,102.6 cap_mim_2f0_m4m5_noshield
X$661 \$83__t5 topn__t17 cap_mim_2f0_m4m5_noshield c_length=4U c_width=4U
* device instance $662 r0 *1 307.2,102.6 cap_mim_2f0_m4m5_noshield
X$662 \$81__t8 topn__t16 cap_mim_2f0_m4m5_noshield c_length=4U c_width=4U
* device instance $663 r0 *1 313.6,102.6 cap_mim_2f0_m4m5_noshield
X$663 \$83__t4 topn__t15 cap_mim_2f0_m4m5_noshield c_length=4U c_width=4U
* device instance $664 r0 *1 320,102.6 cap_mim_2f0_m4m5_noshield
X$664 \$81__t7 topn__t14 cap_mim_2f0_m4m5_noshield c_length=4U c_width=4U
* device instance $665 r0 *1 326.4,102.6 cap_mim_2f0_m4m5_noshield
X$665 \$83__t3 topn__t13 cap_mim_2f0_m4m5_noshield c_length=4U c_width=4U
* device instance $666 r0 *1 332.8,102.6 cap_mim_2f0_m4m5_noshield
X$666 \$81__t6 topn__t12 cap_mim_2f0_m4m5_noshield c_length=4U c_width=4U
* device instance $667 r0 *1 339.2,102.6 cap_mim_2f0_m4m5_noshield
X$667 \$83__t2 topn__t11 cap_mim_2f0_m4m5_noshield c_length=4U c_width=4U
* device instance $668 r0 *1 345.6,102.6 cap_mim_2f0_m4m5_noshield
X$668 \$81__t5 topn__t10 cap_mim_2f0_m4m5_noshield c_length=4U c_width=4U
* device instance $669 r0 *1 352,102.6 cap_mim_2f0_m4m5_noshield
X$669 \$83__t98 topn__t372 cap_mim_2f0_m4m5_noshield c_length=4U c_width=4U
* device instance $670 r0 *1 358.4,102.6 cap_mim_2f0_m4m5_noshield
X$670 \$81__t87 topn__t176 cap_mim_2f0_m4m5_noshield c_length=4U c_width=4U
* device instance $671 r0 *1 364.8,102.6 cap_mim_2f0_m4m5_noshield
X$671 \$83__t45 topn__t177 cap_mim_2f0_m4m5_noshield c_length=4U c_width=4U
* device instance $672 r0 *1 371.2,102.6 cap_mim_2f0_m4m5_noshield
X$672 \$81__t88 topn__t178 cap_mim_2f0_m4m5_noshield c_length=4U c_width=4U
* device instance $673 r0 *1 377.6,102.6 cap_mim_2f0_m4m5_noshield
X$673 \$83__t27 topn__t68 cap_mim_2f0_m4m5_noshield c_length=4U c_width=4U
* device instance $674 r0 *1 384,102.6 cap_mim_2f0_m4m5_noshield
X$674 \$81__t32 topn__t67 cap_mim_2f0_m4m5_noshield c_length=4U c_width=4U
* device instance $675 r0 *1 390.4,102.6 cap_mim_2f0_m4m5_noshield
X$675 \$83__t26 topn__t66 cap_mim_2f0_m4m5_noshield c_length=4U c_width=4U
* device instance $676 r0 *1 396.8,102.6 cap_mim_2f0_m4m5_noshield
X$676 \$81__t31 topn__t65 cap_mim_2f0_m4m5_noshield c_length=4U c_width=4U
* device instance $677 r0 *1 403.2,102.6 cap_mim_2f0_m4m5_noshield
X$677 \$83__t25 topn__t64 cap_mim_2f0_m4m5_noshield c_length=4U c_width=4U
* device instance $678 r0 *1 409.6,102.6 cap_mim_2f0_m4m5_noshield
X$678 \$81__t30 topn__t63 cap_mim_2f0_m4m5_noshield c_length=4U c_width=4U
* device instance $679 r0 *1 416,102.6 cap_mim_2f0_m4m5_noshield
X$679 \$83__t24 topn__t62 cap_mim_2f0_m4m5_noshield c_length=4U c_width=4U
* device instance $680 r0 *1 422.4,102.6 cap_mim_2f0_m4m5_noshield
X$680 \$81__t29 topn__t61 cap_mim_2f0_m4m5_noshield c_length=4U c_width=4U
* device instance $681 r0 *1 2.6,109 cap_mim_2f0_m4m5_noshield
X$681 \$32__t19 topp__t147 cap_mim_2f0_m4m5_noshield c_length=4U c_width=4U
* device instance $682 r0 *1 9,109 cap_mim_2f0_m4m5_noshield
X$682 \$12__t75 topp__t146 cap_mim_2f0_m4m5_noshield c_length=4U c_width=4U
* device instance $683 r0 *1 15.4,109 cap_mim_2f0_m4m5_noshield
X$683 \$32__t18 topp__t145 cap_mim_2f0_m4m5_noshield c_length=4U c_width=4U
* device instance $684 r0 *1 21.8,109 cap_mim_2f0_m4m5_noshield
X$684 \$12__t74 topp__t144 cap_mim_2f0_m4m5_noshield c_length=4U c_width=4U
* device instance $685 r0 *1 28.2,109 cap_mim_2f0_m4m5_noshield
X$685 \$32__t17 topp__t143 cap_mim_2f0_m4m5_noshield c_length=4U c_width=4U
* device instance $686 r0 *1 34.6,109 cap_mim_2f0_m4m5_noshield
X$686 \$12__t73 topp__t142 cap_mim_2f0_m4m5_noshield c_length=4U c_width=4U
* device instance $687 r0 *1 41,109 cap_mim_2f0_m4m5_noshield
X$687 \$32__t16 topp__t141 cap_mim_2f0_m4m5_noshield c_length=4U c_width=4U
* device instance $688 r0 *1 47.4,109 cap_mim_2f0_m4m5_noshield
X$688 \$12__t72 topp__t140 cap_mim_2f0_m4m5_noshield c_length=4U c_width=4U
* device instance $689 r0 *1 53.8,109 cap_mim_2f0_m4m5_noshield
X$689 \$32__t15 topp__t139 cap_mim_2f0_m4m5_noshield c_length=4U c_width=4U
* device instance $690 r0 *1 60.2,109 cap_mim_2f0_m4m5_noshield
X$690 \$12__t96 topp__t188 cap_mim_2f0_m4m5_noshield c_length=4U c_width=4U
* device instance $691 r0 *1 66.6,109 cap_mim_2f0_m4m5_noshield
X$691 \$32__t22 topp__t228 cap_mim_2f0_m4m5_noshield c_length=4U c_width=4U
* device instance $692 r0 *1 73,109 cap_mim_2f0_m4m5_noshield
X$692 \$12__t118 topp__t231 cap_mim_2f0_m4m5_noshield c_length=4U c_width=4U
* device instance $693 r0 *1 79.4,109 cap_mim_2f0_m4m5_noshield
X$693 \$32__t23 topp__t234 cap_mim_2f0_m4m5_noshield c_length=4U c_width=4U
* device instance $694 r0 *1 85.8,109 cap_mim_2f0_m4m5_noshield
X$694 \$12__t116 topp__t229 cap_mim_2f0_m4m5_noshield c_length=4U c_width=4U
* device instance $695 r0 *1 92.2,109 cap_mim_2f0_m4m5_noshield
X$695 \$32__t21 topp__t227 cap_mim_2f0_m4m5_noshield c_length=4U c_width=4U
* device instance $696 r0 *1 98.6,109 cap_mim_2f0_m4m5_noshield
X$696 \$12__t115 topp__t226 cap_mim_2f0_m4m5_noshield c_length=4U c_width=4U
* device instance $697 r0 *1 105,109 cap_mim_2f0_m4m5_noshield
X$697 \$32__t20 topp__t185 cap_mim_2f0_m4m5_noshield c_length=4U c_width=4U
* device instance $698 r0 *1 111.4,109 cap_mim_2f0_m4m5_noshield
X$698 \$12__t93 topp__t184 cap_mim_2f0_m4m5_noshield c_length=4U c_width=4U
* device instance $699 r0 *1 117.8,109 cap_mim_2f0_m4m5_noshield
X$699 \$32__t28 topp__t277 cap_mim_2f0_m4m5_noshield c_length=4U c_width=4U
* device instance $700 r0 *1 124.2,109 cap_mim_2f0_m4m5_noshield
X$700 \$12__t221 topp__t439 cap_mim_2f0_m4m5_noshield c_length=4U c_width=4U
* device instance $701 r0 *1 130.6,109 cap_mim_2f0_m4m5_noshield
X$701 \$32__t47 topp__t438 cap_mim_2f0_m4m5_noshield c_length=4U c_width=4U
* device instance $702 r0 *1 137,109 cap_mim_2f0_m4m5_noshield
X$702 \$12__t220 topp__t437 cap_mim_2f0_m4m5_noshield c_length=4U c_width=4U
* device instance $703 r0 *1 143.4,109 cap_mim_2f0_m4m5_noshield
X$703 \$32__t46 topp__t436 cap_mim_2f0_m4m5_noshield c_length=4U c_width=4U
* device instance $704 r0 *1 149.8,109 cap_mim_2f0_m4m5_noshield
X$704 \$12__t219 topp__t435 cap_mim_2f0_m4m5_noshield c_length=4U c_width=4U
* device instance $705 r0 *1 156.2,109 cap_mim_2f0_m4m5_noshield
X$705 \$32__t45 topp__t434 cap_mim_2f0_m4m5_noshield c_length=4U c_width=4U
* device instance $706 r0 *1 162.6,109 cap_mim_2f0_m4m5_noshield
X$706 \$12__t226 topp__t449 cap_mim_2f0_m4m5_noshield c_length=4U c_width=4U
* device instance $707 r0 *1 169,109 cap_mim_2f0_m4m5_noshield
X$707 \$32__t44 topp__t432 cap_mim_2f0_m4m5_noshield c_length=4U c_width=4U
* device instance $708 r0 *1 175.4,109 cap_mim_2f0_m4m5_noshield
X$708 \$12__t217 topp__t431 cap_mim_2f0_m4m5_noshield c_length=4U c_width=4U
* device instance $709 r0 *1 181.8,109 cap_mim_2f0_m4m5_noshield
X$709 \$32__t43 topp__t430 cap_mim_2f0_m4m5_noshield c_length=4U c_width=4U
* device instance $710 r0 *1 188.2,109 cap_mim_2f0_m4m5_noshield
X$710 \$12__t216 topp__t429 cap_mim_2f0_m4m5_noshield c_length=4U c_width=4U
* device instance $711 r0 *1 194.6,109 cap_mim_2f0_m4m5_noshield
X$711 \$32__t42 topp__t428 cap_mim_2f0_m4m5_noshield c_length=4U c_width=4U
* device instance $712 r0 *1 201,109 cap_mim_2f0_m4m5_noshield
X$712 \$12__t215 topp__t427 cap_mim_2f0_m4m5_noshield c_length=4U c_width=4U
* device instance $713 r0 *1 224,109 cap_mim_2f0_m4m5_noshield
X$713 \$84__t53 topn__t446 cap_mim_2f0_m4m5_noshield c_length=4U c_width=4U
* device instance $714 r0 *1 230.4,109 cap_mim_2f0_m4m5_noshield
X$714 \$81__t224 topn__t445 cap_mim_2f0_m4m5_noshield c_length=4U c_width=4U
* device instance $715 r0 *1 236.8,109 cap_mim_2f0_m4m5_noshield
X$715 \$84__t4 topn__t77 cap_mim_2f0_m4m5_noshield c_length=4U c_width=4U
* device instance $716 r0 *1 243.2,109 cap_mim_2f0_m4m5_noshield
X$716 \$81__t37 topn__t76 cap_mim_2f0_m4m5_noshield c_length=4U c_width=4U
* device instance $717 r0 *1 249.6,109 cap_mim_2f0_m4m5_noshield
X$717 \$84__t3 topn__t75 cap_mim_2f0_m4m5_noshield c_length=4U c_width=4U
* device instance $718 r0 *1 256,109 cap_mim_2f0_m4m5_noshield
X$718 \$81__t36 topn__t74 cap_mim_2f0_m4m5_noshield c_length=4U c_width=4U
* device instance $719 r0 *1 262.4,109 cap_mim_2f0_m4m5_noshield
X$719 \$84__t2 topn__t73 cap_mim_2f0_m4m5_noshield c_length=4U c_width=4U
* device instance $720 r0 *1 268.8,109 cap_mim_2f0_m4m5_noshield
X$720 \$81__t35 topn__t72 cap_mim_2f0_m4m5_noshield c_length=4U c_width=4U
* device instance $721 r0 *1 275.2,109 cap_mim_2f0_m4m5_noshield
X$721 \$84__t8 topn__t119 cap_mim_2f0_m4m5_noshield c_length=4U c_width=4U
* device instance $722 r0 *1 281.6,109 cap_mim_2f0_m4m5_noshield
X$722 \$81__t66 topn__t134 cap_mim_2f0_m4m5_noshield c_length=4U c_width=4U
* device instance $723 r0 *1 288,109 cap_mim_2f0_m4m5_noshield
X$723 \$84__t9 topn__t133 cap_mim_2f0_m4m5_noshield c_length=4U c_width=4U
* device instance $724 r0 *1 294.4,109 cap_mim_2f0_m4m5_noshield
X$724 \$81__t219 topn__t436 cap_mim_2f0_m4m5_noshield c_length=4U c_width=4U
* device instance $725 r0 *1 300.8,109 cap_mim_2f0_m4m5_noshield
X$725 \$84__t0 topn__t0 cap_mim_2f0_m4m5_noshield c_length=4U c_width=4U
* device instance $726 r0 *1 307.2,109 cap_mim_2f0_m4m5_noshield
X$726 \$81__t48 topn__t102 cap_mim_2f0_m4m5_noshield c_length=4U c_width=4U
* device instance $727 r0 *1 313.6,109 cap_mim_2f0_m4m5_noshield
X$727 \$84__t7 topn__t101 cap_mim_2f0_m4m5_noshield c_length=4U c_width=4U
* device instance $728 r0 *1 320,109 cap_mim_2f0_m4m5_noshield
X$728 \$81__t47 topn__t100 cap_mim_2f0_m4m5_noshield c_length=4U c_width=4U
* device instance $729 r0 *1 326.4,109 cap_mim_2f0_m4m5_noshield
X$729 \$84__t6 topn__t99 cap_mim_2f0_m4m5_noshield c_length=4U c_width=4U
* device instance $730 r0 *1 332.8,109 cap_mim_2f0_m4m5_noshield
X$730 \$81__t46 topn__t98 cap_mim_2f0_m4m5_noshield c_length=4U c_width=4U
* device instance $731 r0 *1 339.2,109 cap_mim_2f0_m4m5_noshield
X$731 \$84__t5 topn__t97 cap_mim_2f0_m4m5_noshield c_length=4U c_width=4U
* device instance $732 r0 *1 345.6,109 cap_mim_2f0_m4m5_noshield
X$732 \$81__t45 topn__t96 cap_mim_2f0_m4m5_noshield c_length=4U c_width=4U
* device instance $733 r0 *1 352,109 cap_mim_2f0_m4m5_noshield
X$733 \$84__t40 topn__t373 cap_mim_2f0_m4m5_noshield c_length=4U c_width=4U
* device instance $734 r0 *1 358.4,109 cap_mim_2f0_m4m5_noshield
X$734 \$81__t79 topn__t162 cap_mim_2f0_m4m5_noshield c_length=4U c_width=4U
* device instance $735 r0 *1 364.8,109 cap_mim_2f0_m4m5_noshield
X$735 \$84__t14 topn__t161 cap_mim_2f0_m4m5_noshield c_length=4U c_width=4U
* device instance $736 r0 *1 371.2,109 cap_mim_2f0_m4m5_noshield
X$736 \$81__t78 topn__t160 cap_mim_2f0_m4m5_noshield c_length=4U c_width=4U
* device instance $737 r0 *1 377.6,109 cap_mim_2f0_m4m5_noshield
X$737 \$84__t13 topn__t159 cap_mim_2f0_m4m5_noshield c_length=4U c_width=4U
* device instance $738 r0 *1 384,109 cap_mim_2f0_m4m5_noshield
X$738 \$81__t77 topn__t158 cap_mim_2f0_m4m5_noshield c_length=4U c_width=4U
* device instance $739 r0 *1 390.4,109 cap_mim_2f0_m4m5_noshield
X$739 \$84__t12 topn__t147 cap_mim_2f0_m4m5_noshield c_length=4U c_width=4U
* device instance $740 r0 *1 396.8,109 cap_mim_2f0_m4m5_noshield
X$740 \$81__t71 topn__t146 cap_mim_2f0_m4m5_noshield c_length=4U c_width=4U
* device instance $741 r0 *1 403.2,109 cap_mim_2f0_m4m5_noshield
X$741 \$84__t11 topn__t145 cap_mim_2f0_m4m5_noshield c_length=4U c_width=4U
* device instance $742 r0 *1 409.6,109 cap_mim_2f0_m4m5_noshield
X$742 \$81__t70 topn__t144 cap_mim_2f0_m4m5_noshield c_length=4U c_width=4U
* device instance $743 r0 *1 416,109 cap_mim_2f0_m4m5_noshield
X$743 \$84__t10 topn__t143 cap_mim_2f0_m4m5_noshield c_length=4U c_width=4U
* device instance $744 r0 *1 422.4,109 cap_mim_2f0_m4m5_noshield
X$744 \$81__t69 topn__t142 cap_mim_2f0_m4m5_noshield c_length=4U c_width=4U
* device instance $745 r0 *1 2.6,115.4 cap_mim_2f0_m4m5_noshield
X$745 \$40__t10 topp__t199 cap_mim_2f0_m4m5_noshield c_length=4U c_width=4U
* device instance $746 r0 *1 9,115.4 cap_mim_2f0_m4m5_noshield
X$746 \$12__t77 topp__t150 cap_mim_2f0_m4m5_noshield c_length=4U c_width=4U
* device instance $747 r0 *1 15.4,115.4 cap_mim_2f0_m4m5_noshield
X$747 \$40__t9 topp__t149 cap_mim_2f0_m4m5_noshield c_length=4U c_width=4U
* device instance $748 r0 *1 21.8,115.4 cap_mim_2f0_m4m5_noshield
X$748 \$12__t76 topp__t148 cap_mim_2f0_m4m5_noshield c_length=4U c_width=4U
* device instance $749 r0 *1 28.2,115.4 cap_mim_2f0_m4m5_noshield
X$749 \$40__t8 topp__t138 cap_mim_2f0_m4m5_noshield c_length=4U c_width=4U
* device instance $750 r0 *1 34.6,115.4 cap_mim_2f0_m4m5_noshield
X$750 \$12__t111 topp__t220 cap_mim_2f0_m4m5_noshield c_length=4U c_width=4U
* device instance $751 r0 *1 41,115.4 cap_mim_2f0_m4m5_noshield
X$751 \$40__t12 topp__t219 cap_mim_2f0_m4m5_noshield c_length=4U c_width=4U
* device instance $752 r0 *1 47.4,115.4 cap_mim_2f0_m4m5_noshield
X$752 \$12__t110 topp__t218 cap_mim_2f0_m4m5_noshield c_length=4U c_width=4U
* device instance $753 r0 *1 53.8,115.4 cap_mim_2f0_m4m5_noshield
X$753 \$40__t11 topp__t217 cap_mim_2f0_m4m5_noshield c_length=4U c_width=4U
* device instance $754 r0 *1 60.2,115.4 cap_mim_2f0_m4m5_noshield
X$754 \$12__t97 topp__t189 cap_mim_2f0_m4m5_noshield c_length=4U c_width=4U
* device instance $755 r0 *1 66.6,115.4 cap_mim_2f0_m4m5_noshield
X$755 \$40__t13 topp__t233 cap_mim_2f0_m4m5_noshield c_length=4U c_width=4U
* device instance $756 r0 *1 73,115.4 cap_mim_2f0_m4m5_noshield
X$756 \$12__t119 topp__t232 cap_mim_2f0_m4m5_noshield c_length=4U c_width=4U
* device instance $757 r0 *1 79.4,115.4 cap_mim_2f0_m4m5_noshield
X$757 \$40__t16 topp__t247 cap_mim_2f0_m4m5_noshield c_length=4U c_width=4U
* device instance $758 r0 *1 85.8,115.4 cap_mim_2f0_m4m5_noshield
X$758 \$12__t117 topp__t230 cap_mim_2f0_m4m5_noshield c_length=4U c_width=4U
* device instance $759 r0 *1 92.2,115.4 cap_mim_2f0_m4m5_noshield
X$759 \$40__t15 topp__t246 cap_mim_2f0_m4m5_noshield c_length=4U c_width=4U
* device instance $760 r0 *1 98.6,115.4 cap_mim_2f0_m4m5_noshield
X$760 \$12__t125 topp__t245 cap_mim_2f0_m4m5_noshield c_length=4U c_width=4U
* device instance $761 r0 *1 105,115.4 cap_mim_2f0_m4m5_noshield
X$761 \$48__t7 topp__t244 cap_mim_2f0_m4m5_noshield c_length=4U c_width=4U
* device instance $762 r0 *1 111.4,115.4 cap_mim_2f0_m4m5_noshield
X$762 \$12__t124 topp__t243 cap_mim_2f0_m4m5_noshield c_length=4U c_width=4U
* device instance $763 r0 *1 117.8,115.4 cap_mim_2f0_m4m5_noshield
X$763 \$48__t9 topp__t274 cap_mim_2f0_m4m5_noshield c_length=4U c_width=4U
* device instance $764 r0 *1 124.2,115.4 cap_mim_2f0_m4m5_noshield
X$764 \$12__t189 topp__t378 cap_mim_2f0_m4m5_noshield c_length=4U c_width=4U
* device instance $765 r0 *1 130.6,115.4 cap_mim_2f0_m4m5_noshield
X$765 \$48__t11 topp__t377 cap_mim_2f0_m4m5_noshield c_length=4U c_width=4U
* device instance $766 r0 *1 137,115.4 cap_mim_2f0_m4m5_noshield
X$766 \$12__t188 topp__t376 cap_mim_2f0_m4m5_noshield c_length=4U c_width=4U
* device instance $767 r0 *1 143.4,115.4 cap_mim_2f0_m4m5_noshield
X$767 \$48__t10 topp__t375 cap_mim_2f0_m4m5_noshield c_length=4U c_width=4U
* device instance $768 r0 *1 149.8,115.4 cap_mim_2f0_m4m5_noshield
X$768 \$12__t187 topp__t374 cap_mim_2f0_m4m5_noshield c_length=4U c_width=4U
* device instance $769 r0 *1 156.2,115.4 cap_mim_2f0_m4m5_noshield
X$769 \$56__t5 topp__t373 cap_mim_2f0_m4m5_noshield c_length=4U c_width=4U
* device instance $770 r0 *1 162.6,115.4 cap_mim_2f0_m4m5_noshield
X$770 \$12__t186 topp__t372 cap_mim_2f0_m4m5_noshield c_length=4U c_width=4U
* device instance $771 r0 *1 169,115.4 cap_mim_2f0_m4m5_noshield
X$771 \$56__t4 topp__t371 cap_mim_2f0_m4m5_noshield c_length=4U c_width=4U
* device instance $772 r0 *1 175.4,115.4 cap_mim_2f0_m4m5_noshield
X$772 \$12__t185 topp__t370 cap_mim_2f0_m4m5_noshield c_length=4U c_width=4U
* device instance $773 r0 *1 181.8,115.4 cap_mim_2f0_m4m5_noshield
X$773 \$64__t2 topp__t369 cap_mim_2f0_m4m5_noshield c_length=4U c_width=4U
* device instance $774 r0 *1 188.2,115.4 cap_mim_2f0_m4m5_noshield
X$774 \$12__t184 topp__t368 cap_mim_2f0_m4m5_noshield c_length=4U c_width=4U
* device instance $775 r0 *1 194.6,115.4 cap_mim_2f0_m4m5_noshield
X$775 \$80__t0 topp__t367 cap_mim_2f0_m4m5_noshield c_length=4U c_width=4U
* device instance $776 r0 *1 201,115.4 cap_mim_2f0_m4m5_noshield
X$776 \$12__t209 topp__t416 cap_mim_2f0_m4m5_noshield c_length=4U c_width=4U
* device instance $777 r0 *1 224,115.4 cap_mim_2f0_m4m5_noshield
X$777 \$85__t24 topn__t443 cap_mim_2f0_m4m5_noshield c_length=4U c_width=4U
* device instance $778 r0 *1 230.4,115.4 cap_mim_2f0_m4m5_noshield
X$778 \$81__t223 topn__t442 cap_mim_2f0_m4m5_noshield c_length=4U c_width=4U
* device instance $779 r0 *1 236.8,115.4 cap_mim_2f0_m4m5_noshield
X$779 \$85__t8 topn__t123 cap_mim_2f0_m4m5_noshield c_length=4U c_width=4U
* device instance $780 r0 *1 243.2,115.4 cap_mim_2f0_m4m5_noshield
X$780 \$81__t60 topn__t122 cap_mim_2f0_m4m5_noshield c_length=4U c_width=4U
* device instance $781 r0 *1 249.6,115.4 cap_mim_2f0_m4m5_noshield
X$781 \$85__t7 topn__t121 cap_mim_2f0_m4m5_noshield c_length=4U c_width=4U
* device instance $782 r0 *1 256,115.4 cap_mim_2f0_m4m5_noshield
X$782 \$81__t59 topn__t120 cap_mim_2f0_m4m5_noshield c_length=4U c_width=4U
* device instance $783 r0 *1 262.4,115.4 cap_mim_2f0_m4m5_noshield
X$783 \$85__t3 topn__t82 cap_mim_2f0_m4m5_noshield c_length=4U c_width=4U
* device instance $784 r0 *1 268.8,115.4 cap_mim_2f0_m4m5_noshield
X$784 \$81__t39 topn__t81 cap_mim_2f0_m4m5_noshield c_length=4U c_width=4U
* device instance $785 r0 *1 275.2,115.4 cap_mim_2f0_m4m5_noshield
X$785 \$85__t2 topn__t80 cap_mim_2f0_m4m5_noshield c_length=4U c_width=4U
* device instance $786 r0 *1 281.6,115.4 cap_mim_2f0_m4m5_noshield
X$786 \$81__t38 topn__t79 cap_mim_2f0_m4m5_noshield c_length=4U c_width=4U
* device instance $787 r0 *1 288,115.4 cap_mim_2f0_m4m5_noshield
X$787 \$85__t1 topn__t78 cap_mim_2f0_m4m5_noshield c_length=4U c_width=4U
* device instance $788 r0 *1 294.4,115.4 cap_mim_2f0_m4m5_noshield
X$788 \$81__t220 topn__t437 cap_mim_2f0_m4m5_noshield c_length=4U c_width=4U
* device instance $789 r0 *1 300.8,115.4 cap_mim_2f0_m4m5_noshield
X$789 \$85__t5 topn__t94 cap_mim_2f0_m4m5_noshield c_length=4U c_width=4U
* device instance $790 r0 *1 307.2,115.4 cap_mim_2f0_m4m5_noshield
X$790 \$81__t44 topn__t93 cap_mim_2f0_m4m5_noshield c_length=4U c_width=4U
* device instance $791 r0 *1 313.6,115.4 cap_mim_2f0_m4m5_noshield
X$791 \$85__t4 topn__t92 cap_mim_2f0_m4m5_noshield c_length=4U c_width=4U
* device instance $792 r0 *1 320,115.4 cap_mim_2f0_m4m5_noshield
X$792 \$81__t43 topn__t91 cap_mim_2f0_m4m5_noshield c_length=4U c_width=4U
* device instance $793 r0 *1 326.4,115.4 cap_mim_2f0_m4m5_noshield
X$793 \$86__t4 topn__t90 cap_mim_2f0_m4m5_noshield c_length=4U c_width=4U
* device instance $794 r0 *1 332.8,115.4 cap_mim_2f0_m4m5_noshield
X$794 \$81__t42 topn__t89 cap_mim_2f0_m4m5_noshield c_length=4U c_width=4U
* device instance $795 r0 *1 339.2,115.4 cap_mim_2f0_m4m5_noshield
X$795 \$86__t3 topn__t88 cap_mim_2f0_m4m5_noshield c_length=4U c_width=4U
* device instance $796 r0 *1 345.6,115.4 cap_mim_2f0_m4m5_noshield
X$796 \$81__t49 topn__t103 cap_mim_2f0_m4m5_noshield c_length=4U c_width=4U
* device instance $797 r0 *1 352,115.4 cap_mim_2f0_m4m5_noshield
X$797 \$86__t11 topn__t374 cap_mim_2f0_m4m5_noshield c_length=4U c_width=4U
* device instance $798 r0 *1 358.4,115.4 cap_mim_2f0_m4m5_noshield
X$798 \$81__t34 topn__t71 cap_mim_2f0_m4m5_noshield c_length=4U c_width=4U
* device instance $799 r0 *1 364.8,115.4 cap_mim_2f0_m4m5_noshield
X$799 \$86__t0 topn__t54 cap_mim_2f0_m4m5_noshield c_length=4U c_width=4U
* device instance $800 r0 *1 371.2,115.4 cap_mim_2f0_m4m5_noshield
X$800 \$81__t25 topn__t53 cap_mim_2f0_m4m5_noshield c_length=4U c_width=4U
* device instance $801 r0 *1 377.6,115.4 cap_mim_2f0_m4m5_noshield
X$801 \$87__t1 topn__t52 cap_mim_2f0_m4m5_noshield c_length=4U c_width=4U
* device instance $802 r0 *1 384,115.4 cap_mim_2f0_m4m5_noshield
X$802 \$81__t24 topn__t51 cap_mim_2f0_m4m5_noshield c_length=4U c_width=4U
* device instance $803 r0 *1 390.4,115.4 cap_mim_2f0_m4m5_noshield
X$803 \$87__t0 topn__t50 cap_mim_2f0_m4m5_noshield c_length=4U c_width=4U
* device instance $804 r0 *1 396.8,115.4 cap_mim_2f0_m4m5_noshield
X$804 \$81__t23 topn__t49 cap_mim_2f0_m4m5_noshield c_length=4U c_width=4U
* device instance $805 r0 *1 403.2,115.4 cap_mim_2f0_m4m5_noshield
X$805 \$88__t0 topn__t48 cap_mim_2f0_m4m5_noshield c_length=4U c_width=4U
* device instance $806 r0 *1 409.6,115.4 cap_mim_2f0_m4m5_noshield
X$806 \$81__t22 topn__t47 cap_mim_2f0_m4m5_noshield c_length=4U c_width=4U
* device instance $807 r0 *1 416,115.4 cap_mim_2f0_m4m5_noshield
X$807 \$90__t0 topn__t46 cap_mim_2f0_m4m5_noshield c_length=4U c_width=4U
* device instance $808 r0 *1 422.4,115.4 cap_mim_2f0_m4m5_noshield
X$808 \$81__t21 topn__t45 cap_mim_2f0_m4m5_noshield c_length=4U c_width=4U
* device instance $809 r0 *1 2.6,121.8 cap_mim_2f0_m4m5_noshield
X$809 \$12__t112 topp__t222 cap_mim_2f0_m4m5_noshield c_length=4U c_width=4U
* device instance $810 r0 *1 9,121.8 cap_mim_2f0_m4m5_noshield
X$810 vcm__t0 topp__t221 cap_mim_2f0_m4m5_noshield c_length=4U c_width=4U
* device instance $811 r0 *1 15.4,121.8 cap_mim_2f0_m4m5_noshield
X$811 \$12__t109 topp__t216 cap_mim_2f0_m4m5_noshield c_length=4U c_width=4U
* device instance $812 r0 *1 21.8,121.8 cap_mim_2f0_m4m5_noshield
X$812 \$64__t1 topp__t137 cap_mim_2f0_m4m5_noshield c_length=4U c_width=4U
* device instance $813 r0 *1 28.2,121.8 cap_mim_2f0_m4m5_noshield
X$813 \$12__t71 topp__t136 cap_mim_2f0_m4m5_noshield c_length=4U c_width=4U
* device instance $814 r0 *1 34.6,121.8 cap_mim_2f0_m4m5_noshield
X$814 \$56__t2 topp__t151 cap_mim_2f0_m4m5_noshield c_length=4U c_width=4U
* device instance $815 r0 *1 41,121.8 cap_mim_2f0_m4m5_noshield
X$815 \$12__t114 topp__t225 cap_mim_2f0_m4m5_noshield c_length=4U c_width=4U
* device instance $816 r0 *1 47.4,121.8 cap_mim_2f0_m4m5_noshield
X$816 \$56__t3 topp__t224 cap_mim_2f0_m4m5_noshield c_length=4U c_width=4U
* device instance $817 r0 *1 53.8,121.8 cap_mim_2f0_m4m5_noshield
X$817 \$12__t113 topp__t223 cap_mim_2f0_m4m5_noshield c_length=4U c_width=4U
* device instance $818 r0 *1 60.2,121.8 cap_mim_2f0_m4m5_noshield
X$818 \$48__t3 topp__t191 cap_mim_2f0_m4m5_noshield c_length=4U c_width=4U
* device instance $819 r0 *1 66.6,121.8 cap_mim_2f0_m4m5_noshield
X$819 \$12__t123 topp__t242 cap_mim_2f0_m4m5_noshield c_length=4U c_width=4U
* device instance $820 r0 *1 73,121.8 cap_mim_2f0_m4m5_noshield
X$820 \$48__t6 topp__t241 cap_mim_2f0_m4m5_noshield c_length=4U c_width=4U
* device instance $821 r0 *1 79.4,121.8 cap_mim_2f0_m4m5_noshield
X$821 \$12__t122 topp__t240 cap_mim_2f0_m4m5_noshield c_length=4U c_width=4U
* device instance $822 r0 *1 85.8,121.8 cap_mim_2f0_m4m5_noshield
X$822 \$48__t5 topp__t239 cap_mim_2f0_m4m5_noshield c_length=4U c_width=4U
* device instance $823 r0 *1 92.2,121.8 cap_mim_2f0_m4m5_noshield
X$823 \$12__t121 topp__t238 cap_mim_2f0_m4m5_noshield c_length=4U c_width=4U
* device instance $824 r0 *1 98.6,121.8 cap_mim_2f0_m4m5_noshield
X$824 \$48__t4 topp__t237 cap_mim_2f0_m4m5_noshield c_length=4U c_width=4U
* device instance $825 r0 *1 105,121.8 cap_mim_2f0_m4m5_noshield
X$825 \$12__t120 topp__t236 cap_mim_2f0_m4m5_noshield c_length=4U c_width=4U
* device instance $826 r0 *1 111.4,121.8 cap_mim_2f0_m4m5_noshield
X$826 \$40__t14 topp__t235 cap_mim_2f0_m4m5_noshield c_length=4U c_width=4U
* device instance $827 r0 *1 117.8,121.8 cap_mim_2f0_m4m5_noshield
X$827 \$12__t135 topp__t269 cap_mim_2f0_m4m5_noshield c_length=4U c_width=4U
* device instance $828 r0 *1 124.2,121.8 cap_mim_2f0_m4m5_noshield
X$828 \$40__t23 topp__t413 cap_mim_2f0_m4m5_noshield c_length=4U c_width=4U
* device instance $829 r0 *1 130.6,121.8 cap_mim_2f0_m4m5_noshield
X$829 \$12__t207 topp__t412 cap_mim_2f0_m4m5_noshield c_length=4U c_width=4U
* device instance $830 r0 *1 137,121.8 cap_mim_2f0_m4m5_noshield
X$830 \$40__t22 topp__t411 cap_mim_2f0_m4m5_noshield c_length=4U c_width=4U
* device instance $831 r0 *1 143.4,121.8 cap_mim_2f0_m4m5_noshield
X$831 \$12__t206 topp__t410 cap_mim_2f0_m4m5_noshield c_length=4U c_width=4U
* device instance $832 r0 *1 149.8,121.8 cap_mim_2f0_m4m5_noshield
X$832 \$40__t21 topp__t409 cap_mim_2f0_m4m5_noshield c_length=4U c_width=4U
* device instance $833 r0 *1 156.2,121.8 cap_mim_2f0_m4m5_noshield
X$833 \$12__t205 topp__t408 cap_mim_2f0_m4m5_noshield c_length=4U c_width=4U
* device instance $834 r0 *1 162.6,121.8 cap_mim_2f0_m4m5_noshield
X$834 \$40__t20 topp__t407 cap_mim_2f0_m4m5_noshield c_length=4U c_width=4U
* device instance $835 r0 *1 169,121.8 cap_mim_2f0_m4m5_noshield
X$835 \$12__t211 topp__t420 cap_mim_2f0_m4m5_noshield c_length=4U c_width=4U
* device instance $836 r0 *1 175.4,121.8 cap_mim_2f0_m4m5_noshield
X$836 \$40__t19 topp__t405 cap_mim_2f0_m4m5_noshield c_length=4U c_width=4U
* device instance $837 r0 *1 181.8,121.8 cap_mim_2f0_m4m5_noshield
X$837 \$12__t204 topp__t404 cap_mim_2f0_m4m5_noshield c_length=4U c_width=4U
* device instance $838 r0 *1 188.2,121.8 cap_mim_2f0_m4m5_noshield
X$838 \$40__t18 topp__t403 cap_mim_2f0_m4m5_noshield c_length=4U c_width=4U
* device instance $839 r0 *1 194.6,121.8 cap_mim_2f0_m4m5_noshield
X$839 \$12__t203 topp__t402 cap_mim_2f0_m4m5_noshield c_length=4U c_width=4U
* device instance $840 r0 *1 201,121.8 cap_mim_2f0_m4m5_noshield
X$840 \$40__t17 topp__t401 cap_mim_2f0_m4m5_noshield c_length=4U c_width=4U
* device instance $841 r0 *1 224,121.8 cap_mim_2f0_m4m5_noshield
X$841 \$81__t222 topn__t441 cap_mim_2f0_m4m5_noshield c_length=4U c_width=4U
* device instance $842 r0 *1 230.4,121.8 cap_mim_2f0_m4m5_noshield
X$842 vcm__t1 topn__t440 cap_mim_2f0_m4m5_noshield c_length=4U c_width=4U
* device instance $843 r0 *1 236.8,121.8 cap_mim_2f0_m4m5_noshield
X$843 \$81__t65 topn__t132 cap_mim_2f0_m4m5_noshield c_length=4U c_width=4U
* device instance $844 r0 *1 243.2,121.8 cap_mim_2f0_m4m5_noshield
X$844 \$88__t1 topn__t131 cap_mim_2f0_m4m5_noshield c_length=4U c_width=4U
* device instance $845 r0 *1 249.6,121.8 cap_mim_2f0_m4m5_noshield
X$845 \$81__t64 topn__t130 cap_mim_2f0_m4m5_noshield c_length=4U c_width=4U
* device instance $846 r0 *1 256,121.8 cap_mim_2f0_m4m5_noshield
X$846 \$87__t3 topn__t129 cap_mim_2f0_m4m5_noshield c_length=4U c_width=4U
* device instance $847 r0 *1 262.4,121.8 cap_mim_2f0_m4m5_noshield
X$847 \$81__t63 topn__t128 cap_mim_2f0_m4m5_noshield c_length=4U c_width=4U
* device instance $848 r0 *1 268.8,121.8 cap_mim_2f0_m4m5_noshield
X$848 \$87__t2 topn__t127 cap_mim_2f0_m4m5_noshield c_length=4U c_width=4U
* device instance $849 r0 *1 275.2,121.8 cap_mim_2f0_m4m5_noshield
X$849 \$81__t62 topn__t126 cap_mim_2f0_m4m5_noshield c_length=4U c_width=4U
* device instance $850 r0 *1 281.6,121.8 cap_mim_2f0_m4m5_noshield
X$850 \$86__t5 topn__t125 cap_mim_2f0_m4m5_noshield c_length=4U c_width=4U
* device instance $851 r0 *1 288,121.8 cap_mim_2f0_m4m5_noshield
X$851 \$81__t61 topn__t124 cap_mim_2f0_m4m5_noshield c_length=4U c_width=4U
* device instance $852 r0 *1 294.4,121.8 cap_mim_2f0_m4m5_noshield
X$852 \$86__t13 topn__t438 cap_mim_2f0_m4m5_noshield c_length=4U c_width=4U
* device instance $853 r0 *1 300.8,121.8 cap_mim_2f0_m4m5_noshield
X$853 \$81__t41 topn__t85 cap_mim_2f0_m4m5_noshield c_length=4U c_width=4U
* device instance $854 r0 *1 307.2,121.8 cap_mim_2f0_m4m5_noshield
X$854 \$86__t1 topn__t84 cap_mim_2f0_m4m5_noshield c_length=4U c_width=4U
* device instance $855 r0 *1 313.6,121.8 cap_mim_2f0_m4m5_noshield
X$855 \$81__t40 topn__t83 cap_mim_2f0_m4m5_noshield c_length=4U c_width=4U
* device instance $856 r0 *1 320,121.8 cap_mim_2f0_m4m5_noshield
X$856 \$86__t2 topn__t86 cap_mim_2f0_m4m5_noshield c_length=4U c_width=4U
* device instance $857 r0 *1 326.4,121.8 cap_mim_2f0_m4m5_noshield
X$857 \$81__t212 topn__t423 cap_mim_2f0_m4m5_noshield c_length=4U c_width=4U
* device instance $858 r0 *1 332.8,121.8 cap_mim_2f0_m4m5_noshield
X$858 \$85__t23 topn__t402 cap_mim_2f0_m4m5_noshield c_length=4U c_width=4U
* device instance $859 r0 *1 339.2,121.8 cap_mim_2f0_m4m5_noshield
X$859 \$81__t200 topn__t403 cap_mim_2f0_m4m5_noshield c_length=4U c_width=4U
* device instance $860 r0 *1 345.6,121.8 cap_mim_2f0_m4m5_noshield
X$860 \$85__t6 topn__t95 cap_mim_2f0_m4m5_noshield c_length=4U c_width=4U
* device instance $861 r0 *1 352,121.8 cap_mim_2f0_m4m5_noshield
X$861 \$81__t186 topn__t375 cap_mim_2f0_m4m5_noshield c_length=4U c_width=4U
* device instance $862 r0 *1 358.4,121.8 cap_mim_2f0_m4m5_noshield
X$862 \$85__t13 topn__t157 cap_mim_2f0_m4m5_noshield c_length=4U c_width=4U
* device instance $863 r0 *1 364.8,121.8 cap_mim_2f0_m4m5_noshield
X$863 \$81__t76 topn__t156 cap_mim_2f0_m4m5_noshield c_length=4U c_width=4U
* device instance $864 r0 *1 371.2,121.8 cap_mim_2f0_m4m5_noshield
X$864 \$85__t14 topn__t171 cap_mim_2f0_m4m5_noshield c_length=4U c_width=4U
* device instance $865 r0 *1 377.6,121.8 cap_mim_2f0_m4m5_noshield
X$865 \$81__t75 topn__t155 cap_mim_2f0_m4m5_noshield c_length=4U c_width=4U
* device instance $866 r0 *1 384,121.8 cap_mim_2f0_m4m5_noshield
X$866 \$85__t12 topn__t154 cap_mim_2f0_m4m5_noshield c_length=4U c_width=4U
* device instance $867 r0 *1 390.4,121.8 cap_mim_2f0_m4m5_noshield
X$867 \$81__t74 topn__t153 cap_mim_2f0_m4m5_noshield c_length=4U c_width=4U
* device instance $868 r0 *1 396.8,121.8 cap_mim_2f0_m4m5_noshield
X$868 \$85__t11 topn__t152 cap_mim_2f0_m4m5_noshield c_length=4U c_width=4U
* device instance $869 r0 *1 403.2,121.8 cap_mim_2f0_m4m5_noshield
X$869 \$81__t73 topn__t151 cap_mim_2f0_m4m5_noshield c_length=4U c_width=4U
* device instance $870 r0 *1 409.6,121.8 cap_mim_2f0_m4m5_noshield
X$870 \$85__t10 topn__t150 cap_mim_2f0_m4m5_noshield c_length=4U c_width=4U
* device instance $871 r0 *1 416,121.8 cap_mim_2f0_m4m5_noshield
X$871 \$81__t72 topn__t149 cap_mim_2f0_m4m5_noshield c_length=4U c_width=4U
* device instance $872 r0 *1 422.4,121.8 cap_mim_2f0_m4m5_noshield
X$872 \$85__t9 topn__t148 cap_mim_2f0_m4m5_noshield c_length=4U c_width=4U
* device instance $873 r0 *1 2.6,128.2 cap_mim_2f0_m4m5_noshield
X$873 \$12__t134 topp__t267 cap_mim_2f0_m4m5_noshield c_length=4U c_width=4U
* device instance $874 r0 *1 9,128.2 cap_mim_2f0_m4m5_noshield
X$874 \$32__t26 topp__t266 cap_mim_2f0_m4m5_noshield c_length=4U c_width=4U
* device instance $875 r0 *1 15.4,128.2 cap_mim_2f0_m4m5_noshield
X$875 \$12__t133 topp__t265 cap_mim_2f0_m4m5_noshield c_length=4U c_width=4U
* device instance $876 r0 *1 21.8,128.2 cap_mim_2f0_m4m5_noshield
X$876 \$32__t25 topp__t264 cap_mim_2f0_m4m5_noshield c_length=4U c_width=4U
* device instance $877 r0 *1 28.2,128.2 cap_mim_2f0_m4m5_noshield
X$877 \$12__t139 topp__t279 cap_mim_2f0_m4m5_noshield c_length=4U c_width=4U
* device instance $878 r0 *1 34.6,128.2 cap_mim_2f0_m4m5_noshield
X$878 \$32__t24 topp__t263 cap_mim_2f0_m4m5_noshield c_length=4U c_width=4U
* device instance $879 r0 *1 41,128.2 cap_mim_2f0_m4m5_noshield
X$879 \$12__t161 topp__t322 cap_mim_2f0_m4m5_noshield c_length=4U c_width=4U
* device instance $880 r0 *1 47.4,128.2 cap_mim_2f0_m4m5_noshield
X$880 \$32__t36 topp__t323 cap_mim_2f0_m4m5_noshield c_length=4U c_width=4U
* device instance $881 r0 *1 53.8,128.2 cap_mim_2f0_m4m5_noshield
X$881 \$12__t162 topp__t324 cap_mim_2f0_m4m5_noshield c_length=4U c_width=4U
* device instance $882 r0 *1 60.2,128.2 cap_mim_2f0_m4m5_noshield
X$882 \$32__t41 topp__t334 cap_mim_2f0_m4m5_noshield c_length=4U c_width=4U
* device instance $883 r0 *1 66.6,128.2 cap_mim_2f0_m4m5_noshield
X$883 \$12__t164 topp__t326 cap_mim_2f0_m4m5_noshield c_length=4U c_width=4U
* device instance $884 r0 *1 73,128.2 cap_mim_2f0_m4m5_noshield
X$884 \$32__t37 topp__t327 cap_mim_2f0_m4m5_noshield c_length=4U c_width=4U
* device instance $885 r0 *1 79.4,128.2 cap_mim_2f0_m4m5_noshield
X$885 \$12__t165 topp__t328 cap_mim_2f0_m4m5_noshield c_length=4U c_width=4U
* device instance $886 r0 *1 85.8,128.2 cap_mim_2f0_m4m5_noshield
X$886 \$32__t38 topp__t329 cap_mim_2f0_m4m5_noshield c_length=4U c_width=4U
* device instance $887 r0 *1 92.2,128.2 cap_mim_2f0_m4m5_noshield
X$887 \$12__t166 topp__t330 cap_mim_2f0_m4m5_noshield c_length=4U c_width=4U
* device instance $888 r0 *1 98.6,128.2 cap_mim_2f0_m4m5_noshield
X$888 \$32__t39 topp__t331 cap_mim_2f0_m4m5_noshield c_length=4U c_width=4U
* device instance $889 r0 *1 105,128.2 cap_mim_2f0_m4m5_noshield
X$889 \$12__t167 topp__t332 cap_mim_2f0_m4m5_noshield c_length=4U c_width=4U
* device instance $890 r0 *1 111.4,128.2 cap_mim_2f0_m4m5_noshield
X$890 \$32__t40 topp__t333 cap_mim_2f0_m4m5_noshield c_length=4U c_width=4U
* device instance $891 r0 *1 117.8,128.2 cap_mim_2f0_m4m5_noshield
X$891 \$12__t163 topp__t325 cap_mim_2f0_m4m5_noshield c_length=4U c_width=4U
* device instance $892 r0 *1 124.2,128.2 cap_mim_2f0_m4m5_noshield
X$892 \$32__t35 topp__t321 cap_mim_2f0_m4m5_noshield c_length=4U c_width=4U
* device instance $893 r0 *1 130.6,128.2 cap_mim_2f0_m4m5_noshield
X$893 \$12__t160 topp__t320 cap_mim_2f0_m4m5_noshield c_length=4U c_width=4U
* device instance $894 r0 *1 137,128.2 cap_mim_2f0_m4m5_noshield
X$894 \$32__t34 topp__t319 cap_mim_2f0_m4m5_noshield c_length=4U c_width=4U
* device instance $895 r0 *1 143.4,128.2 cap_mim_2f0_m4m5_noshield
X$895 \$12__t159 topp__t318 cap_mim_2f0_m4m5_noshield c_length=4U c_width=4U
* device instance $896 r0 *1 149.8,128.2 cap_mim_2f0_m4m5_noshield
X$896 \$32__t33 topp__t317 cap_mim_2f0_m4m5_noshield c_length=4U c_width=4U
* device instance $897 r0 *1 156.2,128.2 cap_mim_2f0_m4m5_noshield
X$897 \$12__t158 topp__t316 cap_mim_2f0_m4m5_noshield c_length=4U c_width=4U
* device instance $898 r0 *1 162.6,128.2 cap_mim_2f0_m4m5_noshield
X$898 \$32__t32 topp__t315 cap_mim_2f0_m4m5_noshield c_length=4U c_width=4U
* device instance $899 r0 *1 169,128.2 cap_mim_2f0_m4m5_noshield
X$899 \$12__t157 topp__t314 cap_mim_2f0_m4m5_noshield c_length=4U c_width=4U
* device instance $900 r0 *1 175.4,128.2 cap_mim_2f0_m4m5_noshield
X$900 \$32__t31 topp__t313 cap_mim_2f0_m4m5_noshield c_length=4U c_width=4U
* device instance $901 r0 *1 181.8,128.2 cap_mim_2f0_m4m5_noshield
X$901 \$12__t156 topp__t312 cap_mim_2f0_m4m5_noshield c_length=4U c_width=4U
* device instance $902 r0 *1 188.2,128.2 cap_mim_2f0_m4m5_noshield
X$902 \$32__t30 topp__t311 cap_mim_2f0_m4m5_noshield c_length=4U c_width=4U
* device instance $903 r0 *1 194.6,128.2 cap_mim_2f0_m4m5_noshield
X$903 \$12__t155 topp__t310 cap_mim_2f0_m4m5_noshield c_length=4U c_width=4U
* device instance $904 r0 *1 201,128.2 cap_mim_2f0_m4m5_noshield
X$904 \$32__t29 topp__t309 cap_mim_2f0_m4m5_noshield c_length=4U c_width=4U
* device instance $905 r0 *1 224,128.2 cap_mim_2f0_m4m5_noshield
X$905 \$81__t85 topn__t173 cap_mim_2f0_m4m5_noshield c_length=4U c_width=4U
* device instance $906 r0 *1 230.4,128.2 cap_mim_2f0_m4m5_noshield
X$906 \$84__t15 topn__t172 cap_mim_2f0_m4m5_noshield c_length=4U c_width=4U
* device instance $907 r0 *1 236.8,128.2 cap_mim_2f0_m4m5_noshield
X$907 \$81__t187 topn__t376 cap_mim_2f0_m4m5_noshield c_length=4U c_width=4U
* device instance $908 r0 *1 243.2,128.2 cap_mim_2f0_m4m5_noshield
X$908 \$84__t41 topn__t377 cap_mim_2f0_m4m5_noshield c_length=4U c_width=4U
* device instance $909 r0 *1 249.6,128.2 cap_mim_2f0_m4m5_noshield
X$909 \$81__t188 topn__t378 cap_mim_2f0_m4m5_noshield c_length=4U c_width=4U
* device instance $910 r0 *1 256,128.2 cap_mim_2f0_m4m5_noshield
X$910 \$84__t42 topn__t379 cap_mim_2f0_m4m5_noshield c_length=4U c_width=4U
* device instance $911 r0 *1 262.4,128.2 cap_mim_2f0_m4m5_noshield
X$911 \$81__t189 topn__t380 cap_mim_2f0_m4m5_noshield c_length=4U c_width=4U
* device instance $912 r0 *1 268.8,128.2 cap_mim_2f0_m4m5_noshield
X$912 \$84__t43 topn__t381 cap_mim_2f0_m4m5_noshield c_length=4U c_width=4U
* device instance $913 r0 *1 275.2,128.2 cap_mim_2f0_m4m5_noshield
X$913 \$81__t190 topn__t382 cap_mim_2f0_m4m5_noshield c_length=4U c_width=4U
* device instance $914 r0 *1 281.6,128.2 cap_mim_2f0_m4m5_noshield
X$914 \$84__t44 topn__t383 cap_mim_2f0_m4m5_noshield c_length=4U c_width=4U
* device instance $915 r0 *1 288,128.2 cap_mim_2f0_m4m5_noshield
X$915 \$81__t191 topn__t384 cap_mim_2f0_m4m5_noshield c_length=4U c_width=4U
* device instance $916 r0 *1 294.4,128.2 cap_mim_2f0_m4m5_noshield
X$916 \$84__t52 topn__t401 cap_mim_2f0_m4m5_noshield c_length=4U c_width=4U
* device instance $917 r0 *1 300.8,128.2 cap_mim_2f0_m4m5_noshield
X$917 \$81__t192 topn__t386 cap_mim_2f0_m4m5_noshield c_length=4U c_width=4U
* device instance $918 r0 *1 307.2,128.2 cap_mim_2f0_m4m5_noshield
X$918 \$84__t45 topn__t387 cap_mim_2f0_m4m5_noshield c_length=4U c_width=4U
* device instance $919 r0 *1 313.6,128.2 cap_mim_2f0_m4m5_noshield
X$919 \$81__t193 topn__t388 cap_mim_2f0_m4m5_noshield c_length=4U c_width=4U
* device instance $920 r0 *1 320,128.2 cap_mim_2f0_m4m5_noshield
X$920 \$84__t46 topn__t389 cap_mim_2f0_m4m5_noshield c_length=4U c_width=4U
* device instance $921 r0 *1 326.4,128.2 cap_mim_2f0_m4m5_noshield
X$921 \$81__t194 topn__t390 cap_mim_2f0_m4m5_noshield c_length=4U c_width=4U
* device instance $922 r0 *1 332.8,128.2 cap_mim_2f0_m4m5_noshield
X$922 \$84__t47 topn__t391 cap_mim_2f0_m4m5_noshield c_length=4U c_width=4U
* device instance $923 r0 *1 339.2,128.2 cap_mim_2f0_m4m5_noshield
X$923 \$81__t195 topn__t392 cap_mim_2f0_m4m5_noshield c_length=4U c_width=4U
* device instance $924 r0 *1 345.6,128.2 cap_mim_2f0_m4m5_noshield
X$924 \$84__t48 topn__t393 cap_mim_2f0_m4m5_noshield c_length=4U c_width=4U
* device instance $925 r0 *1 352,128.2 cap_mim_2f0_m4m5_noshield
X$925 \$81__t196 topn__t394 cap_mim_2f0_m4m5_noshield c_length=4U c_width=4U
* device instance $926 r0 *1 358.4,128.2 cap_mim_2f0_m4m5_noshield
X$926 \$84__t49 topn__t395 cap_mim_2f0_m4m5_noshield c_length=4U c_width=4U
* device instance $927 r0 *1 364.8,128.2 cap_mim_2f0_m4m5_noshield
X$927 \$81__t197 topn__t396 cap_mim_2f0_m4m5_noshield c_length=4U c_width=4U
* device instance $928 r0 *1 371.2,128.2 cap_mim_2f0_m4m5_noshield
X$928 \$84__t50 topn__t397 cap_mim_2f0_m4m5_noshield c_length=4U c_width=4U
* device instance $929 r0 *1 377.6,128.2 cap_mim_2f0_m4m5_noshield
X$929 \$81__t198 topn__t398 cap_mim_2f0_m4m5_noshield c_length=4U c_width=4U
* device instance $930 r0 *1 384,128.2 cap_mim_2f0_m4m5_noshield
X$930 \$84__t51 topn__t399 cap_mim_2f0_m4m5_noshield c_length=4U c_width=4U
* device instance $931 r0 *1 390.4,128.2 cap_mim_2f0_m4m5_noshield
X$931 \$81__t106 topn__t217 cap_mim_2f0_m4m5_noshield c_length=4U c_width=4U
* device instance $932 r0 *1 396.8,128.2 cap_mim_2f0_m4m5_noshield
X$932 \$84__t18 topn__t219 cap_mim_2f0_m4m5_noshield c_length=4U c_width=4U
* device instance $933 r0 *1 403.2,128.2 cap_mim_2f0_m4m5_noshield
X$933 \$81__t107 topn__t220 cap_mim_2f0_m4m5_noshield c_length=4U c_width=4U
* device instance $934 r0 *1 409.6,128.2 cap_mim_2f0_m4m5_noshield
X$934 \$84__t19 topn__t221 cap_mim_2f0_m4m5_noshield c_length=4U c_width=4U
* device instance $935 r0 *1 416,128.2 cap_mim_2f0_m4m5_noshield
X$935 \$81__t108 topn__t222 cap_mim_2f0_m4m5_noshield c_length=4U c_width=4U
* device instance $936 r0 *1 422.4,128.2 cap_mim_2f0_m4m5_noshield
X$936 \$84__t20 topn__t223 cap_mim_2f0_m4m5_noshield c_length=4U c_width=4U
* device instance $937 r0 *1 2.6,134.6 cap_mim_2f0_m4m5_noshield
X$937 \$12__t19 topp__t36 cap_mim_2f0_m4m5_noshield c_length=4U c_width=4U
* device instance $938 r0 *1 9,134.6 cap_mim_2f0_m4m5_noshield
X$938 \$24__t63 topp__t210 cap_mim_2f0_m4m5_noshield c_length=4U c_width=4U
* device instance $939 r0 *1 15.4,134.6 cap_mim_2f0_m4m5_noshield
X$939 \$12__t105 topp__t209 cap_mim_2f0_m4m5_noshield c_length=4U c_width=4U
* device instance $940 r0 *1 21.8,134.6 cap_mim_2f0_m4m5_noshield
X$940 \$24__t62 topp__t208 cap_mim_2f0_m4m5_noshield c_length=4U c_width=4U
* device instance $941 r0 *1 28.2,134.6 cap_mim_2f0_m4m5_noshield
X$941 \$12__t22 topp__t41 cap_mim_2f0_m4m5_noshield c_length=4U c_width=4U
* device instance $942 r0 *1 34.6,134.6 cap_mim_2f0_m4m5_noshield
X$942 \$24__t10 topp__t40 cap_mim_2f0_m4m5_noshield c_length=4U c_width=4U
* device instance $943 r0 *1 41,134.6 cap_mim_2f0_m4m5_noshield
X$943 \$12__t21 topp__t39 cap_mim_2f0_m4m5_noshield c_length=4U c_width=4U
* device instance $944 r0 *1 47.4,134.6 cap_mim_2f0_m4m5_noshield
X$944 \$24__t9 topp__t38 cap_mim_2f0_m4m5_noshield c_length=4U c_width=4U
* device instance $945 r0 *1 53.8,134.6 cap_mim_2f0_m4m5_noshield
X$945 \$12__t20 topp__t37 cap_mim_2f0_m4m5_noshield c_length=4U c_width=4U
* device instance $946 r0 *1 60.2,134.6 cap_mim_2f0_m4m5_noshield
X$946 \$24__t26 topp__t110 cap_mim_2f0_m4m5_noshield c_length=4U c_width=4U
* device instance $947 r0 *1 66.6,134.6 cap_mim_2f0_m4m5_noshield
X$947 \$12__t104 topp__t207 cap_mim_2f0_m4m5_noshield c_length=4U c_width=4U
* device instance $948 r0 *1 73,134.6 cap_mim_2f0_m4m5_noshield
X$948 \$24__t61 topp__t205 cap_mim_2f0_m4m5_noshield c_length=4U c_width=4U
* device instance $949 r0 *1 79.4,134.6 cap_mim_2f0_m4m5_noshield
X$949 \$12__t102 topp__t204 cap_mim_2f0_m4m5_noshield c_length=4U c_width=4U
* device instance $950 r0 *1 85.8,134.6 cap_mim_2f0_m4m5_noshield
X$950 \$24__t60 topp__t203 cap_mim_2f0_m4m5_noshield c_length=4U c_width=4U
* device instance $951 r0 *1 92.2,134.6 cap_mim_2f0_m4m5_noshield
X$951 \$12__t103 topp__t206 cap_mim_2f0_m4m5_noshield c_length=4U c_width=4U
* device instance $952 r0 *1 98.6,134.6 cap_mim_2f0_m4m5_noshield
X$952 \$24__t58 topp__t201 cap_mim_2f0_m4m5_noshield c_length=4U c_width=4U
* device instance $953 r0 *1 105,134.6 cap_mim_2f0_m4m5_noshield
X$953 \$12__t101 topp__t200 cap_mim_2f0_m4m5_noshield c_length=4U c_width=4U
* device instance $954 r0 *1 111.4,134.6 cap_mim_2f0_m4m5_noshield
X$954 \$24__t54 topp__t193 cap_mim_2f0_m4m5_noshield c_length=4U c_width=4U
* device instance $955 r0 *1 117.8,134.6 cap_mim_2f0_m4m5_noshield
X$955 \$12__t138 topp__t278 cap_mim_2f0_m4m5_noshield c_length=4U c_width=4U
* device instance $956 r0 *1 124.2,134.6 cap_mim_2f0_m4m5_noshield
X$956 \$24__t27 topp__t112 cap_mim_2f0_m4m5_noshield c_length=4U c_width=4U
* device instance $957 r0 *1 130.6,134.6 cap_mim_2f0_m4m5_noshield
X$957 \$12__t132 topp__t262 cap_mim_2f0_m4m5_noshield c_length=4U c_width=4U
* device instance $958 r0 *1 137,134.6 cap_mim_2f0_m4m5_noshield
X$958 \$24__t89 topp__t307 cap_mim_2f0_m4m5_noshield c_length=4U c_width=4U
* device instance $959 r0 *1 143.4,134.6 cap_mim_2f0_m4m5_noshield
X$959 \$12__t147 topp__t293 cap_mim_2f0_m4m5_noshield c_length=4U c_width=4U
* device instance $960 r0 *1 149.8,134.6 cap_mim_2f0_m4m5_noshield
X$960 \$24__t82 topp__t292 cap_mim_2f0_m4m5_noshield c_length=4U c_width=4U
* device instance $961 r0 *1 156.2,134.6 cap_mim_2f0_m4m5_noshield
X$961 \$12__t146 topp__t291 cap_mim_2f0_m4m5_noshield c_length=4U c_width=4U
* device instance $962 r0 *1 162.6,134.6 cap_mim_2f0_m4m5_noshield
X$962 \$24__t17 topp__t89 cap_mim_2f0_m4m5_noshield c_length=4U c_width=4U
* device instance $963 r0 *1 169,134.6 cap_mim_2f0_m4m5_noshield
X$963 \$12__t45 topp__t88 cap_mim_2f0_m4m5_noshield c_length=4U c_width=4U
* device instance $964 r0 *1 175.4,134.6 cap_mim_2f0_m4m5_noshield
X$964 \$24__t15 topp__t74 cap_mim_2f0_m4m5_noshield c_length=4U c_width=4U
* device instance $965 r0 *1 181.8,134.6 cap_mim_2f0_m4m5_noshield
X$965 \$12__t38 topp__t73 cap_mim_2f0_m4m5_noshield c_length=4U c_width=4U
* device instance $966 r0 *1 188.2,134.6 cap_mim_2f0_m4m5_noshield
X$966 \$24__t29 topp__t115 cap_mim_2f0_m4m5_noshield c_length=4U c_width=4U
* device instance $967 r0 *1 194.6,134.6 cap_mim_2f0_m4m5_noshield
X$967 \$12__t58 topp__t114 cap_mim_2f0_m4m5_noshield c_length=4U c_width=4U
* device instance $968 r0 *1 201,134.6 cap_mim_2f0_m4m5_noshield
X$968 \$24__t28 topp__t113 cap_mim_2f0_m4m5_noshield c_length=4U c_width=4U
* device instance $969 r0 *1 224,134.6 cap_mim_2f0_m4m5_noshield
X$969 \$81__t2 topn__t6 cap_mim_2f0_m4m5_noshield c_length=4U c_width=4U
* device instance $970 r0 *1 230.4,134.6 cap_mim_2f0_m4m5_noshield
X$970 \$83__t1 topn__t5 cap_mim_2f0_m4m5_noshield c_length=4U c_width=4U
* device instance $971 r0 *1 236.8,134.6 cap_mim_2f0_m4m5_noshield
X$971 \$81__t233 topn__t465 cap_mim_2f0_m4m5_noshield c_length=4U c_width=4U
* device instance $972 r0 *1 243.2,134.6 cap_mim_2f0_m4m5_noshield
X$972 \$83__t118 topn__t466 cap_mim_2f0_m4m5_noshield c_length=4U c_width=4U
* device instance $973 r0 *1 249.6,134.6 cap_mim_2f0_m4m5_noshield
X$973 \$81__t234 topn__t467 cap_mim_2f0_m4m5_noshield c_length=4U c_width=4U
* device instance $974 r0 *1 256,134.6 cap_mim_2f0_m4m5_noshield
X$974 \$83__t119 topn__t468 cap_mim_2f0_m4m5_noshield c_length=4U c_width=4U
* device instance $975 r0 *1 262.4,134.6 cap_mim_2f0_m4m5_noshield
X$975 \$81__t235 topn__t469 cap_mim_2f0_m4m5_noshield c_length=4U c_width=4U
* device instance $976 r0 *1 268.8,134.6 cap_mim_2f0_m4m5_noshield
X$976 \$83__t120 topn__t470 cap_mim_2f0_m4m5_noshield c_length=4U c_width=4U
* device instance $977 r0 *1 275.2,134.6 cap_mim_2f0_m4m5_noshield
X$977 \$81__t206 topn__t412 cap_mim_2f0_m4m5_noshield c_length=4U c_width=4U
* device instance $978 r0 *1 281.6,134.6 cap_mim_2f0_m4m5_noshield
X$978 \$83__t101 topn__t410 cap_mim_2f0_m4m5_noshield c_length=4U c_width=4U
* device instance $979 r0 *1 288,134.6 cap_mim_2f0_m4m5_noshield
X$979 \$81__t205 topn__t411 cap_mim_2f0_m4m5_noshield c_length=4U c_width=4U
* device instance $980 r0 *1 294.4,134.6 cap_mim_2f0_m4m5_noshield
X$980 \$83__t72 topn__t273 cap_mim_2f0_m4m5_noshield c_length=4U c_width=4U
* device instance $981 r0 *1 300.8,134.6 cap_mim_2f0_m4m5_noshield
X$981 \$81__t216 topn__t431 cap_mim_2f0_m4m5_noshield c_length=4U c_width=4U
* device instance $982 r0 *1 307.2,134.6 cap_mim_2f0_m4m5_noshield
X$982 \$83__t111 topn__t432 cap_mim_2f0_m4m5_noshield c_length=4U c_width=4U
* device instance $983 r0 *1 313.6,134.6 cap_mim_2f0_m4m5_noshield
X$983 \$81__t221 topn__t439 cap_mim_2f0_m4m5_noshield c_length=4U c_width=4U
* device instance $984 r0 *1 320,134.6 cap_mim_2f0_m4m5_noshield
X$984 \$83__t107 topn__t424 cap_mim_2f0_m4m5_noshield c_length=4U c_width=4U
* device instance $985 r0 *1 326.4,134.6 cap_mim_2f0_m4m5_noshield
X$985 \$81__t213 topn__t425 cap_mim_2f0_m4m5_noshield c_length=4U c_width=4U
* device instance $986 r0 *1 332.8,134.6 cap_mim_2f0_m4m5_noshield
X$986 \$83__t108 topn__t426 cap_mim_2f0_m4m5_noshield c_length=4U c_width=4U
* device instance $987 r0 *1 339.2,134.6 cap_mim_2f0_m4m5_noshield
X$987 \$81__t214 topn__t427 cap_mim_2f0_m4m5_noshield c_length=4U c_width=4U
* device instance $988 r0 *1 345.6,134.6 cap_mim_2f0_m4m5_noshield
X$988 \$83__t109 topn__t428 cap_mim_2f0_m4m5_noshield c_length=4U c_width=4U
* device instance $989 r0 *1 352,134.6 cap_mim_2f0_m4m5_noshield
X$989 \$81__t118 topn__t240 cap_mim_2f0_m4m5_noshield c_length=4U c_width=4U
* device instance $990 r0 *1 358.4,134.6 cap_mim_2f0_m4m5_noshield
X$990 \$83__t51 topn__t189 cap_mim_2f0_m4m5_noshield c_length=4U c_width=4U
* device instance $991 r0 *1 364.8,134.6 cap_mim_2f0_m4m5_noshield
X$991 \$81__t97 topn__t201 cap_mim_2f0_m4m5_noshield c_length=4U c_width=4U
* device instance $992 r0 *1 371.2,134.6 cap_mim_2f0_m4m5_noshield
X$992 \$83__t74 topn__t279 cap_mim_2f0_m4m5_noshield c_length=4U c_width=4U
* device instance $993 r0 *1 377.6,134.6 cap_mim_2f0_m4m5_noshield
X$993 \$81__t145 topn__t291 cap_mim_2f0_m4m5_noshield c_length=4U c_width=4U
* device instance $994 r0 *1 384,134.6 cap_mim_2f0_m4m5_noshield
X$994 \$83__t79 topn__t303 cap_mim_2f0_m4m5_noshield c_length=4U c_width=4U
* device instance $995 r0 *1 390.4,134.6 cap_mim_2f0_m4m5_noshield
X$995 \$81__t89 topn__t183 cap_mim_2f0_m4m5_noshield c_length=4U c_width=4U
* device instance $996 r0 *1 396.8,134.6 cap_mim_2f0_m4m5_noshield
X$996 \$83__t48 topn__t184 cap_mim_2f0_m4m5_noshield c_length=4U c_width=4U
* device instance $997 r0 *1 403.2,134.6 cap_mim_2f0_m4m5_noshield
X$997 \$81__t90 topn__t185 cap_mim_2f0_m4m5_noshield c_length=4U c_width=4U
* device instance $998 r0 *1 409.6,134.6 cap_mim_2f0_m4m5_noshield
X$998 \$83__t49 topn__t186 cap_mim_2f0_m4m5_noshield c_length=4U c_width=4U
* device instance $999 r0 *1 416,134.6 cap_mim_2f0_m4m5_noshield
X$999 \$81__t91 topn__t187 cap_mim_2f0_m4m5_noshield c_length=4U c_width=4U
* device instance $1000 r0 *1 422.4,134.6 cap_mim_2f0_m4m5_noshield
X$1000 \$83__t50 topn__t188 cap_mim_2f0_m4m5_noshield c_length=4U c_width=4U
* device instance $1001 r0 *1 2.6,141 cap_mim_2f0_m4m5_noshield
X$1001 \$12__t18 topp__t35 cap_mim_2f0_m4m5_noshield c_length=4U c_width=4U
* device instance $1002 r0 *1 9,141 cap_mim_2f0_m4m5_noshield
X$1002 \$24__t8 topp__t34 cap_mim_2f0_m4m5_noshield c_length=4U c_width=4U
* device instance $1003 r0 *1 15.4,141 cap_mim_2f0_m4m5_noshield
X$1003 \$12__t17 topp__t33 cap_mim_2f0_m4m5_noshield c_length=4U c_width=4U
* device instance $1004 r0 *1 21.8,141 cap_mim_2f0_m4m5_noshield
X$1004 \$24__t7 topp__t32 cap_mim_2f0_m4m5_noshield c_length=4U c_width=4U
* device instance $1005 r0 *1 28.2,141 cap_mim_2f0_m4m5_noshield
X$1005 \$12__t70 topp__t135 cap_mim_2f0_m4m5_noshield c_length=4U c_width=4U
* device instance $1006 r0 *1 34.6,141 cap_mim_2f0_m4m5_noshield
X$1006 \$24__t65 topp__t214 cap_mim_2f0_m4m5_noshield c_length=4U c_width=4U
* device instance $1007 r0 *1 41,141 cap_mim_2f0_m4m5_noshield
X$1007 \$12__t107 topp__t213 cap_mim_2f0_m4m5_noshield c_length=4U c_width=4U
* device instance $1008 r0 *1 47.4,141 cap_mim_2f0_m4m5_noshield
X$1008 \$24__t64 topp__t212 cap_mim_2f0_m4m5_noshield c_length=4U c_width=4U
* device instance $1009 r0 *1 53.8,141 cap_mim_2f0_m4m5_noshield
X$1009 \$12__t106 topp__t211 cap_mim_2f0_m4m5_noshield c_length=4U c_width=4U
* device instance $1010 r0 *1 60.2,141 cap_mim_2f0_m4m5_noshield
X$1010 \$24__t6 topp__t29 cap_mim_2f0_m4m5_noshield c_length=4U c_width=4U
* device instance $1011 r0 *1 66.6,141 cap_mim_2f0_m4m5_noshield
X$1011 \$12__t108 topp__t215 cap_mim_2f0_m4m5_noshield c_length=4U c_width=4U
* device instance $1012 r0 *1 73,141 cap_mim_2f0_m4m5_noshield
X$1012 \$24__t57 topp__t198 cap_mim_2f0_m4m5_noshield c_length=4U c_width=4U
* device instance $1013 r0 *1 79.4,141 cap_mim_2f0_m4m5_noshield
X$1013 \$12__t100 topp__t197 cap_mim_2f0_m4m5_noshield c_length=4U c_width=4U
* device instance $1014 r0 *1 85.8,141 cap_mim_2f0_m4m5_noshield
X$1014 \$24__t56 topp__t196 cap_mim_2f0_m4m5_noshield c_length=4U c_width=4U
* device instance $1015 r0 *1 92.2,141 cap_mim_2f0_m4m5_noshield
X$1015 \$12__t99 topp__t195 cap_mim_2f0_m4m5_noshield c_length=4U c_width=4U
* device instance $1016 r0 *1 98.6,141 cap_mim_2f0_m4m5_noshield
X$1016 \$24__t55 topp__t194 cap_mim_2f0_m4m5_noshield c_length=4U c_width=4U
* device instance $1017 r0 *1 105,141 cap_mim_2f0_m4m5_noshield
X$1017 \$12__t98 topp__t192 cap_mim_2f0_m4m5_noshield c_length=4U c_width=4U
* device instance $1018 r0 *1 111.4,141 cap_mim_2f0_m4m5_noshield
X$1018 \$24__t59 topp__t202 cap_mim_2f0_m4m5_noshield c_length=4U c_width=4U
* device instance $1019 r0 *1 117.8,141 cap_mim_2f0_m4m5_noshield
X$1019 \$12__t137 topp__t276 cap_mim_2f0_m4m5_noshield c_length=4U c_width=4U
* device instance $1020 r0 *1 124.2,141 cap_mim_2f0_m4m5_noshield
X$1020 \$24__t73 topp__t261 cap_mim_2f0_m4m5_noshield c_length=4U c_width=4U
* device instance $1021 r0 *1 130.6,141 cap_mim_2f0_m4m5_noshield
X$1021 \$12__t131 topp__t260 cap_mim_2f0_m4m5_noshield c_length=4U c_width=4U
* device instance $1022 r0 *1 137,141 cap_mim_2f0_m4m5_noshield
X$1022 \$24__t72 topp__t259 cap_mim_2f0_m4m5_noshield c_length=4U c_width=4U
* device instance $1023 r0 *1 143.4,141 cap_mim_2f0_m4m5_noshield
X$1023 \$12__t130 topp__t258 cap_mim_2f0_m4m5_noshield c_length=4U c_width=4U
* device instance $1024 r0 *1 149.8,141 cap_mim_2f0_m4m5_noshield
X$1024 \$24__t71 topp__t257 cap_mim_2f0_m4m5_noshield c_length=4U c_width=4U
* device instance $1025 r0 *1 156.2,141 cap_mim_2f0_m4m5_noshield
X$1025 \$12__t129 topp__t256 cap_mim_2f0_m4m5_noshield c_length=4U c_width=4U
* device instance $1026 r0 *1 162.6,141 cap_mim_2f0_m4m5_noshield
X$1026 \$24__t70 topp__t255 cap_mim_2f0_m4m5_noshield c_length=4U c_width=4U
* device instance $1027 r0 *1 169,141 cap_mim_2f0_m4m5_noshield
X$1027 \$12__t128 topp__t254 cap_mim_2f0_m4m5_noshield c_length=4U c_width=4U
* device instance $1028 r0 *1 175.4,141 cap_mim_2f0_m4m5_noshield
X$1028 \$24__t69 topp__t253 cap_mim_2f0_m4m5_noshield c_length=4U c_width=4U
* device instance $1029 r0 *1 181.8,141 cap_mim_2f0_m4m5_noshield
X$1029 \$12__t127 topp__t252 cap_mim_2f0_m4m5_noshield c_length=4U c_width=4U
* device instance $1030 r0 *1 188.2,141 cap_mim_2f0_m4m5_noshield
X$1030 \$24__t68 topp__t251 cap_mim_2f0_m4m5_noshield c_length=4U c_width=4U
* device instance $1031 r0 *1 194.6,141 cap_mim_2f0_m4m5_noshield
X$1031 \$12__t126 topp__t250 cap_mim_2f0_m4m5_noshield c_length=4U c_width=4U
* device instance $1032 r0 *1 201,141 cap_mim_2f0_m4m5_noshield
X$1032 \$24__t67 topp__t249 cap_mim_2f0_m4m5_noshield c_length=4U c_width=4U
* device instance $1033 r0 *1 224,141 cap_mim_2f0_m4m5_noshield
X$1033 \$81__t68 topn__t138 cap_mim_2f0_m4m5_noshield c_length=4U c_width=4U
* device instance $1034 r0 *1 230.4,141 cap_mim_2f0_m4m5_noshield
X$1034 \$83__t38 topn__t139 cap_mim_2f0_m4m5_noshield c_length=4U c_width=4U
* device instance $1035 r0 *1 236.8,141 cap_mim_2f0_m4m5_noshield
X$1035 \$81__t207 topn__t413 cap_mim_2f0_m4m5_noshield c_length=4U c_width=4U
* device instance $1036 r0 *1 243.2,141 cap_mim_2f0_m4m5_noshield
X$1036 \$83__t102 topn__t414 cap_mim_2f0_m4m5_noshield c_length=4U c_width=4U
* device instance $1037 r0 *1 249.6,141 cap_mim_2f0_m4m5_noshield
X$1037 \$81__t208 topn__t415 cap_mim_2f0_m4m5_noshield c_length=4U c_width=4U
* device instance $1038 r0 *1 256,141 cap_mim_2f0_m4m5_noshield
X$1038 \$83__t103 topn__t416 cap_mim_2f0_m4m5_noshield c_length=4U c_width=4U
* device instance $1039 r0 *1 262.4,141 cap_mim_2f0_m4m5_noshield
X$1039 \$81__t253 topn__t507 cap_mim_2f0_m4m5_noshield c_length=4U c_width=4U
* device instance $1040 r0 *1 268.8,141 cap_mim_2f0_m4m5_noshield
X$1040 \$83__t126 topn__t508 cap_mim_2f0_m4m5_noshield c_length=4U c_width=4U
* device instance $1041 r0 *1 275.2,141 cap_mim_2f0_m4m5_noshield
X$1041 \$81__t254 topn__t509 cap_mim_2f0_m4m5_noshield c_length=4U c_width=4U
* device instance $1042 r0 *1 281.6,141 cap_mim_2f0_m4m5_noshield
X$1042 \$83__t127 topn__t511 cap_mim_2f0_m4m5_noshield c_length=4U c_width=4U
* device instance $1043 r0 *1 288,141 cap_mim_2f0_m4m5_noshield
X$1043 \$81__t201 topn__t404 cap_mim_2f0_m4m5_noshield c_length=4U c_width=4U
* device instance $1044 r0 *1 294.4,141 cap_mim_2f0_m4m5_noshield
X$1044 \$83__t65 topn__t259 cap_mim_2f0_m4m5_noshield c_length=4U c_width=4U
* device instance $1045 r0 *1 300.8,141 cap_mim_2f0_m4m5_noshield
X$1045 \$81__t209 topn__t417 cap_mim_2f0_m4m5_noshield c_length=4U c_width=4U
* device instance $1046 r0 *1 307.2,141 cap_mim_2f0_m4m5_noshield
X$1046 \$83__t104 topn__t418 cap_mim_2f0_m4m5_noshield c_length=4U c_width=4U
* device instance $1047 r0 *1 313.6,141 cap_mim_2f0_m4m5_noshield
X$1047 \$81__t210 topn__t419 cap_mim_2f0_m4m5_noshield c_length=4U c_width=4U
* device instance $1048 r0 *1 320,141 cap_mim_2f0_m4m5_noshield
X$1048 \$83__t105 topn__t420 cap_mim_2f0_m4m5_noshield c_length=4U c_width=4U
* device instance $1049 r0 *1 326.4,141 cap_mim_2f0_m4m5_noshield
X$1049 \$81__t211 topn__t421 cap_mim_2f0_m4m5_noshield c_length=4U c_width=4U
* device instance $1050 r0 *1 332.8,141 cap_mim_2f0_m4m5_noshield
X$1050 \$83__t106 topn__t422 cap_mim_2f0_m4m5_noshield c_length=4U c_width=4U
* device instance $1051 r0 *1 339.2,141 cap_mim_2f0_m4m5_noshield
X$1051 \$81__t215 topn__t429 cap_mim_2f0_m4m5_noshield c_length=4U c_width=4U
* device instance $1052 r0 *1 345.6,141 cap_mim_2f0_m4m5_noshield
X$1052 \$83__t110 topn__t430 cap_mim_2f0_m4m5_noshield c_length=4U c_width=4U
* device instance $1053 r0 *1 352,141 cap_mim_2f0_m4m5_noshield
X$1053 \$81__t110 topn__t225 cap_mim_2f0_m4m5_noshield c_length=4U c_width=4U
* device instance $1054 r0 *1 358.4,141 cap_mim_2f0_m4m5_noshield
X$1054 \$83__t52 topn__t190 cap_mim_2f0_m4m5_noshield c_length=4U c_width=4U
* device instance $1055 r0 *1 364.8,141 cap_mim_2f0_m4m5_noshield
X$1055 \$81__t92 topn__t191 cap_mim_2f0_m4m5_noshield c_length=4U c_width=4U
* device instance $1056 r0 *1 371.2,141 cap_mim_2f0_m4m5_noshield
X$1056 \$83__t53 topn__t192 cap_mim_2f0_m4m5_noshield c_length=4U c_width=4U
* device instance $1057 r0 *1 377.6,141 cap_mim_2f0_m4m5_noshield
X$1057 \$81__t102 topn__t209 cap_mim_2f0_m4m5_noshield c_length=4U c_width=4U
* device instance $1058 r0 *1 384,141 cap_mim_2f0_m4m5_noshield
X$1058 \$83__t54 topn__t194 cap_mim_2f0_m4m5_noshield c_length=4U c_width=4U
* device instance $1059 r0 *1 390.4,141 cap_mim_2f0_m4m5_noshield
X$1059 \$81__t94 topn__t195 cap_mim_2f0_m4m5_noshield c_length=4U c_width=4U
* device instance $1060 r0 *1 396.8,141 cap_mim_2f0_m4m5_noshield
X$1060 \$83__t55 topn__t196 cap_mim_2f0_m4m5_noshield c_length=4U c_width=4U
* device instance $1061 r0 *1 403.2,141 cap_mim_2f0_m4m5_noshield
X$1061 \$81__t95 topn__t197 cap_mim_2f0_m4m5_noshield c_length=4U c_width=4U
* device instance $1062 r0 *1 409.6,141 cap_mim_2f0_m4m5_noshield
X$1062 \$83__t56 topn__t198 cap_mim_2f0_m4m5_noshield c_length=4U c_width=4U
* device instance $1063 r0 *1 416,141 cap_mim_2f0_m4m5_noshield
X$1063 \$81__t96 topn__t199 cap_mim_2f0_m4m5_noshield c_length=4U c_width=4U
* device instance $1064 r0 *1 422.4,141 cap_mim_2f0_m4m5_noshield
X$1064 \$83__t57 topn__t200 cap_mim_2f0_m4m5_noshield c_length=4U c_width=4U
* device instance $1065 r0 *1 2.6,147.4 cap_mim_2f0_m4m5_noshield
X$1065 \$24__t25 topp__t108 cap_mim_2f0_m4m5_noshield c_length=4U c_width=4U
* device instance $1066 r0 *1 9,147.4 cap_mim_2f0_m4m5_noshield
X$1066 \$12__t61 topp__t119 cap_mim_2f0_m4m5_noshield c_length=4U c_width=4U
* device instance $1067 r0 *1 15.4,147.4 cap_mim_2f0_m4m5_noshield
X$1067 \$24__t24 topp__t106 cap_mim_2f0_m4m5_noshield c_length=4U c_width=4U
* device instance $1068 r0 *1 21.8,147.4 cap_mim_2f0_m4m5_noshield
X$1068 \$12__t55 topp__t105 cap_mim_2f0_m4m5_noshield c_length=4U c_width=4U
* device instance $1069 r0 *1 28.2,147.4 cap_mim_2f0_m4m5_noshield
X$1069 \$24__t23 topp__t104 cap_mim_2f0_m4m5_noshield c_length=4U c_width=4U
* device instance $1070 r0 *1 34.6,147.4 cap_mim_2f0_m4m5_noshield
X$1070 \$12__t54 topp__t103 cap_mim_2f0_m4m5_noshield c_length=4U c_width=4U
* device instance $1071 r0 *1 41,147.4 cap_mim_2f0_m4m5_noshield
X$1071 \$24__t22 topp__t102 cap_mim_2f0_m4m5_noshield c_length=4U c_width=4U
* device instance $1072 r0 *1 47.4,147.4 cap_mim_2f0_m4m5_noshield
X$1072 \$12__t53 topp__t101 cap_mim_2f0_m4m5_noshield c_length=4U c_width=4U
* device instance $1073 r0 *1 53.8,147.4 cap_mim_2f0_m4m5_noshield
X$1073 \$24__t21 topp__t100 cap_mim_2f0_m4m5_noshield c_length=4U c_width=4U
* device instance $1074 r0 *1 60.2,147.4 cap_mim_2f0_m4m5_noshield
X$1074 \$12__t52 topp__t99 cap_mim_2f0_m4m5_noshield c_length=4U c_width=4U
* device instance $1075 r0 *1 66.6,147.4 cap_mim_2f0_m4m5_noshield
X$1075 \$24__t20 topp__t98 cap_mim_2f0_m4m5_noshield c_length=4U c_width=4U
* device instance $1076 r0 *1 73,147.4 cap_mim_2f0_m4m5_noshield
X$1076 \$12__t51 topp__t97 cap_mim_2f0_m4m5_noshield c_length=4U c_width=4U
* device instance $1077 r0 *1 79.4,147.4 cap_mim_2f0_m4m5_noshield
X$1077 \$24__t19 topp__t96 cap_mim_2f0_m4m5_noshield c_length=4U c_width=4U
* device instance $1078 r0 *1 85.8,147.4 cap_mim_2f0_m4m5_noshield
X$1078 \$12__t50 topp__t95 cap_mim_2f0_m4m5_noshield c_length=4U c_width=4U
* device instance $1079 r0 *1 92.2,147.4 cap_mim_2f0_m4m5_noshield
X$1079 \$24__t18 topp__t94 cap_mim_2f0_m4m5_noshield c_length=4U c_width=4U
* device instance $1080 r0 *1 98.6,147.4 cap_mim_2f0_m4m5_noshield
X$1080 \$12__t49 topp__t93 cap_mim_2f0_m4m5_noshield c_length=4U c_width=4U
* device instance $1081 r0 *1 105,147.4 cap_mim_2f0_m4m5_noshield
X$1081 \$24__t16 topp__t77 cap_mim_2f0_m4m5_noshield c_length=4U c_width=4U
* device instance $1082 r0 *1 111.4,147.4 cap_mim_2f0_m4m5_noshield
X$1082 \$12__t16 topp__t30 cap_mim_2f0_m4m5_noshield c_length=4U c_width=4U
* device instance $1083 r0 *1 117.8,147.4 cap_mim_2f0_m4m5_noshield
X$1083 \$24__t76 topp__t275 cap_mim_2f0_m4m5_noshield c_length=4U c_width=4U
* device instance $1084 r0 *1 124.2,147.4 cap_mim_2f0_m4m5_noshield
X$1084 \$12__t154 topp__t306 cap_mim_2f0_m4m5_noshield c_length=4U c_width=4U
* device instance $1085 r0 *1 130.6,147.4 cap_mim_2f0_m4m5_noshield
X$1085 \$24__t88 topp__t305 cap_mim_2f0_m4m5_noshield c_length=4U c_width=4U
* device instance $1086 r0 *1 137,147.4 cap_mim_2f0_m4m5_noshield
X$1086 \$12__t153 topp__t304 cap_mim_2f0_m4m5_noshield c_length=4U c_width=4U
* device instance $1087 r0 *1 143.4,147.4 cap_mim_2f0_m4m5_noshield
X$1087 \$24__t87 topp__t303 cap_mim_2f0_m4m5_noshield c_length=4U c_width=4U
* device instance $1088 r0 *1 149.8,147.4 cap_mim_2f0_m4m5_noshield
X$1088 \$12__t152 topp__t302 cap_mim_2f0_m4m5_noshield c_length=4U c_width=4U
* device instance $1089 r0 *1 156.2,147.4 cap_mim_2f0_m4m5_noshield
X$1089 \$24__t86 topp__t301 cap_mim_2f0_m4m5_noshield c_length=4U c_width=4U
* device instance $1090 r0 *1 162.6,147.4 cap_mim_2f0_m4m5_noshield
X$1090 \$12__t151 topp__t300 cap_mim_2f0_m4m5_noshield c_length=4U c_width=4U
* device instance $1091 r0 *1 169,147.4 cap_mim_2f0_m4m5_noshield
X$1091 \$24__t85 topp__t299 cap_mim_2f0_m4m5_noshield c_length=4U c_width=4U
* device instance $1092 r0 *1 175.4,147.4 cap_mim_2f0_m4m5_noshield
X$1092 \$12__t150 topp__t298 cap_mim_2f0_m4m5_noshield c_length=4U c_width=4U
* device instance $1093 r0 *1 181.8,147.4 cap_mim_2f0_m4m5_noshield
X$1093 \$24__t84 topp__t297 cap_mim_2f0_m4m5_noshield c_length=4U c_width=4U
* device instance $1094 r0 *1 188.2,147.4 cap_mim_2f0_m4m5_noshield
X$1094 \$12__t149 topp__t296 cap_mim_2f0_m4m5_noshield c_length=4U c_width=4U
* device instance $1095 r0 *1 194.6,147.4 cap_mim_2f0_m4m5_noshield
X$1095 \$24__t83 topp__t295 cap_mim_2f0_m4m5_noshield c_length=4U c_width=4U
* device instance $1096 r0 *1 201,147.4 cap_mim_2f0_m4m5_noshield
X$1096 \$12__t148 topp__t294 cap_mim_2f0_m4m5_noshield c_length=4U c_width=4U
* device instance $1097 r0 *1 224,147.4 cap_mim_2f0_m4m5_noshield
X$1097 \$83__t39 topn__t140 cap_mim_2f0_m4m5_noshield c_length=4U c_width=4U
* device instance $1098 r0 *1 230.4,147.4 cap_mim_2f0_m4m5_noshield
X$1098 \$81__t67 topn__t137 cap_mim_2f0_m4m5_noshield c_length=4U c_width=4U
* device instance $1099 r0 *1 236.8,147.4 cap_mim_2f0_m4m5_noshield
X$1099 \$83__t66 topn__t262 cap_mim_2f0_m4m5_noshield c_length=4U c_width=4U
* device instance $1100 r0 *1 243.2,147.4 cap_mim_2f0_m4m5_noshield
X$1100 \$81__t130 topn__t263 cap_mim_2f0_m4m5_noshield c_length=4U c_width=4U
* device instance $1101 r0 *1 249.6,147.4 cap_mim_2f0_m4m5_noshield
X$1101 \$83__t67 topn__t264 cap_mim_2f0_m4m5_noshield c_length=4U c_width=4U
* device instance $1102 r0 *1 256,147.4 cap_mim_2f0_m4m5_noshield
X$1102 \$81__t131 topn__t265 cap_mim_2f0_m4m5_noshield c_length=4U c_width=4U
* device instance $1103 r0 *1 262.4,147.4 cap_mim_2f0_m4m5_noshield
X$1103 \$83__t68 topn__t266 cap_mim_2f0_m4m5_noshield c_length=4U c_width=4U
* device instance $1104 r0 *1 268.8,147.4 cap_mim_2f0_m4m5_noshield
X$1104 \$81__t132 topn__t267 cap_mim_2f0_m4m5_noshield c_length=4U c_width=4U
* device instance $1105 r0 *1 275.2,147.4 cap_mim_2f0_m4m5_noshield
X$1105 \$83__t69 topn__t268 cap_mim_2f0_m4m5_noshield c_length=4U c_width=4U
* device instance $1106 r0 *1 281.6,147.4 cap_mim_2f0_m4m5_noshield
X$1106 \$81__t133 topn__t269 cap_mim_2f0_m4m5_noshield c_length=4U c_width=4U
* device instance $1107 r0 *1 288,147.4 cap_mim_2f0_m4m5_noshield
X$1107 \$83__t70 topn__t270 cap_mim_2f0_m4m5_noshield c_length=4U c_width=4U
* device instance $1108 r0 *1 294.4,147.4 cap_mim_2f0_m4m5_noshield
X$1108 \$81__t134 topn__t271 cap_mim_2f0_m4m5_noshield c_length=4U c_width=4U
* device instance $1109 r0 *1 300.8,147.4 cap_mim_2f0_m4m5_noshield
X$1109 \$83__t71 topn__t272 cap_mim_2f0_m4m5_noshield c_length=4U c_width=4U
* device instance $1110 r0 *1 307.2,147.4 cap_mim_2f0_m4m5_noshield
X$1110 \$81__t93 topn__t193 cap_mim_2f0_m4m5_noshield c_length=4U c_width=4U
* device instance $1111 r0 *1 313.6,147.4 cap_mim_2f0_m4m5_noshield
X$1111 \$83__t61 topn__t251 cap_mim_2f0_m4m5_noshield c_length=4U c_width=4U
* device instance $1112 r0 *1 320,147.4 cap_mim_2f0_m4m5_noshield
X$1112 \$81__t124 topn__t252 cap_mim_2f0_m4m5_noshield c_length=4U c_width=4U
* device instance $1113 r0 *1 326.4,147.4 cap_mim_2f0_m4m5_noshield
X$1113 \$83__t62 topn__t253 cap_mim_2f0_m4m5_noshield c_length=4U c_width=4U
* device instance $1114 r0 *1 332.8,147.4 cap_mim_2f0_m4m5_noshield
X$1114 \$81__t125 topn__t254 cap_mim_2f0_m4m5_noshield c_length=4U c_width=4U
* device instance $1115 r0 *1 339.2,147.4 cap_mim_2f0_m4m5_noshield
X$1115 \$83__t63 topn__t255 cap_mim_2f0_m4m5_noshield c_length=4U c_width=4U
* device instance $1116 r0 *1 345.6,147.4 cap_mim_2f0_m4m5_noshield
X$1116 \$81__t126 topn__t256 cap_mim_2f0_m4m5_noshield c_length=4U c_width=4U
* device instance $1117 r0 *1 352,147.4 cap_mim_2f0_m4m5_noshield
X$1117 \$83__t46 topn__t179 cap_mim_2f0_m4m5_noshield c_length=4U c_width=4U
* device instance $1118 r0 *1 358.4,147.4 cap_mim_2f0_m4m5_noshield
X$1118 \$81__t98 topn__t202 cap_mim_2f0_m4m5_noshield c_length=4U c_width=4U
* device instance $1119 r0 *1 364.8,147.4 cap_mim_2f0_m4m5_noshield
X$1119 \$83__t58 topn__t203 cap_mim_2f0_m4m5_noshield c_length=4U c_width=4U
* device instance $1120 r0 *1 371.2,147.4 cap_mim_2f0_m4m5_noshield
X$1120 \$81__t99 topn__t204 cap_mim_2f0_m4m5_noshield c_length=4U c_width=4U
* device instance $1121 r0 *1 377.6,147.4 cap_mim_2f0_m4m5_noshield
X$1121 \$83__t59 topn__t205 cap_mim_2f0_m4m5_noshield c_length=4U c_width=4U
* device instance $1122 r0 *1 384,147.4 cap_mim_2f0_m4m5_noshield
X$1122 \$81__t100 topn__t206 cap_mim_2f0_m4m5_noshield c_length=4U c_width=4U
* device instance $1123 r0 *1 390.4,147.4 cap_mim_2f0_m4m5_noshield
X$1123 \$83__t60 topn__t207 cap_mim_2f0_m4m5_noshield c_length=4U c_width=4U
* device instance $1124 r0 *1 396.8,147.4 cap_mim_2f0_m4m5_noshield
X$1124 \$81__t101 topn__t208 cap_mim_2f0_m4m5_noshield c_length=4U c_width=4U
* device instance $1125 r0 *1 403.2,147.4 cap_mim_2f0_m4m5_noshield
X$1125 \$83__t64 topn__t257 cap_mim_2f0_m4m5_noshield c_length=4U c_width=4U
* device instance $1126 r0 *1 409.6,147.4 cap_mim_2f0_m4m5_noshield
X$1126 \$81__t135 topn__t274 cap_mim_2f0_m4m5_noshield c_length=4U c_width=4U
* device instance $1127 r0 *1 416,147.4 cap_mim_2f0_m4m5_noshield
X$1127 \$83__t73 topn__t275 cap_mim_2f0_m4m5_noshield c_length=4U c_width=4U
* device instance $1128 r0 *1 422.4,147.4 cap_mim_2f0_m4m5_noshield
X$1128 \$81__t138 topn__t278 cap_mim_2f0_m4m5_noshield c_length=4U c_width=4U
* device instance $1129 r0 *1 2.6,153.8 cap_mim_2f0_m4m5_noshield
X$1129 \$24__t11 topp__t43 cap_mim_2f0_m4m5_noshield c_length=4U c_width=4U
* device instance $1130 r0 *1 9,153.8 cap_mim_2f0_m4m5_noshield
X$1130 \$12__t23 topp__t42 cap_mim_2f0_m4m5_noshield c_length=4U c_width=4U
* device instance $1131 r0 *1 15.4,153.8 cap_mim_2f0_m4m5_noshield
X$1131 \$24__t12 topp__t44 cap_mim_2f0_m4m5_noshield c_length=4U c_width=4U
* device instance $1132 r0 *1 21.8,153.8 cap_mim_2f0_m4m5_noshield
X$1132 \$12__t3 topp__t5 cap_mim_2f0_m4m5_noshield c_length=4U c_width=4U
* device instance $1133 r0 *1 28.2,153.8 cap_mim_2f0_m4m5_noshield
X$1133 \$24__t1 topp__t4 cap_mim_2f0_m4m5_noshield c_length=4U c_width=4U
* device instance $1134 r0 *1 34.6,153.8 cap_mim_2f0_m4m5_noshield
X$1134 \$12__t26 topp__t48 cap_mim_2f0_m4m5_noshield c_length=4U c_width=4U
* device instance $1135 r0 *1 41,153.8 cap_mim_2f0_m4m5_noshield
X$1135 \$24__t14 topp__t63 cap_mim_2f0_m4m5_noshield c_length=4U c_width=4U
* device instance $1136 r0 *1 47.4,153.8 cap_mim_2f0_m4m5_noshield
X$1136 \$12__t24 topp__t46 cap_mim_2f0_m4m5_noshield c_length=4U c_width=4U
* device instance $1137 r0 *1 53.8,153.8 cap_mim_2f0_m4m5_noshield
X$1137 \$24__t13 topp__t45 cap_mim_2f0_m4m5_noshield c_length=4U c_width=4U
* device instance $1138 r0 *1 60.2,153.8 cap_mim_2f0_m4m5_noshield
X$1138 \$12__t57 topp__t111 cap_mim_2f0_m4m5_noshield c_length=4U c_width=4U
* device instance $1139 r0 *1 66.6,153.8 cap_mim_2f0_m4m5_noshield
X$1139 \$24__t4 topp__t26 cap_mim_2f0_m4m5_noshield c_length=4U c_width=4U
* device instance $1140 r0 *1 73,153.8 cap_mim_2f0_m4m5_noshield
X$1140 \$12__t14 topp__t25 cap_mim_2f0_m4m5_noshield c_length=4U c_width=4U
* device instance $1141 r0 *1 79.4,153.8 cap_mim_2f0_m4m5_noshield
X$1141 \$24__t3 topp__t16 cap_mim_2f0_m4m5_noshield c_length=4U c_width=4U
* device instance $1142 r0 *1 85.8,153.8 cap_mim_2f0_m4m5_noshield
X$1142 \$12__t5 topp__t8 cap_mim_2f0_m4m5_noshield c_length=4U c_width=4U
* device instance $1143 r0 *1 92.2,153.8 cap_mim_2f0_m4m5_noshield
X$1143 \$24__t2 topp__t7 cap_mim_2f0_m4m5_noshield c_length=4U c_width=4U
* device instance $1144 r0 *1 98.6,153.8 cap_mim_2f0_m4m5_noshield
X$1144 \$12__t4 topp__t6 cap_mim_2f0_m4m5_noshield c_length=4U c_width=4U
* device instance $1145 r0 *1 105,153.8 cap_mim_2f0_m4m5_noshield
X$1145 \$24__t5 topp__t28 cap_mim_2f0_m4m5_noshield c_length=4U c_width=4U
* device instance $1146 r0 *1 111.4,153.8 cap_mim_2f0_m4m5_noshield
X$1146 \$12__t15 topp__t27 cap_mim_2f0_m4m5_noshield c_length=4U c_width=4U
* device instance $1147 r0 *1 117.8,153.8 cap_mim_2f0_m4m5_noshield
X$1147 \$24__t75 topp__t272 cap_mim_2f0_m4m5_noshield c_length=4U c_width=4U
* device instance $1148 r0 *1 124.2,153.8 cap_mim_2f0_m4m5_noshield
X$1148 \$12__t145 topp__t290 cap_mim_2f0_m4m5_noshield c_length=4U c_width=4U
* device instance $1149 r0 *1 130.6,153.8 cap_mim_2f0_m4m5_noshield
X$1149 \$24__t81 topp__t289 cap_mim_2f0_m4m5_noshield c_length=4U c_width=4U
* device instance $1150 r0 *1 137,153.8 cap_mim_2f0_m4m5_noshield
X$1150 \$12__t144 topp__t288 cap_mim_2f0_m4m5_noshield c_length=4U c_width=4U
* device instance $1151 r0 *1 143.4,153.8 cap_mim_2f0_m4m5_noshield
X$1151 \$24__t80 topp__t287 cap_mim_2f0_m4m5_noshield c_length=4U c_width=4U
* device instance $1152 r0 *1 149.8,153.8 cap_mim_2f0_m4m5_noshield
X$1152 \$12__t143 topp__t286 cap_mim_2f0_m4m5_noshield c_length=4U c_width=4U
* device instance $1153 r0 *1 156.2,153.8 cap_mim_2f0_m4m5_noshield
X$1153 \$24__t79 topp__t285 cap_mim_2f0_m4m5_noshield c_length=4U c_width=4U
* device instance $1154 r0 *1 162.6,153.8 cap_mim_2f0_m4m5_noshield
X$1154 \$12__t142 topp__t284 cap_mim_2f0_m4m5_noshield c_length=4U c_width=4U
* device instance $1155 r0 *1 169,153.8 cap_mim_2f0_m4m5_noshield
X$1155 \$24__t78 topp__t283 cap_mim_2f0_m4m5_noshield c_length=4U c_width=4U
* device instance $1156 r0 *1 175.4,153.8 cap_mim_2f0_m4m5_noshield
X$1156 \$12__t141 topp__t282 cap_mim_2f0_m4m5_noshield c_length=4U c_width=4U
* device instance $1157 r0 *1 181.8,153.8 cap_mim_2f0_m4m5_noshield
X$1157 \$24__t77 topp__t281 cap_mim_2f0_m4m5_noshield c_length=4U c_width=4U
* device instance $1158 r0 *1 188.2,153.8 cap_mim_2f0_m4m5_noshield
X$1158 \$12__t140 topp__t280 cap_mim_2f0_m4m5_noshield c_length=4U c_width=4U
* device instance $1159 r0 *1 194.6,153.8 cap_mim_2f0_m4m5_noshield
X$1159 \$24__t66 topp__t248 cap_mim_2f0_m4m5_noshield c_length=4U c_width=4U
* device instance $1160 r0 *1 201,153.8 cap_mim_2f0_m4m5_noshield
X$1160 \$12__t46 topp__t90 cap_mim_2f0_m4m5_noshield c_length=4U c_width=4U
* device instance $1161 r0 *1 224,153.8 cap_mim_2f0_m4m5_noshield
X$1161 \$83__t0 topn__t4 cap_mim_2f0_m4m5_noshield c_length=4U c_width=4U
* device instance $1162 r0 *1 230.4,153.8 cap_mim_2f0_m4m5_noshield
X$1162 \$81__t1 topn__t3 cap_mim_2f0_m4m5_noshield c_length=4U c_width=4U
* device instance $1163 r0 *1 236.8,153.8 cap_mim_2f0_m4m5_noshield
X$1163 \$83__t121 topn__t471 cap_mim_2f0_m4m5_noshield c_length=4U c_width=4U
* device instance $1164 r0 *1 243.2,153.8 cap_mim_2f0_m4m5_noshield
X$1164 \$81__t228 topn__t454 cap_mim_2f0_m4m5_noshield c_length=4U c_width=4U
* device instance $1165 r0 *1 249.6,153.8 cap_mim_2f0_m4m5_noshield
X$1165 \$83__t114 topn__t455 cap_mim_2f0_m4m5_noshield c_length=4U c_width=4U
* device instance $1166 r0 *1 256,153.8 cap_mim_2f0_m4m5_noshield
X$1166 \$81__t229 topn__t456 cap_mim_2f0_m4m5_noshield c_length=4U c_width=4U
* device instance $1167 r0 *1 262.4,153.8 cap_mim_2f0_m4m5_noshield
X$1167 \$83__t115 topn__t457 cap_mim_2f0_m4m5_noshield c_length=4U c_width=4U
* device instance $1168 r0 *1 268.8,153.8 cap_mim_2f0_m4m5_noshield
X$1168 \$81__t230 topn__t458 cap_mim_2f0_m4m5_noshield c_length=4U c_width=4U
* device instance $1169 r0 *1 275.2,153.8 cap_mim_2f0_m4m5_noshield
X$1169 \$83__t116 topn__t459 cap_mim_2f0_m4m5_noshield c_length=4U c_width=4U
* device instance $1170 r0 *1 281.6,153.8 cap_mim_2f0_m4m5_noshield
X$1170 \$81__t231 topn__t460 cap_mim_2f0_m4m5_noshield c_length=4U c_width=4U
* device instance $1171 r0 *1 288,153.8 cap_mim_2f0_m4m5_noshield
X$1171 \$83__t117 topn__t461 cap_mim_2f0_m4m5_noshield c_length=4U c_width=4U
* device instance $1172 r0 *1 294.4,153.8 cap_mim_2f0_m4m5_noshield
X$1172 \$81__t127 topn__t258 cap_mim_2f0_m4m5_noshield c_length=4U c_width=4U
* device instance $1173 r0 *1 300.8,153.8 cap_mim_2f0_m4m5_noshield
X$1173 \$83__t124 topn__t488 cap_mim_2f0_m4m5_noshield c_length=4U c_width=4U
* device instance $1174 r0 *1 307.2,153.8 cap_mim_2f0_m4m5_noshield
X$1174 \$81__t245 topn__t489 cap_mim_2f0_m4m5_noshield c_length=4U c_width=4U
* device instance $1175 r0 *1 313.6,153.8 cap_mim_2f0_m4m5_noshield
X$1175 \$83__t122 topn__t474 cap_mim_2f0_m4m5_noshield c_length=4U c_width=4U
* device instance $1176 r0 *1 320,153.8 cap_mim_2f0_m4m5_noshield
X$1176 \$81__t241 topn__t483 cap_mim_2f0_m4m5_noshield c_length=4U c_width=4U
* device instance $1177 r0 *1 326.4,153.8 cap_mim_2f0_m4m5_noshield
X$1177 \$83__t123 topn__t484 cap_mim_2f0_m4m5_noshield c_length=4U c_width=4U
* device instance $1178 r0 *1 332.8,153.8 cap_mim_2f0_m4m5_noshield
X$1178 \$81__t242 topn__t485 cap_mim_2f0_m4m5_noshield c_length=4U c_width=4U
* device instance $1179 r0 *1 339.2,153.8 cap_mim_2f0_m4m5_noshield
X$1179 \$83__t125 topn__t502 cap_mim_2f0_m4m5_noshield c_length=4U c_width=4U
* device instance $1180 r0 *1 345.6,153.8 cap_mim_2f0_m4m5_noshield
X$1180 \$81__t244 topn__t487 cap_mim_2f0_m4m5_noshield c_length=4U c_width=4U
* device instance $1181 r0 *1 352,153.8 cap_mim_2f0_m4m5_noshield
X$1181 \$83__t47 topn__t180 cap_mim_2f0_m4m5_noshield c_length=4U c_width=4U
* device instance $1182 r0 *1 358.4,153.8 cap_mim_2f0_m4m5_noshield
X$1182 \$81__t139 topn__t280 cap_mim_2f0_m4m5_noshield c_length=4U c_width=4U
* device instance $1183 r0 *1 364.8,153.8 cap_mim_2f0_m4m5_noshield
X$1183 \$83__t75 topn__t281 cap_mim_2f0_m4m5_noshield c_length=4U c_width=4U
* device instance $1184 r0 *1 371.2,153.8 cap_mim_2f0_m4m5_noshield
X$1184 \$81__t140 topn__t282 cap_mim_2f0_m4m5_noshield c_length=4U c_width=4U
* device instance $1185 r0 *1 377.6,153.8 cap_mim_2f0_m4m5_noshield
X$1185 \$83__t76 topn__t283 cap_mim_2f0_m4m5_noshield c_length=4U c_width=4U
* device instance $1186 r0 *1 384,153.8 cap_mim_2f0_m4m5_noshield
X$1186 \$81__t141 topn__t284 cap_mim_2f0_m4m5_noshield c_length=4U c_width=4U
* device instance $1187 r0 *1 390.4,153.8 cap_mim_2f0_m4m5_noshield
X$1187 \$83__t77 topn__t285 cap_mim_2f0_m4m5_noshield c_length=4U c_width=4U
* device instance $1188 r0 *1 396.8,153.8 cap_mim_2f0_m4m5_noshield
X$1188 \$81__t142 topn__t286 cap_mim_2f0_m4m5_noshield c_length=4U c_width=4U
* device instance $1189 r0 *1 403.2,153.8 cap_mim_2f0_m4m5_noshield
X$1189 \$83__t78 topn__t287 cap_mim_2f0_m4m5_noshield c_length=4U c_width=4U
* device instance $1190 r0 *1 409.6,153.8 cap_mim_2f0_m4m5_noshield
X$1190 \$81__t143 topn__t288 cap_mim_2f0_m4m5_noshield c_length=4U c_width=4U
* device instance $1191 r0 *1 416,153.8 cap_mim_2f0_m4m5_noshield
X$1191 \$83__t80 topn__t305 cap_mim_2f0_m4m5_noshield c_length=4U c_width=4U
* device instance $1192 r0 *1 422.4,153.8 cap_mim_2f0_m4m5_noshield
X$1192 \$81__t144 topn__t290 cap_mim_2f0_m4m5_noshield c_length=4U c_width=4U
* device instance $1193 r0 *1 2.6,160.2 cap_mim_2f0_m4m5_noshield
X$1193 \$32__t0 topp__t3 cap_mim_2f0_m4m5_noshield c_length=4U c_width=4U
* device instance $1194 r0 *1 9,160.2 cap_mim_2f0_m4m5_noshield
X$1194 \$12__t2 topp__t2 cap_mim_2f0_m4m5_noshield c_length=4U c_width=4U
* device instance $1195 r0 *1 15.4,160.2 cap_mim_2f0_m4m5_noshield
X$1195 \$32__t8 topp__t55 cap_mim_2f0_m4m5_noshield c_length=4U c_width=4U
* device instance $1196 r0 *1 21.8,160.2 cap_mim_2f0_m4m5_noshield
X$1196 \$12__t29 topp__t54 cap_mim_2f0_m4m5_noshield c_length=4U c_width=4U
* device instance $1197 r0 *1 28.2,160.2 cap_mim_2f0_m4m5_noshield
X$1197 \$32__t7 topp__t53 cap_mim_2f0_m4m5_noshield c_length=4U c_width=4U
* device instance $1198 r0 *1 34.6,160.2 cap_mim_2f0_m4m5_noshield
X$1198 \$12__t28 topp__t52 cap_mim_2f0_m4m5_noshield c_length=4U c_width=4U
* device instance $1199 r0 *1 41,160.2 cap_mim_2f0_m4m5_noshield
X$1199 \$32__t6 topp__t51 cap_mim_2f0_m4m5_noshield c_length=4U c_width=4U
* device instance $1200 r0 *1 47.4,160.2 cap_mim_2f0_m4m5_noshield
X$1200 \$12__t27 topp__t50 cap_mim_2f0_m4m5_noshield c_length=4U c_width=4U
* device instance $1201 r0 *1 53.8,160.2 cap_mim_2f0_m4m5_noshield
X$1201 \$32__t5 topp__t49 cap_mim_2f0_m4m5_noshield c_length=4U c_width=4U
* device instance $1202 r0 *1 60.2,160.2 cap_mim_2f0_m4m5_noshield
X$1202 \$12__t56 topp__t109 cap_mim_2f0_m4m5_noshield c_length=4U c_width=4U
* device instance $1203 r0 *1 66.6,160.2 cap_mim_2f0_m4m5_noshield
X$1203 \$32__t4 topp__t24 cap_mim_2f0_m4m5_noshield c_length=4U c_width=4U
* device instance $1204 r0 *1 73,160.2 cap_mim_2f0_m4m5_noshield
X$1204 \$12__t13 topp__t23 cap_mim_2f0_m4m5_noshield c_length=4U c_width=4U
* device instance $1205 r0 *1 79.4,160.2 cap_mim_2f0_m4m5_noshield
X$1205 \$32__t3 topp__t22 cap_mim_2f0_m4m5_noshield c_length=4U c_width=4U
* device instance $1206 r0 *1 85.8,160.2 cap_mim_2f0_m4m5_noshield
X$1206 \$12__t12 topp__t21 cap_mim_2f0_m4m5_noshield c_length=4U c_width=4U
* device instance $1207 r0 *1 92.2,160.2 cap_mim_2f0_m4m5_noshield
X$1207 \$32__t2 topp__t20 cap_mim_2f0_m4m5_noshield c_length=4U c_width=4U
* device instance $1208 r0 *1 98.6,160.2 cap_mim_2f0_m4m5_noshield
X$1208 \$12__t11 topp__t19 cap_mim_2f0_m4m5_noshield c_length=4U c_width=4U
* device instance $1209 r0 *1 105,160.2 cap_mim_2f0_m4m5_noshield
X$1209 \$32__t1 topp__t18 cap_mim_2f0_m4m5_noshield c_length=4U c_width=4U
* device instance $1210 r0 *1 111.4,160.2 cap_mim_2f0_m4m5_noshield
X$1210 \$12__t10 topp__t17 cap_mim_2f0_m4m5_noshield c_length=4U c_width=4U
* device instance $1211 r0 *1 117.8,160.2 cap_mim_2f0_m4m5_noshield
X$1211 \$32__t27 topp__t270 cap_mim_2f0_m4m5_noshield c_length=4U c_width=4U
* device instance $1212 r0 *1 124.2,160.2 cap_mim_2f0_m4m5_noshield
X$1212 \$12__t44 topp__t87 cap_mim_2f0_m4m5_noshield c_length=4U c_width=4U
* device instance $1213 r0 *1 130.6,160.2 cap_mim_2f0_m4m5_noshield
X$1213 \$32__t14 topp__t86 cap_mim_2f0_m4m5_noshield c_length=4U c_width=4U
* device instance $1214 r0 *1 137,160.2 cap_mim_2f0_m4m5_noshield
X$1214 \$12__t43 topp__t85 cap_mim_2f0_m4m5_noshield c_length=4U c_width=4U
* device instance $1215 r0 *1 143.4,160.2 cap_mim_2f0_m4m5_noshield
X$1215 \$32__t13 topp__t84 cap_mim_2f0_m4m5_noshield c_length=4U c_width=4U
* device instance $1216 r0 *1 149.8,160.2 cap_mim_2f0_m4m5_noshield
X$1216 \$12__t42 topp__t83 cap_mim_2f0_m4m5_noshield c_length=4U c_width=4U
* device instance $1217 r0 *1 156.2,160.2 cap_mim_2f0_m4m5_noshield
X$1217 \$32__t12 topp__t82 cap_mim_2f0_m4m5_noshield c_length=4U c_width=4U
* device instance $1218 r0 *1 162.6,160.2 cap_mim_2f0_m4m5_noshield
X$1218 \$12__t41 topp__t81 cap_mim_2f0_m4m5_noshield c_length=4U c_width=4U
* device instance $1219 r0 *1 169,160.2 cap_mim_2f0_m4m5_noshield
X$1219 \$32__t11 topp__t80 cap_mim_2f0_m4m5_noshield c_length=4U c_width=4U
* device instance $1220 r0 *1 175.4,160.2 cap_mim_2f0_m4m5_noshield
X$1220 \$12__t40 topp__t79 cap_mim_2f0_m4m5_noshield c_length=4U c_width=4U
* device instance $1221 r0 *1 181.8,160.2 cap_mim_2f0_m4m5_noshield
X$1221 \$32__t10 topp__t78 cap_mim_2f0_m4m5_noshield c_length=4U c_width=4U
* device instance $1222 r0 *1 188.2,160.2 cap_mim_2f0_m4m5_noshield
X$1222 \$12__t47 topp__t91 cap_mim_2f0_m4m5_noshield c_length=4U c_width=4U
* device instance $1223 r0 *1 194.6,160.2 cap_mim_2f0_m4m5_noshield
X$1223 \$32__t9 topp__t76 cap_mim_2f0_m4m5_noshield c_length=4U c_width=4U
* device instance $1224 r0 *1 201,160.2 cap_mim_2f0_m4m5_noshield
X$1224 \$12__t39 topp__t75 cap_mim_2f0_m4m5_noshield c_length=4U c_width=4U
* device instance $1225 r0 *1 224,160.2 cap_mim_2f0_m4m5_noshield
X$1225 \$84__t1 topn__t2 cap_mim_2f0_m4m5_noshield c_length=4U c_width=4U
* device instance $1226 r0 *1 230.4,160.2 cap_mim_2f0_m4m5_noshield
X$1226 \$81__t0 topn__t1 cap_mim_2f0_m4m5_noshield c_length=4U c_width=4U
* device instance $1227 r0 *1 236.8,160.2 cap_mim_2f0_m4m5_noshield
X$1227 \$84__t62 topn__t501 cap_mim_2f0_m4m5_noshield c_length=4U c_width=4U
* device instance $1228 r0 *1 243.2,160.2 cap_mim_2f0_m4m5_noshield
X$1228 \$81__t243 topn__t486 cap_mim_2f0_m4m5_noshield c_length=4U c_width=4U
* device instance $1229 r0 *1 249.6,160.2 cap_mim_2f0_m4m5_noshield
X$1229 \$84__t54 topn__t447 cap_mim_2f0_m4m5_noshield c_length=4U c_width=4U
* device instance $1230 r0 *1 256,160.2 cap_mim_2f0_m4m5_noshield
X$1230 \$81__t225 topn__t448 cap_mim_2f0_m4m5_noshield c_length=4U c_width=4U
* device instance $1231 r0 *1 262.4,160.2 cap_mim_2f0_m4m5_noshield
X$1231 \$84__t55 topn__t449 cap_mim_2f0_m4m5_noshield c_length=4U c_width=4U
* device instance $1232 r0 *1 268.8,160.2 cap_mim_2f0_m4m5_noshield
X$1232 \$81__t226 topn__t450 cap_mim_2f0_m4m5_noshield c_length=4U c_width=4U
* device instance $1233 r0 *1 275.2,160.2 cap_mim_2f0_m4m5_noshield
X$1233 \$84__t56 topn__t451 cap_mim_2f0_m4m5_noshield c_length=4U c_width=4U
* device instance $1234 r0 *1 281.6,160.2 cap_mim_2f0_m4m5_noshield
X$1234 \$81__t227 topn__t452 cap_mim_2f0_m4m5_noshield c_length=4U c_width=4U
* device instance $1235 r0 *1 288,160.2 cap_mim_2f0_m4m5_noshield
X$1235 \$84__t57 topn__t453 cap_mim_2f0_m4m5_noshield c_length=4U c_width=4U
* device instance $1236 r0 *1 294.4,160.2 cap_mim_2f0_m4m5_noshield
X$1236 \$81__t128 topn__t260 cap_mim_2f0_m4m5_noshield c_length=4U c_width=4U
* device instance $1237 r0 *1 300.8,160.2 cap_mim_2f0_m4m5_noshield
X$1237 \$84__t59 topn__t490 cap_mim_2f0_m4m5_noshield c_length=4U c_width=4U
* device instance $1238 r0 *1 307.2,160.2 cap_mim_2f0_m4m5_noshield
X$1238 \$81__t246 topn__t491 cap_mim_2f0_m4m5_noshield c_length=4U c_width=4U
* device instance $1239 r0 *1 313.6,160.2 cap_mim_2f0_m4m5_noshield
X$1239 \$84__t60 topn__t492 cap_mim_2f0_m4m5_noshield c_length=4U c_width=4U
* device instance $1240 r0 *1 320,160.2 cap_mim_2f0_m4m5_noshield
X$1240 \$81__t247 topn__t493 cap_mim_2f0_m4m5_noshield c_length=4U c_width=4U
* device instance $1241 r0 *1 326.4,160.2 cap_mim_2f0_m4m5_noshield
X$1241 \$84__t61 topn__t494 cap_mim_2f0_m4m5_noshield c_length=4U c_width=4U
* device instance $1242 r0 *1 332.8,160.2 cap_mim_2f0_m4m5_noshield
X$1242 \$81__t255 topn__t510 cap_mim_2f0_m4m5_noshield c_length=4U c_width=4U
* device instance $1243 r0 *1 339.2,160.2 cap_mim_2f0_m4m5_noshield
X$1243 \$84__t58 topn__t472 cap_mim_2f0_m4m5_noshield c_length=4U c_width=4U
* device instance $1244 r0 *1 345.6,160.2 cap_mim_2f0_m4m5_noshield
X$1244 \$81__t236 topn__t473 cap_mim_2f0_m4m5_noshield c_length=4U c_width=4U
* device instance $1245 r0 *1 352,160.2 cap_mim_2f0_m4m5_noshield
X$1245 \$84__t16 topn__t181 cap_mim_2f0_m4m5_noshield c_length=4U c_width=4U
* device instance $1246 r0 *1 358.4,160.2 cap_mim_2f0_m4m5_noshield
X$1246 \$81__t146 topn__t292 cap_mim_2f0_m4m5_noshield c_length=4U c_width=4U
* device instance $1247 r0 *1 364.8,160.2 cap_mim_2f0_m4m5_noshield
X$1247 \$84__t26 topn__t293 cap_mim_2f0_m4m5_noshield c_length=4U c_width=4U
* device instance $1248 r0 *1 371.2,160.2 cap_mim_2f0_m4m5_noshield
X$1248 \$81__t147 topn__t294 cap_mim_2f0_m4m5_noshield c_length=4U c_width=4U
* device instance $1249 r0 *1 377.6,160.2 cap_mim_2f0_m4m5_noshield
X$1249 \$84__t27 topn__t295 cap_mim_2f0_m4m5_noshield c_length=4U c_width=4U
* device instance $1250 r0 *1 384,160.2 cap_mim_2f0_m4m5_noshield
X$1250 \$81__t148 topn__t296 cap_mim_2f0_m4m5_noshield c_length=4U c_width=4U
* device instance $1251 r0 *1 390.4,160.2 cap_mim_2f0_m4m5_noshield
X$1251 \$84__t28 topn__t297 cap_mim_2f0_m4m5_noshield c_length=4U c_width=4U
* device instance $1252 r0 *1 396.8,160.2 cap_mim_2f0_m4m5_noshield
X$1252 \$81__t149 topn__t298 cap_mim_2f0_m4m5_noshield c_length=4U c_width=4U
* device instance $1253 r0 *1 403.2,160.2 cap_mim_2f0_m4m5_noshield
X$1253 \$84__t29 topn__t299 cap_mim_2f0_m4m5_noshield c_length=4U c_width=4U
* device instance $1254 r0 *1 409.6,160.2 cap_mim_2f0_m4m5_noshield
X$1254 \$81__t150 topn__t300 cap_mim_2f0_m4m5_noshield c_length=4U c_width=4U
* device instance $1255 r0 *1 416,160.2 cap_mim_2f0_m4m5_noshield
X$1255 \$84__t30 topn__t301 cap_mim_2f0_m4m5_noshield c_length=4U c_width=4U
* device instance $1256 r0 *1 422.4,160.2 cap_mim_2f0_m4m5_noshield
X$1256 \$81__t151 topn__t302 cap_mim_2f0_m4m5_noshield c_length=4U c_width=4U
* device instance $1257 r0 *1 2.6,166.6 cap_mim_2f0_m4m5_noshield
X$1257 \$40__t0 topp__t1 cap_mim_2f0_m4m5_noshield c_length=4U c_width=4U
* device instance $1258 r0 *1 9,166.6 cap_mim_2f0_m4m5_noshield
X$1258 \$12__t25 topp__t47 cap_mim_2f0_m4m5_noshield c_length=4U c_width=4U
* device instance $1259 r0 *1 15.4,166.6 cap_mim_2f0_m4m5_noshield
X$1259 \$40__t7 topp__t62 cap_mim_2f0_m4m5_noshield c_length=4U c_width=4U
* device instance $1260 r0 *1 21.8,166.6 cap_mim_2f0_m4m5_noshield
X$1260 \$12__t32 topp__t61 cap_mim_2f0_m4m5_noshield c_length=4U c_width=4U
* device instance $1261 r0 *1 28.2,166.6 cap_mim_2f0_m4m5_noshield
X$1261 \$40__t6 topp__t60 cap_mim_2f0_m4m5_noshield c_length=4U c_width=4U
* device instance $1262 r0 *1 34.6,166.6 cap_mim_2f0_m4m5_noshield
X$1262 \$12__t31 topp__t59 cap_mim_2f0_m4m5_noshield c_length=4U c_width=4U
* device instance $1263 r0 *1 41,166.6 cap_mim_2f0_m4m5_noshield
X$1263 \$40__t5 topp__t58 cap_mim_2f0_m4m5_noshield c_length=4U c_width=4U
* device instance $1264 r0 *1 47.4,166.6 cap_mim_2f0_m4m5_noshield
X$1264 \$12__t30 topp__t57 cap_mim_2f0_m4m5_noshield c_length=4U c_width=4U
* device instance $1265 r0 *1 53.8,166.6 cap_mim_2f0_m4m5_noshield
X$1265 \$40__t4 topp__t56 cap_mim_2f0_m4m5_noshield c_length=4U c_width=4U
* device instance $1266 r0 *1 60.2,166.6 cap_mim_2f0_m4m5_noshield
X$1266 \$12__t48 topp__t92 cap_mim_2f0_m4m5_noshield c_length=4U c_width=4U
* device instance $1267 r0 *1 66.6,166.6 cap_mim_2f0_m4m5_noshield
X$1267 \$40__t3 topp__t31 cap_mim_2f0_m4m5_noshield c_length=4U c_width=4U
* device instance $1268 r0 *1 73,166.6 cap_mim_2f0_m4m5_noshield
X$1268 \$12__t9 topp__t15 cap_mim_2f0_m4m5_noshield c_length=4U c_width=4U
* device instance $1269 r0 *1 79.4,166.6 cap_mim_2f0_m4m5_noshield
X$1269 \$40__t2 topp__t14 cap_mim_2f0_m4m5_noshield c_length=4U c_width=4U
* device instance $1270 r0 *1 85.8,166.6 cap_mim_2f0_m4m5_noshield
X$1270 \$12__t8 topp__t13 cap_mim_2f0_m4m5_noshield c_length=4U c_width=4U
* device instance $1271 r0 *1 92.2,166.6 cap_mim_2f0_m4m5_noshield
X$1271 \$40__t1 topp__t12 cap_mim_2f0_m4m5_noshield c_length=4U c_width=4U
* device instance $1272 r0 *1 98.6,166.6 cap_mim_2f0_m4m5_noshield
X$1272 \$12__t7 topp__t11 cap_mim_2f0_m4m5_noshield c_length=4U c_width=4U
* device instance $1273 r0 *1 105,166.6 cap_mim_2f0_m4m5_noshield
X$1273 \$48__t0 topp__t10 cap_mim_2f0_m4m5_noshield c_length=4U c_width=4U
* device instance $1274 r0 *1 111.4,166.6 cap_mim_2f0_m4m5_noshield
X$1274 \$12__t6 topp__t9 cap_mim_2f0_m4m5_noshield c_length=4U c_width=4U
* device instance $1275 r0 *1 117.8,166.6 cap_mim_2f0_m4m5_noshield
X$1275 \$48__t8 topp__t268 cap_mim_2f0_m4m5_noshield c_length=4U c_width=4U
* device instance $1276 r0 *1 124.2,166.6 cap_mim_2f0_m4m5_noshield
X$1276 \$12__t37 topp__t72 cap_mim_2f0_m4m5_noshield c_length=4U c_width=4U
* device instance $1277 r0 *1 130.6,166.6 cap_mim_2f0_m4m5_noshield
X$1277 \$48__t2 topp__t71 cap_mim_2f0_m4m5_noshield c_length=4U c_width=4U
* device instance $1278 r0 *1 137,166.6 cap_mim_2f0_m4m5_noshield
X$1278 \$12__t36 topp__t70 cap_mim_2f0_m4m5_noshield c_length=4U c_width=4U
* device instance $1279 r0 *1 143.4,166.6 cap_mim_2f0_m4m5_noshield
X$1279 \$48__t1 topp__t69 cap_mim_2f0_m4m5_noshield c_length=4U c_width=4U
* device instance $1280 r0 *1 149.8,166.6 cap_mim_2f0_m4m5_noshield
X$1280 \$12__t35 topp__t68 cap_mim_2f0_m4m5_noshield c_length=4U c_width=4U
* device instance $1281 r0 *1 156.2,166.6 cap_mim_2f0_m4m5_noshield
X$1281 \$56__t1 topp__t67 cap_mim_2f0_m4m5_noshield c_length=4U c_width=4U
* device instance $1282 r0 *1 162.6,166.6 cap_mim_2f0_m4m5_noshield
X$1282 \$12__t34 topp__t66 cap_mim_2f0_m4m5_noshield c_length=4U c_width=4U
* device instance $1283 r0 *1 169,166.6 cap_mim_2f0_m4m5_noshield
X$1283 \$56__t0 topp__t65 cap_mim_2f0_m4m5_noshield c_length=4U c_width=4U
* device instance $1284 r0 *1 175.4,166.6 cap_mim_2f0_m4m5_noshield
X$1284 \$12__t33 topp__t64 cap_mim_2f0_m4m5_noshield c_length=4U c_width=4U
* device instance $1285 r0 *1 181.8,166.6 cap_mim_2f0_m4m5_noshield
X$1285 \$64__t0 topp__t107 cap_mim_2f0_m4m5_noshield c_length=4U c_width=4U
* device instance $1286 r0 *1 188.2,166.6 cap_mim_2f0_m4m5_noshield
X$1286 \$12__t60 topp__t118 cap_mim_2f0_m4m5_noshield c_length=4U c_width=4U
* device instance $1287 r0 *1 194.6,166.6 cap_mim_2f0_m4m5_noshield
X$1287 \$72__t0 topp__t117 cap_mim_2f0_m4m5_noshield c_length=4U c_width=4U
* device instance $1288 r0 *1 201,166.6 cap_mim_2f0_m4m5_noshield
X$1288 \$12__t59 topp__t116 cap_mim_2f0_m4m5_noshield c_length=4U c_width=4U
* device instance $1289 r0 *1 224,166.6 cap_mim_2f0_m4m5_noshield
X$1289 \$85__t0 topn__t8 cap_mim_2f0_m4m5_noshield c_length=4U c_width=4U
* device instance $1290 r0 *1 230.4,166.6 cap_mim_2f0_m4m5_noshield
X$1290 \$81__t3 topn__t7 cap_mim_2f0_m4m5_noshield c_length=4U c_width=4U
* device instance $1291 r0 *1 236.8,166.6 cap_mim_2f0_m4m5_noshield
X$1291 \$85__t25 topn__t462 cap_mim_2f0_m4m5_noshield c_length=4U c_width=4U
* device instance $1292 r0 *1 243.2,166.6 cap_mim_2f0_m4m5_noshield
X$1292 \$81__t232 topn__t463 cap_mim_2f0_m4m5_noshield c_length=4U c_width=4U
* device instance $1293 r0 *1 249.6,166.6 cap_mim_2f0_m4m5_noshield
X$1293 \$85__t26 topn__t464 cap_mim_2f0_m4m5_noshield c_length=4U c_width=4U
* device instance $1294 r0 *1 256,166.6 cap_mim_2f0_m4m5_noshield
X$1294 \$81__t248 topn__t495 cap_mim_2f0_m4m5_noshield c_length=4U c_width=4U
* device instance $1295 r0 *1 262.4,166.6 cap_mim_2f0_m4m5_noshield
X$1295 \$85__t29 topn__t496 cap_mim_2f0_m4m5_noshield c_length=4U c_width=4U
* device instance $1296 r0 *1 268.8,166.6 cap_mim_2f0_m4m5_noshield
X$1296 \$81__t249 topn__t497 cap_mim_2f0_m4m5_noshield c_length=4U c_width=4U
* device instance $1297 r0 *1 275.2,166.6 cap_mim_2f0_m4m5_noshield
X$1297 \$85__t30 topn__t498 cap_mim_2f0_m4m5_noshield c_length=4U c_width=4U
* device instance $1298 r0 *1 281.6,166.6 cap_mim_2f0_m4m5_noshield
X$1298 \$81__t250 topn__t499 cap_mim_2f0_m4m5_noshield c_length=4U c_width=4U
* device instance $1299 r0 *1 288,166.6 cap_mim_2f0_m4m5_noshield
X$1299 \$85__t31 topn__t500 cap_mim_2f0_m4m5_noshield c_length=4U c_width=4U
* device instance $1300 r0 *1 294.4,166.6 cap_mim_2f0_m4m5_noshield
X$1300 \$81__t129 topn__t261 cap_mim_2f0_m4m5_noshield c_length=4U c_width=4U
* device instance $1301 r0 *1 300.8,166.6 cap_mim_2f0_m4m5_noshield
X$1301 \$85__t27 topn__t475 cap_mim_2f0_m4m5_noshield c_length=4U c_width=4U
* device instance $1302 r0 *1 307.2,166.6 cap_mim_2f0_m4m5_noshield
X$1302 \$81__t237 topn__t476 cap_mim_2f0_m4m5_noshield c_length=4U c_width=4U
* device instance $1303 r0 *1 313.6,166.6 cap_mim_2f0_m4m5_noshield
X$1303 \$85__t28 topn__t477 cap_mim_2f0_m4m5_noshield c_length=4U c_width=4U
* device instance $1304 r0 *1 320,166.6 cap_mim_2f0_m4m5_noshield
X$1304 \$81__t238 topn__t478 cap_mim_2f0_m4m5_noshield c_length=4U c_width=4U
* device instance $1305 r0 *1 326.4,166.6 cap_mim_2f0_m4m5_noshield
X$1305 \$86__t14 topn__t479 cap_mim_2f0_m4m5_noshield c_length=4U c_width=4U
* device instance $1306 r0 *1 332.8,166.6 cap_mim_2f0_m4m5_noshield
X$1306 \$81__t239 topn__t480 cap_mim_2f0_m4m5_noshield c_length=4U c_width=4U
* device instance $1307 r0 *1 339.2,166.6 cap_mim_2f0_m4m5_noshield
X$1307 \$86__t15 topn__t481 cap_mim_2f0_m4m5_noshield c_length=4U c_width=4U
* device instance $1308 r0 *1 345.6,166.6 cap_mim_2f0_m4m5_noshield
X$1308 \$81__t240 topn__t482 cap_mim_2f0_m4m5_noshield c_length=4U c_width=4U
* device instance $1309 r0 *1 352,166.6 cap_mim_2f0_m4m5_noshield
X$1309 \$86__t6 topn__t182 cap_mim_2f0_m4m5_noshield c_length=4U c_width=4U
* device instance $1310 r0 *1 358.4,166.6 cap_mim_2f0_m4m5_noshield
X$1310 \$81__t152 topn__t304 cap_mim_2f0_m4m5_noshield c_length=4U c_width=4U
* device instance $1311 r0 *1 364.8,166.6 cap_mim_2f0_m4m5_noshield
X$1311 \$86__t8 topn__t289 cap_mim_2f0_m4m5_noshield c_length=4U c_width=4U
* device instance $1312 r0 *1 371.2,166.6 cap_mim_2f0_m4m5_noshield
X$1312 \$81__t119 topn__t242 cap_mim_2f0_m4m5_noshield c_length=4U c_width=4U
* device instance $1313 r0 *1 377.6,166.6 cap_mim_2f0_m4m5_noshield
X$1313 \$87__t4 topn__t243 cap_mim_2f0_m4m5_noshield c_length=4U c_width=4U
* device instance $1314 r0 *1 384,166.6 cap_mim_2f0_m4m5_noshield
X$1314 \$81__t120 topn__t244 cap_mim_2f0_m4m5_noshield c_length=4U c_width=4U
* device instance $1315 r0 *1 390.4,166.6 cap_mim_2f0_m4m5_noshield
X$1315 \$87__t5 topn__t245 cap_mim_2f0_m4m5_noshield c_length=4U c_width=4U
* device instance $1316 r0 *1 396.8,166.6 cap_mim_2f0_m4m5_noshield
X$1316 \$81__t121 topn__t246 cap_mim_2f0_m4m5_noshield c_length=4U c_width=4U
* device instance $1317 r0 *1 403.2,166.6 cap_mim_2f0_m4m5_noshield
X$1317 \$88__t2 topn__t247 cap_mim_2f0_m4m5_noshield c_length=4U c_width=4U
* device instance $1318 r0 *1 409.6,166.6 cap_mim_2f0_m4m5_noshield
X$1318 \$81__t122 topn__t248 cap_mim_2f0_m4m5_noshield c_length=4U c_width=4U
* device instance $1319 r0 *1 416,166.6 cap_mim_2f0_m4m5_noshield
X$1319 \$89__t0 topn__t249 cap_mim_2f0_m4m5_noshield c_length=4U c_width=4U
* device instance $1320 r0 *1 422.4,166.6 cap_mim_2f0_m4m5_noshield
X$1320 \$81__t123 topn__t250 cap_mim_2f0_m4m5_noshield c_length=4U c_width=4U
* device instance _100_t0 r0 *1 0,0
R_100_t0 \$100__t0 \$100 135.591504929
* device instance _100_t1 r0 *1 0,0
R_100_t1 \$100__t1 \$100 36.2048686624
* device instance _100_t2 r0 *1 0,0
R_100_t2 \$100__t2 \$100 166.824926409
* device instance _100 r0 *1 0,0
C_100 \$100 vsubs 7.017453e-15
* device instance _102_t0 r0 *1 0,0
R_102_t0 \$102__t0 \$102 162.444438203
* device instance _102_t1 r0 *1 0,0
R_102_t1 \$102__t1 \$102 43.7126105743
* device instance _102_t2 r0 *1 0,0
R_102_t2 \$102__t2 \$102 200.179851222
* device instance _102 r0 *1 0,0
C_102 \$102 vsubs 7.547896e-15
* device instance _104_t0 r0 *1 0,0
R_104_t0 \$104__t0 \$104 135.591504929
* device instance _104_t1 r0 *1 0,0
R_104_t1 \$104__t1 \$104 36.2048686624
* device instance _104_t2 r0 *1 0,0
R_104_t2 \$104__t2 \$104 166.824926409
* device instance _104 r0 *1 0,0
C_104 \$104 vsubs 7.017453e-15
* device instance _106_t0 r0 *1 0,0
R_106_t0 \$106__t0 \$106 162.444438203
* device instance _106_t1 r0 *1 0,0
R_106_t1 \$106__t1 \$106 43.7126105743
* device instance _106_t2 r0 *1 0,0
R_106_t2 \$106__t2 \$106 200.179851222
* device instance _106 r0 *1 0,0
C_106 \$106 vsubs 7.547896e-15
* device instance _108_t0 r0 *1 0,0
R_108_t0 \$108__t0 \$108 135.591504929
* device instance _108_t1 r0 *1 0,0
R_108_t1 \$108__t1 \$108 36.2048686624
* device instance _108_t2 r0 *1 0,0
R_108_t2 \$108__t2 \$108 166.824926409
* device instance _108 r0 *1 0,0
C_108 \$108 vsubs 7.006437e-15
* device instance _11_t0 r0 *1 0,0
R_11_t0 \$11__t0 \$11 162.444438203
* device instance _11_t1 r0 *1 0,0
R_11_t1 \$11__t1 \$11 43.7126105743
* device instance _11_t2 r0 *1 0,0
R_11_t2 \$11__t2 \$11 200.179851222
* device instance _11 r0 *1 0,0
C_11 \$11 vsubs 7.553404e-15
* device instance _110_t0 r0 *1 0,0
R_110_t0 \$110__t0 \$110 162.444438203
* device instance _110_t1 r0 *1 0,0
R_110_t1 \$110__t1 \$110 43.7126105743
* device instance _110_t2 r0 *1 0,0
R_110_t2 \$110__t2 \$110 200.179851222
* device instance _110 r0 *1 0,0
C_110 \$110 vsubs 7.53688e-15
* device instance _112_t0 r0 *1 0,0
R_112_t0 \$112__t0 \$112 135.591504929
* device instance _112_t1 r0 *1 0,0
R_112_t1 \$112__t1 \$112 36.2048686624
* device instance _112_t2 r0 *1 0,0
R_112_t2 \$112__t2 \$112 166.824926409
* device instance _112 r0 *1 0,0
C_112 \$112 vsubs 7.017453e-15
* device instance _114_t0 r0 *1 0,0
R_114_t0 \$114__t0 \$114 162.444438203
* device instance _114_t1 r0 *1 0,0
R_114_t1 \$114__t1 \$114 43.7126105743
* device instance _114_t2 r0 *1 0,0
R_114_t2 \$114__t2 \$114 200.179851222
* device instance _114 r0 *1 0,0
C_114 \$114 vsubs 7.547896e-15
* device instance _116_t0 r0 *1 0,0
R_116_t0 \$116__t0 \$116 135.591504929
* device instance _116_t1 r0 *1 0,0
R_116_t1 \$116__t1 \$116 36.2048686624
* device instance _116_t2 r0 *1 0,0
R_116_t2 \$116__t2 \$116 166.824926409
* device instance _116 r0 *1 0,0
C_116 \$116 vsubs 7.017453e-15
* device instance _118_t0 r0 *1 0,0
R_118_t0 \$118__t0 \$118 162.444438203
* device instance _118_t1 r0 *1 0,0
R_118_t1 \$118__t1 \$118 43.7126105743
* device instance _118_t2 r0 *1 0,0
R_118_t2 \$118__t2 \$118 200.179851222
* device instance _118 r0 *1 0,0
C_118 \$118 vsubs 7.547896e-15
* device instance _12_t0 r0 *1 0,0
R_12_t0 \$12__t0 \$12 19.6806022307
* device instance _12_t1 r0 *1 0,0
R_12_t1 \$12__t1 \$12 17.174848773
* device instance _12_t2 r0 *1 0,0
R_12_t2 \$12__t2 \$12 14.2031435449
* device instance _12_t3 r0 *1 0,0
R_12_t3 \$12__t3 \$12 12.1937257142
* device instance _12_t4 r0 *1 0,0
R_12_t4 \$12__t4 \$12 5.4171139579
* device instance _12_t5 r0 *1 0,0
R_12_t5 \$12__t5 \$12 5.75188838103
* device instance _12_t6 r0 *1 0,0
R_12_t6 \$12__t6 \$12 7.4001568748
* device instance _12_t7 r0 *1 0,0
R_12_t7 \$12__t7 \$12 7.21394032887
* device instance _12_t8 r0 *1 0,0
R_12_t8 \$12__t8 \$12 7.46860304096
* device instance _12_t9 r0 *1 0,0
R_12_t9 \$12__t9 \$12 8.12278343404
* device instance _12_t10 r0 *1 0,0
R_12_t10 \$12__t10 \$12 6.52739271659
* device instance _12_t11 r0 *1 0,0
R_12_t11 \$12__t11 \$12 6.31549435701
* device instance _12_t12 r0 *1 0,0
R_12_t12 \$12__t12 \$12 6.60488949857
* device instance _12_t13 r0 *1 0,0
R_12_t13 \$12__t13 \$12 7.33649402789
* device instance _12_t14 r0 *1 0,0
R_12_t14 \$12__t14 \$12 6.57904242886
* device instance _12_t15 r0 *1 0,0
R_12_t15 \$12__t15 \$12 5.6627299367
* device instance _12_t16 r0 *1 0,0
R_12_t16 \$12__t16 \$12 4.81053902904
* device instance _12_t17 r0 *1 0,0
R_12_t17 \$12__t17 \$12 12.3650740074
* device instance _12_t18 r0 *1 0,0
R_12_t18 \$12__t18 \$12 14.0935194732
* device instance _12_t19 r0 *1 0,0
R_12_t19 \$12__t19 \$12 13.8900074897
* device instance _12_t20 r0 *1 0,0
R_12_t20 \$12__t20 \$12 6.98328450259
* device instance _12_t21 r0 *1 0,0
R_12_t21 \$12__t21 \$12 8.66700924899
* device instance _12_t22 r0 *1 0,0
R_12_t22 \$12__t22 \$12 10.3888555297
* device instance _12_t23 r0 *1 0,0
R_12_t23 \$12__t23 \$12 13.8271089247
* device instance _12_t24 r0 *1 0,0
R_12_t24 \$12__t24 \$12 9.11396768705
* device instance _12_t25 r0 *1 0,0
R_12_t25 \$12__t25 \$12 14.6247992346
* device instance _12_t26 r0 *1 0,0
R_12_t26 \$12__t26 \$12 10.6134553934
* device instance _12_t27 r0 *1 0,0
R_12_t27 \$12__t27 \$12 9.67495490125
* device instance _12_t28 r0 *1 0,0
R_12_t28 \$12__t28 \$12 11.0989089882
* device instance _12_t29 r0 *1 0,0
R_12_t29 \$12__t29 \$12 12.6185297136
* device instance _12_t30 r0 *1 0,0
R_12_t30 \$12__t30 \$12 10.283978726
* device instance _12_t31 r0 *1 0,0
R_12_t31 \$12__t31 \$12 11.6336256955
* device instance _12_t32 r0 *1 0,0
R_12_t32 \$12__t32 \$12 13.0913237768
* device instance _12_t33 r0 *1 0,0
R_12_t33 \$12__t33 \$12 12.8559908431
* device instance _12_t34 r0 *1 0,0
R_12_t34 \$12__t34 \$12 11.4128304449
* device instance _12_t35 r0 *1 0,0
R_12_t35 \$12__t35 \$12 10.0841152309
* device instance _12_t36 r0 *1 0,0
R_12_t36 \$12__t36 \$12 8.92112908952
* device instance _12_t37 r0 *1 0,0
R_12_t37 \$12__t37 \$12 7.99651120757
* device instance _12_t38 r0 *1 0,0
R_12_t38 \$12__t38 \$12 11.8568528563
* device instance _12_t39 r0 *1 0,0
R_12_t39 \$12__t39 \$12 15.5740196193
* device instance _12_t40 r0 *1 0,0
R_12_t40 \$12__t40 \$12 12.3742084378
* device instance _12_t41 r0 *1 0,0
R_12_t41 \$12__t41 \$12 10.867255066
* device instance _12_t42 r0 *1 0,0
R_12_t42 \$12__t42 \$12 9.46223619944
* device instance _12_t43 r0 *1 0,0
R_12_t43 \$12__t43 \$12 8.21164284031
* device instance _12_t44 r0 *1 0,0
R_12_t44 \$12__t44 \$12 7.19643838282
* device instance _12_t45 r0 *1 0,0
R_12_t45 \$12__t45 \$12 10.115874473
* device instance _12_t46 r0 *1 0,0
R_12_t46 \$12__t46 \$12 15.2318659974
* device instance _12_t47 r0 *1 0,0
R_12_t47 \$12__t47 \$12 13.9501010489
* device instance _12_t48 r0 *1 0,0
R_12_t48 \$12__t48 \$12 9.09063656007
* device instance _12_t49 r0 *1 0,0
R_12_t49 \$12__t49 \$12 4.51883824083
* device instance _12_t50 r0 *1 0,0
R_12_t50 \$12__t50 \$12 4.91518009453
* device instance _12_t51 r0 *1 0,0
R_12_t51 \$12__t51 \$12 5.86161877766
* device instance _12_t52 r0 *1 0,0
R_12_t52 \$12__t52 \$12 7.14273316354
* device instance _12_t53 r0 *1 0,0
R_12_t53 \$12__t53 \$12 8.61041128022
* device instance _12_t54 r0 *1 0,0
R_12_t54 \$12__t54 \$12 10.1843119945
* device instance _12_t55 r0 *1 0,0
R_12_t55 \$12__t55 \$12 11.8220862036
* device instance _12_t56 r0 *1 0,0
R_12_t56 \$12__t56 \$12 8.39548729808
* device instance _12_t57 r0 *1 0,0
R_12_t57 \$12__t57 \$12 7.7423421283
* device instance _12_t58 r0 *1 0,0
R_12_t58 \$12__t58 \$12 13.6124753802
* device instance _12_t59 r0 *1 0,0
R_12_t59 \$12__t59 \$12 15.9594972727
* device instance _12_t60 r0 *1 0,0
R_12_t60 \$12__t60 \$12 14.3791788837
* device instance _12_t61 r0 *1 0,0
R_12_t61 \$12__t61 \$12 13.5005080138
* device instance _12_t62 r0 *1 0,0
R_12_t62 \$12__t62 \$12 7.54228025454
* device instance _12_t63 r0 *1 0,0
R_12_t63 \$12__t63 \$12 9.29876442464
* device instance _12_t64 r0 *1 0,0
R_12_t64 \$12__t64 \$12 11.0683572056
* device instance _12_t65 r0 *1 0,0
R_12_t65 \$12__t65 \$12 10.6436280847
* device instance _12_t66 r0 *1 0,0
R_12_t66 \$12__t66 \$12 14.0815768879
* device instance _12_t67 r0 *1 0,0
R_12_t67 \$12__t67 \$12 12.3514603071
* device instance _12_t68 r0 *1 0,0
R_12_t68 \$12__t68 \$12 7.35695331171
* device instance _12_t69 r0 *1 0,0
R_12_t69 \$12__t69 \$12 12.8456422826
* device instance _12_t70 r0 *1 0,0
R_12_t70 \$12__t70 \$12 10.659423169
* device instance _12_t71 r0 *1 0,0
R_12_t71 \$12__t71 \$12 10.0689480745
* device instance _12_t72 r0 *1 0,0
R_12_t72 \$12__t72 \$12 7.38277527374
* device instance _12_t73 r0 *1 0,0
R_12_t73 \$12__t73 \$12 9.16986363745
* device instance _12_t74 r0 *1 0,0
R_12_t74 \$12__t74 \$12 10.9602878856
* device instance _12_t75 r0 *1 0,0
R_12_t75 \$12__t75 \$12 12.7526430577
* device instance _12_t76 r0 *1 0,0
R_12_t76 \$12__t76 \$12 10.9253105491
* device instance _12_t77 r0 *1 0,0
R_12_t77 \$12__t77 \$12 12.7225942723
* device instance _12_t78 r0 *1 0,0
R_12_t78 \$12__t78 \$12 2.6278897209
* device instance _12_t79 r0 *1 0,0
R_12_t79 \$12__t79 \$12 3.30174890553
* device instance _12_t80 r0 *1 0,0
R_12_t80 \$12__t80 \$12 4.59359610415
* device instance _12_t81 r0 *1 0,0
R_12_t81 \$12__t81 \$12 4.56121007286
* device instance _12_t82 r0 *1 0,0
R_12_t82 \$12__t82 \$12 2.67627530726
* device instance _12_t83 r0 *1 0,0
R_12_t83 \$12__t83 \$12 3.65054032973
* device instance _12_t84 r0 *1 0,0
R_12_t84 \$12__t84 \$12 3.71958324344
* device instance _12_t85 r0 *1 0,0
R_12_t85 \$12__t85 \$12 3.1438569025
* device instance _12_t86 r0 *1 0,0
R_12_t86 \$12__t86 \$12 4.13586553434
* device instance _12_t87 r0 *1 0,0
R_12_t87 \$12__t87 \$12 5.85102197661
* device instance _12_t88 r0 *1 0,0
R_12_t88 \$12__t88 \$12 7.80267472652
* device instance _12_t89 r0 *1 0,0
R_12_t89 \$12__t89 \$12 9.5111913699
* device instance _12_t90 r0 *1 0,0
R_12_t90 \$12__t90 \$12 11.2474118214
* device instance _12_t91 r0 *1 0,0
R_12_t91 \$12__t91 \$12 13.0002410402
* device instance _12_t92 r0 *1 0,0
R_12_t92 \$12__t92 \$12 8.97081651293
* device instance _12_t93 r0 *1 0,0
R_12_t93 \$12__t93 \$12 1.87282515948
* device instance _12_t94 r0 *1 0,0
R_12_t94 \$12__t94 \$12 6.14501322366
* device instance _12_t95 r0 *1 0,0
R_12_t95 \$12__t95 \$12 5.8108042532
* device instance _12_t96 r0 *1 0,0
R_12_t96 \$12__t96 \$12 5.60221611272
* device instance _12_t97 r0 *1 0,0
R_12_t97 \$12__t97 \$12 5.5334731799
* device instance _12_t98 r0 *1 0,0
R_12_t98 \$12__t98 \$12 3.69633983686
* device instance _12_t99 r0 *1 0,0
R_12_t99 \$12__t99 \$12 3.76454286673
* device instance _12_t100 r0 *1 0,0
R_12_t100 \$12__t100 \$12 4.59794745722
* device instance _12_t101 r0 *1 0,0
R_12_t101 \$12__t101 \$12 2.82275487998
* device instance _12_t102 r0 *1 0,0
R_12_t102 \$12__t102 \$12 3.93015747041
* device instance _12_t103 r0 *1 0,0
R_12_t103 \$12__t103 \$12 2.91149444759
* device instance _12_t104 r0 *1 0,0
R_12_t104 \$12__t104 \$12 5.37363550905
* device instance _12_t105 r0 *1 0,0
R_12_t105 \$12__t105 \$12 12.1326036831
* device instance _12_t106 r0 *1 0,0
R_12_t106 \$12__t106 \$12 7.37978627883
* device instance _12_t107 r0 *1 0,0
R_12_t107 \$12__t107 \$12 8.9895512902
* device instance _12_t108 r0 *1 0,0
R_12_t108 \$12__t108 \$12 5.87970591622
* device instance _12_t109 r0 *1 0,0
R_12_t109 \$12__t109 \$12 11.8598258099
* device instance _12_t110 r0 *1 0,0
R_12_t110 \$12__t110 \$12 7.33074831116
* device instance _12_t111 r0 *1 0,0
R_12_t111 \$12__t111 \$12 9.12802822019
* device instance _12_t112 r0 *1 0,0
R_12_t112 \$12__t112 \$12 13.6523882223
* device instance _12_t113 r0 *1 0,0
R_12_t113 \$12__t113 \$12 6.497819523
* device instance _12_t114 r0 *1 0,0
R_12_t114 \$12__t114 \$12 8.28084811063
* device instance _12_t115 r0 *1 0,0
R_12_t115 \$12__t115 \$12 0.886615686121
* device instance _12_t116 r0 *1 0,0
R_12_t116 \$12__t116 \$12 2.12724791451
* device instance _12_t117 r0 *1 0,0
R_12_t117 \$12__t117 \$12 1.93899039421
* device instance _12_t118 r0 *1 0,0
R_12_t118 \$12__t118 \$12 3.83728589275
* device instance _12_t119 r0 *1 0,0
R_12_t119 \$12__t119 \$12 3.73620972133
* device instance _12_t120 r0 *1 0,0
R_12_t120 \$12__t120 \$12 1.19303865059
* device instance _12_t121 r0 *1 0,0
R_12_t121 \$12__t121 \$12 1.39003454191
* device instance _12_t122 r0 *1 0,0
R_12_t122 \$12__t122 \$12 2.98354384107
* device instance _12_t123 r0 *1 0,0
R_12_t123 \$12__t123 \$12 4.72560627788
* device instance _12_t124 r0 *1 0,0
R_12_t124 \$12__t124 \$12 1.65589073826
* device instance _12_t125 r0 *1 0,0
R_12_t125 \$12__t125 \$12 0.143483218318
* device instance _12_t126 r0 *1 0,0
R_12_t126 \$12__t126 \$12 13.820074857
* device instance _12_t127 r0 *1 0,0
R_12_t127 \$12__t127 \$12 12.0946245387
* device instance _12_t128 r0 *1 0,0
R_12_t128 \$12__t128 \$12 10.3935508576
* device instance _12_t129 r0 *1 0,0
R_12_t129 \$12__t129 \$12 8.73111328217
* device instance _12_t130 r0 *1 0,0
R_12_t130 \$12__t130 \$12 7.13437186302
* device instance _12_t131 r0 *1 0,0
R_12_t131 \$12__t131 \$12 5.65921086652
* device instance _12_t132 r0 *1 0,0
R_12_t132 \$12__t132 \$12 5.13144078741
* device instance _12_t133 r0 *1 0,0
R_12_t133 \$12__t133 \$12 11.9632859119
* device instance _12_t134 r0 *1 0,0
R_12_t134 \$12__t134 \$12 13.7423595405
* device instance _12_t135 r0 *1 0,0
R_12_t135 \$12__t135 \$12 2.71568949512
* device instance _12_t136 r0 *1 0,0
R_12_t136 \$12__t136 \$12 4.3906802333
* device instance _12_t137 r0 *1 0,0
R_12_t137 \$12__t137 \$12 4.4288323971
* device instance _12_t138 r0 *1 0,0
R_12_t138 \$12__t138 \$12 3.73089444029
* device instance _12_t139 r0 *1 0,0
R_12_t139 \$12__t139 \$12 10.1906063066
* device instance _12_t140 r0 *1 0,0
R_12_t140 \$12__t140 \$12 13.5670547258
* device instance _12_t141 r0 *1 0,0
R_12_t141 \$12__t141 \$12 11.9407156034
* device instance _12_t142 r0 *1 0,0
R_12_t142 \$12__t142 \$12 10.3709636644
* device instance _12_t143 r0 *1 0,0
R_12_t143 \$12__t143 \$12 8.88783261281
* device instance _12_t144 r0 *1 0,0
R_12_t144 \$12__t144 \$12 7.54259456661
* device instance _12_t145 r0 *1 0,0
R_12_t145 \$12__t145 \$12 6.42249017571
* device instance _12_t146 r0 *1 0,0
R_12_t146 \$12__t146 \$12 8.39865203881
* device instance _12_t147 r0 *1 0,0
R_12_t147 \$12__t147 \$12 6.72341273483
* device instance _12_t148 r0 *1 0,0
R_12_t148 \$12__t148 \$12 14.9360140994
* device instance _12_t149 r0 *1 0,0
R_12_t149 \$12__t149 \$12 13.2340375301
* device instance _12_t150 r0 *1 0,0
R_12_t150 \$12__t150 \$12 11.5609456592
* device instance _12_t151 r0 *1 0,0
R_12_t151 \$12__t151 \$12 9.93134747869
* device instance _12_t152 r0 *1 0,0
R_12_t152 \$12__t152 \$12 8.37068360215
* device instance _12_t153 r0 *1 0,0
R_12_t153 \$12__t153 \$12 6.92571355242
* device instance _12_t154 r0 *1 0,0
R_12_t154 \$12__t154 \$12 5.68534567736
* device instance _12_t155 r0 *1 0,0
R_12_t155 \$12__t155 \$12 13.4617838214
* device instance _12_t156 r0 *1 0,0
R_12_t156 \$12__t156 \$12 11.6835395892
* device instance _12_t157 r0 *1 0,0
R_12_t157 \$12__t157 \$12 9.91216696947
* device instance _12_t158 r0 *1 0,0
R_12_t158 \$12__t158 \$12 8.15214657292
* device instance _12_t159 r0 *1 0,0
R_12_t159 \$12__t159 \$12 6.41283217309
* device instance _12_t160 r0 *1 0,0
R_12_t160 \$12__t160 \$12 4.71718371829
* device instance _12_t161 r0 *1 0,0
R_12_t161 \$12__t161 \$12 8.42835612676
* device instance _12_t162 r0 *1 0,0
R_12_t162 \$12__t162 \$12 6.68478871181
* device instance _12_t163 r0 *1 0,0
R_12_t163 \$12__t163 \$12 3.13683136333
* device instance _12_t164 r0 *1 0,0
R_12_t164 \$12__t164 \$12 4.979567879
* device instance _12_t165 r0 *1 0,0
R_12_t165 \$12__t165 \$12 3.37139072486
* device instance _12_t166 r0 *1 0,0
R_12_t166 \$12__t166 \$12 2.09688759731
* device instance _12_t167 r0 *1 0,0
R_12_t167 \$12__t167 \$12 1.97182220037
* device instance _12_t168 r0 *1 0,0
R_12_t168 \$12__t168 \$12 14.3358568146
* device instance _12_t169 r0 *1 0,0
R_12_t169 \$12__t169 \$12 12.6405915478
* device instance _12_t170 r0 *1 0,0
R_12_t170 \$12__t170 \$12 10.9778322889
* device instance _12_t171 r0 *1 0,0
R_12_t171 \$12__t171 \$12 9.36490960274
* device instance _12_t172 r0 *1 0,0
R_12_t172 \$12__t172 \$12 7.83267163806
* device instance _12_t173 r0 *1 0,0
R_12_t173 \$12__t173 \$12 6.43897826753
* device instance _12_t174 r0 *1 0,0
R_12_t174 \$12__t174 \$12 5.29439517676
* device instance _12_t175 r0 *1 0,0
R_12_t175 \$12__t175 \$12 4.58925728891
* device instance _12_t176 r0 *1 0,0
R_12_t176 \$12__t176 \$12 4.53347853838
* device instance _12_t177 r0 *1 0,0
R_12_t177 \$12__t177 \$12 5.14820899635
* device instance _12_t178 r0 *1 0,0
R_12_t178 \$12__t178 \$12 6.23828238381
* device instance _12_t179 r0 *1 0,0
R_12_t179 \$12__t179 \$12 7.60189195848
* device instance _12_t180 r0 *1 0,0
R_12_t180 \$12__t180 \$12 9.11711788969
* device instance _12_t181 r0 *1 0,0
R_12_t181 \$12__t181 \$12 10.7198600223
* device instance _12_t182 r0 *1 0,0
R_12_t182 \$12__t182 \$12 12.3761642766
* device instance _12_t183 r0 *1 0,0
R_12_t183 \$12__t183 \$12 14.0671236762
* device instance _12_t184 r0 *1 0,0
R_12_t184 \$12__t184 \$12 12.4394709588
* device instance _12_t185 r0 *1 0,0
R_12_t185 \$12__t185 \$12 10.6421874125
* device instance _12_t186 r0 *1 0,0
R_12_t186 \$12__t186 \$12 8.84490537709
* device instance _12_t187 r0 *1 0,0
R_12_t187 \$12__t187 \$12 7.04762600841
* device instance _12_t188 r0 *1 0,0
R_12_t188 \$12__t188 \$12 5.25035204508
* device instance _12_t189 r0 *1 0,0
R_12_t189 \$12__t189 \$12 3.45309192727
* device instance _12_t190 r0 *1 0,0
R_12_t190 \$12__t190 \$12 9.23981673065
* device instance _12_t191 r0 *1 0,0
R_12_t191 \$12__t191 \$12 7.53730020901
* device instance _12_t192 r0 *1 0,0
R_12_t192 \$12__t192 \$12 13.8078957688
* device instance _12_t193 r0 *1 0,0
R_12_t193 \$12__t193 \$12 12.0807060738
* device instance _12_t194 r0 *1 0,0
R_12_t194 \$12__t194 \$12 10.3773511042
* device instance _12_t195 r0 *1 0,0
R_12_t195 \$12__t195 \$12 14.3468228608
* device instance _12_t196 r0 *1 0,0
R_12_t196 \$12__t196 \$12 12.565291814
* device instance _12_t197 r0 *1 0,0
R_12_t197 \$12__t197 \$12 5.94517952492
* device instance _12_t198 r0 *1 0,0
R_12_t198 \$12__t198 \$12 6.76767198167
* device instance _12_t199 r0 *1 0,0
R_12_t199 \$12__t199 \$12 5.62940353335
* device instance _12_t200 r0 *1 0,0
R_12_t200 \$12__t200 \$12 10.7889885327
* device instance _12_t201 r0 *1 0,0
R_12_t201 \$12__t201 \$12 9.02100170524
* device instance _12_t202 r0 *1 0,0
R_12_t202 \$12__t202 \$12 7.2674034559
* device instance _12_t203 r0 *1 0,0
R_12_t203 \$12__t203 \$12 13.3699245355
* device instance _12_t204 r0 *1 0,0
R_12_t204 \$12__t204 \$12 11.5775798751
* device instance _12_t205 r0 *1 0,0
R_12_t205 \$12__t205 \$12 7.99954699832
* device instance _12_t206 r0 *1 0,0
R_12_t206 \$12__t206 \$12 6.21769048057
* device instance _12_t207 r0 *1 0,0
R_12_t207 \$12__t207 \$12 4.44826715295
* device instance _12_t208 r0 *1 0,0
R_12_t208 \$12__t208 \$12 4.3664294274
* device instance _12_t209 r0 *1 0,0
R_12_t209 \$12__t209 \$12 14.2367554437
* device instance _12_t210 r0 *1 0,0
R_12_t210 \$12__t210 \$12 2.42653967069
* device instance _12_t211 r0 *1 0,0
R_12_t211 \$12__t211 \$12 9.78704819966
* device instance _12_t212 r0 *1 0,0
R_12_t212 \$12__t212 \$12 14.4854087843
* device instance _12_t213 r0 *1 0,0
R_12_t213 \$12__t213 \$12 12.7232975215
* device instance _12_t214 r0 *1 0,0
R_12_t214 \$12__t214 \$12 10.9726029277
* device instance _12_t215 r0 *1 0,0
R_12_t215 \$12__t215 \$12 14.2636147419
* device instance _12_t216 r0 *1 0,0
R_12_t216 \$12__t216 \$12 12.4702019901
* device instance _12_t217 r0 *1 0,0
R_12_t217 \$12__t217 \$12 10.6780921921
* device instance _12_t218 r0 *1 0,0
R_12_t218 \$12__t218 \$12 7.11075090194
* device instance _12_t219 r0 *1 0,0
R_12_t219 \$12__t219 \$12 7.1017274163
* device instance _12_t220 r0 *1 0,0
R_12_t220 \$12__t220 \$12 5.32275272188
* device instance _12_t221 r0 *1 0,0
R_12_t221 \$12__t221 \$12 3.56221052145
* device instance _12_t222 r0 *1 0,0
R_12_t222 \$12__t222 \$12 5.8913545712
* device instance _12_t223 r0 *1 0,0
R_12_t223 \$12__t223 \$12 8.71182275161
* device instance _12_t224 r0 *1 0,0
R_12_t224 \$12__t224 \$12 5.54186947101
* device instance _12_t225 r0 *1 0,0
R_12_t225 \$12__t225 \$12 3.88200521568
* device instance _12_t226 r0 *1 0,0
R_12_t226 \$12__t226 \$12 8.88807352977
* device instance _12_t227 r0 *1 0,0
R_12_t227 \$12__t227 \$12 11.3733858405
* device instance _12_t228 r0 *1 0,0
R_12_t228 \$12__t228 \$12 12.9855942641
* device instance _12_t229 r0 *1 0,0
R_12_t229 \$12__t229 \$12 14.6409663043
* device instance _12_t230 r0 *1 0,0
R_12_t230 \$12__t230 \$12 1.77952467539
* device instance _12_t231 r0 *1 0,0
R_12_t231 \$12__t231 \$12 10.1202355109
* device instance _12_t232 r0 *1 0,0
R_12_t232 \$12__t232 \$12 8.77986842326
* device instance _12_t233 r0 *1 0,0
R_12_t233 \$12__t233 \$12 7.62977688282
* device instance _12_t234 r0 *1 0,0
R_12_t234 \$12__t234 \$12 14.3779369951
* device instance _12_t235 r0 *1 0,0
R_12_t235 \$12__t235 \$12 12.7283363373
* device instance _12_t236 r0 *1 0,0
R_12_t236 \$12__t236 \$12 11.1245899975
* device instance _12_t237 r0 *1 0,0
R_12_t237 \$12__t237 \$12 9.58973108736
* device instance _12_t238 r0 *1 0,0
R_12_t238 \$12__t238 \$12 8.16271186934
* device instance _12_t239 r0 *1 0,0
R_12_t239 \$12__t239 \$12 6.91066355813
* device instance _12_t240 r0 *1 0,0
R_12_t240 \$12__t240 \$12 14.737072189
* device instance _12_t241 r0 *1 0,0
R_12_t241 \$12__t241 \$12 13.1326604457
* device instance _12_t242 r0 *1 0,0
R_12_t242 \$12__t242 \$12 6.87953112277
* device instance _12_t243 r0 *1 0,0
R_12_t243 \$12__t243 \$12 7.79472701966
* device instance _12_t244 r0 *1 0,0
R_12_t244 \$12__t244 \$12 8.98042722653
* device instance _12_t245 r0 *1 0,0
R_12_t245 \$12__t245 \$12 10.344025331
* device instance _12_t246 r0 *1 0,0
R_12_t246 \$12__t246 \$12 11.8241333697
* device instance _12_t247 r0 *1 0,0
R_12_t247 \$12__t247 \$12 13.3821479165
* device instance _12_t248 r0 *1 0,0
R_12_t248 \$12__t248 \$12 14.9938026795
* device instance _12_t249 r0 *1 0,0
R_12_t249 \$12__t249 \$12 6.35284272159
* device instance _12_t250 r0 *1 0,0
R_12_t250 \$12__t250 \$12 9.82561120648
* device instance _12_t251 r0 *1 0,0
R_12_t251 \$12__t251 \$12 8.37805757339
* device instance _12_t252 r0 *1 0,0
R_12_t252 \$12__t252 \$12 7.09235820042
* device instance _12_t253 r0 *1 0,0
R_12_t253 \$12__t253 \$12 6.07220915328
* device instance _12_t254 r0 *1 0,0
R_12_t254 \$12__t254 \$12 5.46830743259
* device instance _12_t255 r0 *1 0,0
R_12_t255 \$12__t255 \$12 5.42158015448
* device instance _12_t256 r0 *1 0,0
R_12_t256 \$12__t256 \$12 11.5850216694
* device instance _12_t257 r0 *1 0,0
R_12_t257 \$12__t257 \$12 6.31266630192
* device instance _12_t258 r0 *1 0,0
R_12_t258 \$12__t258 \$12 16.7770271186
* device instance _12_t259 r0 *1 0,0
R_12_t259 \$12__t259 \$12 16.5893289842
* device instance _12_t260 r0 *1 0,0
R_12_t260 \$12__t260 \$12 16.9722863422
* device instance _12_t261 r0 *1 0,0
R_12_t261 \$12__t261 \$12 19.1916208898
* device instance _12_t262 r0 *1 0,0
R_12_t262 \$12__t262 \$12 19.43344224
* device instance _12_t263 r0 *1 0,0
R_12_t263 \$12__t263 \$12 18.9553425032
* device instance _12 r0 *1 0,0
C_12 \$12 vsubs 5.64037401e-13
* device instance _120_t0 r0 *1 0,0
R_120_t0 \$120__t0 \$120 135.591504929
* device instance _120_t1 r0 *1 0,0
R_120_t1 \$120__t1 \$120 36.2048686624
* device instance _120_t2 r0 *1 0,0
R_120_t2 \$120__t2 \$120 166.824926409
* device instance _120 r0 *1 0,0
C_120 \$120 vsubs 7.017453e-15
* device instance _122_t0 r0 *1 0,0
R_122_t0 \$122__t0 \$122 162.444438203
* device instance _122_t1 r0 *1 0,0
R_122_t1 \$122__t1 \$122 43.7126105743
* device instance _122_t2 r0 *1 0,0
R_122_t2 \$122__t2 \$122 200.179851222
* device instance _122 r0 *1 0,0
C_122 \$122 vsubs 7.547896e-15
* device instance _124_t0 r0 *1 0,0
R_124_t0 \$124__t0 \$124 135.591504929
* device instance _124_t1 r0 *1 0,0
R_124_t1 \$124__t1 \$124 36.2048686624
* device instance _124_t2 r0 *1 0,0
R_124_t2 \$124__t2 \$124 166.824926409
* device instance _124 r0 *1 0,0
C_124 \$124 vsubs 7.017453e-15
* device instance _126_t0 r0 *1 0,0
R_126_t0 \$126__t0 \$126 162.444438203
* device instance _126_t1 r0 *1 0,0
R_126_t1 \$126__t1 \$126 43.7126105743
* device instance _126_t2 r0 *1 0,0
R_126_t2 \$126__t2 \$126 200.179851222
* device instance _126 r0 *1 0,0
C_126 \$126 vsubs 7.547896e-15
* device instance _127_t0 r0 *1 0,0
R_127_t0 \$127__t0 \$127 81.7777390336
* device instance _127_t1 r0 *1 0,0
R_127_t1 \$127__t1 \$127 21.4987692264
* device instance _127_t2 r0 *1 0,0
R_127_t2 \$127__t2 \$127 100.29899174
* device instance _127 r0 *1 0,0
C_127 \$127 vsubs 5.956568e-15
* device instance _129_t0 r0 *1 0,0
R_129_t0 \$129__t0 \$129 108.687402234
* device instance _129_t1 r0 *1 0,0
R_129_t1 \$129__t1 \$129 28.7964709909
* device instance _129_t2 r0 *1 0,0
R_129_t2 \$129__t2 \$129 133.512826775
* device instance _129 r0 *1 0,0
C_129 \$129 vsubs 6.487011e-15
* device instance _130_t0 r0 *1 0,0
R_130_t0 \$130__t0 \$130 81.7777390336
* device instance _130_t1 r0 *1 0,0
R_130_t1 \$130__t1 \$130 21.4987692264
* device instance _130_t2 r0 *1 0,0
R_130_t2 \$130__t2 \$130 100.29899174
* device instance _130 r0 *1 0,0
C_130 \$130 vsubs 5.956568e-15
* device instance _132_t0 r0 *1 0,0
R_132_t0 \$132__t0 \$132 108.687402234
* device instance _132_t1 r0 *1 0,0
R_132_t1 \$132__t1 \$132 28.7964709909
* device instance _132_t2 r0 *1 0,0
R_132_t2 \$132__t2 \$132 133.512826775
* device instance _132 r0 *1 0,0
C_132 \$132 vsubs 6.487011e-15
* device instance _133_t0 r0 *1 0,0
R_133_t0 \$133__t0 \$133 81.7777390336
* device instance _133_t1 r0 *1 0,0
R_133_t1 \$133__t1 \$133 21.4987692264
* device instance _133_t2 r0 *1 0,0
R_133_t2 \$133__t2 \$133 100.29899174
* device instance _133 r0 *1 0,0
C_133 \$133 vsubs 5.956568e-15
* device instance _135_t0 r0 *1 0,0
R_135_t0 \$135__t0 \$135 108.687402234
* device instance _135_t1 r0 *1 0,0
R_135_t1 \$135__t1 \$135 28.7964709909
* device instance _135_t2 r0 *1 0,0
R_135_t2 \$135__t2 \$135 133.512826775
* device instance _135 r0 *1 0,0
C_135 \$135 vsubs 6.487011e-15
* device instance _136_t0 r0 *1 0,0
R_136_t0 \$136__t0 \$136 81.7777390336
* device instance _136_t1 r0 *1 0,0
R_136_t1 \$136__t1 \$136 21.4987692264
* device instance _136_t2 r0 *1 0,0
R_136_t2 \$136__t2 \$136 100.29899174
* device instance _136 r0 *1 0,0
C_136 \$136 vsubs 5.956568e-15
* device instance _138_t0 r0 *1 0,0
R_138_t0 \$138__t0 \$138 108.687402234
* device instance _138_t1 r0 *1 0,0
R_138_t1 \$138__t1 \$138 28.7964709909
* device instance _138_t2 r0 *1 0,0
R_138_t2 \$138__t2 \$138 133.512826775
* device instance _138 r0 *1 0,0
C_138 \$138 vsubs 6.487011e-15
* device instance _139_t0 r0 *1 0,0
R_139_t0 \$139__t0 \$139 81.7777390336
* device instance _139_t1 r0 *1 0,0
R_139_t1 \$139__t1 \$139 21.4987692264
* device instance _139_t2 r0 *1 0,0
R_139_t2 \$139__t2 \$139 100.29899174
* device instance _139 r0 *1 0,0
C_139 \$139 vsubs 5.95106e-15
* device instance _141_t0 r0 *1 0,0
R_141_t0 \$141__t0 \$141 108.687402234
* device instance _141_t1 r0 *1 0,0
R_141_t1 \$141__t1 \$141 28.7964709909
* device instance _141_t2 r0 *1 0,0
R_141_t2 \$141__t2 \$141 133.512826775
* device instance _141 r0 *1 0,0
C_141 \$141 vsubs 6.467838e-15
* device instance _142_t0 r0 *1 0,0
R_142_t0 \$142__t0 \$142 81.7777390336
* device instance _142_t1 r0 *1 0,0
R_142_t1 \$142__t1 \$142 21.4987692264
* device instance _142_t2 r0 *1 0,0
R_142_t2 \$142__t2 \$142 100.29899174
* device instance _142 r0 *1 0,0
C_142 \$142 vsubs 5.956568e-15
* device instance _144_t0 r0 *1 0,0
R_144_t0 \$144__t0 \$144 108.687402234
* device instance _144_t1 r0 *1 0,0
R_144_t1 \$144__t1 \$144 28.7964709909
* device instance _144_t2 r0 *1 0,0
R_144_t2 \$144__t2 \$144 133.512826775
* device instance _144 r0 *1 0,0
C_144 \$144 vsubs 6.487011e-15
* device instance _145_t0 r0 *1 0,0
R_145_t0 \$145__t0 \$145 81.7777390336
* device instance _145_t1 r0 *1 0,0
R_145_t1 \$145__t1 \$145 21.4987692264
* device instance _145_t2 r0 *1 0,0
R_145_t2 \$145__t2 \$145 100.29899174
* device instance _145 r0 *1 0,0
C_145 \$145 vsubs 5.956568e-15
* device instance _147_t0 r0 *1 0,0
R_147_t0 \$147__t0 \$147 108.687402234
* device instance _147_t1 r0 *1 0,0
R_147_t1 \$147__t1 \$147 28.7964709909
* device instance _147_t2 r0 *1 0,0
R_147_t2 \$147__t2 \$147 133.512826775
* device instance _147 r0 *1 0,0
C_147 \$147 vsubs 6.487011e-15
* device instance _148_t0 r0 *1 0,0
R_148_t0 \$148__t0 \$148 81.7777390336
* device instance _148_t1 r0 *1 0,0
R_148_t1 \$148__t1 \$148 21.4987692264
* device instance _148_t2 r0 *1 0,0
R_148_t2 \$148__t2 \$148 100.29899174
* device instance _148 r0 *1 0,0
C_148 \$148 vsubs 5.956568e-15
* device instance _150_t0 r0 *1 0,0
R_150_t0 \$150__t0 \$150 108.687402234
* device instance _150_t1 r0 *1 0,0
R_150_t1 \$150__t1 \$150 28.7964709909
* device instance _150_t2 r0 *1 0,0
R_150_t2 \$150__t2 \$150 133.512826775
* device instance _150 r0 *1 0,0
C_150 \$150 vsubs 6.487011e-15
* device instance _151_t0 r0 *1 0,0
R_151_t0 \$151__t0 \$151 81.7777390336
* device instance _151_t1 r0 *1 0,0
R_151_t1 \$151__t1 \$151 21.4987692264
* device instance _151_t2 r0 *1 0,0
R_151_t2 \$151__t2 \$151 100.29899174
* device instance _151 r0 *1 0,0
C_151 \$151 vsubs 5.956568e-15
* device instance _153_t0 r0 *1 0,0
R_153_t0 \$153__t0 \$153 108.687402234
* device instance _153_t1 r0 *1 0,0
R_153_t1 \$153__t1 \$153 28.7964709909
* device instance _153_t2 r0 *1 0,0
R_153_t2 \$153__t2 \$153 133.512826775
* device instance _153 r0 *1 0,0
C_153 \$153 vsubs 6.487011e-15
* device instance _157_t0 r0 *1 0,0
R_157_t0 \$157__t0 \$157 84.9620979822
* device instance _157_t1 r0 *1 0,0
R_157_t1 \$157__t1 \$157 24.9695335856
* device instance _157_t2 r0 *1 0,0
R_157_t2 \$157__t2 \$157 86.6725684323
* device instance _157 r0 *1 0,0
C_157 \$157 vsubs 3.621691e-15
* device instance _158_t0 r0 *1 0,0
R_158_t0 \$158__t0 \$158 84.9620979822
* device instance _158_t1 r0 *1 0,0
R_158_t1 \$158__t1 \$158 24.9695335856
* device instance _158_t2 r0 *1 0,0
R_158_t2 \$158__t2 \$158 86.6725684323
* device instance _158 r0 *1 0,0
C_158 \$158 vsubs 3.621691e-15
* device instance _17_t0 r0 *1 0,0
R_17_t0 \$17__t0 \$17 81.7777390336
* device instance _17_t1 r0 *1 0,0
R_17_t1 \$17__t1 \$17 21.4987692264
* device instance _17_t2 r0 *1 0,0
R_17_t2 \$17__t2 \$17 100.29899174
* device instance _17 r0 *1 0,0
C_17 \$17 vsubs 5.962076e-15
* device instance _19_t0 r0 *1 0,0
R_19_t0 \$19__t0 \$19 108.687402234
* device instance _19_t1 r0 *1 0,0
R_19_t1 \$19__t1 \$19 28.7964709909
* device instance _19_t2 r0 *1 0,0
R_19_t2 \$19__t2 \$19 133.512826775
* device instance _19 r0 *1 0,0
C_19 \$19 vsubs 6.492519e-15
* device instance _21_t0 r0 *1 0,0
R_21_t0 \$21__t0 \$21 135.591504929
* device instance _21_t1 r0 *1 0,0
R_21_t1 \$21__t1 \$21 36.2048686624
* device instance _21_t2 r0 *1 0,0
R_21_t2 \$21__t2 \$21 166.824926409
* device instance _21 r0 *1 0,0
C_21 \$21 vsubs 7.022961e-15
* device instance _23_t0 r0 *1 0,0
R_23_t0 \$23__t0 \$23 162.444438203
* device instance _23_t1 r0 *1 0,0
R_23_t1 \$23__t1 \$23 43.7126105743
* device instance _23_t2 r0 *1 0,0
R_23_t2 \$23__t2 \$23 200.179851222
* device instance _23 r0 *1 0,0
C_23 \$23 vsubs 7.553404e-15
* device instance _24_t0 r0 *1 0,0
R_24_t0 \$24__t0 \$24 20.5348083509
* device instance _24_t1 r0 *1 0,0
R_24_t1 \$24__t1 \$24 17.2841938976
* device instance _24_t2 r0 *1 0,0
R_24_t2 \$24__t2 \$24 8.81561118035
* device instance _24_t3 r0 *1 0,0
R_24_t3 \$24__t3 \$24 9.68328915444
* device instance _24_t4 r0 *1 0,0
R_24_t4 \$24__t4 \$24 11.1307892286
* device instance _24_t5 r0 *1 0,0
R_24_t5 \$24__t5 \$24 8.70294224706
* device instance _24_t6 r0 *1 0,0
R_24_t6 \$24__t6 \$24 10.2652957245
* device instance _24_t7 r0 *1 0,0
R_24_t7 \$24__t7 \$24 17.359179808
* device instance _24_t8 r0 *1 0,0
R_24_t8 \$24__t8 \$24 19.8700104676
* device instance _24_t9 r0 *1 0,0
R_24_t9 \$24__t9 \$24 11.9360347135
* device instance _24_t10 r0 *1 0,0
R_24_t10 \$24__t10 \$24 14.4149413381
* device instance _24_t11 r0 *1 0,0
R_24_t11 \$24__t11 \$24 22.0385059258
* device instance _24_t12 r0 *1 0,0
R_24_t12 \$24__t12 \$24 19.6260262215
* device instance _24_t13 r0 *1 0,0
R_24_t13 \$24__t13 \$24 12.9653438247
* device instance _24_t14 r0 *1 0,0
R_24_t14 \$24__t14 \$24 15.0460328251
* device instance _24_t15 r0 *1 0,0
R_24_t15 \$24__t15 \$24 16.232802401
* device instance _24_t16 r0 *1 0,0
R_24_t16 \$24__t16 \$24 7.38585599964
* device instance _24_t17 r0 *1 0,0
R_24_t17 \$24__t17 \$24 13.7132259701
* device instance _24_t18 r0 *1 0,0
R_24_t18 \$24__t18 \$24 7.51828873979
* device instance _24_t19 r0 *1 0,0
R_24_t19 \$24__t19 \$24 8.51914044609
* device instance _24_t20 r0 *1 0,0
R_24_t20 \$24__t20 \$24 10.1343048081
* device instance _24_t21 r0 *1 0,0
R_24_t21 \$24__t21 \$24 12.1206355273
* device instance _24_t22 r0 *1 0,0
R_24_t22 \$24__t22 \$24 14.3245512622
* device instance _24_t23 r0 *1 0,0
R_24_t23 \$24__t23 \$24 16.6599226824
* device instance _24_t24 r0 *1 0,0
R_24_t24 \$24__t24 \$24 19.0785369024
* device instance _24_t25 r0 *1 0,0
R_24_t25 \$24__t25 \$24 21.5523875367
* device instance _24_t26 r0 *1 0,0
R_24_t26 \$24__t26 \$24 9.55115737603
* device instance _24_t27 r0 *1 0,0
R_24_t27 \$24__t27 \$24 6.79429131622
* device instance _24_t28 r0 *1 0,0
R_24_t28 \$24__t28 \$24 21.369098326
* device instance _24_t29 r0 *1 0,0
R_24_t29 \$24__t29 \$24 18.7891583821
* device instance _24_t30 r0 *1 0,0
R_24_t30 \$24__t30 \$24 12.4660124327
* device instance _24_t31 r0 *1 0,0
R_24_t31 \$24__t31 \$24 15.0917765982
* device instance _24_t32 r0 *1 0,0
R_24_t32 \$24__t32 \$24 17.7256669112
* device instance _24_t33 r0 *1 0,0
R_24_t33 \$24__t33 \$24 14.3968660347
* device instance _24_t34 r0 *1 0,0
R_24_t34 \$24__t34 \$24 19.4973035247
* device instance _24_t35 r0 *1 0,0
R_24_t35 \$24__t35 \$24 16.9312921054
* device instance _24_t36 r0 *1 0,0
R_24_t36 \$24__t36 \$24 11.9141991977
* device instance _24_t37 r0 *1 0,0
R_24_t37 \$24__t37 \$24 4.77330609208
* device instance _24_t38 r0 *1 0,0
R_24_t38 \$24__t38 \$24 5.45423683172
* device instance _24_t39 r0 *1 0,0
R_24_t39 \$24__t39 \$24 7.73802813512
* device instance _24_t40 r0 *1 0,0
R_24_t40 \$24__t40 \$24 5.14776374765
* device instance _24_t41 r0 *1 0,0
R_24_t41 \$24__t41 \$24 4.62975404422
* device instance _24_t42 r0 *1 0,0
R_24_t42 \$24__t42 \$24 7.31688453105
* device instance _24_t43 r0 *1 0,0
R_24_t43 \$24__t43 \$24 3.7010283775
* device instance _24_t44 r0 *1 0,0
R_24_t44 \$24__t44 \$24 9.85487202827
* device instance _24_t45 r0 *1 0,0
R_24_t45 \$24__t45 \$24 7.27412063772
* device instance _24_t46 r0 *1 0,0
R_24_t46 \$24__t46 \$24 5.51788592273
* device instance _24_t47 r0 *1 0,0
R_24_t47 \$24__t47 \$24 20.3645305774
* device instance _24_t48 r0 *1 0,0
R_24_t48 \$24__t48 \$24 10.202095425
* device instance _24_t49 r0 *1 0,0
R_24_t49 \$24__t49 \$24 12.7422805785
* device instance _24_t50 r0 *1 0,0
R_24_t50 \$24__t50 \$24 15.3207692124
* device instance _24_t51 r0 *1 0,0
R_24_t51 \$24__t51 \$24 17.9210355676
* device instance _24_t52 r0 *1 0,0
R_24_t52 \$24__t52 \$24 3.42400559633
* device instance _24_t53 r0 *1 0,0
R_24_t53 \$24__t53 \$24 9.52385557761
* device instance _24_t54 r0 *1 0,0
R_24_t54 \$24__t54 \$24 5.19810097632
* device instance _24_t55 r0 *1 0,0
R_24_t55 \$24__t55 \$24 6.00891785246
* device instance _24_t56 r0 *1 0,0
R_24_t56 \$24__t56 \$24 6.71710773354
* device instance _24_t57 r0 *1 0,0
R_24_t57 \$24__t57 \$24 8.25889039087
* device instance _24_t58 r0 *1 0,0
R_24_t58 \$24__t58 \$24 4.68565946996
* device instance _24_t59 r0 *1 0,0
R_24_t59 \$24__t59 \$24 6.41653667092
* device instance _24_t60 r0 *1 0,0
R_24_t60 \$24__t60 \$24 5.5648762084
* device instance _24_t61 r0 *1 0,0
R_24_t61 \$24__t61 \$24 7.35238610243
* device instance _24_t62 r0 *1 0,0
R_24_t62 \$24__t62 \$24 16.9466644068
* device instance _24_t63 r0 *1 0,0
R_24_t63 \$24__t63 \$24 19.5106541892
* device instance _24_t64 r0 *1 0,0
R_24_t64 \$24__t64 \$24 12.5148157706
* device instance _24_t65 r0 *1 0,0
R_24_t65 \$24__t65 \$24 14.897725426
* device instance _24_t66 r0 *1 0,0
R_24_t66 \$24__t66 \$24 21.3562354484
* device instance _24_t67 r0 *1 0,0
R_24_t67 \$24__t67 \$24 21.6976969367
* device instance _24_t68 r0 *1 0,0
R_24_t68 \$24__t68 \$24 19.1620500416
* device instance _24_t69 r0 *1 0,0
R_24_t69 \$24__t69 \$24 16.6629998163
* device instance _24_t70 r0 *1 0,0
R_24_t70 \$24__t70 \$24 14.2198542748
* device instance _24_t71 r0 *1 0,0
R_24_t71 \$24__t71 \$24 11.8671917467
* device instance _24_t72 r0 *1 0,0
R_24_t72 \$24__t72 \$24 9.67127271597
* device instance _24_t73 r0 *1 0,0
R_24_t73 \$24__t73 \$24 7.76621423726
* device instance _24_t74 r0 *1 0,0
R_24_t74 \$24__t74 \$24 4.10646573912
* device instance _24_t75 r0 *1 0,0
R_24_t75 \$24__t75 \$24 9.37255027548
* device instance _24_t76 r0 *1 0,0
R_24_t76 \$24__t76 \$24 8.16421237831
* device instance _24_t77 r0 *1 0,0
R_24_t77 \$24__t77 \$24 18.9610534462
* device instance _24_t78 r0 *1 0,0
R_24_t78 \$24__t78 \$24 16.6442661205
* device instance _24_t79 r0 *1 0,0
R_24_t79 \$24__t79 \$24 14.4436468119
* device instance _24_t80 r0 *1 0,0
R_24_t80 \$24__t80 \$24 12.4210934866
* device instance _24_t81 r0 *1 0,0
R_24_t81 \$24__t81 \$24 10.6782716399
* device instance _24_t82 r0 *1 0,0
R_24_t82 \$24__t82 \$24 11.2551566343
* device instance _24_t83 r0 *1 0,0
R_24_t83 \$24__t83 \$24 20.8542191803
* device instance _24_t84 r0 *1 0,0
R_24_t84 \$24__t84 \$24 18.3937819081
* device instance _24_t85 r0 *1 0,0
R_24_t85 \$24__t85 \$24 15.9950385989
* device instance _24_t86 r0 *1 0,0
R_24_t86 \$24__t86 \$24 13.6904564686
* device instance _24_t87 r0 *1 0,0
R_24_t87 \$24__t87 \$24 11.5366038544
* device instance _24_t88 r0 *1 0,0
R_24_t88 \$24__t88 \$24 9.63509991161
* device instance _24_t89 r0 *1 0,0
R_24_t89 \$24__t89 \$24 8.90964796484
* device instance _24_t90 r0 *1 0,0
R_24_t90 \$24__t90 \$24 4.88132248825
* device instance _24_t91 r0 *1 0,0
R_24_t91 \$24__t91 \$24 19.8531543821
* device instance _24_t92 r0 *1 0,0
R_24_t92 \$24__t92 \$24 17.339883118
* device instance _24_t93 r0 *1 0,0
R_24_t93 \$24__t93 \$24 14.8752359917
* device instance _24_t94 r0 *1 0,0
R_24_t94 \$24__t94 \$24 12.4880357427
* device instance _24_t95 r0 *1 0,0
R_24_t95 \$24__t95 \$24 10.2326301238
* device instance _24_t96 r0 *1 0,0
R_24_t96 \$24__t96 \$24 8.21825367262
* device instance _24_t97 r0 *1 0,0
R_24_t97 \$24__t97 \$24 6.66708026374
* device instance _24_t98 r0 *1 0,0
R_24_t98 \$24__t98 \$24 21.6822617661
* device instance _24_t99 r0 *1 0,0
R_24_t99 \$24__t99 \$24 6.36414690185
* device instance _24_t100 r0 *1 0,0
R_24_t100 \$24__t100 \$24 7.72298559613
* device instance _24_t101 r0 *1 0,0
R_24_t101 \$24__t101 \$24 9.63659373875
* device instance _24_t102 r0 *1 0,0
R_24_t102 \$24__t102 \$24 11.8389468658
* device instance _24_t103 r0 *1 0,0
R_24_t103 \$24__t103 \$24 14.1962910133
* device instance _24_t104 r0 *1 0,0
R_24_t104 \$24__t104 \$24 16.6428959564
* device instance _24_t105 r0 *1 0,0
R_24_t105 \$24__t105 \$24 19.1445706334
* device instance _24_t106 r0 *1 0,0
R_24_t106 \$24__t106 \$24 5.95294185229
* device instance _24_t107 r0 *1 0,0
R_24_t107 \$24__t107 \$24 21.3569094465
* device instance _24_t108 r0 *1 0,0
R_24_t108 \$24__t108 \$24 18.7752946861
* device instance _24_t109 r0 *1 0,0
R_24_t109 \$24__t109 \$24 16.2167534245
* device instance _24_t110 r0 *1 0,0
R_24_t110 \$24__t110 \$24 19.6241472357
* device instance _24_t111 r0 *1 0,0
R_24_t111 \$24__t111 \$24 12.0250382035
* device instance _24_t112 r0 *1 0,0
R_24_t112 \$24__t112 \$24 8.88037413057
* device instance _24_t113 r0 *1 0,0
R_24_t113 \$24__t113 \$24 14.3544403196
* device instance _24_t114 r0 *1 0,0
R_24_t114 \$24__t114 \$24 11.7318922356
* device instance _24_t115 r0 *1 0,0
R_24_t115 \$24__t115 \$24 9.12698885734
* device instance _24_t116 r0 *1 0,0
R_24_t116 \$24__t116 \$24 16.9864625508
* device instance _24_t117 r0 *1 0,0
R_24_t117 \$24__t117 \$24 6.75585763107
* device instance _24_t118 r0 *1 0,0
R_24_t118 \$24__t118 \$24 2.18164294876
* device instance _24_t119 r0 *1 0,0
R_24_t119 \$24__t119 \$24 2.59487238285
* device instance _24_t120 r0 *1 0,0
R_24_t120 \$24__t120 \$24 19.8007929916
* device instance _24_t121 r0 *1 0,0
R_24_t121 \$24__t121 \$24 17.1902343893
* device instance _24_t122 r0 *1 0,0
R_24_t122 \$24__t122 \$24 14.5950061753
* device instance _24_t123 r0 *1 0,0
R_24_t123 \$24__t123 \$24 9.50085122343
* device instance _24_t124 r0 *1 0,0
R_24_t124 \$24__t124 \$24 7.071640247
* device instance _24_t125 r0 *1 0,0
R_24_t125 \$24__t125 \$24 13.6942244888
* device instance _24_t126 r0 *1 0,0
R_24_t126 \$24__t126 \$24 11.2319975385
* device instance _24_t127 r0 *1 0,0
R_24_t127 \$24__t127 \$24 6.5607810065
* device instance _24_t128 r0 *1 0,0
R_24_t128 \$24__t128 \$24 21.1920515705
* device instance _24_t129 r0 *1 0,0
R_24_t129 \$24__t129 \$24 21.2357630582
* device instance _24_t130 r0 *1 0,0
R_24_t130 \$24__t130 \$24 21.2961235546
* device instance _24_t131 r0 *1 0,0
R_24_t131 \$24__t131 \$24 21.3729920023
* device instance _24_t132 r0 *1 0,0
R_24_t132 \$24__t132 \$24 23.6115870328
* device instance _24_t133 r0 *1 0,0
R_24_t133 \$24__t133 \$24 23.4143937909
* device instance _24_t134 r0 *1 0,0
R_24_t134 \$24__t134 \$24 23.230869417
* device instance _24_t135 r0 *1 0,0
R_24_t135 \$24__t135 \$24 23.061340248
* device instance _24 r0 *1 0,0
C_24 \$24 vsubs 3.07467522e-13
* device instance _25_t0 r0 *1 0,0
R_25_t0 \$25__t0 \$25 81.7777390336
* device instance _25_t1 r0 *1 0,0
R_25_t1 \$25__t1 \$25 21.4987692264
* device instance _25_t2 r0 *1 0,0
R_25_t2 \$25__t2 \$25 100.29899174
* device instance _25 r0 *1 0,0
C_25 \$25 vsubs 5.962076e-15
* device instance _27_t0 r0 *1 0,0
R_27_t0 \$27__t0 \$27 108.687402234
* device instance _27_t1 r0 *1 0,0
R_27_t1 \$27__t1 \$27 28.7964709909
* device instance _27_t2 r0 *1 0,0
R_27_t2 \$27__t2 \$27 133.512826775
* device instance _27 r0 *1 0,0
C_27 \$27 vsubs 6.492519e-15
* device instance _29_t0 r0 *1 0,0
R_29_t0 \$29__t0 \$29 135.591504929
* device instance _29_t1 r0 *1 0,0
R_29_t1 \$29__t1 \$29 36.2048686624
* device instance _29_t2 r0 *1 0,0
R_29_t2 \$29__t2 \$29 166.824926409
* device instance _29 r0 *1 0,0
C_29 \$29 vsubs 7.022961e-15
* device instance _31_t0 r0 *1 0,0
R_31_t0 \$31__t0 \$31 162.444438203
* device instance _31_t1 r0 *1 0,0
R_31_t1 \$31__t1 \$31 43.7126105743
* device instance _31_t2 r0 *1 0,0
R_31_t2 \$31__t2 \$31 200.179851222
* device instance _31 r0 *1 0,0
C_31 \$31 vsubs 7.553404e-15
* device instance _32_t0 r0 *1 0,0
R_32_t0 \$32__t0 \$32 35.7620392391
* device instance _32_t1 r0 *1 0,0
R_32_t1 \$32__t1 \$32 16.7290645481
* device instance _32_t2 r0 *1 0,0
R_32_t2 \$32__t2 \$32 17.1596833046
* device instance _32_t3 r0 *1 0,0
R_32_t3 \$32__t3 \$32 18.4542454758
* device instance _32_t4 r0 *1 0,0
R_32_t4 \$32__t4 \$32 20.4493260416
* device instance _32_t5 r0 *1 0,0
R_32_t5 \$32__t5 \$32 22.9630574954
* device instance _32_t6 r0 *1 0,0
R_32_t6 \$32__t6 \$32 25.8445429061
* device instance _32_t7 r0 *1 0,0
R_32_t7 \$32__t7 \$32 28.984307841
* device instance _32_t8 r0 *1 0,0
R_32_t8 \$32__t8 \$32 32.3071372691
* device instance _32_t9 r0 *1 0,0
R_32_t9 \$32__t9 \$32 32.5580480625
* device instance _32_t10 r0 *1 0,0
R_32_t10 \$32__t10 \$32 29.2239699998
* device instance _32_t11 r0 *1 0,0
R_32_t11 \$32__t11 \$32 26.0684803156
* device instance _32_t12 r0 *1 0,0
R_32_t12 \$32__t12 \$32 23.1646762094
* device instance _32_t13 r0 *1 0,0
R_32_t13 \$32__t13 \$32 20.6191681772
* device instance _32_t14 r0 *1 0,0
R_32_t14 \$32__t14 \$32 18.5798084828
* device instance _32_t15 r0 *1 0,0
R_32_t15 \$32__t15 \$32 15.7539253748
* device instance _32_t16 r0 *1 0,0
R_32_t16 \$32__t16 \$32 19.7186346689
* device instance _32_t17 r0 *1 0,0
R_32_t17 \$32__t17 \$32 23.6848951064
* device instance _32_t18 r0 *1 0,0
R_32_t18 \$32__t18 \$32 27.6520392323
* device instance _32_t19 r0 *1 0,0
R_32_t19 \$32__t19 \$32 31.6197344346
* device instance _32_t20 r0 *1 0,0
R_32_t20 \$32__t20 \$32 0.86357155652
* device instance _32_t21 r0 *1 0,0
R_32_t21 \$32__t21 \$32 3.91648902628
* device instance _32_t22 r0 *1 0,0
R_32_t22 \$32__t22 \$32 11.7923318616
* device instance _32_t23 r0 *1 0,0
R_32_t23 \$32__t23 \$32 7.83857967109
* device instance _32_t24 r0 *1 0,0
R_32_t24 \$32__t24 \$32 22.7276311457
* device instance _32_t25 r0 *1 0,0
R_32_t25 \$32__t25 \$32 26.5414878586
* device instance _32_t26 r0 *1 0,0
R_32_t26 \$32__t26 \$32 30.3951846927
* device instance _32_t27 r0 *1 0,0
R_32_t27 \$32__t27 \$32 17.227297661
* device instance _32_t28 r0 *1 0,0
R_32_t28 \$32__t28 \$32 4.20284901951
* device instance _32_t29 r0 *1 0,0
R_32_t29 \$32__t29 \$32 30.6806967719
* device instance _32_t30 r0 *1 0,0
R_32_t30 \$32__t30 \$32 26.8246794215
* device instance _32_t31 r0 *1 0,0
R_32_t31 \$32__t31 \$32 23.0072382573
* device instance _32_t32 r0 *1 0,0
R_32_t32 \$32__t32 \$32 19.2513353536
* device instance _32_t33 r0 *1 0,0
R_32_t33 \$32__t33 \$32 15.6014783939
* device instance _32_t34 r0 *1 0,0
R_32_t34 \$32__t34 \$32 12.1535862098
* device instance _32_t35 r0 *1 0,0
R_32_t35 \$32__t35 \$32 9.13917403003
* device instance _32_t36 r0 *1 0,0
R_32_t36 \$32__t36 \$32 18.9776492684
* device instance _32_t37 r0 *1 0,0
R_32_t37 \$32__t37 \$32 11.9120537184
* device instance _32_t38 r0 *1 0,0
R_32_t38 \$32__t38 \$32 8.94633565039
* device instance _32_t39 r0 *1 0,0
R_32_t39 \$32__t39 \$32 7.0489810509
* device instance _32_t40 r0 *1 0,0
R_32_t40 \$32__t40 \$32 7.13096491717
* device instance _32_t41 r0 *1 0,0
R_32_t41 \$32__t41 \$32 15.3384627821
* device instance _32_t42 r0 *1 0,0
R_32_t42 \$32__t42 \$32 27.9447785609
* device instance _32_t43 r0 *1 0,0
R_32_t43 \$32__t43 \$32 23.9775849019
* device instance _32_t44 r0 *1 0,0
R_32_t44 \$32__t44 \$32 20.0112423688
* device instance _32_t45 r0 *1 0,0
R_32_t45 \$32__t45 \$32 16.0463821177
* device instance _32_t46 r0 *1 0,0
R_32_t46 \$32__t46 \$32 12.0844632275
* device instance _32_t47 r0 *1 0,0
R_32_t47 \$32__t47 \$32 8.12978710888
* device instance _32_t48 r0 *1 0,0
R_32_t48 \$32__t48 \$32 23.506222958
* device instance _32_t49 r0 *1 0,0
R_32_t49 \$32__t49 \$32 27.2111719336
* device instance _32_t50 r0 *1 0,0
R_32_t50 \$32__t50 \$32 30.9816809221
* device instance _32_t51 r0 *1 0,0
R_32_t51 \$32__t51 \$32 31.2618370328
* device instance _32_t52 r0 *1 0,0
R_32_t52 \$32__t52 \$32 27.4874648944
* device instance _32_t53 r0 *1 0,0
R_32_t53 \$32__t53 \$32 23.7766758081
* device instance _32_t54 r0 *1 0,0
R_32_t54 \$32__t54 \$32 20.1646029753
* device instance _32_t55 r0 *1 0,0
R_32_t55 \$32__t55 \$32 13.5538539911
* device instance _32_t56 r0 *1 0,0
R_32_t56 \$32__t56 \$32 10.9326027187
* device instance _32_t57 r0 *1 0,0
R_32_t57 \$32__t57 \$32 16.7153650373
* device instance _32_t58 r0 *1 0,0
R_32_t58 \$32__t58 \$32 19.9034788921
* device instance _32_t59 r0 *1 0,0
R_32_t59 \$32__t59 \$32 16.4701469566
* device instance _32_t60 r0 *1 0,0
R_32_t60 \$32__t60 \$32 13.3377031022
* device instance _32_t61 r0 *1 0,0
R_32_t61 \$32__t61 \$32 10.7719182053
* device instance _32_t62 r0 *1 0,0
R_32_t62 \$32__t62 \$32 9.25664270182
* device instance _32_t63 r0 *1 0,0
R_32_t63 \$32__t63 \$32 9.31922533814
* device instance _32_t64 r0 *1 0,0
R_32_t64 \$32__t64 \$32 32.1199641948
* device instance _32_t65 r0 *1 0,0
R_32_t65 \$32__t65 \$32 31.8009661534
* device instance _32_t66 r0 *1 0,0
R_32_t66 \$32__t66 \$32 31.5040641348
* device instance _32_t67 r0 *1 0,0
R_32_t67 \$32__t67 \$32 31.2298883447
* device instance _32_t68 r0 *1 0,0
R_32_t68 \$32__t68 \$32 31.4443122035
* device instance _32_t69 r0 *1 0,0
R_32_t69 \$32__t69 \$32 31.5044315132
* device instance _32_t70 r0 *1 0,0
R_32_t70 \$32__t70 \$32 31.6999030897
* device instance _32_t71 r0 *1 0,0
R_32_t71 \$32__t71 \$32 31.5896961094
* device instance _32 r0 *1 0,0
C_32 \$32 vsubs 1.74844138e-13
* device instance _33_t0 r0 *1 0,0
R_33_t0 \$33__t0 \$33 81.7777390336
* device instance _33_t1 r0 *1 0,0
R_33_t1 \$33__t1 \$33 21.4987692264
* device instance _33_t2 r0 *1 0,0
R_33_t2 \$33__t2 \$33 100.29899174
* device instance _33 r0 *1 0,0
C_33 \$33 vsubs 5.962076e-15
* device instance _35_t0 r0 *1 0,0
R_35_t0 \$35__t0 \$35 108.687402234
* device instance _35_t1 r0 *1 0,0
R_35_t1 \$35__t1 \$35 28.7964709909
* device instance _35_t2 r0 *1 0,0
R_35_t2 \$35__t2 \$35 133.512826775
* device instance _35 r0 *1 0,0
C_35 \$35 vsubs 6.492519e-15
* device instance _37_t0 r0 *1 0,0
R_37_t0 \$37__t0 \$37 135.591504929
* device instance _37_t1 r0 *1 0,0
R_37_t1 \$37__t1 \$37 36.2048686624
* device instance _37_t2 r0 *1 0,0
R_37_t2 \$37__t2 \$37 166.824926409
* device instance _37 r0 *1 0,0
C_37 \$37 vsubs 7.022961e-15
* device instance _39_t0 r0 *1 0,0
R_39_t0 \$39__t0 \$39 162.444438203
* device instance _39_t1 r0 *1 0,0
R_39_t1 \$39__t1 \$39 43.7126105743
* device instance _39_t2 r0 *1 0,0
R_39_t2 \$39__t2 \$39 200.179851222
* device instance _39 r0 *1 0,0
C_39 \$39 vsubs 7.553404e-15
* device instance _40_t0 r0 *1 0,0
R_40_t0 \$40__t0 \$40 63.5750648064
* device instance _40_t1 r0 *1 0,0
R_40_t1 \$40__t1 \$40 35.3118507277
* device instance _40_t2 r0 *1 0,0
R_40_t2 \$40__t2 \$40 37.7357410999
* device instance _40_t3 r0 *1 0,0
R_40_t3 \$40__t3 \$40 40.9281614018
* device instance _40_t4 r0 *1 0,0
R_40_t4 \$40__t4 \$40 44.7248423133
* device instance _40_t5 r0 *1 0,0
R_40_t5 \$40__t5 \$40 48.9854828392
* device instance _40_t6 r0 *1 0,0
R_40_t6 \$40__t6 \$40 53.5995561817
* device instance _40_t7 r0 *1 0,0
R_40_t7 \$40__t7 \$40 58.4834694729
* device instance _40_t8 r0 *1 0,0
R_40_t8 \$40__t8 \$40 42.8965547564
* device instance _40_t9 r0 *1 0,0
R_40_t9 \$40__t9 \$40 48.8622368367
* device instance _40_t10 r0 *1 0,0
R_40_t10 \$40__t10 \$40 54.8542692252
* device instance _40_t11 r0 *1 0,0
R_40_t11 \$40__t11 \$40 31.1048791516
* device instance _40_t12 r0 *1 0,0
R_40_t12 \$40__t12 \$40 36.9699812833
* device instance _40_t13 r0 *1 0,0
R_40_t13 \$40__t13 \$40 25.3439614667
* device instance _40_t14 r0 *1 0,0
R_40_t14 \$40__t14 \$40 12.3169961247
* device instance _40_t15 r0 *1 0,0
R_40_t15 \$40__t15 \$40 14.6331400903
* device instance _40_t16 r0 *1 0,0
R_40_t16 \$40__t16 \$40 19.7784767727
* device instance _40_t17 r0 *1 0,0
R_40_t17 \$40__t17 \$40 41.9993449693
* device instance _40_t18 r0 *1 0,0
R_40_t18 \$40__t18 \$40 36.2135169695
* device instance _40_t19 r0 *1 0,0
R_40_t19 \$40__t19 \$40 30.5444189598
* device instance _40_t20 r0 *1 0,0
R_40_t20 \$40__t20 \$40 25.0713608069
* device instance _40_t21 r0 *1 0,0
R_40_t21 \$40__t21 \$40 19.9562927585
* device instance _40_t22 r0 *1 0,0
R_40_t22 \$40__t22 \$40 15.5564453991
* device instance _40_t23 r0 *1 0,0
R_40_t23 \$40__t23 \$40 12.6420429946
* device instance _40_t24 r0 *1 0,0
R_40_t24 \$40__t24 \$40 20.0604086558
* device instance _40_t25 r0 *1 0,0
R_40_t25 \$40__t25 \$40 15.6897854742
* device instance _40_t26 r0 *1 0,0
R_40_t26 \$40__t26 \$40 25.1543138941
* device instance _40_t27 r0 *1 0,0
R_40_t27 \$40__t27 \$40 12.8057653363
* device instance _40_t28 r0 *1 0,0
R_40_t28 \$40__t28 \$40 42.0489161884
* device instance _40_t29 r0 *1 0,0
R_40_t29 \$40__t29 \$40 36.2709964858
* device instance _40_t30 r0 *1 0,0
R_40_t30 \$40__t30 \$40 12.4849817103
* device instance _40_t31 r0 *1 0,0
R_40_t31 \$40__t31 \$40 30.6125448854
* device instance _40_t32 r0 *1 0,0
R_40_t32 \$40__t32 \$40 51.736545064
* device instance _40_t33 r0 *1 0,0
R_40_t33 \$40__t33 \$40 52.5805420858
* device instance _40_t34 r0 *1 0,0
R_40_t34 \$40__t34 \$40 53.4462950467
* device instance _40_t35 r0 *1 0,0
R_40_t35 \$40__t35 \$40 54.3327639614
* device instance _40_t36 r0 *1 0,0
R_40_t36 \$40__t36 \$40 49.661812123
* device instance _40_t37 r0 *1 0,0
R_40_t37 \$40__t37 \$40 47.8071039279
* device instance _40_t38 r0 *1 0,0
R_40_t38 \$40__t38 \$40 48.3945063803
* device instance _40_t39 r0 *1 0,0
R_40_t39 \$40__t39 \$40 49.0131313723
* device instance _40 r0 *1 0,0
C_40 \$40 vsubs 1.4581235e-13
* device instance _41_t0 r0 *1 0,0
R_41_t0 \$41__t0 \$41 81.7777390336
* device instance _41_t1 r0 *1 0,0
R_41_t1 \$41__t1 \$41 21.4987692264
* device instance _41_t2 r0 *1 0,0
R_41_t2 \$41__t2 \$41 100.29899174
* device instance _41 r0 *1 0,0
C_41 \$41 vsubs 5.956568e-15
* device instance _43_t0 r0 *1 0,0
R_43_t0 \$43__t0 \$43 108.687402234
* device instance _43_t1 r0 *1 0,0
R_43_t1 \$43__t1 \$43 28.7964709909
* device instance _43_t2 r0 *1 0,0
R_43_t2 \$43__t2 \$43 133.512826775
* device instance _43 r0 *1 0,0
C_43 \$43 vsubs 6.473346e-15
* device instance _45_t0 r0 *1 0,0
R_45_t0 \$45__t0 \$45 135.591504929
* device instance _45_t1 r0 *1 0,0
R_45_t1 \$45__t1 \$45 36.2048686624
* device instance _45_t2 r0 *1 0,0
R_45_t2 \$45__t2 \$45 166.824926409
* device instance _45 r0 *1 0,0
C_45 \$45 vsubs 7.017453e-15
* device instance _47_t0 r0 *1 0,0
R_47_t0 \$47__t0 \$47 162.444438203
* device instance _47_t1 r0 *1 0,0
R_47_t1 \$47__t1 \$47 43.7126105743
* device instance _47_t2 r0 *1 0,0
R_47_t2 \$47__t2 \$47 200.179851222
* device instance _47 r0 *1 0,0
C_47 \$47 vsubs 7.547896e-15
* device instance _48_t0 r0 *1 0,0
R_48_t0 \$48__t0 \$48 68.6564414303
* device instance _48_t1 r0 *1 0,0
R_48_t1 \$48__t1 \$48 62.8853192817
* device instance _48_t2 r0 *1 0,0
R_48_t2 \$48__t2 \$48 63.4699084418
* device instance _48_t3 r0 *1 0,0
R_48_t3 \$48__t3 \$48 67.5932309337
* device instance _48_t4 r0 *1 0,0
R_48_t4 \$48__t4 \$48 43.9123071765
* device instance _48_t5 r0 *1 0,0
R_48_t5 \$48__t5 \$48 51.2766367586
* device instance _48_t6 r0 *1 0,0
R_48_t6 \$48__t6 \$48 59.2408490213
* device instance _48_t7 r0 *1 0,0
R_48_t7 \$48__t7 \$48 37.2260035799
* device instance _48_t8 r0 *1 0,0
R_48_t8 \$48__t8 \$48 65.4329972861
* device instance _48_t9 r0 *1 0,0
R_48_t9 \$48__t9 \$48 30.8795324853
* device instance _48_t10 r0 *1 0,0
R_48_t10 \$48__t10 \$48 25.0326142029
* device instance _48_t11 r0 *1 0,0
R_48_t11 \$48__t11 \$48 26.4669165237
* device instance _48_t12 r0 *1 0,0
R_48_t12 \$48__t12 \$48 33.3002485168
* device instance _48_t13 r0 *1 0,0
R_48_t13 \$48__t13 \$48 42.5430288882
* device instance _48_t14 r0 *1 0,0
R_48_t14 \$48__t14 \$48 51.8661163235
* device instance _48_t15 r0 *1 0,0
R_48_t15 \$48__t15 \$48 61.232840027
* device instance _48_t16 r0 *1 0,0
R_48_t16 \$48__t16 \$48 85.9718503238
* device instance _48_t17 r0 *1 0,0
R_48_t17 \$48__t17 \$48 87.6600196013
* device instance _48_t18 r0 *1 0,0
R_48_t18 \$48__t18 \$48 89.3670527186
* device instance _48_t19 r0 *1 0,0
R_48_t19 \$48__t19 \$48 84.303678131
* device instance _48_t20 r0 *1 0,0
R_48_t20 \$48__t20 \$48 75.4322511095
* device instance _48_t21 r0 *1 0,0
R_48_t21 \$48__t21 \$48 76.856093944
* device instance _48_t22 r0 *1 0,0
R_48_t22 \$48__t22 \$48 78.3119718301
* device instance _48_t23 r0 *1 0,0
R_48_t23 \$48__t23 \$48 74.0422914643
* device instance _48 r0 *1 0,0
C_48 \$48 vsubs 1.32779351e-13
* device instance _49_t0 r0 *1 0,0
R_49_t0 \$49__t0 \$49 81.7777390336
* device instance _49_t1 r0 *1 0,0
R_49_t1 \$49__t1 \$49 21.4987692264
* device instance _49_t2 r0 *1 0,0
R_49_t2 \$49__t2 \$49 100.29899174
* device instance _49 r0 *1 0,0
C_49 \$49 vsubs 5.962076e-15
* device instance _5_t0 r0 *1 0,0
R_5_t0 \$5__t0 \$5 100.29899174
* device instance _5_t1 r0 *1 0,0
R_5_t1 \$5__t1 \$5 21.4987692264
* device instance _5_t2 r0 *1 0,0
R_5_t2 \$5__t2 \$5 81.7777390336
* device instance _5 r0 *1 0,0
C_5 \$5 vsubs 5.962076e-15
* device instance _51_t0 r0 *1 0,0
R_51_t0 \$51__t0 \$51 108.687402234
* device instance _51_t1 r0 *1 0,0
R_51_t1 \$51__t1 \$51 28.7964709909
* device instance _51_t2 r0 *1 0,0
R_51_t2 \$51__t2 \$51 133.512826775
* device instance _51 r0 *1 0,0
C_51 \$51 vsubs 6.492519e-15
* device instance _53_t0 r0 *1 0,0
R_53_t0 \$53__t0 \$53 135.591504929
* device instance _53_t1 r0 *1 0,0
R_53_t1 \$53__t1 \$53 36.2048686624
* device instance _53_t2 r0 *1 0,0
R_53_t2 \$53__t2 \$53 166.824926409
* device instance _53 r0 *1 0,0
C_53 \$53 vsubs 7.022961e-15
* device instance _55_t0 r0 *1 0,0
R_55_t0 \$55__t0 \$55 162.444438203
* device instance _55_t1 r0 *1 0,0
R_55_t1 \$55__t1 \$55 43.7126105743
* device instance _55_t2 r0 *1 0,0
R_55_t2 \$55__t2 \$55 200.179851222
* device instance _55 r0 *1 0,0
C_55 \$55 vsubs 7.553404e-15
* device instance _56_t0 r0 *1 0,0
R_56_t0 \$56__t0 \$56 86.3849133
* device instance _56_t1 r0 *1 0,0
R_56_t1 \$56__t1 \$56 88.7698933301
* device instance _56_t2 r0 *1 0,0
R_56_t2 \$56__t2 \$56 134.098215711
* device instance _56_t3 r0 *1 0,0
R_56_t3 \$56__t3 \$56 124.337752899
* device instance _56_t4 r0 *1 0,0
R_56_t4 \$56__t4 \$56 45.4484549899
* device instance _56_t5 r0 *1 0,0
R_56_t5 \$56__t5 \$56 49.8327480374
* device instance _56_t6 r0 *1 0,0
R_56_t6 \$56__t6 \$56 114.737828634
* device instance _56_t7 r0 *1 0,0
R_56_t7 \$56__t7 \$56 125.248648618
* device instance _56_t8 r0 *1 0,0
R_56_t8 \$56__t8 \$56 87.8405388707
* device instance _56_t9 r0 *1 0,0
R_56_t9 \$56__t9 \$56 89.9037133955
* device instance _56_t10 r0 *1 0,0
R_56_t10 \$56__t10 \$56 91.9815797066
* device instance _56_t11 r0 *1 0,0
R_56_t11 \$56__t11 \$56 94.0731642829
* device instance _56_t12 r0 *1 0,0
R_56_t12 \$56__t12 \$56 73.8330875536
* device instance _56_t13 r0 *1 0,0
R_56_t13 \$56__t13 \$56 75.655267792
* device instance _56_t14 r0 *1 0,0
R_56_t14 \$56__t14 \$56 77.5069685996
* device instance _56_t15 r0 *1 0,0
R_56_t15 \$56__t15 \$56 79.3861242797
* device instance _56 r0 *1 0,0
C_56 \$56 vsubs 1.26906803e-13
* device instance _57_t0 r0 *1 0,0
R_57_t0 \$57__t0 \$57 81.7777390336
* device instance _57_t1 r0 *1 0,0
R_57_t1 \$57__t1 \$57 21.4987692264
* device instance _57_t2 r0 *1 0,0
R_57_t2 \$57__t2 \$57 100.29899174
* device instance _57 r0 *1 0,0
C_57 \$57 vsubs 5.962076e-15
* device instance _59_t0 r0 *1 0,0
R_59_t0 \$59__t0 \$59 108.687402234
* device instance _59_t1 r0 *1 0,0
R_59_t1 \$59__t1 \$59 28.7964709909
* device instance _59_t2 r0 *1 0,0
R_59_t2 \$59__t2 \$59 133.512826775
* device instance _59 r0 *1 0,0
C_59 \$59 vsubs 6.492519e-15
* device instance _61_t0 r0 *1 0,0
R_61_t0 \$61__t0 \$61 135.591504929
* device instance _61_t1 r0 *1 0,0
R_61_t1 \$61__t1 \$61 36.2048686624
* device instance _61_t2 r0 *1 0,0
R_61_t2 \$61__t2 \$61 166.824926409
* device instance _61 r0 *1 0,0
C_61 \$61 vsubs 7.022961e-15
* device instance _63_t0 r0 *1 0,0
R_63_t0 \$63__t0 \$63 162.444438203
* device instance _63_t1 r0 *1 0,0
R_63_t1 \$63__t1 \$63 43.7126105743
* device instance _63_t2 r0 *1 0,0
R_63_t2 \$63__t2 \$63 200.179851222
* device instance _63 r0 *1 0,0
C_63 \$63 vsubs 7.553404e-15
* device instance _64_t0 r0 *1 0,0
R_64_t0 \$64__t0 \$64 146.949644361
* device instance _64_t1 r0 *1 0,0
R_64_t1 \$64__t1 \$64 252.863932211
* device instance _64_t2 r0 *1 0,0
R_64_t2 \$64__t2 \$64 102.380518794
* device instance _64_t3 r0 *1 0,0
R_64_t3 \$64__t3 \$64 240.807918259
* device instance _64_t4 r0 *1 0,0
R_64_t4 \$64__t4 \$64 92.9642864051
* device instance _64_t5 r0 *1 0,0
R_64_t5 \$64__t5 \$64 95.7793979853
* device instance _64_t6 r0 *1 0,0
R_64_t6 \$64__t6 \$64 98.6087679444
* device instance _64_t7 r0 *1 0,0
R_64_t7 \$64__t7 \$64 101.451203335
* device instance _64_t8 r0 *1 0,0
R_64_t8 \$64__t8 \$64 80.6730035165
* device instance _64_t9 r0 *1 0,0
R_64_t9 \$64__t9 \$64 78.0795365719
* device instance _64_t10 r0 *1 0,0
R_64_t10 \$64__t10 \$64 75.5205672098
* device instance _64_t11 r0 *1 0,0
R_64_t11 \$64__t11 \$64 72.9997234076
* device instance _64 r0 *1 0,0
C_64 \$64 vsubs 1.24716345e-13
* device instance _65_t0 r0 *1 0,0
R_65_t0 \$65__t0 \$65 81.7777390336
* device instance _65_t1 r0 *1 0,0
R_65_t1 \$65__t1 \$65 21.4987692264
* device instance _65_t2 r0 *1 0,0
R_65_t2 \$65__t2 \$65 100.29899174
* device instance _65 r0 *1 0,0
C_65 \$65 vsubs 5.962076e-15
* device instance _67_t0 r0 *1 0,0
R_67_t0 \$67__t0 \$67 108.687402234
* device instance _67_t1 r0 *1 0,0
R_67_t1 \$67__t1 \$67 28.7964709909
* device instance _67_t2 r0 *1 0,0
R_67_t2 \$67__t2 \$67 133.512826775
* device instance _67 r0 *1 0,0
C_67 \$67 vsubs 6.492519e-15
* device instance _69_t0 r0 *1 0,0
R_69_t0 \$69__t0 \$69 135.591504929
* device instance _69_t1 r0 *1 0,0
R_69_t1 \$69__t1 \$69 36.2048686624
* device instance _69_t2 r0 *1 0,0
R_69_t2 \$69__t2 \$69 166.824926409
* device instance _69 r0 *1 0,0
C_69 \$69 vsubs 7.022961e-15
* device instance _7_t0 r0 *1 0,0
R_7_t0 \$7__t0 \$7 108.687402234
* device instance _7_t1 r0 *1 0,0
R_7_t1 \$7__t1 \$7 28.7964709909
* device instance _7_t2 r0 *1 0,0
R_7_t2 \$7__t2 \$7 133.512826775
* device instance _7 r0 *1 0,0
C_7 \$7 vsubs 6.492519e-15
* device instance _71_t0 r0 *1 0,0
R_71_t0 \$71__t0 \$71 162.444438203
* device instance _71_t1 r0 *1 0,0
R_71_t1 \$71__t1 \$71 43.7126105743
* device instance _71_t2 r0 *1 0,0
R_71_t2 \$71__t2 \$71 200.179851222
* device instance _71 r0 *1 0,0
C_71 \$71 vsubs 7.553404e-15
* device instance _72_t0 r0 *1 0,0
R_72_t0 \$72__t0 \$72 254.061525599
* device instance _72_t1 r0 *1 0,0
R_72_t1 \$72__t1 \$72 430.2150524
* device instance _72_t2 r0 *1 0,0
R_72_t2 \$72__t2 \$72 89.466427095
* device instance _72_t3 r0 *1 0,0
R_72_t3 \$72__t3 \$72 93.2917599877
* device instance _72_t4 r0 *1 0,0
R_72_t4 \$72__t4 \$72 97.1320607937
* device instance _72_t5 r0 *1 0,0
R_72_t5 \$72__t5 \$72 100.985621919
* device instance _72_t6 r0 *1 0,0
R_72_t6 \$72__t6 \$72 61.8779217555
* device instance _72_t7 r0 *1 0,0
R_72_t7 \$72__t7 \$72 65.2488695775
* device instance _72_t8 r0 *1 0,0
R_72_t8 \$72__t8 \$72 68.6886206694
* device instance _72_t9 r0 *1 0,0
R_72_t9 \$72__t9 \$72 72.187340204
* device instance _72 r0 *1 0,0
C_72 \$72 vsubs 8.8233851e-14
* device instance _73_t0 r0 *1 0,0
R_73_t0 \$73__t0 \$73 81.7777390336
* device instance _73_t1 r0 *1 0,0
R_73_t1 \$73__t1 \$73 21.4987692264
* device instance _73_t2 r0 *1 0,0
R_73_t2 \$73__t2 \$73 100.29899174
* device instance _73 r0 *1 0,0
C_73 \$73 vsubs 5.962076e-15
* device instance _75_t0 r0 *1 0,0
R_75_t0 \$75__t0 \$75 108.687402234
* device instance _75_t1 r0 *1 0,0
R_75_t1 \$75__t1 \$75 28.7964709909
* device instance _75_t2 r0 *1 0,0
R_75_t2 \$75__t2 \$75 133.512826775
* device instance _75 r0 *1 0,0
C_75 \$75 vsubs 6.492519e-15
* device instance _77_t0 r0 *1 0,0
R_77_t0 \$77__t0 \$77 135.591504929
* device instance _77_t1 r0 *1 0,0
R_77_t1 \$77__t1 \$77 36.2048686624
* device instance _77_t2 r0 *1 0,0
R_77_t2 \$77__t2 \$77 166.824926409
* device instance _77 r0 *1 0,0
C_77 \$77 vsubs 7.022961e-15
* device instance _79_t0 r0 *1 0,0
R_79_t0 \$79__t0 \$79 162.444438203
* device instance _79_t1 r0 *1 0,0
R_79_t1 \$79__t1 \$79 43.7126105743
* device instance _79_t2 r0 *1 0,0
R_79_t2 \$79__t2 \$79 200.179851222
* device instance _79 r0 *1 0,0
C_79 \$79 vsubs 7.553404e-15
* device instance _80_t0 r0 *1 0,0
R_80_t0 \$80__t0 \$80 623.00385451
* device instance _80_t1 r0 *1 0,0
R_80_t1 \$80__t1 \$80 95.9998829198
* device instance _80_t2 r0 *1 0,0
R_80_t2 \$80__t2 \$80 103.86395309
* device instance _80_t3 r0 *1 0,0
R_80_t3 \$80__t3 \$80 111.771352504
* device instance _80_t4 r0 *1 0,0
R_80_t4 \$80__t4 \$80 119.71349543
* device instance _80_t5 r0 *1 0,0
R_80_t5 \$80__t5 \$80 63.1623495827
* device instance _80_t6 r0 *1 0,0
R_80_t6 \$80__t6 \$80 57.2067469074
* device instance _80_t7 r0 *1 0,0
R_80_t7 \$80__t7 \$80 51.856654702
* device instance _80_t8 r0 *1 0,0
R_80_t8 \$80__t8 \$80 47.3179103542
* device instance _80 r0 *1 0,0
C_80 \$80 vsubs 6.7094976e-14
* device instance _81_t0 r0 *1 0,0
R_81_t0 \$81__t0 \$81 12.3358471278
* device instance _81_t1 r0 *1 0,0
R_81_t1 \$81__t1 \$81 11.9719163261
* device instance _81_t2 r0 *1 0,0
R_81_t2 \$81__t2 \$81 12.0017182001
* device instance _81_t3 r0 *1 0,0
R_81_t3 \$81__t3 \$81 12.7439906512
* device instance _81_t4 r0 *1 0,0
R_81_t4 \$81__t4 \$81 2.71678527375
* device instance _81_t5 r0 *1 0,0
R_81_t5 \$81__t5 \$81 4.44853839778
* device instance _81_t6 r0 *1 0,0
R_81_t6 \$81__t6 \$81 2.99574500126
* device instance _81_t7 r0 *1 0,0
R_81_t7 \$81__t7 \$81 1.92841914921
* device instance _81_t8 r0 *1 0,0
R_81_t8 \$81__t8 \$81 2.00559985637
* device instance _81_t9 r0 *1 0,0
R_81_t9 \$81__t9 \$81 2.77210255808
* device instance _81_t10 r0 *1 0,0
R_81_t10 \$81__t10 \$81 3.4481551553
* device instance _81_t11 r0 *1 0,0
R_81_t11 \$81__t11 \$81 3.86950428053
* device instance _81_t12 r0 *1 0,0
R_81_t12 \$81__t12 \$81 4.73298524931
* device instance _81_t13 r0 *1 0,0
R_81_t13 \$81__t13 \$81 3.79022461596
* device instance _81_t14 r0 *1 0,0
R_81_t14 \$81__t14 \$81 4.84268682502
* device instance _81_t15 r0 *1 0,0
R_81_t15 \$81__t15 \$81 4.61602055029
* device instance _81_t16 r0 *1 0,0
R_81_t16 \$81__t16 \$81 6.18782920648
* device instance _81_t17 r0 *1 0,0
R_81_t17 \$81__t17 \$81 7.79936746941
* device instance _81_t18 r0 *1 0,0
R_81_t18 \$81__t18 \$81 9.43028915907
* device instance _81_t19 r0 *1 0,0
R_81_t19 \$81__t19 \$81 8.93661557642
* device instance _81_t20 r0 *1 0,0
R_81_t20 \$81__t20 \$81 7.42629093362
* device instance _81_t21 r0 *1 0,0
R_81_t21 \$81__t21 \$81 14.0808541213
* device instance _81_t22 r0 *1 0,0
R_81_t22 \$81__t22 \$81 12.4136835236
* device instance _81_t23 r0 *1 0,0
R_81_t23 \$81__t23 \$81 10.7465316511
* device instance _81_t24 r0 *1 0,0
R_81_t24 \$81__t24 \$81 9.07940881881
* device instance _81_t25 r0 *1 0,0
R_81_t25 \$81__t25 \$81 7.41233462116
* device instance _81_t26 r0 *1 0,0
R_81_t26 \$81__t26 \$81 13.6879110586
* device instance _81_t27 r0 *1 0,0
R_81_t27 \$81__t27 \$81 14.3208704227
* device instance _81_t28 r0 *1 0,0
R_81_t28 \$81__t28 \$81 12.6852834222
* device instance _81_t29 r0 *1 0,0
R_81_t29 \$81__t29 \$81 14.1924348811
* device instance _81_t30 r0 *1 0,0
R_81_t30 \$81__t30 \$81 12.5401074035
* device instance _81_t31 r0 *1 0,0
R_81_t31 \$81__t31 \$81 10.8923228742
* device instance _81_t32 r0 *1 0,0
R_81_t32 \$81__t32 \$81 9.25150904267
* device instance _81_t33 r0 *1 0,0
R_81_t33 \$81__t33 \$81 3.55480096788
* device instance _81_t34 r0 *1 0,0
R_81_t34 \$81__t34 \$81 5.7453513939
* device instance _81_t35 r0 *1 0,0
R_81_t35 \$81__t35 \$81 6.00141133373
* device instance _81_t36 r0 *1 0,0
R_81_t36 \$81__t36 \$81 7.65230949655
* device instance _81_t37 r0 *1 0,0
R_81_t37 \$81__t37 \$81 9.30903117041
* device instance _81_t38 r0 *1 0,0
R_81_t38 \$81__t38 \$81 4.26062092343
* device instance _81_t39 r0 *1 0,0
R_81_t39 \$81__t39 \$81 5.92743411782
* device instance _81_t40 r0 *1 0,0
R_81_t40 \$81__t40 \$81 0.726851095343
* device instance _81_t41 r0 *1 0,0
R_81_t41 \$81__t41 \$81 1.9004215103
* device instance _81_t42 r0 *1 0,0
R_81_t42 \$81__t42 \$81 2.41241228755
* device instance _81_t43 r0 *1 0,0
R_81_t43 \$81__t43 \$81 0.751029525081
* device instance _81_t44 r0 *1 0,0
R_81_t44 \$81__t44 \$81 0.931491125222
* device instance _81_t45 r0 *1 0,0
R_81_t45 \$81__t45 \$81 4.18535561028
* device instance _81_t46 r0 *1 0,0
R_81_t46 \$81__t46 \$81 2.58885994611
* device instance _81_t47 r0 *1 0,0
R_81_t47 \$81__t47 \$81 1.2027086609
* device instance _81_t48 r0 *1 0,0
R_81_t48 \$81__t48 \$81 1.32292799948
* device instance _81_t49 r0 *1 0,0
R_81_t49 \$81__t49 \$81 4.07857068212
* device instance _81_t50 r0 *1 0,0
R_81_t50 \$81__t50 \$81 6.1496013188
* device instance _81_t51 r0 *1 0,0
R_81_t51 \$81__t51 \$81 7.58807221772
* device instance _81_t52 r0 *1 0,0
R_81_t52 \$81__t52 \$81 4.99697583837
* device instance _81_t53 r0 *1 0,0
R_81_t53 \$81__t53 \$81 6.47698634376
* device instance _81_t54 r0 *1 0,0
R_81_t54 \$81__t54 \$81 8.03070698828
* device instance _81_t55 r0 *1 0,0
R_81_t55 \$81__t55 \$81 9.62249839867
* device instance _81_t56 r0 *1 0,0
R_81_t56 \$81__t56 \$81 10.6667371479
* device instance _81_t57 r0 *1 0,0
R_81_t57 \$81__t57 \$81 4.85959574918
* device instance _81_t58 r0 *1 0,0
R_81_t58 \$81__t58 \$81 9.10491085343
* device instance _81_t59 r0 *1 0,0
R_81_t59 \$81__t59 \$81 7.59443071306
* device instance _81_t60 r0 *1 0,0
R_81_t60 \$81__t60 \$81 9.2615116777
* device instance _81_t61 r0 *1 0,0
R_81_t61 \$81__t61 \$81 3.50060128909
* device instance _81_t62 r0 *1 0,0
R_81_t62 \$81__t62 \$81 5.14355275272
* device instance _81_t63 r0 *1 0,0
R_81_t63 \$81__t63 \$81 6.79833645248
* device instance _81_t64 r0 *1 0,0
R_81_t64 \$81__t64 \$81 8.4580104155
* device instance _81_t65 r0 *1 0,0
R_81_t65 \$81__t65 \$81 10.1201689671
* device instance _81_t66 r0 *1 0,0
R_81_t66 \$81__t66 \$81 4.36295237524
* device instance _81_t67 r0 *1 0,0
R_81_t67 \$81__t67 \$81 11.6563401716
* device instance _81_t68 r0 *1 0,0
R_81_t68 \$81__t68 \$81 12.1950028719
* device instance _81_t69 r0 *1 0,0
R_81_t69 \$81__t69 \$81 14.1121548873
* device instance _81_t70 r0 *1 0,0
R_81_t70 \$81__t70 \$81 12.4491767358
* device instance _81_t71 r0 *1 0,0
R_81_t71 \$81__t71 \$81 10.7875115436
* device instance _81_t72 r0 *1 0,0
R_81_t72 \$81__t72 \$81 13.2664029672
* device instance _81_t73 r0 *1 0,0
R_81_t73 \$81__t73 \$81 11.6019908877
* device instance _81_t74 r0 *1 0,0
R_81_t74 \$81__t74 \$81 9.93852380873
* device instance _81_t75 r0 *1 0,0
R_81_t75 \$81__t75 \$81 8.27657154264
* device instance _81_t76 r0 *1 0,0
R_81_t76 \$81__t76 \$81 6.61727553987
* device instance _81_t77 r0 *1 0,0
R_81_t77 \$81__t77 \$81 9.12787638362
* device instance _81_t78 r0 *1 0,0
R_81_t78 \$81__t78 \$81 7.47162414148
* device instance _81_t79 r0 *1 0,0
R_81_t79 \$81__t79 \$81 5.82164284501
* device instance _81_t80 r0 *1 0,0
R_81_t80 \$81__t80 \$81 9.44735631673
* device instance _81_t81 r0 *1 0,0
R_81_t81 \$81__t81 \$81 7.85872644976
* device instance _81_t82 r0 *1 0,0
R_81_t82 \$81__t82 \$81 6.31077962818
* device instance _81_t83 r0 *1 0,0
R_81_t83 \$81__t83 \$81 12.0817074133
* device instance _81_t84 r0 *1 0,0
R_81_t84 \$81__t84 \$81 10.4945565393
* device instance _81_t85 r0 *1 0,0
R_81_t85 \$81__t85 \$81 11.8639881145
* device instance _81_t86 r0 *1 0,0
R_81_t86 \$81__t86 \$81 11.0591509351
* device instance _81_t87 r0 *1 0,0
R_81_t87 \$81__t87 \$81 6.01363598057
* device instance _81_t88 r0 *1 0,0
R_81_t88 \$81__t88 \$81 7.62216895664
* device instance _81_t89 r0 *1 0,0
R_81_t89 \$81__t89 \$81 10.1960030173
* device instance _81_t90 r0 *1 0,0
R_81_t90 \$81__t90 \$81 11.8232996491
* device instance _81_t91 r0 *1 0,0
R_81_t91 \$81__t91 \$81 13.4603740557
* device instance _81_t92 r0 *1 0,0
R_81_t92 \$81__t92 \$81 7.32457595316
* device instance _81_t93 r0 *1 0,0
R_81_t93 \$81__t93 \$81 4.15966399942
* device instance _81_t94 r0 *1 0,0
R_81_t94 \$81__t94 \$81 10.4228274868
* device instance _81_t95 r0 *1 0,0
R_81_t95 \$81__t95 \$81 12.0194538097
* device instance _81_t96 r0 *1 0,0
R_81_t96 \$81__t96 \$81 13.6329939856
* device instance _81_t97 r0 *1 0,0
R_81_t97 \$81__t97 \$81 6.99803955423
* device instance _81_t98 r0 *1 0,0
R_81_t98 \$81__t98 \$81 7.0316563846
* device instance _81_t99 r0 *1 0,0
R_81_t99 \$81__t99 \$81 8.44854031225
* device instance _81_t100 r0 *1 0,0
R_81_t100 \$81__t100 \$81 9.94337937377
* device instance _81_t101 r0 *1 0,0
R_81_t101 \$81__t101 \$81 11.4857769176
* device instance _81_t102 r0 *1 0,0
R_81_t102 \$81__t102 \$81 8.85227167587
* device instance _81_t103 r0 *1 0,0
R_81_t103 \$81__t103 \$81 11.3160360808
* device instance _81_t104 r0 *1 0,0
R_81_t104 \$81__t104 \$81 8.33205786292
* device instance _81_t105 r0 *1 0,0
R_81_t105 \$81__t105 \$81 14.5208037045
* device instance _81_t106 r0 *1 0,0
R_81_t106 \$81__t106 \$81 10.0335164202
* device instance _81_t107 r0 *1 0,0
R_81_t107 \$81__t107 \$81 11.6834664726
* device instance _81_t108 r0 *1 0,0
R_81_t108 \$81__t108 \$81 13.3377150947
* device instance _81_t109 r0 *1 0,0
R_81_t109 \$81__t109 \$81 13.0177757353
* device instance _81_t110 r0 *1 0,0
R_81_t110 \$81__t110 \$81 5.87328102767
* device instance _81_t111 r0 *1 0,0
R_81_t111 \$81__t111 \$81 11.5598679937
* device instance _81_t112 r0 *1 0,0
R_81_t112 \$81__t112 \$81 10.16651017
* device instance _81_t113 r0 *1 0,0
R_81_t113 \$81__t113 \$81 8.86818065367
* device instance _81_t114 r0 *1 0,0
R_81_t114 \$81__t114 \$81 14.1997288829
* device instance _81_t115 r0 *1 0,0
R_81_t115 \$81__t115 \$81 12.6586352037
* device instance _81_t116 r0 *1 0,0
R_81_t116 \$81__t116 \$81 11.1538830977
* device instance _81_t117 r0 *1 0,0
R_81_t117 \$81__t117 \$81 9.70239605257
* device instance _81_t118 r0 *1 0,0
R_81_t118 \$81__t118 \$81 5.46063867502
* device instance _81_t119 r0 *1 0,0
R_81_t119 \$81__t119 \$81 9.89529509059
* device instance _81_t120 r0 *1 0,0
R_81_t120 \$81__t120 \$81 11.198652816
* device instance _81_t121 r0 *1 0,0
R_81_t121 \$81__t121 \$81 12.5881731368
* device instance _81_t122 r0 *1 0,0
R_81_t122 \$81__t122 \$81 14.0382940209
* device instance _81_t123 r0 *1 0,0
R_81_t123 \$81__t123 \$81 15.5320511582
* device instance _81_t124 r0 *1 0,0
R_81_t124 \$81__t124 \$81 4.12300548377
* device instance _81_t125 r0 *1 0,0
R_81_t125 \$81__t125 \$81 4.71750590002
* device instance _81_t126 r0 *1 0,0
R_81_t126 \$81__t126 \$81 5.7506406322
* device instance _81_t127 r0 *1 0,0
R_81_t127 \$81__t127 \$81 5.53373900246
* device instance _81_t128 r0 *1 0,0
R_81_t128 \$81__t128 \$81 6.2824048889
* device instance _81_t129 r0 *1 0,0
R_81_t129 \$81__t129 \$81 7.05016202263
* device instance _81_t130 r0 *1 0,0
R_81_t130 \$81__t130 \$81 10.1099321179
* device instance _81_t131 r0 *1 0,0
R_81_t131 \$81__t131 \$81 8.60874594393
* device instance _81_t132 r0 *1 0,0
R_81_t132 \$81__t132 \$81 7.18119795666
* device instance _81_t133 r0 *1 0,0
R_81_t133 \$81__t133 \$81 5.88115800883
* device instance _81_t134 r0 *1 0,0
R_81_t134 \$81__t134 \$81 4.81308144781
* device instance _81_t135 r0 *1 0,0
R_81_t135 \$81__t135 \$81 13.0588922768
* device instance _81_t136 r0 *1 0,0
R_81_t136 \$81__t136 \$81 7.09007795215
* device instance _81_t137 r0 *1 0,0
R_81_t137 \$81__t137 \$81 7.71301790757
* device instance _81_t138 r0 *1 0,0
R_81_t138 \$81__t138 \$81 14.6528352771
* device instance _81_t139 r0 *1 0,0
R_81_t139 \$81__t139 \$81 7.54325565225
* device instance _81_t140 r0 *1 0,0
R_81_t140 \$81__t140 \$81 8.87887085906
* device instance _81_t141 r0 *1 0,0
R_81_t141 \$81__t141 \$81 10.3115133562
* device instance _81_t142 r0 *1 0,0
R_81_t142 \$81__t142 \$81 11.8059131677
* device instance _81_t143 r0 *1 0,0
R_81_t143 \$81__t143 \$81 13.3413335848
* device instance _81_t144 r0 *1 0,0
R_81_t144 \$81__t144 \$81 14.9051030182
* device instance _81_t145 r0 *1 0,0
R_81_t145 \$81__t145 \$81 8.58404674571
* device instance _81_t146 r0 *1 0,0
R_81_t146 \$81__t146 \$81 8.10845544329
* device instance _81_t147 r0 *1 0,0
R_81_t147 \$81__t147 \$81 9.36379685665
* device instance _81_t148 r0 *1 0,0
R_81_t148 \$81__t148 \$81 10.7318987852
* device instance _81_t149 r0 *1 0,0
R_81_t149 \$81__t149 \$81 12.1748071675
* device instance _81_t150 r0 *1 0,0
R_81_t150 \$81__t150 \$81 13.66885239
* device instance _81_t151 r0 *1 0,0
R_81_t151 \$81__t151 \$81 15.1989618008
* device instance _81_t152 r0 *1 0,0
R_81_t152 \$81__t152 \$81 8.71683560893
* device instance _81_t153 r0 *1 0,0
R_81_t153 \$81__t153 \$81 12.5163996431
* device instance _81_t154 r0 *1 0,0
R_81_t154 \$81__t154 \$81 10.9645365714
* device instance _81_t155 r0 *1 0,0
R_81_t155 \$81__t155 \$81 9.45204647104
* device instance _81_t156 r0 *1 0,0
R_81_t156 \$81__t156 \$81 8.00128869765
* device instance _81_t157 r0 *1 0,0
R_81_t157 \$81__t157 \$81 6.65277214566
* device instance _81_t158 r0 *1 0,0
R_81_t158 \$81__t158 \$81 5.48246766404
* device instance _81_t159 r0 *1 0,0
R_81_t159 \$81__t159 \$81 4.62761755322
* device instance _81_t160 r0 *1 0,0
R_81_t160 \$81__t160 \$81 4.28153650187
* device instance _81_t161 r0 *1 0,0
R_81_t161 \$81__t161 \$81 4.56153301876
* device instance _81_t162 r0 *1 0,0
R_81_t162 \$81__t162 \$81 5.3705614429
* device instance _81_t163 r0 *1 0,0
R_81_t163 \$81__t163 \$81 6.51441440262
* device instance _81_t164 r0 *1 0,0
R_81_t164 \$81__t164 \$81 7.8480301906
* device instance _81_t165 r0 *1 0,0
R_81_t165 \$81__t165 \$81 9.29004191608
* device instance _81_t166 r0 *1 0,0
R_81_t166 \$81__t166 \$81 10.7971059918
* device instance _81_t167 r0 *1 0,0
R_81_t167 \$81__t167 \$81 12.3454216154
* device instance _81_t168 r0 *1 0,0
R_81_t168 \$81__t168 \$81 13.9212316262
* device instance _81_t169 r0 *1 0,0
R_81_t169 \$81__t169 \$81 6.86370904983
* device instance _81_t170 r0 *1 0,0
R_81_t170 \$81__t170 \$81 7.83022524935
* device instance _81_t171 r0 *1 0,0
R_81_t171 \$81__t171 \$81 9.00409190628
* device instance _81_t172 r0 *1 0,0
R_81_t172 \$81__t172 \$81 10.3147580061
* device instance _81_t173 r0 *1 0,0
R_81_t173 \$81__t173 \$81 11.7164035633
* device instance _81_t174 r0 *1 0,0
R_81_t174 \$81__t174 \$81 6.77465721977
* device instance _81_t175 r0 *1 0,0
R_81_t175 \$81__t175 \$81 6.15309952095
* device instance _81_t176 r0 *1 0,0
R_81_t176 \$81__t176 \$81 5.94849603264
* device instance _81_t177 r0 *1 0,0
R_81_t177 \$81__t177 \$81 6.0559508395
* device instance _81_t178 r0 *1 0,0
R_81_t178 \$81__t178 \$81 5.35155994451
* device instance _81_t179 r0 *1 0,0
R_81_t179 \$81__t179 \$81 5.11499415203
* device instance _81_t180 r0 *1 0,0
R_81_t180 \$81__t180 \$81 5.40799912882
* device instance _81_t181 r0 *1 0,0
R_81_t181 \$81__t181 \$81 6.15540916964
* device instance _81_t182 r0 *1 0,0
R_81_t182 \$81__t182 \$81 7.21740864719
* device instance _81_t183 r0 *1 0,0
R_81_t183 \$81__t183 \$81 8.4765695409
* device instance _81_t184 r0 *1 0,0
R_81_t184 \$81__t184 \$81 9.85762612647
* device instance _81_t185 r0 *1 0,0
R_81_t185 \$81__t185 \$81 5.99965117047
* device instance _81_t186 r0 *1 0,0
R_81_t186 \$81__t186 \$81 4.96330058601
* device instance _81_t187 r0 *1 0,0
R_81_t187 \$81__t187 \$81 10.2134722881
* device instance _81_t188 r0 *1 0,0
R_81_t188 \$81__t188 \$81 8.5694303455
* device instance _81_t189 r0 *1 0,0
R_81_t189 \$81__t189 \$81 6.93646702428
* device instance _81_t190 r0 *1 0,0
R_81_t190 \$81__t190 \$81 5.32478461327
* device instance _81_t191 r0 *1 0,0
R_81_t191 \$81__t191 \$81 3.76183540881
* device instance _81_t192 r0 *1 0,0
R_81_t192 \$81__t192 \$81 2.34708290747
* device instance _81_t193 r0 *1 0,0
R_81_t193 \$81__t193 \$81 1.55740449869
* device instance _81_t194 r0 *1 0,0
R_81_t194 \$81__t194 \$81 2.21394160648
* device instance _81_t195 r0 *1 0,0
R_81_t195 \$81__t195 \$81 3.59678803485
* device instance _81_t196 r0 *1 0,0
R_81_t196 \$81__t196 \$81 5.15087846535
* device instance _81_t197 r0 *1 0,0
R_81_t197 \$81__t197 \$81 6.75910732481
* device instance _81_t198 r0 *1 0,0
R_81_t198 \$81__t198 \$81 8.39040122748
* device instance _81_t199 r0 *1 0,0
R_81_t199 \$81__t199 \$81 6.20224914465
* device instance _81_t200 r0 *1 0,0
R_81_t200 \$81__t200 \$81 3.3226025808
* device instance _81_t201 r0 *1 0,0
R_81_t201 \$81__t201 \$81 4.70268930594
* device instance _81_t202 r0 *1 0,0
R_81_t202 \$81__t202 \$81 12.2563648438
* device instance _81_t203 r0 *1 0,0
R_81_t203 \$81__t203 \$81 11.2361921575
* device instance _81_t204 r0 *1 0,0
R_81_t204 \$81__t204 \$81 11.0720319901
* device instance _81_t205 r0 *1 0,0
R_81_t205 \$81__t205 \$81 4.17593479562
* device instance _81_t206 r0 *1 0,0
R_81_t206 \$81__t206 \$81 5.62497617347
* device instance _81_t207 r0 *1 0,0
R_81_t207 \$81__t207 \$81 10.5961737078
* device instance _81_t208 r0 *1 0,0
R_81_t208 \$81__t208 \$81 9.02214040634
* device instance _81_t209 r0 *1 0,0
R_81_t209 \$81__t209 \$81 3.6705148467
* device instance _81_t210 r0 *1 0,0
R_81_t210 \$81__t210 \$81 3.22325764372
* device instance _81_t211 r0 *1 0,0
R_81_t211 \$81__t211 \$81 3.58683962593
* device instance _81_t212 r0 *1 0,0
R_81_t212 \$81__t212 \$81 1.73330354502
* device instance _81_t213 r0 *1 0,0
R_81_t213 \$81__t213 \$81 2.86156656593
* device instance _81_t214 r0 *1 0,0
R_81_t214 \$81__t214 \$81 4.02789150077
* device instance _81_t215 r0 *1 0,0
R_81_t215 \$81__t215 \$81 4.57173547276
* device instance _81_t216 r0 *1 0,0
R_81_t216 \$81__t216 \$81 2.96577543804
* device instance _81_t217 r0 *1 0,0
R_81_t217 \$81__t217 \$81 3.68069300916
* device instance _81_t218 r0 *1 0,0
R_81_t218 \$81__t218 \$81 3.14410229145
* device instance _81_t219 r0 *1 0,0
R_81_t219 \$81__t219 \$81 2.75918229318
* device instance _81_t220 r0 *1 0,0
R_81_t220 \$81__t220 \$81 2.5943446478
* device instance _81_t221 r0 *1 0,0
R_81_t221 \$81__t221 \$81 2.39009090766
* device instance _81_t222 r0 *1 0,0
R_81_t222 \$81__t222 \$81 11.7837607631
* device instance _81_t223 r0 *1 0,0
R_81_t223 \$81__t223 \$81 10.9286384021
* device instance _81_t224 r0 *1 0,0
R_81_t224 \$81__t224 \$81 10.9689379659
* device instance _81_t225 r0 *1 0,0
R_81_t225 \$81__t225 \$81 9.50859426477
* device instance _81_t226 r0 *1 0,0
R_81_t226 \$81__t226 \$81 8.23847451035
* device instance _81_t227 r0 *1 0,0
R_81_t227 \$81__t227 \$81 7.13378424748
* device instance _81_t228 r0 *1 0,0
R_81_t228 \$81__t228 \$81 10.4722128393
* device instance _81_t229 r0 *1 0,0
R_81_t229 \$81__t229 \$81 9.03144623254
* device instance _81_t230 r0 *1 0,0
R_81_t230 \$81__t230 \$81 7.68284572388
* device instance _81_t231 r0 *1 0,0
R_81_t231 \$81__t231 \$81 6.48417564914
* device instance _81_t232 r0 *1 0,0
R_81_t232 \$81__t232 \$81 11.346795096
* device instance _81_t233 r0 *1 0,0
R_81_t233 \$81__t233 \$81 10.3731404095
* device instance _81_t234 r0 *1 0,0
R_81_t234 \$81__t234 \$81 8.75911880389
* device instance _81_t235 r0 *1 0,0
R_81_t235 \$81__t235 \$81 7.16949095496
* device instance _81_t236 r0 *1 0,0
R_81_t236 \$81__t236 \$81 7.02657283784
* device instance _81_t237 r0 *1 0,0
R_81_t237 \$81__t237 \$81 6.62131679579
* device instance _81_t238 r0 *1 0,0
R_81_t238 \$81__t238 \$81 6.59834871323
* device instance _81_t239 r0 *1 0,0
R_81_t239 \$81__t239 \$81 6.98526258912
* device instance _81_t240 r0 *1 0,0
R_81_t240 \$81__t240 \$81 7.72067997024
* device instance _81_t241 r0 *1 0,0
R_81_t241 \$81__t241 \$81 4.94526930948
* device instance _81_t242 r0 *1 0,0
R_81_t242 \$81__t242 \$81 5.4508142732
* device instance _81_t243 r0 *1 0,0
R_81_t243 \$81__t243 \$81 10.8863945176
* device instance _81_t244 r0 *1 0,0
R_81_t244 \$81__t244 \$81 6.36603345929
* device instance _81_t245 r0 *1 0,0
R_81_t245 \$81__t245 \$81 4.9758736833
* device instance _81_t246 r0 *1 0,0
R_81_t246 \$81__t246 \$81 5.79703913674
* device instance _81_t247 r0 *1 0,0
R_81_t247 \$81__t247 \$81 5.77079131351
* device instance _81_t248 r0 *1 0,0
R_81_t248 \$81__t248 \$81 10.0324243456
* device instance _81_t249 r0 *1 0,0
R_81_t249 \$81__t249 \$81 8.83790900694
* device instance _81_t250 r0 *1 0,0
R_81_t250 \$81__t250 \$81 7.81837905496
* device instance _81_t251 r0 *1 0,0
R_81_t251 \$81__t251 \$81 12.825438409
* device instance _81_t252 r0 *1 0,0
R_81_t252 \$81__t252 \$81 13.1800345318
* device instance _81_t253 r0 *1 0,0
R_81_t253 \$81__t253 \$81 7.48855499039
* device instance _81_t254 r0 *1 0,0
R_81_t254 \$81__t254 \$81 6.02637637747
* device instance _81_t255 r0 *1 0,0
R_81_t255 \$81__t255 \$81 6.20948629772
* device instance _81_t256 r0 *1 0,0
R_81_t256 \$81__t256 \$81 37.292404809
* device instance _81_t257 r0 *1 0,0
R_81_t257 \$81__t257 \$81 36.9295444756
* device instance _81_t258 r0 *1 0,0
R_81_t258 \$81__t258 \$81 36.566931706
* device instance _81_t259 r0 *1 0,0
R_81_t259 \$81__t259 \$81 36.2045739387
* device instance _81_t260 r0 *1 0,0
R_81_t260 \$81__t260 \$81 39.7834005291
* device instance _81_t261 r0 *1 0,0
R_81_t261 \$81__t261 \$81 40.5096975078
* device instance _81_t262 r0 *1 0,0
R_81_t262 \$81__t262 \$81 39.4205885435
* device instance _81_t263 r0 *1 0,0
R_81_t263 \$81__t263 \$81 40.1464388791
* device instance _81 r0 *1 0,0
C_81 \$81 vsubs 5.73982947e-13
* device instance _83_t0 r0 *1 0,0
R_83_t0 \$83__t0 \$83 17.1609607957
* device instance _83_t1 r0 *1 0,0
R_83_t1 \$83__t1 \$83 14.8504690887
* device instance _83_t2 r0 *1 0,0
R_83_t2 \$83__t2 \$83 5.96038696917
* device instance _83_t3 r0 *1 0,0
R_83_t3 \$83__t3 \$83 3.85461658926
* device instance _83_t4 r0 *1 0,0
R_83_t4 \$83__t4 \$83 2.28028786581
* device instance _83_t5 r0 *1 0,0
R_83_t5 \$83__t5 \$83 2.55952025284
* device instance _83_t6 r0 *1 0,0
R_83_t6 \$83__t6 \$83 3.39213210481
* device instance _83_t7 r0 *1 0,0
R_83_t7 \$83__t7 \$83 3.58580414834
* device instance _83_t8 r0 *1 0,0
R_83_t8 \$83__t8 \$83 4.45705583351
* device instance _83_t9 r0 *1 0,0
R_83_t9 \$83__t9 \$83 6.25955743654
* device instance _83_t10 r0 *1 0,0
R_83_t10 \$83__t10 \$83 4.90089882223
* device instance _83_t11 r0 *1 0,0
R_83_t11 \$83__t11 \$83 4.34883462221
* device instance _83_t12 r0 *1 0,0
R_83_t12 \$83__t12 \$83 6.50256631576
* device instance _83_t13 r0 *1 0,0
R_83_t13 \$83__t13 \$83 8.75580734618
* device instance _83_t14 r0 *1 0,0
R_83_t14 \$83__t14 \$83 10.6465661685
* device instance _83_t15 r0 *1 0,0
R_83_t15 \$83__t15 \$83 11.0478388542
* device instance _83_t16 r0 *1 0,0
R_83_t16 \$83__t16 \$83 13.3587092149
* device instance _83_t17 r0 *1 0,0
R_83_t17 \$83__t17 \$83 8.08424992253
* device instance _83_t18 r0 *1 0,0
R_83_t18 \$83__t18 \$83 12.2772364254
* device instance _83_t19 r0 *1 0,0
R_83_t19 \$83__t19 \$83 10.1261010163
* device instance _83_t20 r0 *1 0,0
R_83_t20 \$83__t20 \$83 21.2978604276
* device instance _83_t21 r0 *1 0,0
R_83_t21 \$83__t21 \$83 4.60053437284
* device instance _83_t22 r0 *1 0,0
R_83_t22 \$83__t22 \$83 19.0096579782
* device instance _83_t23 r0 *1 0,0
R_83_t23 \$83__t23 \$83 19.9260497804
* device instance _83_t24 r0 *1 0,0
R_83_t24 \$83__t24 \$83 19.7671599474
* device instance _83_t25 r0 *1 0,0
R_83_t25 \$83__t25 \$83 17.4359898995
* device instance _83_t26 r0 *1 0,0
R_83_t26 \$83__t26 \$83 15.1094891588
* device instance _83_t27 r0 *1 0,0
R_83_t27 \$83__t27 \$83 12.7902059786
* device instance _83_t28 r0 *1 0,0
R_83_t28 \$83__t28 \$83 6.4678481961
* device instance _83_t29 r0 *1 0,0
R_83_t29 \$83__t29 \$83 12.815804539
* device instance _83_t30 r0 *1 0,0
R_83_t30 \$83__t30 \$83 5.02187316017
* device instance _83_t31 r0 *1 0,0
R_83_t31 \$83__t31 \$83 6.97066827187
* device instance _83_t32 r0 *1 0,0
R_83_t32 \$83__t32 \$83 9.10884239346
* device instance _83_t33 r0 *1 0,0
R_83_t33 \$83__t33 \$83 11.3296774365
* device instance _83_t34 r0 *1 0,0
R_83_t34 \$83__t34 \$83 13.5927171438
* device instance _83_t35 r0 *1 0,0
R_83_t35 \$83__t35 \$83 8.57109583731
* device instance _83_t36 r0 *1 0,0
R_83_t36 \$83__t36 \$83 6.67740847906
* device instance _83_t37 r0 *1 0,0
R_83_t37 \$83__t37 \$83 14.4890625705
* device instance _83_t38 r0 *1 0,0
R_83_t38 \$83__t38 \$83 15.1902687895
* device instance _83_t39 r0 *1 0,0
R_83_t39 \$83__t39 \$83 16.696881384
* device instance _83_t40 r0 *1 0,0
R_83_t40 \$83__t40 \$83 15.316772183
* device instance _83_t41 r0 *1 0,0
R_83_t41 \$83__t41 \$83 13.034424285
* device instance _83_t42 r0 *1 0,0
R_83_t42 \$83__t42 \$83 10.7795505588
* device instance _83_t43 r0 *1 0,0
R_83_t43 \$83__t43 \$83 16.7375363054
* device instance _83_t44 r0 *1 0,0
R_83_t44 \$83__t44 \$83 17.6159186886
* device instance _83_t45 r0 *1 0,0
R_83_t45 \$83__t45 \$83 10.4829319747
* device instance _83_t46 r0 *1 0,0
R_83_t46 \$83__t46 \$83 10.0062342627
* device instance _83_t47 r0 *1 0,0
R_83_t47 \$83__t47 \$83 10.7627808488
* device instance _83_t48 r0 *1 0,0
R_83_t48 \$83__t48 \$83 16.5689904783
* device instance _83_t49 r0 *1 0,0
R_83_t49 \$83__t49 \$83 18.8614267844
* device instance _83_t50 r0 *1 0,0
R_83_t50 \$83__t50 \$83 21.1656604596
* device instance _83_t51 r0 *1 0,0
R_83_t51 \$83__t51 \$83 9.84501120812
* device instance _83_t52 r0 *1 0,0
R_83_t52 \$83__t52 \$83 10.3504627641
* device instance _83_t53 r0 *1 0,0
R_83_t53 \$83__t53 \$83 12.4629327161
* device instance _83_t54 r0 *1 0,0
R_83_t54 \$83__t54 \$83 14.6467433859
* device instance _83_t55 r0 *1 0,0
R_83_t55 \$83__t55 \$83 16.8742193661
* device instance _83_t56 r0 *1 0,0
R_83_t56 \$83__t56 \$83 19.1301138022
* device instance _83_t57 r0 *1 0,0
R_83_t57 \$83__t57 \$83 21.4054436168
* device instance _83_t58 r0 *1 0,0
R_83_t58 \$83__t58 \$83 11.950416011
* device instance _83_t59 r0 *1 0,0
R_83_t59 \$83__t59 \$83 14.0182006345
* device instance _83_t60 r0 *1 0,0
R_83_t60 \$83__t60 \$83 16.1622165154
* device instance _83_t61 r0 *1 0,0
R_83_t61 \$83__t61 \$83 6.17416332815
* device instance _83_t62 r0 *1 0,0
R_83_t62 \$83__t62 \$83 6.91221014596
* device instance _83_t63 r0 *1 0,0
R_83_t63 \$83__t63 \$83 8.27325769416
* device instance _83_t64 r0 *1 0,0
R_83_t64 \$83__t64 \$83 18.355770859
* device instance _83_t65 r0 *1 0,0
R_83_t65 \$83__t65 \$83 5.59605479365
* device instance _83_t66 r0 *1 0,0
R_83_t66 \$83__t66 \$83 14.5387651449
* device instance _83_t67 r0 *1 0,0
R_83_t67 \$83__t67 \$83 12.4489085225
* device instance _83_t68 r0 *1 0,0
R_83_t68 \$83__t68 \$83 10.4682731305
* device instance _83_t69 r0 *1 0,0
R_83_t69 \$83__t69 \$83 8.67202102988
* device instance _83_t70 r0 *1 0,0
R_83_t70 \$83__t70 \$83 7.1995098877
* device instance _83_t71 r0 *1 0,0
R_83_t71 \$83__t71 \$83 6.28265262261
* device instance _83_t72 r0 *1 0,0
R_83_t72 \$83__t72 \$83 4.59434386063
* device instance _83_t73 r0 *1 0,0
R_83_t73 \$83__t73 \$83 20.5830316629
* device instance _83_t74 r0 *1 0,0
R_83_t74 \$83__t74 \$83 12.0464458718
* device instance _83_t75 r0 *1 0,0
R_83_t75 \$83__t75 \$83 12.5906779133
* device instance _83_t76 r0 *1 0,0
R_83_t76 \$83__t76 \$83 14.5678645143
* device instance _83_t77 r0 *1 0,0
R_83_t77 \$83__t77 \$83 16.6412130018
* device instance _83_t78 r0 *1 0,0
R_83_t78 \$83__t78 \$83 18.7788990974
* device instance _83_t79 r0 *1 0,0
R_83_t79 \$83__t79 \$83 14.2940287557
* device instance _83_t80 r0 *1 0,0
R_83_t80 \$83__t80 \$83 20.9612480525
* device instance _83_t81 r0 *1 0,0
R_83_t81 \$83__t81 \$83 15.4260121049
* device instance _83_t82 r0 *1 0,0
R_83_t82 \$83__t82 \$83 13.2686316998
* device instance _83_t83 r0 *1 0,0
R_83_t83 \$83__t83 \$83 11.1875427321
* device instance _83_t84 r0 *1 0,0
R_83_t84 \$83__t84 \$83 9.23446939755
* device instance _83_t85 r0 *1 0,0
R_83_t85 \$83__t85 \$83 7.50996173081
* device instance _83_t86 r0 *1 0,0
R_83_t86 \$83__t86 \$83 6.20752872045
* device instance _83_t87 r0 *1 0,0
R_83_t87 \$83__t87 \$83 5.62824021387
* device instance _83_t88 r0 *1 0,0
R_83_t88 \$83__t88 \$83 7.14099436377
* device instance _83_t89 r0 *1 0,0
R_83_t89 \$83__t89 \$83 8.78446572149
* device instance _83_t90 r0 *1 0,0
R_83_t90 \$83__t90 \$83 10.6934401852
* device instance _83_t91 r0 *1 0,0
R_83_t91 \$83__t91 \$83 12.7492068556
* device instance _83_t92 r0 *1 0,0
R_83_t92 \$83__t92 \$83 14.8910938274
* device instance _83_t93 r0 *1 0,0
R_83_t93 \$83__t93 \$83 17.0867452365
* device instance _83_t94 r0 *1 0,0
R_83_t94 \$83__t94 \$83 19.3178372922
* device instance _83_t95 r0 *1 0,0
R_83_t95 \$83__t95 \$83 5.98586255002
* device instance _83_t96 r0 *1 0,0
R_83_t96 \$83__t96 \$83 21.5733771115
* device instance _83_t97 r0 *1 0,0
R_83_t97 \$83__t97 \$83 8.57385511499
* device instance _83_t98 r0 *1 0,0
R_83_t98 \$83__t98 \$83 8.1978133711
* device instance _83_t99 r0 *1 0,0
R_83_t99 \$83__t99 \$83 15.038288076
* device instance _83_t100 r0 *1 0,0
R_83_t100 \$83__t100 \$83 15.6800914506
* device instance _83_t101 r0 *1 0,0
R_83_t101 \$83__t101 \$83 6.24292462655
* device instance _83_t102 r0 *1 0,0
R_83_t102 \$83__t102 \$83 12.9938063562
* device instance _83_t103 r0 *1 0,0
R_83_t103 \$83__t103 \$83 10.8601808835
* device instance _83_t104 r0 *1 0,0
R_83_t104 \$83__t104 \$83 4.94565509749
* device instance _83_t105 r0 *1 0,0
R_83_t105 \$83__t105 \$83 5.34910898245
* device instance _83_t106 r0 *1 0,0
R_83_t106 \$83__t106 \$83 6.61635979537
* device instance _83_t107 r0 *1 0,0
R_83_t107 \$83__t107 \$83 4.29012041349
* device instance _83_t108 r0 *1 0,0
R_83_t108 \$83__t108 \$83 5.79382284834
* device instance _83_t109 r0 *1 0,0
R_83_t109 \$83__t109 \$83 7.72925744858
* device instance _83_t110 r0 *1 0,0
R_83_t110 \$83__t110 \$83 8.36356708889
* device instance _83_t111 r0 *1 0,0
R_83_t111 \$83__t111 \$83 3.77513848746
* device instance _83_t112 r0 *1 0,0
R_83_t112 \$83__t112 \$83 5.16930088244
* device instance _83_t113 r0 *1 0,0
R_83_t113 \$83__t113 \$83 15.8799280654
* device instance _83_t114 r0 *1 0,0
R_83_t114 \$83__t114 \$83 13.0647637132
* device instance _83_t115 r0 *1 0,0
R_83_t115 \$83__t115 \$83 11.1936352368
* device instance _83_t116 r0 *1 0,0
R_83_t116 \$83__t116 \$83 9.53502366137
* device instance _83_t117 r0 *1 0,0
R_83_t117 \$83__t117 \$83 8.21861728659
* device instance _83_t118 r0 *1 0,0
R_83_t118 \$83__t118 \$83 12.5948866561
* device instance _83_t119 r0 *1 0,0
R_83_t119 \$83__t119 \$83 10.3795806793
* device instance _83_t120 r0 *1 0,0
R_83_t120 \$83__t120 \$83 8.23711161444
* device instance _83_t121 r0 *1 0,0
R_83_t121 \$83__t121 \$83 15.0694531891
* device instance _83_t122 r0 *1 0,0
R_83_t122 \$83__t122 \$83 7.337098901
* device instance _83_t123 r0 *1 0,0
R_83_t123 \$83__t123 \$83 7.96814762553
* device instance _83_t124 r0 *1 0,0
R_83_t124 \$83__t124 \$83 7.42862379292
* device instance _83_t125 r0 *1 0,0
R_83_t125 \$83__t125 \$83 9.17384981097
* device instance _83_t126 r0 *1 0,0
R_83_t126 \$83__t126 \$83 8.83503488916
* device instance _83_t127 r0 *1 0,0
R_83_t127 \$83__t127 \$83 7.01298378985
* device instance _83_t128 r0 *1 0,0
R_83_t128 \$83__t128 \$83 42.8586309091
* device instance _83_t129 r0 *1 0,0
R_83_t129 \$83__t129 \$83 42.3552788565
* device instance _83_t130 r0 *1 0,0
R_83_t130 \$83__t130 \$83 41.8525318363
* device instance _83_t131 r0 *1 0,0
R_83_t131 \$83__t131 \$83 41.3504119169
* device instance _83_t132 r0 *1 0,0
R_83_t132 \$83__t132 \$83 45.857865185
* device instance _83_t133 r0 *1 0,0
R_83_t133 \$83__t133 \$83 46.3617189688
* device instance _83_t134 r0 *1 0,0
R_83_t134 \$83__t134 \$83 46.8661022771
* device instance _83_t135 r0 *1 0,0
R_83_t135 \$83__t135 \$83 47.3709981955
* device instance _83 r0 *1 0,0
C_83 \$83 vsubs 3.13607775e-13
* device instance _84_t0 r0 *1 0,0
R_84_t0 \$84__t0 \$84 0.310015967392
* device instance _84_t1 r0 *1 0,0
R_84_t1 \$84__t1 \$84 24.6276605345
* device instance _84_t2 r0 *1 0,0
R_84_t2 \$84__t2 \$84 10.4045026778
* device instance _84_t3 r0 *1 0,0
R_84_t3 \$84__t3 \$84 13.8235382067
* device instance _84_t4 r0 *1 0,0
R_84_t4 \$84__t4 \$84 17.242933231
* device instance _84_t5 r0 *1 0,0
R_84_t5 \$84__t5 \$84 10.1225782947
* device instance _84_t6 r0 *1 0,0
R_84_t6 \$84__t6 \$84 6.70455757253
* device instance _84_t7 r0 *1 0,0
R_84_t7 \$84__t7 \$84 3.29053163373
* device instance _84_t8 r0 *1 0,0
R_84_t8 \$84__t8 \$84 6.98635446205
* device instance _84_t9 r0 *1 0,0
R_84_t9 \$84__t9 \$84 3.57164200973
* device instance _84_t10 r0 *1 0,0
R_84_t10 \$84__t10 \$84 30.639707843
* device instance _84_t11 r0 *1 0,0
R_84_t11 \$84__t11 \$84 27.2199222253
* device instance _84_t12 r0 *1 0,0
R_84_t12 \$84__t12 \$84 23.8001815218
* device instance _84_t13 r0 *1 0,0
R_84_t13 \$84__t13 \$84 20.3805083417
* device instance _84_t14 r0 *1 0,0
R_84_t14 \$84__t14 \$84 16.9609435275
* device instance _84_t15 r0 *1 0,0
R_84_t15 \$84__t15 \$84 19.5624231019
* device instance _84_t16 r0 *1 0,0
R_84_t16 \$84__t16 \$84 19.0514164711
* device instance _84_t17 r0 *1 0,0
R_84_t17 \$84__t17 \$84 17.6187658219
* device instance _84_t18 r0 *1 0,0
R_84_t18 \$84__t18 \$84 25.9662431408
* device instance _84_t19 r0 *1 0,0
R_84_t19 \$84__t19 \$84 29.3328708272
* device instance _84_t20 r0 *1 0,0
R_84_t20 \$84__t20 \$84 32.7105616638
* device instance _84_t21 r0 *1 0,0
R_84_t21 \$84__t21 \$84 33.5308592686
* device instance _84_t22 r0 *1 0,0
R_84_t22 \$84__t22 \$84 30.2449167612
* device instance _84_t23 r0 *1 0,0
R_84_t23 \$84__t23 \$84 26.992285227
* device instance _84_t24 r0 *1 0,0
R_84_t24 \$84__t24 \$84 23.7866336192
* device instance _84_t25 r0 *1 0,0
R_84_t25 \$84__t25 \$84 20.6498528172
* device instance _84_t26 r0 *1 0,0
R_84_t26 \$84__t26 \$84 21.6161046259
* device instance _84_t27 r0 *1 0,0
R_84_t27 \$84__t27 \$84 24.391545546
* device instance _84_t28 r0 *1 0,0
R_84_t28 \$84__t28 \$84 27.3135683191
* device instance _84_t29 r0 *1 0,0
R_84_t29 \$84__t29 \$84 30.3398506885
* device instance _84_t30 r0 *1 0,0
R_84_t30 \$84__t30 \$84 33.4421002714
* device instance _84_t31 r0 *1 0,0
R_84_t31 \$84__t31 \$84 17.863413337
* device instance _84_t32 r0 *1 0,0
R_84_t32 \$84__t32 \$84 12.1904019767
* device instance _84_t33 r0 *1 0,0
R_84_t33 \$84__t33 \$84 10.1383629795
* device instance _84_t34 r0 *1 0,0
R_84_t34 \$84__t34 \$84 8.96431328841
* device instance _84_t35 r0 *1 0,0
R_84_t35 \$84__t35 \$84 9.01795025708
* device instance _84_t36 r0 *1 0,0
R_84_t36 \$84__t36 \$84 10.2800752052
* device instance _84_t37 r0 *1 0,0
R_84_t37 \$84__t37 \$84 12.3866246769
* device instance _84_t38 r0 *1 0,0
R_84_t38 \$84__t38 \$84 14.9856264743
* device instance _84_t39 r0 *1 0,0
R_84_t39 \$84__t39 \$84 14.7586382191
* device instance _84_t40 r0 *1 0,0
R_84_t40 \$84__t40 \$84 13.5415691742
* device instance _84_t41 r0 *1 0,0
R_84_t41 \$84__t41 \$84 16.2715659087
* device instance _84_t42 r0 *1 0,0
R_84_t42 \$84__t42 \$84 13.0472725847
* device instance _84_t43 r0 *1 0,0
R_84_t43 \$84__t43 \$84 9.95443579312
* device instance _84_t44 r0 *1 0,0
R_84_t44 \$84__t44 \$84 7.16535186132
* device instance _84_t45 r0 *1 0,0
R_84_t45 \$84__t45 \$84 5.10110123457
* device instance _84_t46 r0 *1 0,0
R_84_t46 \$84__t46 \$84 6.96051183297
* device instance _84_t47 r0 *1 0,0
R_84_t47 \$84__t47 \$84 9.70918232534
* device instance _84_t48 r0 *1 0,0
R_84_t48 \$84__t48 \$84 12.7859189406
* device instance _84_t49 r0 *1 0,0
R_84_t49 \$84__t49 \$84 16.0026007312
* device instance _84_t50 r0 *1 0,0
R_84_t50 \$84__t50 \$84 19.2893427168
* device instance _84_t51 r0 *1 0,0
R_84_t51 \$84__t51 \$84 22.6156198236
* device instance _84_t52 r0 *1 0,0
R_84_t52 \$84__t52 \$84 5.19478083386
* device instance _84_t53 r0 *1 0,0
R_84_t53 \$84__t53 \$84 20.6625092752
* device instance _84_t54 r0 *1 0,0
R_84_t54 \$84__t54 \$84 19.2528590709
* device instance _84_t55 r0 *1 0,0
R_84_t55 \$84__t55 \$84 16.9657316325
* device instance _84_t56 r0 *1 0,0
R_84_t56 \$84__t56 \$84 15.1126279159
* device instance _84_t57 r0 *1 0,0
R_84_t57 \$84__t57 \$84 13.8686336926
* device instance _84_t58 r0 *1 0,0
R_84_t58 \$84__t58 \$84 16.7943134777
* device instance _84_t59 r0 *1 0,0
R_84_t59 \$84__t59 \$84 13.4044203065
* device instance _84_t60 r0 *1 0,0
R_84_t60 \$84__t60 \$84 13.7989119965
* device instance _84_t61 r0 *1 0,0
R_84_t61 \$84__t61 \$84 14.9844408003
* device instance _84_t62 r0 *1 0,0
R_84_t62 \$84__t62 \$84 21.8380658545
* device instance _84_t63 r0 *1 0,0
R_84_t63 \$84__t63 \$84 20.9051686562
* device instance _84_t64 r0 *1 0,0
R_84_t64 \$84__t64 \$84 45.8884686221
* device instance _84_t65 r0 *1 0,0
R_84_t65 \$84__t65 \$84 46.5997483009
* device instance _84_t66 r0 *1 0,0
R_84_t66 \$84__t66 \$84 47.3128497471
* device instance _84_t67 r0 *1 0,0
R_84_t67 \$84__t67 \$84 48.0276918136
* device instance _84_t68 r0 *1 0,0
R_84_t68 \$84__t68 \$84 53.1088436745
* device instance _84_t69 r0 *1 0,0
R_84_t69 \$84__t69 \$84 52.3908897016
* device instance _84_t70 r0 *1 0,0
R_84_t70 \$84__t70 \$84 53.8282216818
* device instance _84_t71 r0 *1 0,0
R_84_t71 \$84__t71 \$84 54.5489673842
* device instance _84 r0 *1 0,0
C_84 \$84 vsubs 1.77182155e-13
* device instance _85_t0 r0 *1 0,0
R_85_t0 \$85__t0 \$85 40.6643409023
* device instance _85_t1 r0 *1 0,0
R_85_t1 \$85__t1 \$85 5.79415215427
* device instance _85_t2 r0 *1 0,0
R_85_t2 \$85__t2 \$85 9.51566602732
* device instance _85_t3 r0 *1 0,0
R_85_t3 \$85__t3 \$85 14.4470006713
* device instance _85_t4 r0 *1 0,0
R_85_t4 \$85__t4 \$85 10.158616085
* device instance _85_t5 r0 *1 0,0
R_85_t5 \$85__t5 \$85 6.14725354337
* device instance _85_t6 r0 *1 0,0
R_85_t6 \$85__t6 \$85 23.9017597558
* device instance _85_t7 r0 *1 0,0
R_85_t7 \$85__t7 \$85 19.6996442746
* device instance _85_t8 r0 *1 0,0
R_85_t8 \$85__t8 \$85 25.072462352
* device instance _85_t9 r0 *1 0,0
R_85_t9 \$85__t9 \$85 56.2731449656
* device instance _85_t10 r0 *1 0,0
R_85_t10 \$85__t10 \$85 50.8047650743
* device instance _85_t11 r0 *1 0,0
R_85_t11 \$85__t11 \$85 45.3516669142
* device instance _85_t12 r0 *1 0,0
R_85_t12 \$85__t12 \$85 39.9201134422
* device instance _85_t13 r0 *1 0,0
R_85_t13 \$85__t13 \$85 29.1697732422
* device instance _85_t14 r0 *1 0,0
R_85_t14 \$85__t14 \$85 34.5202759298
* device instance _85_t15 r0 *1 0,0
R_85_t15 \$85__t15 \$85 31.3743719883
* device instance _85_t16 r0 *1 0,0
R_85_t16 \$85__t16 \$85 57.4468658064
* device instance _85_t17 r0 *1 0,0
R_85_t17 \$85__t17 \$85 52.1018205145
* device instance _85_t18 r0 *1 0,0
R_85_t18 \$85__t18 \$85 41.5582844196
* device instance _85_t19 r0 *1 0,0
R_85_t19 \$85__t19 \$85 36.4022663708
* device instance _85_t20 r0 *1 0,0
R_85_t20 \$85__t20 \$85 46.8000987025
* device instance _85_t21 r0 *1 0,0
R_85_t21 \$85__t21 \$85 26.5474983019
* device instance _85_t22 r0 *1 0,0
R_85_t22 \$85__t22 \$85 22.0540323345
* device instance _85_t23 r0 *1 0,0
R_85_t23 \$85__t23 \$85 18.7857604464
* device instance _85_t24 r0 *1 0,0
R_85_t24 \$85__t24 \$85 30.5020159979
* device instance _85_t25 r0 *1 0,0
R_85_t25 \$85__t25 \$85 36.7674313691
* device instance _85_t26 r0 *1 0,0
R_85_t26 \$85__t26 \$85 33.3360409412
* device instance _85_t27 r0 *1 0,0
R_85_t27 \$85__t27 \$85 27.5863076038
* device instance _85_t28 r0 *1 0,0
R_85_t28 \$85__t28 \$85 28.7474020017
* device instance _85_t29 r0 *1 0,0
R_85_t29 \$85__t29 \$85 30.5275526285
* device instance _85_t30 r0 *1 0,0
R_85_t30 \$85__t30 \$85 28.5265409931
* device instance _85_t31 r0 *1 0,0
R_85_t31 \$85__t31 \$85 27.509777176
* device instance _85_t32 r0 *1 0,0
R_85_t32 \$85__t32 \$85 51.0713235356
* device instance _85_t33 r0 *1 0,0
R_85_t33 \$85__t33 \$85 52.1523279446
* device instance _85_t34 r0 *1 0,0
R_85_t34 \$85__t34 \$85 53.2404769788
* device instance _85_t35 r0 *1 0,0
R_85_t35 \$85__t35 \$85 54.3353413936
* device instance _85_t36 r0 *1 0,0
R_85_t36 \$85__t36 \$85 61.3056594771
* device instance _85_t37 r0 *1 0,0
R_85_t37 \$85__t37 \$85 63.5354736422
* device instance _85_t38 r0 *1 0,0
R_85_t38 \$85__t38 \$85 62.4181161136
* device instance _85_t39 r0 *1 0,0
R_85_t39 \$85__t39 \$85 64.6574779839
* device instance _85 r0 *1 0,0
C_85 \$85 vsubs 1.44349639e-13
* device instance _86_t0 r0 *1 0,0
R_86_t0 \$86__t0 \$86 72.8318372444
* device instance _86_t1 r0 *1 0,0
R_86_t1 \$86__t1 \$86 31.3697488842
* device instance _86_t2 r0 *1 0,0
R_86_t2 \$86__t2 \$86 38.864779931
* device instance _86_t3 r0 *1 0,0
R_86_t3 \$86__t3 \$86 50.472760055
* device instance _86_t4 r0 *1 0,0
R_86_t4 \$86__t4 \$86 39.9380804289
* device instance _86_t5 r0 *1 0,0
R_86_t5 \$86__t5 \$86 27.9878496386
* device instance _86_t6 r0 *1 0,0
R_86_t6 \$86__t6 \$86 89.73986513
* device instance _86_t7 r0 *1 0,0
R_86_t7 \$86__t7 \$86 26.289905862
* device instance _86_t8 r0 *1 0,0
R_86_t8 \$86__t8 \$86 97.8455159237
* device instance _86_t9 r0 *1 0,0
R_86_t9 \$86__t9 \$86 22.145377228
* device instance _86_t10 r0 *1 0,0
R_86_t10 \$86__t10 \$86 34.893683157
* device instance _86_t11 r0 *1 0,0
R_86_t11 \$86__t11 \$86 61.5140221704
* device instance _86_t12 r0 *1 0,0
R_86_t12 \$86__t12 \$86 21.1843185636
* device instance _86_t13 r0 *1 0,0
R_86_t13 \$86__t13 \$86 27.2337538328
* device instance _86_t14 r0 *1 0,0
R_86_t14 \$86__t14 \$86 76.5788400168
* device instance _86_t15 r0 *1 0,0
R_86_t15 \$86__t15 \$86 82.5637207104
* device instance _86_t16 r0 *1 0,0
R_86_t16 \$86__t16 \$86 67.203594104
* device instance _86_t17 r0 *1 0,0
R_86_t17 \$86__t17 \$86 65.2565669157
* device instance _86_t18 r0 *1 0,0
R_86_t18 \$86__t18 \$86 71.2409054255
* device instance _86_t19 r0 *1 0,0
R_86_t19 \$86__t19 \$86 69.1997501482
* device instance _86_t20 r0 *1 0,0
R_86_t20 \$86__t20 \$86 89.960378837
* device instance _86_t21 r0 *1 0,0
R_86_t21 \$86__t21 \$86 87.7477377179
* device instance _86_t22 r0 *1 0,0
R_86_t22 \$86__t22 \$86 92.1979005812
* device instance _86_t23 r0 *1 0,0
R_86_t23 \$86__t23 \$86 85.5619074935
* device instance _86 r0 *1 0,0
C_86 \$86 vsubs 1.2749138e-13
* device instance _87_t0 r0 *1 0,0
R_87_t0 \$87__t0 \$87 141.920059825
* device instance _87_t1 r0 *1 0,0
R_87_t1 \$87__t1 \$87 125.016727085
* device instance _87_t2 r0 *1 0,0
R_87_t2 \$87__t2 \$87 72.2396640895
* device instance _87_t3 r0 *1 0,0
R_87_t3 \$87__t3 \$87 83.9329276865
* device instance _87_t4 r0 *1 0,0
R_87_t4 \$87__t4 \$87 168.33607375
* device instance _87_t5 r0 *1 0,0
R_87_t5 \$87__t5 \$87 181.243358652
* device instance _87_t6 r0 *1 0,0
R_87_t6 \$87__t6 \$87 43.0273545853
* device instance _87_t7 r0 *1 0,0
R_87_t7 \$87__t7 \$87 60.6425636404
* device instance _87_t8 r0 *1 0,0
R_87_t8 \$87__t8 \$87 53.137056906
* device instance _87_t9 r0 *1 0,0
R_87_t9 \$87__t9 \$87 54.3131212759
* device instance _87_t10 r0 *1 0,0
R_87_t10 \$87__t10 \$87 55.7679108023
* device instance _87_t11 r0 *1 0,0
R_87_t11 \$87__t11 \$87 57.4802663024
* device instance _87_t12 r0 *1 0,0
R_87_t12 \$87__t12 \$87 75.6541556398
* device instance _87_t13 r0 *1 0,0
R_87_t13 \$87__t13 \$87 78.3196641165
* device instance _87_t14 r0 *1 0,0
R_87_t14 \$87__t14 \$87 81.1058858252
* device instance _87_t15 r0 *1 0,0
R_87_t15 \$87__t15 \$87 84.0008098181
* device instance _87 r0 *1 0,0
C_87 \$87 vsubs 1.17770046e-13
* device instance _88_t0 r0 *1 0,0
R_88_t0 \$88__t0 \$88 213.906295844
* device instance _88_t1 r0 *1 0,0
R_88_t1 \$88__t1 \$88 213.891180066
* device instance _88_t2 r0 *1 0,0
R_88_t2 \$88__t2 \$88 289.713773711
* device instance _88_t3 r0 *1 0,0
R_88_t3 \$88__t3 \$88 175.348726988
* device instance _88_t4 r0 *1 0,0
R_88_t4 \$88__t4 \$88 54.3141014677
* device instance _88_t5 r0 *1 0,0
R_88_t5 \$88__t5 \$88 56.4680012372
* device instance _88_t6 r0 *1 0,0
R_88_t6 \$88__t6 \$88 59.2541512659
* device instance _88_t7 r0 *1 0,0
R_88_t7 \$88__t7 \$88 62.588173434
* device instance _88_t8 r0 *1 0,0
R_88_t8 \$88__t8 \$88 66.4116942459
* device instance _88_t9 r0 *1 0,0
R_88_t9 \$88__t9 \$88 68.6226715932
* device instance _88_t10 r0 *1 0,0
R_88_t10 \$88__t10 \$88 71.3542900855
* device instance _88_t11 r0 *1 0,0
R_88_t11 \$88__t11 \$88 74.5493400619
* device instance _88 r0 *1 0,0
C_88 \$88 vsubs 1.11718715e-13
* device instance _89_t0 r0 *1 0,0
R_89_t0 \$89__t0 \$89 373.996867344
* device instance _89_t1 r0 *1 0,0
R_89_t1 \$89__t1 \$89 393.445773919
* device instance _89_t2 r0 *1 0,0
R_89_t2 \$89__t2 \$89 64.3840584941
* device instance _89_t3 r0 *1 0,0
R_89_t3 \$89__t3 \$89 71.5104978885
* device instance _89_t4 r0 *1 0,0
R_89_t4 \$89__t4 \$89 78.9595246804
* device instance _89_t5 r0 *1 0,0
R_89_t5 \$89__t5 \$89 86.6479813766
* device instance _89_t6 r0 *1 0,0
R_89_t6 \$89__t6 \$89 58.7201977431
* device instance _89_t7 r0 *1 0,0
R_89_t7 \$89__t7 \$89 54.4557350201
* device instance _89_t8 r0 *1 0,0
R_89_t8 \$89__t8 \$89 54.5334241482
* device instance _89_t9 r0 *1 0,0
R_89_t9 \$89__t9 \$89 55.9890393869
* device instance _89 r0 *1 0,0
C_89 \$89 vsubs 7.219247e-14
* device instance _9_t0 r0 *1 0,0
R_9_t0 \$9__t0 \$9 135.591504929
* device instance _9_t1 r0 *1 0,0
R_9_t1 \$9__t1 \$9 36.2048686624
* device instance _9_t2 r0 *1 0,0
R_9_t2 \$9__t2 \$9 166.824926409
* device instance _9 r0 *1 0,0
C_9 \$9 vsubs 7.022961e-15
* device instance _90_t0 r0 *1 0,0
R_90_t0 \$90__t0 \$90 438.262254277
* device instance _90_t1 r0 *1 0,0
R_90_t1 \$90__t1 \$90 81.3844454092
* device instance _90_t2 r0 *1 0,0
R_90_t2 \$90__t2 \$90 98.772428992
* device instance _90_t3 r0 *1 0,0
R_90_t3 \$90__t3 \$90 116.734047769
* device instance _90_t4 r0 *1 0,0
R_90_t4 \$90__t4 \$90 65.0318659218
* device instance _90_t5 r0 *1 0,0
R_90_t5 \$90__t5 \$90 87.9257278374
* device instance _90_t6 r0 *1 0,0
R_90_t6 \$90__t6 \$90 100.343517804
* device instance _90_t7 r0 *1 0,0
R_90_t7 \$90__t7 \$90 114.651602343
* device instance _90_t8 r0 *1 0,0
R_90_t8 \$90__t8 \$90 130.228409648
* device instance _90 r0 *1 0,0
C_90 \$90 vsubs 5.1062839e-14
* device instance _92_t0 r0 *1 0,0
R_92_t0 \$92__t0 \$92 135.591504929
* device instance _92_t1 r0 *1 0,0
R_92_t1 \$92__t1 \$92 36.2048686624
* device instance _92_t2 r0 *1 0,0
R_92_t2 \$92__t2 \$92 166.824926409
* device instance _92 r0 *1 0,0
C_92 \$92 vsubs 7.017453e-15
* device instance _94_t0 r0 *1 0,0
R_94_t0 \$94__t0 \$94 162.444438203
* device instance _94_t1 r0 *1 0,0
R_94_t1 \$94__t1 \$94 43.7126105743
* device instance _94_t2 r0 *1 0,0
R_94_t2 \$94__t2 \$94 200.179851222
* device instance _94 r0 *1 0,0
C_94 \$94 vsubs 7.547896e-15
* device instance _96_t0 r0 *1 0,0
R_96_t0 \$96__t0 \$96 135.591504929
* device instance _96_t1 r0 *1 0,0
R_96_t1 \$96__t1 \$96 36.2048686624
* device instance _96_t2 r0 *1 0,0
R_96_t2 \$96__t2 \$96 166.824926409
* device instance _96 r0 *1 0,0
C_96 \$96 vsubs 7.017453e-15
* device instance _98_t0 r0 *1 0,0
R_98_t0 \$98__t0 \$98 162.444438203
* device instance _98_t1 r0 *1 0,0
R_98_t1 \$98__t1 \$98 43.7126105743
* device instance _98_t2 r0 *1 0,0
R_98_t2 \$98__t2 \$98 200.179851222
* device instance _98 r0 *1 0,0
C_98 \$98 vsubs 7.547896e-15
* device instance hi_128_n_t0 r0 *1 0,0
Rhi_128_n_t0 hi_128_n__t0 hi_128_n 159.628415411
* device instance hi_128_n_t1 r0 *1 0,0
Rhi_128_n_t1 hi_128_n__t1 hi_128_n 17.8399437493
* device instance hi_128_n_t2 r0 *1 0,0
Rhi_128_n_t2 hi_128_n__t2 hi_128_n 156.869440839
* device instance hi_128_n r0 *1 0,0
Chi_128_n hi_128_n vsubs 4.857429e-15
* device instance hi_128_p_t0 r0 *1 0,0
Rhi_128_p_t0 hi_128_p__t0 hi_128_p 159.628415411
* device instance hi_128_p_t1 r0 *1 0,0
Rhi_128_p_t1 hi_128_p__t1 hi_128_p 17.8399437493
* device instance hi_128_p_t2 r0 *1 0,0
Rhi_128_p_t2 hi_128_p__t2 hi_128_p 156.869440839
* device instance hi_128_p r0 *1 0,0
Chi_128_p hi_128_p vsubs 4.857429e-15
* device instance hi_16_n_t0 r0 *1 0,0
Rhi_16_n_t0 hi_16_n__t0 hi_16_n 159.628415411
* device instance hi_16_n_t1 r0 *1 0,0
Rhi_16_n_t1 hi_16_n__t1 hi_16_n 17.8399437493
* device instance hi_16_n_t2 r0 *1 0,0
Rhi_16_n_t2 hi_16_n__t2 hi_16_n 156.869440839
* device instance hi_16_n r0 *1 0,0
Chi_16_n hi_16_n vsubs 4.851921e-15
* device instance hi_16_p_t0 r0 *1 0,0
Rhi_16_p_t0 hi_16_p__t0 hi_16_p 159.628415411
* device instance hi_16_p_t1 r0 *1 0,0
Rhi_16_p_t1 hi_16_p__t1 hi_16_p 17.8399437493
* device instance hi_16_p_t2 r0 *1 0,0
Rhi_16_p_t2 hi_16_p__t2 hi_16_p 156.869440839
* device instance hi_16_p r0 *1 0,0
Chi_16_p hi_16_p vsubs 4.851921e-15
* device instance hi_1_n_t0 r0 *1 0,0
Rhi_1_n_t0 hi_1_n__t0 hi_1_n 159.628415411
* device instance hi_1_n_t1 r0 *1 0,0
Rhi_1_n_t1 hi_1_n__t1 hi_1_n 17.8399437493
* device instance hi_1_n_t2 r0 *1 0,0
Rhi_1_n_t2 hi_1_n__t2 hi_1_n 156.869440839
* device instance hi_1_n r0 *1 0,0
Chi_1_n hi_1_n vsubs 4.857429e-15
* device instance hi_1_p_t0 r0 *1 0,0
Rhi_1_p_t0 hi_1_p__t0 hi_1_p 159.628415411
* device instance hi_1_p_t1 r0 *1 0,0
Rhi_1_p_t1 hi_1_p__t1 hi_1_p 17.8399437493
* device instance hi_1_p_t2 r0 *1 0,0
Rhi_1_p_t2 hi_1_p__t2 hi_1_p 156.869440839
* device instance hi_1_p r0 *1 0,0
Chi_1_p hi_1_p vsubs 4.857429e-15
* device instance hi_256_n_t0 r0 *1 0,0
Rhi_256_n_t0 hi_256_n__t0 hi_256_n 159.628415411
* device instance hi_256_n_t1 r0 *1 0,0
Rhi_256_n_t1 hi_256_n__t1 hi_256_n 17.8399437493
* device instance hi_256_n_t2 r0 *1 0,0
Rhi_256_n_t2 hi_256_n__t2 hi_256_n 156.869440839
* device instance hi_256_n r0 *1 0,0
Chi_256_n hi_256_n vsubs 4.857429e-15
* device instance hi_256_p_t0 r0 *1 0,0
Rhi_256_p_t0 hi_256_p__t0 hi_256_p 159.628415411
* device instance hi_256_p_t1 r0 *1 0,0
Rhi_256_p_t1 hi_256_p__t1 hi_256_p 17.8399437493
* device instance hi_256_p_t2 r0 *1 0,0
Rhi_256_p_t2 hi_256_p__t2 hi_256_p 156.869440839
* device instance hi_256_p r0 *1 0,0
Chi_256_p hi_256_p vsubs 4.857429e-15
* device instance hi_2_n_t0 r0 *1 0,0
Rhi_2_n_t0 hi_2_n__t0 hi_2_n 159.628415411
* device instance hi_2_n_t1 r0 *1 0,0
Rhi_2_n_t1 hi_2_n__t1 hi_2_n 17.8399437493
* device instance hi_2_n_t2 r0 *1 0,0
Rhi_2_n_t2 hi_2_n__t2 hi_2_n 156.869440839
* device instance hi_2_n r0 *1 0,0
Chi_2_n hi_2_n vsubs 4.857429e-15
* device instance hi_2_p_t0 r0 *1 0,0
Rhi_2_p_t0 hi_2_p__t0 hi_2_p 159.628415411
* device instance hi_2_p_t1 r0 *1 0,0
Rhi_2_p_t1 hi_2_p__t1 hi_2_p 17.8399437493
* device instance hi_2_p_t2 r0 *1 0,0
Rhi_2_p_t2 hi_2_p__t2 hi_2_p 156.869440839
* device instance hi_2_p r0 *1 0,0
Chi_2_p hi_2_p vsubs 4.857429e-15
* device instance hi_32_n_t0 r0 *1 0,0
Rhi_32_n_t0 hi_32_n__t0 hi_32_n 159.628415411
* device instance hi_32_n_t1 r0 *1 0,0
Rhi_32_n_t1 hi_32_n__t1 hi_32_n 17.8399437493
* device instance hi_32_n_t2 r0 *1 0,0
Rhi_32_n_t2 hi_32_n__t2 hi_32_n 156.869440839
* device instance hi_32_n r0 *1 0,0
Chi_32_n hi_32_n vsubs 4.857429e-15
* device instance hi_32_p_t0 r0 *1 0,0
Rhi_32_p_t0 hi_32_p__t0 hi_32_p 159.628415411
* device instance hi_32_p_t1 r0 *1 0,0
Rhi_32_p_t1 hi_32_p__t1 hi_32_p 17.8399437493
* device instance hi_32_p_t2 r0 *1 0,0
Rhi_32_p_t2 hi_32_p__t2 hi_32_p 156.869440839
* device instance hi_32_p r0 *1 0,0
Chi_32_p hi_32_p vsubs 4.857429e-15
* device instance hi_4_n_t0 r0 *1 0,0
Rhi_4_n_t0 hi_4_n__t0 hi_4_n 159.628415411
* device instance hi_4_n_t1 r0 *1 0,0
Rhi_4_n_t1 hi_4_n__t1 hi_4_n 17.8399437493
* device instance hi_4_n_t2 r0 *1 0,0
Rhi_4_n_t2 hi_4_n__t2 hi_4_n 156.869440839
* device instance hi_4_n r0 *1 0,0
Chi_4_n hi_4_n vsubs 4.857429e-15
* device instance hi_4_p_t0 r0 *1 0,0
Rhi_4_p_t0 hi_4_p__t0 hi_4_p 159.628415411
* device instance hi_4_p_t1 r0 *1 0,0
Rhi_4_p_t1 hi_4_p__t1 hi_4_p 17.8399437493
* device instance hi_4_p_t2 r0 *1 0,0
Rhi_4_p_t2 hi_4_p__t2 hi_4_p 156.869440839
* device instance hi_4_p r0 *1 0,0
Chi_4_p hi_4_p vsubs 4.857429e-15
* device instance hi_64_n_t0 r0 *1 0,0
Rhi_64_n_t0 hi_64_n__t0 hi_64_n 159.628415411
* device instance hi_64_n_t1 r0 *1 0,0
Rhi_64_n_t1 hi_64_n__t1 hi_64_n 17.8399437493
* device instance hi_64_n_t2 r0 *1 0,0
Rhi_64_n_t2 hi_64_n__t2 hi_64_n 156.869440839
* device instance hi_64_n r0 *1 0,0
Chi_64_n hi_64_n vsubs 4.857429e-15
* device instance hi_64_p_t0 r0 *1 0,0
Rhi_64_p_t0 hi_64_p__t0 hi_64_p 159.628415411
* device instance hi_64_p_t1 r0 *1 0,0
Rhi_64_p_t1 hi_64_p__t1 hi_64_p 17.8399437493
* device instance hi_64_p_t2 r0 *1 0,0
Rhi_64_p_t2 hi_64_p__t2 hi_64_p 156.869440839
* device instance hi_64_p r0 *1 0,0
Chi_64_p hi_64_p vsubs 4.857429e-15
* device instance hi_8_n_t0 r0 *1 0,0
Rhi_8_n_t0 hi_8_n__t0 hi_8_n 159.628415411
* device instance hi_8_n_t1 r0 *1 0,0
Rhi_8_n_t1 hi_8_n__t1 hi_8_n 17.8399437493
* device instance hi_8_n_t2 r0 *1 0,0
Rhi_8_n_t2 hi_8_n__t2 hi_8_n 156.869440839
* device instance hi_8_n r0 *1 0,0
Chi_8_n hi_8_n vsubs 4.857429e-15
* device instance hi_8_p_t0 r0 *1 0,0
Rhi_8_p_t0 hi_8_p__t0 hi_8_p 159.628415411
* device instance hi_8_p_t1 r0 *1 0,0
Rhi_8_p_t1 hi_8_p__t1 hi_8_p 17.8399437493
* device instance hi_8_p_t2 r0 *1 0,0
Rhi_8_p_t2 hi_8_p__t2 hi_8_p 156.869440839
* device instance hi_8_p r0 *1 0,0
Chi_8_p hi_8_p vsubs 4.857429e-15
* device instance lo_128_n_t0 r0 *1 0,0
Rlo_128_n_t0 lo_128_n__t0 lo_128_n 192.317036104
* device instance lo_128_n_t1 r0 *1 0,0
Rlo_128_n_t1 lo_128_n__t1 lo_128_n 21.6360274196
* device instance lo_128_n_t2 r0 *1 0,0
Rlo_128_n_t2 lo_128_n__t2 lo_128_n 188.273336477
* device instance lo_128_n r0 *1 0,0
Clo_128_n lo_128_n vsubs 5.390587e-15
* device instance lo_128_p_t0 r0 *1 0,0
Rlo_128_p_t0 lo_128_p__t0 lo_128_p 192.317036104
* device instance lo_128_p_t1 r0 *1 0,0
Rlo_128_p_t1 lo_128_p__t1 lo_128_p 21.6360274196
* device instance lo_128_p_t2 r0 *1 0,0
Rlo_128_p_t2 lo_128_p__t2 lo_128_p 188.273336477
* device instance lo_128_p r0 *1 0,0
Clo_128_p lo_128_p vsubs 5.394106e-15
* device instance lo_16_n_t0 r0 *1 0,0
Rlo_16_n_t0 lo_16_n__t0 lo_16_n 192.317036104
* device instance lo_16_n_t1 r0 *1 0,0
Rlo_16_n_t1 lo_16_n__t1 lo_16_n 21.6360274196
* device instance lo_16_n_t2 r0 *1 0,0
Rlo_16_n_t2 lo_16_n__t2 lo_16_n 188.273336477
* device instance lo_16_n r0 *1 0,0
Clo_16_n lo_16_n vsubs 5.385079e-15
* device instance lo_16_p_t0 r0 *1 0,0
Rlo_16_p_t0 lo_16_p__t0 lo_16_p 192.317036104
* device instance lo_16_p_t1 r0 *1 0,0
Rlo_16_p_t1 lo_16_p__t1 lo_16_p 21.6360274196
* device instance lo_16_p_t2 r0 *1 0,0
Rlo_16_p_t2 lo_16_p__t2 lo_16_p 188.273336477
* device instance lo_16_p r0 *1 0,0
Clo_16_p lo_16_p vsubs 5.388598e-15
* device instance lo_1_n_t0 r0 *1 0,0
Rlo_1_n_t0 lo_1_n__t0 lo_1_n 192.317036104
* device instance lo_1_n_t1 r0 *1 0,0
Rlo_1_n_t1 lo_1_n__t1 lo_1_n 21.6360274196
* device instance lo_1_n_t2 r0 *1 0,0
Rlo_1_n_t2 lo_1_n__t2 lo_1_n 188.273336477
* device instance lo_1_n r0 *1 0,0
Clo_1_n lo_1_n vsubs 5.390587e-15
* device instance lo_1_p_t0 r0 *1 0,0
Rlo_1_p_t0 lo_1_p__t0 lo_1_p 192.317036104
* device instance lo_1_p_t1 r0 *1 0,0
Rlo_1_p_t1 lo_1_p__t1 lo_1_p 21.6360274196
* device instance lo_1_p_t2 r0 *1 0,0
Rlo_1_p_t2 lo_1_p__t2 lo_1_p 188.273336477
* device instance lo_1_p r0 *1 0,0
Clo_1_p lo_1_p vsubs 5.394106e-15
* device instance lo_256_n_t0 r0 *1 0,0
Rlo_256_n_t0 lo_256_n__t0 lo_256_n 192.317036104
* device instance lo_256_n_t1 r0 *1 0,0
Rlo_256_n_t1 lo_256_n__t1 lo_256_n 21.6360274196
* device instance lo_256_n_t2 r0 *1 0,0
Rlo_256_n_t2 lo_256_n__t2 lo_256_n 188.273336477
* device instance lo_256_n r0 *1 0,0
Clo_256_n lo_256_n vsubs 5.390587e-15
* device instance lo_256_p_t0 r0 *1 0,0
Rlo_256_p_t0 lo_256_p__t0 lo_256_p 192.317036104
* device instance lo_256_p_t1 r0 *1 0,0
Rlo_256_p_t1 lo_256_p__t1 lo_256_p 21.6360274196
* device instance lo_256_p_t2 r0 *1 0,0
Rlo_256_p_t2 lo_256_p__t2 lo_256_p 188.273336477
* device instance lo_256_p r0 *1 0,0
Clo_256_p lo_256_p vsubs 5.394106e-15
* device instance lo_2_n_t0 r0 *1 0,0
Rlo_2_n_t0 lo_2_n__t0 lo_2_n 192.317036104
* device instance lo_2_n_t1 r0 *1 0,0
Rlo_2_n_t1 lo_2_n__t1 lo_2_n 21.6360274196
* device instance lo_2_n_t2 r0 *1 0,0
Rlo_2_n_t2 lo_2_n__t2 lo_2_n 188.273336477
* device instance lo_2_n r0 *1 0,0
Clo_2_n lo_2_n vsubs 5.390587e-15
* device instance lo_2_p_t0 r0 *1 0,0
Rlo_2_p_t0 lo_2_p__t0 lo_2_p 192.317036104
* device instance lo_2_p_t1 r0 *1 0,0
Rlo_2_p_t1 lo_2_p__t1 lo_2_p 21.6360274196
* device instance lo_2_p_t2 r0 *1 0,0
Rlo_2_p_t2 lo_2_p__t2 lo_2_p 188.273336477
* device instance lo_2_p r0 *1 0,0
Clo_2_p lo_2_p vsubs 5.394106e-15
* device instance lo_32_n_t0 r0 *1 0,0
Rlo_32_n_t0 lo_32_n__t0 lo_32_n 192.317036104
* device instance lo_32_n_t1 r0 *1 0,0
Rlo_32_n_t1 lo_32_n__t1 lo_32_n 21.6360274196
* device instance lo_32_n_t2 r0 *1 0,0
Rlo_32_n_t2 lo_32_n__t2 lo_32_n 188.273336477
* device instance lo_32_n r0 *1 0,0
Clo_32_n lo_32_n vsubs 5.390587e-15
* device instance lo_32_p_t0 r0 *1 0,0
Rlo_32_p_t0 lo_32_p__t0 lo_32_p 192.317036104
* device instance lo_32_p_t1 r0 *1 0,0
Rlo_32_p_t1 lo_32_p__t1 lo_32_p 21.6360274196
* device instance lo_32_p_t2 r0 *1 0,0
Rlo_32_p_t2 lo_32_p__t2 lo_32_p 188.273336477
* device instance lo_32_p r0 *1 0,0
Clo_32_p lo_32_p vsubs 5.394106e-15
* device instance lo_4_n_t0 r0 *1 0,0
Rlo_4_n_t0 lo_4_n__t0 lo_4_n 192.317036104
* device instance lo_4_n_t1 r0 *1 0,0
Rlo_4_n_t1 lo_4_n__t1 lo_4_n 21.6360274196
* device instance lo_4_n_t2 r0 *1 0,0
Rlo_4_n_t2 lo_4_n__t2 lo_4_n 188.273336477
* device instance lo_4_n r0 *1 0,0
Clo_4_n lo_4_n vsubs 5.390587e-15
* device instance lo_4_p_t0 r0 *1 0,0
Rlo_4_p_t0 lo_4_p__t0 lo_4_p 192.317036104
* device instance lo_4_p_t1 r0 *1 0,0
Rlo_4_p_t1 lo_4_p__t1 lo_4_p 21.6360274196
* device instance lo_4_p_t2 r0 *1 0,0
Rlo_4_p_t2 lo_4_p__t2 lo_4_p 188.273336477
* device instance lo_4_p r0 *1 0,0
Clo_4_p lo_4_p vsubs 5.394106e-15
* device instance lo_64_n_t0 r0 *1 0,0
Rlo_64_n_t0 lo_64_n__t0 lo_64_n 192.317036104
* device instance lo_64_n_t1 r0 *1 0,0
Rlo_64_n_t1 lo_64_n__t1 lo_64_n 21.6360274196
* device instance lo_64_n_t2 r0 *1 0,0
Rlo_64_n_t2 lo_64_n__t2 lo_64_n 188.273336477
* device instance lo_64_n r0 *1 0,0
Clo_64_n lo_64_n vsubs 5.390587e-15
* device instance lo_64_p_t0 r0 *1 0,0
Rlo_64_p_t0 lo_64_p__t0 lo_64_p 192.317036104
* device instance lo_64_p_t1 r0 *1 0,0
Rlo_64_p_t1 lo_64_p__t1 lo_64_p 21.6360274196
* device instance lo_64_p_t2 r0 *1 0,0
Rlo_64_p_t2 lo_64_p__t2 lo_64_p 188.273336477
* device instance lo_64_p r0 *1 0,0
Clo_64_p lo_64_p vsubs 5.394106e-15
* device instance lo_8_n_t0 r0 *1 0,0
Rlo_8_n_t0 lo_8_n__t0 lo_8_n 192.317036104
* device instance lo_8_n_t1 r0 *1 0,0
Rlo_8_n_t1 lo_8_n__t1 lo_8_n 21.6360274196
* device instance lo_8_n_t2 r0 *1 0,0
Rlo_8_n_t2 lo_8_n__t2 lo_8_n 188.273336477
* device instance lo_8_n r0 *1 0,0
Clo_8_n lo_8_n vsubs 5.390587e-15
* device instance lo_8_p_t0 r0 *1 0,0
Rlo_8_p_t0 lo_8_p__t0 lo_8_p 192.317036104
* device instance lo_8_p_t1 r0 *1 0,0
Rlo_8_p_t1 lo_8_p__t1 lo_8_p 21.6360274196
* device instance lo_8_p_t2 r0 *1 0,0
Rlo_8_p_t2 lo_8_p__t2 lo_8_p 188.273336477
* device instance lo_8_p r0 *1 0,0
Clo_8_p lo_8_p vsubs 5.394106e-15
* device instance pinn_t0 r0 *1 0,0
Rpinn_t0 vinn__t0 vinn 161.958109832
* device instance pinn_t1 r0 *1 0,0
Rpinn_t1 vinn__t1 vinn 233.907460461
* device instance pinn_t2 r0 *1 0,0
Rpinn_t2 vinn__t2 vinn 90.0297060612
* device instance pinn_t3 r0 *1 0,0
Rpinn_t3 vinn__t3 vinn 305.862976071
* device instance pinn_t4 r0 *1 0,0
Rpinn_t4 vinn__t4 vinn 18.3699743913
* device instance pinn_t5 r0 *1 0,0
Rpinn_t5 vinn__t5 vinn 54.0994759425
* device instance pinn_t6 r0 *1 0,0
Rpinn_t6 vinn__t6 vinn 125.989047095
* device instance pinn_t7 r0 *1 0,0
Rpinn_t7 vinn__t7 vinn 269.884755824
* device instance pinn_t8 r0 *1 0,0
Rpinn_t8 vinn__t8 vinn 197.931594322
* device instance pinn_t9 r0 *1 0,0
Rpinn_t9 vinn__t9 vinn 18.3699743913
* device instance pinn_t10 r0 *1 0,0
Rpinn_t10 vinn__t10 vinn 125.989047095
* device instance pinn_t11 r0 *1 0,0
Rpinn_t11 vinn__t11 vinn 197.931594322
* device instance pinn_t12 r0 *1 0,0
Rpinn_t12 vinn__t12 vinn 90.0297060612
* device instance pinn_t13 r0 *1 0,0
Rpinn_t13 vinn__t13 vinn 305.862976071
* device instance pinn_t14 r0 *1 0,0
Rpinn_t14 vinn__t14 vinn 161.958109832
* device instance pinn_t15 r0 *1 0,0
Rpinn_t15 vinn__t15 vinn 269.884755824
* device instance pinn_t16 r0 *1 0,0
Rpinn_t16 vinn__t16 vinn 54.0994759425
* device instance pinn_t17 r0 *1 0,0
Rpinn_t17 vinn__t17 vinn 233.907460461
* device instance pinn r0 *1 0,0
Cpinn vinn vsubs 8.37261e-14
* device instance pinp_t0 r0 *1 0,0
Rpinp_t0 vinp__t0 vinp 305.862976071
* device instance pinp_t1 r0 *1 0,0
Rpinp_t1 vinp__t1 vinp 269.884755824
* device instance pinp_t2 r0 *1 0,0
Rpinp_t2 vinp__t2 vinp 161.958109832
* device instance pinp_t3 r0 *1 0,0
Rpinp_t3 vinp__t3 vinp 54.0994759425
* device instance pinp_t4 r0 *1 0,0
Rpinp_t4 vinp__t4 vinp 90.0297060612
* device instance pinp_t5 r0 *1 0,0
Rpinp_t5 vinp__t5 vinp 305.862976071
* device instance pinp_t6 r0 *1 0,0
Rpinp_t6 vinp__t6 vinp 197.931594322
* device instance pinp_t7 r0 *1 0,0
Rpinp_t7 vinp__t7 vinp 18.3699743913
* device instance pinp_t8 r0 *1 0,0
Rpinp_t8 vinp__t8 vinp 233.907460461
* device instance pinp_t9 r0 *1 0,0
Rpinp_t9 vinp__t9 vinp 125.989047095
* device instance pinp_t10 r0 *1 0,0
Rpinp_t10 vinp__t10 vinp 197.931594322
* device instance pinp_t11 r0 *1 0,0
Rpinp_t11 vinp__t11 vinp 54.0994759425
* device instance pinp_t12 r0 *1 0,0
Rpinp_t12 vinp__t12 vinp 233.907460461
* device instance pinp_t13 r0 *1 0,0
Rpinp_t13 vinp__t13 vinp 161.958109832
* device instance pinp_t14 r0 *1 0,0
Rpinp_t14 vinp__t14 vinp 125.989047095
* device instance pinp_t15 r0 *1 0,0
Rpinp_t15 vinp__t15 vinp 269.884755824
* device instance pinp_t16 r0 *1 0,0
Rpinp_t16 vinp__t16 vinp 90.0297060612
* device instance pinp_t17 r0 *1 0,0
Rpinp_t17 vinp__t17 vinp 18.3699743913
* device instance pinp r0 *1 0,0
Cpinp vinp vsubs 8.378118e-14
* device instance rel_128_n_t0 r0 *1 0,0
Rrel_128_n_t0 rel_128_n__t0 rel_128_n 127.025622285
* device instance rel_128_n_t1 r0 *1 0,0
Rrel_128_n_t1 rel_128_n__t1 rel_128_n 14.1171220219
* device instance rel_128_n_t2 r0 *1 0,0
Rrel_128_n_t2 rel_128_n__t2 rel_128_n 125.307355693
* device instance rel_128_n r0 *1 0,0
Crel_128_n rel_128_n vsubs 4.320752e-15
* device instance rel_128_p_t0 r0 *1 0,0
Rrel_128_p_t0 rel_128_p__t0 rel_128_p 127.025622285
* device instance rel_128_p_t1 r0 *1 0,0
Rrel_128_p_t1 rel_128_p__t1 rel_128_p 14.1171220219
* device instance rel_128_p_t2 r0 *1 0,0
Rrel_128_p_t2 rel_128_p__t2 rel_128_p 125.307355693
* device instance rel_128_p r0 *1 0,0
Crel_128_p rel_128_p vsubs 4.320752e-15
* device instance rel_16_n_t0 r0 *1 0,0
Rrel_16_n_t0 rel_16_n__t0 rel_16_n 127.025622285
* device instance rel_16_n_t1 r0 *1 0,0
Rrel_16_n_t1 rel_16_n__t1 rel_16_n 14.1171220219
* device instance rel_16_n_t2 r0 *1 0,0
Rrel_16_n_t2 rel_16_n__t2 rel_16_n 125.307355693
* device instance rel_16_n r0 *1 0,0
Crel_16_n rel_16_n vsubs 4.320701e-15
* device instance rel_16_p_t0 r0 *1 0,0
Rrel_16_p_t0 rel_16_p__t0 rel_16_p 127.025622285
* device instance rel_16_p_t1 r0 *1 0,0
Rrel_16_p_t1 rel_16_p__t1 rel_16_p 14.1171220219
* device instance rel_16_p_t2 r0 *1 0,0
Rrel_16_p_t2 rel_16_p__t2 rel_16_p 125.307355693
* device instance rel_16_p r0 *1 0,0
Crel_16_p rel_16_p vsubs 4.320701e-15
* device instance rel_1_n_t0 r0 *1 0,0
Rrel_1_n_t0 rel_1_n__t0 rel_1_n 127.025622285
* device instance rel_1_n_t1 r0 *1 0,0
Rrel_1_n_t1 rel_1_n__t1 rel_1_n 14.1171220219
* device instance rel_1_n_t2 r0 *1 0,0
Rrel_1_n_t2 rel_1_n__t2 rel_1_n 125.307355693
* device instance rel_1_n r0 *1 0,0
Crel_1_n rel_1_n vsubs 4.320752e-15
* device instance rel_1_p_t0 r0 *1 0,0
Rrel_1_p_t0 rel_1_p__t0 rel_1_p 127.025622285
* device instance rel_1_p_t1 r0 *1 0,0
Rrel_1_p_t1 rel_1_p__t1 rel_1_p 14.1171220219
* device instance rel_1_p_t2 r0 *1 0,0
Rrel_1_p_t2 rel_1_p__t2 rel_1_p 125.307355693
* device instance rel_1_p r0 *1 0,0
Crel_1_p rel_1_p vsubs 4.320752e-15
* device instance rel_256_n_t0 r0 *1 0,0
Rrel_256_n_t0 rel_256_n__t0 rel_256_n 127.025622285
* device instance rel_256_n_t1 r0 *1 0,0
Rrel_256_n_t1 rel_256_n__t1 rel_256_n 14.1171220219
* device instance rel_256_n_t2 r0 *1 0,0
Rrel_256_n_t2 rel_256_n__t2 rel_256_n 125.307355693
* device instance rel_256_n r0 *1 0,0
Crel_256_n rel_256_n vsubs 4.320752e-15
* device instance rel_256_p_t0 r0 *1 0,0
Rrel_256_p_t0 rel_256_p__t0 rel_256_p 127.025622285
* device instance rel_256_p_t1 r0 *1 0,0
Rrel_256_p_t1 rel_256_p__t1 rel_256_p 14.1171220219
* device instance rel_256_p_t2 r0 *1 0,0
Rrel_256_p_t2 rel_256_p__t2 rel_256_p 125.307355693
* device instance rel_256_p r0 *1 0,0
Crel_256_p rel_256_p vsubs 4.320752e-15
* device instance rel_2_n_t0 r0 *1 0,0
Rrel_2_n_t0 rel_2_n__t0 rel_2_n 127.025622285
* device instance rel_2_n_t1 r0 *1 0,0
Rrel_2_n_t1 rel_2_n__t1 rel_2_n 14.1171220219
* device instance rel_2_n_t2 r0 *1 0,0
Rrel_2_n_t2 rel_2_n__t2 rel_2_n 125.307355693
* device instance rel_2_n r0 *1 0,0
Crel_2_n rel_2_n vsubs 4.320752e-15
* device instance rel_2_p_t0 r0 *1 0,0
Rrel_2_p_t0 rel_2_p__t0 rel_2_p 127.025622285
* device instance rel_2_p_t1 r0 *1 0,0
Rrel_2_p_t1 rel_2_p__t1 rel_2_p 14.1171220219
* device instance rel_2_p_t2 r0 *1 0,0
Rrel_2_p_t2 rel_2_p__t2 rel_2_p 125.307355693
* device instance rel_2_p r0 *1 0,0
Crel_2_p rel_2_p vsubs 4.320752e-15
* device instance rel_32_n_t0 r0 *1 0,0
Rrel_32_n_t0 rel_32_n__t0 rel_32_n 127.025622285
* device instance rel_32_n_t1 r0 *1 0,0
Rrel_32_n_t1 rel_32_n__t1 rel_32_n 14.1171220219
* device instance rel_32_n_t2 r0 *1 0,0
Rrel_32_n_t2 rel_32_n__t2 rel_32_n 125.307355693
* device instance rel_32_n r0 *1 0,0
Crel_32_n rel_32_n vsubs 4.320752e-15
* device instance rel_32_p_t0 r0 *1 0,0
Rrel_32_p_t0 rel_32_p__t0 rel_32_p 127.025622285
* device instance rel_32_p_t1 r0 *1 0,0
Rrel_32_p_t1 rel_32_p__t1 rel_32_p 14.1171220219
* device instance rel_32_p_t2 r0 *1 0,0
Rrel_32_p_t2 rel_32_p__t2 rel_32_p 125.307355693
* device instance rel_32_p r0 *1 0,0
Crel_32_p rel_32_p vsubs 4.320752e-15
* device instance rel_4_n_t0 r0 *1 0,0
Rrel_4_n_t0 rel_4_n__t0 rel_4_n 127.025622285
* device instance rel_4_n_t1 r0 *1 0,0
Rrel_4_n_t1 rel_4_n__t1 rel_4_n 14.1171220219
* device instance rel_4_n_t2 r0 *1 0,0
Rrel_4_n_t2 rel_4_n__t2 rel_4_n 125.307355693
* device instance rel_4_n r0 *1 0,0
Crel_4_n rel_4_n vsubs 4.320752e-15
* device instance rel_4_p_t0 r0 *1 0,0
Rrel_4_p_t0 rel_4_p__t0 rel_4_p 127.025622285
* device instance rel_4_p_t1 r0 *1 0,0
Rrel_4_p_t1 rel_4_p__t1 rel_4_p 14.1171220219
* device instance rel_4_p_t2 r0 *1 0,0
Rrel_4_p_t2 rel_4_p__t2 rel_4_p 125.307355693
* device instance rel_4_p r0 *1 0,0
Crel_4_p rel_4_p vsubs 4.320752e-15
* device instance rel_64_n_t0 r0 *1 0,0
Rrel_64_n_t0 rel_64_n__t0 rel_64_n 127.025622285
* device instance rel_64_n_t1 r0 *1 0,0
Rrel_64_n_t1 rel_64_n__t1 rel_64_n 14.1171220219
* device instance rel_64_n_t2 r0 *1 0,0
Rrel_64_n_t2 rel_64_n__t2 rel_64_n 125.307355693
* device instance rel_64_n r0 *1 0,0
Crel_64_n rel_64_n vsubs 4.320752e-15
* device instance rel_64_p_t0 r0 *1 0,0
Rrel_64_p_t0 rel_64_p__t0 rel_64_p 127.025622285
* device instance rel_64_p_t1 r0 *1 0,0
Rrel_64_p_t1 rel_64_p__t1 rel_64_p 14.1171220219
* device instance rel_64_p_t2 r0 *1 0,0
Rrel_64_p_t2 rel_64_p__t2 rel_64_p 125.307355693
* device instance rel_64_p r0 *1 0,0
Crel_64_p rel_64_p vsubs 4.320752e-15
* device instance rel_8_n_t0 r0 *1 0,0
Rrel_8_n_t0 rel_8_n__t0 rel_8_n 127.025622285
* device instance rel_8_n_t1 r0 *1 0,0
Rrel_8_n_t1 rel_8_n__t1 rel_8_n 14.1171220219
* device instance rel_8_n_t2 r0 *1 0,0
Rrel_8_n_t2 rel_8_n__t2 rel_8_n 125.307355693
* device instance rel_8_n r0 *1 0,0
Crel_8_n rel_8_n vsubs 4.320752e-15
* device instance rel_8_p_t0 r0 *1 0,0
Rrel_8_p_t0 rel_8_p__t0 rel_8_p 127.025622285
* device instance rel_8_p_t1 r0 *1 0,0
Rrel_8_p_t1 rel_8_p__t1 rel_8_p 14.1171220219
* device instance rel_8_p_t2 r0 *1 0,0
Rrel_8_p_t2 rel_8_p__t2 rel_8_p 125.307355693
* device instance rel_8_p r0 *1 0,0
Crel_8_p rel_8_p vsubs 4.320752e-15
* device instance sel_in_t0 r0 *1 0,0
Rsel_in_t0 sel_in__t0 sel_in 157.797645186
* device instance sel_in_t1 r0 *1 0,0
Rsel_in_t1 sel_in__t1 sel_in 148.648729445
* device instance sel_in_t2 r0 *1 0,0
Rsel_in_t2 sel_in__t2 sel_in 139.236537157
* device instance sel_in_t3 r0 *1 0,0
Rsel_in_t3 sel_in__t3 sel_in 30.6654078867
* device instance sel_in_t4 r0 *1 0,0
Rsel_in_t4 sel_in__t4 sel_in 30.4490443407
* device instance sel_in_t5 r0 *1 0,0
Rsel_in_t5 sel_in__t5 sel_in 16.2004021299
* device instance sel_in_t6 r0 *1 0,0
Rsel_in_t6 sel_in__t6 sel_in 121.056337038
* device instance sel_in_t7 r0 *1 0,0
Rsel_in_t7 sel_in__t7 sel_in 65.9995139608
* device instance sel_in_t8 r0 *1 0,0
Rsel_in_t8 sel_in__t8 sel_in 157.883944996
* device instance sel_in_t9 r0 *1 0,0
Rsel_in_t9 sel_in__t9 sel_in 157.842063937
* device instance sel_in_t10 r0 *1 0,0
Rsel_in_t10 sel_in__t10 sel_in 121.001709895
* device instance sel_in_t11 r0 *1 0,0
Rsel_in_t11 sel_in__t11 sel_in 84.2992576345
* device instance sel_in_t12 r0 *1 0,0
Rsel_in_t12 sel_in__t12 sel_in 48.1891399383
* device instance sel_in_t13 r0 *1 0,0
Rsel_in_t13 sel_in__t13 sel_in 84.37764975
* device instance sel_in_t14 r0 *1 0,0
Rsel_in_t14 sel_in__t14 sel_in 48.0517457372
* device instance sel_in_t15 r0 *1 0,0
Rsel_in_t15 sel_in__t15 sel_in 102.514188461
* device instance sel_in_t16 r0 *1 0,0
Rsel_in_t16 sel_in__t16 sel_in 65.8992632998
* device instance sel_in_t17 r0 *1 0,0
Rsel_in_t17 sel_in__t17 sel_in 139.28401279
* device instance sel_in_t18 r0 *1 0,0
Rsel_in_t18 sel_in__t18 sel_in 15.7870228217
* device instance sel_in_t19 r0 *1 0,0
Rsel_in_t19 sel_in__t19 sel_in 102.449674944
* device instance sel_in_t20 r0 *1 0,0
Rsel_in_t20 sel_in__t20 sel_in 14.003796355
* device instance sel_in_t21 r0 *1 0,0
Rsel_in_t21 sel_in__t21 sel_in 75.1359937022
* device instance sel_in_t22 r0 *1 0,0
Rsel_in_t22 sel_in__t22 sel_in 111.698499336
* device instance sel_in_t23 r0 *1 0,0
Rsel_in_t23 sel_in__t23 sel_in 111.461486602
* device instance sel_in_t24 r0 *1 0,0
Rsel_in_t24 sel_in__t24 sel_in 38.7174763814
* device instance sel_in_t25 r0 *1 0,0
Rsel_in_t25 sel_in__t25 sel_in 111.810802818
* device instance sel_in_t26 r0 *1 0,0
Rsel_in_t26 sel_in__t26 sel_in 75.1300264791
* device instance sel_in_t27 r0 *1 0,0
Rsel_in_t27 sel_in__t27 sel_in 39.7231957361
* device instance sel_in_t28 r0 *1 0,0
Rsel_in_t28 sel_in__t28 sel_in 74.7831919032
* device instance sel_in_t29 r0 *1 0,0
Rsel_in_t29 sel_in__t29 sel_in 148.826531653
* device instance sel_in_t30 r0 *1 0,0
Rsel_in_t30 sel_in__t30 sel_in 148.29853199
* device instance sel_in_t31 r0 *1 0,0
Rsel_in_t31 sel_in__t31 sel_in 39.0517671956
* device instance sel_in_t32 r0 *1 0,0
Rsel_in_t32 sel_in__t32 sel_in 11.9672283327
* device instance sel_in_t33 r0 *1 0,0
Rsel_in_t33 sel_in__t33 sel_in 75.4812071785
* device instance sel_in_t34 r0 *1 0,0
Rsel_in_t34 sel_in__t34 sel_in 148.476753564
* device instance sel_in_t35 r0 *1 0,0
Rsel_in_t35 sel_in__t35 sel_in 39.3946028756
* device instance sel_in_t36 r0 *1 0,0
Rsel_in_t36 sel_in__t36 sel_in 112.047076648
* device instance sel_in_t37 r0 *1 0,0
Rsel_in_t37 sel_in__t37 sel_in 102.502645232
* device instance sel_in_t38 r0 *1 0,0
Rsel_in_t38 sel_in__t38 sel_in 31.2748755219
* device instance sel_in_t39 r0 *1 0,0
Rsel_in_t39 sel_in__t39 sel_in 139.559245959
* device instance sel_in_t40 r0 *1 0,0
Rsel_in_t40 sel_in__t40 sel_in 139.322174957
* device instance sel_in_t41 r0 *1 0,0
Rsel_in_t41 sel_in__t41 sel_in 65.8830062688
* device instance sel_in_t42 r0 *1 0,0
Rsel_in_t42 sel_in__t42 sel_in 83.9775408175
* device instance sel_in_t43 r0 *1 0,0
Rsel_in_t43 sel_in__t43 sel_in 120.723972556
* device instance sel_in_t44 r0 *1 0,0
Rsel_in_t44 sel_in__t44 sel_in 14.8691007584
* device instance sel_in_t45 r0 *1 0,0
Rsel_in_t45 sel_in__t45 sel_in 16.9471193819
* device instance sel_in_t46 r0 *1 0,0
Rsel_in_t46 sel_in__t46 sel_in 48.3109331548
* device instance sel_in_t47 r0 *1 0,0
Rsel_in_t47 sel_in__t47 sel_in 47.6217551578
* device instance sel_in_t48 r0 *1 0,0
Rsel_in_t48 sel_in__t48 sel_in 30.1993897444
* device instance sel_in_t49 r0 *1 0,0
Rsel_in_t49 sel_in__t49 sel_in 102.824641879
* device instance sel_in_t50 r0 *1 0,0
Rsel_in_t50 sel_in__t50 sel_in 120.997488601
* device instance sel_in_t51 r0 *1 0,0
Rsel_in_t51 sel_in__t51 sel_in 66.3828683697
* device instance sel_in_t52 r0 *1 0,0
Rsel_in_t52 sel_in__t52 sel_in 84.3702676287
* device instance sel_in_t53 r0 *1 0,0
Rsel_in_t53 sel_in__t53 sel_in 157.58801391
* device instance sel_in r0 *1 0,0
Csel_in sel_in vsubs 1.11280818e-13
* device instance topn_t0 r0 *1 0,0
Rtopn_t0 topn__t0 topn 0.382165226954
* device instance topn_t1 r0 *1 0,0
Rtopn_t1 topn__t1 topn 1.57526024694
* device instance topn_t2 r0 *1 0,0
Rtopn_t2 topn__t2 topn 1.66573298021
* device instance topn_t3 r0 *1 0,0
Rtopn_t3 topn__t3 topn 1.53763181266
* device instance topn_t4 r0 *1 0,0
Rtopn_t4 topn__t4 topn 1.63019419306
* device instance topn_t5 r0 *1 0,0
Rtopn_t5 topn__t5 topn 1.45929289424
* device instance topn_t6 r0 *1 0,0
Rtopn_t6 topn__t6 topn 1.55652088549
* device instance topn_t7 r0 *1 0,0
Rtopn_t7 topn__t7 topn 1.61802825078
* device instance topn_t8 r0 *1 0,0
Rtopn_t8 topn__t8 topn 1.7062347248
* device instance topn_t9 r0 *1 0,0
Rtopn_t9 topn__t9 topn 0.347288281445
* device instance topn_t10 r0 *1 0,0
Rtopn_t10 topn__t10 topn 0.415672476475
* device instance topn_t11 r0 *1 0,0
Rtopn_t11 topn__t11 topn 0.340783443309
* device instance topn_t12 r0 *1 0,0
Rtopn_t12 topn__t12 topn 0.280927790058
* device instance topn_t13 r0 *1 0,0
Rtopn_t13 topn__t13 topn 0.247274769597
* device instance topn_t14 r0 *1 0,0
Rtopn_t14 topn__t14 topn 0.250612291378
* device instance topn_t15 r0 *1 0,0
Rtopn_t15 topn__t15 topn 0.289664547294
* device instance topn_t16 r0 *1 0,0
Rtopn_t16 topn__t16 topn 0.352763234744
* device instance topn_t17 r0 *1 0,0
Rtopn_t17 topn__t17 topn 0.429436339955
* device instance topn_t18 r0 *1 0,0
Rtopn_t18 topn__t18 topn 0.376441469286
* device instance topn_t19 r0 *1 0,0
Rtopn_t19 topn__t19 topn 0.426901077096
* device instance topn_t20 r0 *1 0,0
Rtopn_t20 topn__t20 topn 0.49215668228
* device instance topn_t21 r0 *1 0,0
Rtopn_t21 topn__t21 topn 0.467918935389
* device instance topn_t22 r0 *1 0,0
Rtopn_t22 topn__t22 topn 0.509396191509
* device instance topn_t23 r0 *1 0,0
Rtopn_t23 topn__t23 topn 0.56520628996
* device instance topn_t24 r0 *1 0,0
Rtopn_t24 topn__t24 topn 0.501174555789
* device instance topn_t25 r0 *1 0,0
Rtopn_t25 topn__t25 topn 0.462561350919
* device instance topn_t26 r0 *1 0,0
Rtopn_t26 topn__t26 topn 0.442930459345
* device instance topn_t27 r0 *1 0,0
Rtopn_t27 topn__t27 topn 0.444802316458
* device instance topn_t28 r0 *1 0,0
Rtopn_t28 topn__t28 topn 0.480193958248
* device instance topn_t29 r0 *1 0,0
Rtopn_t29 topn__t29 topn 0.60222493474
* device instance topn_t30 r0 *1 0,0
Rtopn_t30 topn__t30 topn 0.693513160426
* device instance topn_t31 r0 *1 0,0
Rtopn_t31 topn__t31 topn 0.786564336724
* device instance topn_t32 r0 *1 0,0
Rtopn_t32 topn__t32 topn 0.88081991825
* device instance topn_t33 r0 *1 0,0
Rtopn_t33 topn__t33 topn 0.975931002389
* device instance topn_t34 r0 *1 0,0
Rtopn_t34 topn__t34 topn 1.13292489383
* device instance topn_t35 r0 *1 0,0
Rtopn_t35 topn__t35 topn 1.07166983485
* device instance topn_t36 r0 *1 0,0
Rtopn_t36 topn__t36 topn 1.16788204408
* device instance topn_t37 r0 *1 0,0
Rtopn_t37 topn__t37 topn 1.26445957756
* device instance topn_t38 r0 *1 0,0
Rtopn_t38 topn__t38 topn 1.36132468506
* device instance topn_t39 r0 *1 0,0
Rtopn_t39 topn__t39 topn 0.554820861031
* device instance topn_t40 r0 *1 0,0
Rtopn_t40 topn__t40 topn 0.939487763114
* device instance topn_t41 r0 *1 0,0
Rtopn_t41 topn__t41 topn 0.853698074428
* device instance topn_t42 r0 *1 0,0
Rtopn_t42 topn__t42 topn 0.770973973609
* device instance topn_t43 r0 *1 0,0
Rtopn_t43 topn__t43 topn 0.692415088037
* device instance topn_t44 r0 *1 0,0
Rtopn_t44 topn__t44 topn 1.5823211473
* device instance topn_t45 r0 *1 0,0
Rtopn_t45 topn__t45 topn 1.52033033738
* device instance topn_t46 r0 *1 0,0
Rtopn_t46 topn__t46 topn 1.42179683386
* device instance topn_t47 r0 *1 0,0
Rtopn_t47 topn__t47 topn 1.323270743
* device instance topn_t48 r0 *1 0,0
Rtopn_t48 topn__t48 topn 1.22475385373
* device instance topn_t49 r0 *1 0,0
Rtopn_t49 topn__t49 topn 1.12624858074
* device instance topn_t50 r0 *1 0,0
Rtopn_t50 topn__t50 topn 1.02775826413
* device instance topn_t51 r0 *1 0,0
Rtopn_t51 topn__t51 topn 0.929287659349
* device instance topn_t52 r0 *1 0,0
Rtopn_t52 topn__t52 topn 0.830843775087
* device instance topn_t53 r0 *1 0,0
Rtopn_t53 topn__t53 topn 0.732437385613
* device instance topn_t54 r0 *1 0,0
Rtopn_t54 topn__t54 topn 0.634085948073
* device instance topn_t55 r0 *1 0,0
Rtopn_t55 topn__t55 topn 0.344887578086
* device instance topn_t56 r0 *1 0,0
Rtopn_t56 topn__t56 topn 1.48789855676
* device instance topn_t57 r0 *1 0,0
Rtopn_t57 topn__t57 topn 1.39405212876
* device instance topn_t58 r0 *1 0,0
Rtopn_t58 topn__t58 topn 1.55772278114
* device instance topn_t59 r0 *1 0,0
Rtopn_t59 topn__t59 topn 1.46171206635
* device instance topn_t60 r0 *1 0,0
Rtopn_t60 topn__t60 topn 1.36606785608
* device instance topn_t61 r0 *1 0,0
Rtopn_t61 topn__t61 topn 1.53905738459
* device instance topn_t62 r0 *1 0,0
Rtopn_t62 topn__t62 topn 1.44180426379
* device instance topn_t63 r0 *1 0,0
Rtopn_t63 topn__t63 topn 1.34474486709
* device instance topn_t64 r0 *1 0,0
Rtopn_t64 topn__t64 topn 1.24792439696
* device instance topn_t65 r0 *1 0,0
Rtopn_t65 topn__t65 topn 1.15140312833
* device instance topn_t66 r0 *1 0,0
Rtopn_t66 topn__t66 topn 1.05526316518
* device instance topn_t67 r0 *1 0,0
Rtopn_t67 topn__t67 topn 0.959619118255
* device instance topn_t68 r0 *1 0,0
Rtopn_t68 topn__t68 topn 0.864635574623
* device instance topn_t69 r0 *1 0,0
Rtopn_t69 topn__t69 topn 0.417056333212
* device instance topn_t70 r0 *1 0,0
Rtopn_t70 topn__t70 topn 0.369760805205
* device instance topn_t71 r0 *1 0,0
Rtopn_t71 topn__t71 topn 0.535819723137
* device instance topn_t72 r0 *1 0,0
Rtopn_t72 topn__t72 topn 0.858765636833
* device instance topn_t73 r0 *1 0,0
Rtopn_t73 topn__t73 topn 0.956073225252
* device instance topn_t74 r0 *1 0,0
Rtopn_t74 topn__t74 topn 1.0536180169
* device instance topn_t75 r0 *1 0,0
Rtopn_t75 topn__t75 topn 1.15133972375
* device instance topn_t76 r0 *1 0,0
Rtopn_t76 topn__t76 topn 1.24919682753
* device instance topn_t77 r0 *1 0,0
Rtopn_t77 topn__t77 topn 1.34715982303
* device instance topn_t78 r0 *1 0,0
Rtopn_t78 topn__t78 topn 0.552613403493
* device instance topn_t79 r0 *1 0,0
Rtopn_t79 topn__t79 topn 0.650897231045
* device instance topn_t80 r0 *1 0,0
Rtopn_t80 topn__t80 topn 0.749259739679
* device instance topn_t81 r0 *1 0,0
Rtopn_t81 topn__t81 topn 0.847673539804
* device instance topn_t82 r0 *1 0,0
Rtopn_t82 topn__t82 topn 0.946122625837
* device instance topn_t83 r0 *1 0,0
Rtopn_t83 topn__t83 topn 0.164686317567
* device instance topn_t84 r0 *1 0,0
Rtopn_t84 topn__t84 topn 0.260111385798
* device instance topn_t85 r0 *1 0,0
Rtopn_t85 topn__t85 topn 0.35725565539
* device instance topn_t86 r0 *1 0,0
Rtopn_t86 topn__t86 topn 0.0776051146797
* device instance topn_t87 r0 *1 0,0
Rtopn_t87 topn__t87 topn 1.31677659587
* device instance topn_t88 r0 *1 0,0
Rtopn_t88 topn__t88 topn 0.242569694998
* device instance topn_t89 r0 *1 0,0
Rtopn_t89 topn__t89 topn 0.147061636482
* device instance topn_t90 r0 *1 0,0
Rtopn_t90 topn__t90 topn 0.0620605621708
* device instance topn_t91 r0 *1 0,0
Rtopn_t91 topn__t91 topn 0.0742510760032
* device instance topn_t92 r0 *1 0,0
Rtopn_t92 topn__t92 topn 0.163132619843
* device instance topn_t93 r0 *1 0,0
Rtopn_t93 topn__t93 topn 0.259130471934
* device instance topn_t94 r0 *1 0,0
Rtopn_t94 topn__t94 topn 0.356542103785
* device instance topn_t95 r0 *1 0,0
Rtopn_t95 topn__t95 topn 0.34058720019
* device instance topn_t96 r0 *1 0,0
Rtopn_t96 topn__t96 topn 0.366631011125
* device instance topn_t97 r0 *1 0,0
Rtopn_t97 topn__t97 topn 0.278869227154
* device instance topn_t98 r0 *1 0,0
Rtopn_t98 topn__t98 topn 0.201383002874
* device instance topn_t99 r0 *1 0,0
Rtopn_t99 topn__t99 topn 0.150928798772
* device instance topn_t100 r0 *1 0,0
Rtopn_t100 topn__t100 topn 0.156336851732
* device instance topn_t101 r0 *1 0,0
Rtopn_t101 topn__t101 topn 0.213401594602
* device instance topn_t102 r0 *1 0,0
Rtopn_t102 topn__t102 topn 0.29338812247
* device instance topn_t103 r0 *1 0,0
Rtopn_t103 topn__t103 topn 0.339838652005
* device instance topn_t104 r0 *1 0,0
Rtopn_t104 topn__t104 topn 0.868173966404
* device instance topn_t105 r0 *1 0,0
Rtopn_t105 topn__t105 topn 0.648442365875
* device instance topn_t106 r0 *1 0,0
Rtopn_t106 topn__t106 topn 1.04282496209
* device instance topn_t107 r0 *1 0,0
Rtopn_t107 topn__t107 topn 0.734004859333
* device instance topn_t108 r0 *1 0,0
Rtopn_t108 topn__t108 topn 0.822487741942
* device instance topn_t109 r0 *1 0,0
Rtopn_t109 topn__t109 topn 0.913042363872
* device instance topn_t110 r0 *1 0,0
Rtopn_t110 topn__t110 topn 1.00510892507
* device instance topn_t111 r0 *1 0,0
Rtopn_t111 topn__t111 topn 1.09830727247
* device instance topn_t112 r0 *1 0,0
Rtopn_t112 topn__t112 topn 1.1923720471
* device instance topn_t113 r0 *1 0,0
Rtopn_t113 topn__t113 topn 1.28711330237
* device instance topn_t114 r0 *1 0,0
Rtopn_t114 topn__t114 topn 1.38239195889
* device instance topn_t115 r0 *1 0,0
Rtopn_t115 topn__t115 topn 1.4100522963
* device instance topn_t116 r0 *1 0,0
Rtopn_t116 topn__t116 topn 0.95440364025
* device instance topn_t117 r0 *1 0,0
Rtopn_t117 topn__t117 topn 0.705490929891
* device instance topn_t118 r0 *1 0,0
Rtopn_t118 topn__t118 topn 1.22433289959
* device instance topn_t119 r0 *1 0,0
Rtopn_t119 topn__t119 topn 0.761786155312
* device instance topn_t120 r0 *1 0,0
Rtopn_t120 topn__t120 topn 1.04459702116
* device instance topn_t121 r0 *1 0,0
Rtopn_t121 topn__t121 topn 1.14309018479
* device instance topn_t122 r0 *1 0,0
Rtopn_t122 topn__t122 topn 1.2415976502
* device instance topn_t123 r0 *1 0,0
Rtopn_t123 topn__t123 topn 1.34011626356
* device instance topn_t124 r0 *1 0,0
Rtopn_t124 topn__t124 topn 0.553074050428
* device instance topn_t125 r0 *1 0,0
Rtopn_t125 topn__t125 topn 0.651288366946
* device instance topn_t126 r0 *1 0,0
Rtopn_t126 topn__t126 topn 0.749599552455
* device instance topn_t127 r0 *1 0,0
Rtopn_t127 topn__t127 topn 0.847973915648
* device instance topn_t128 r0 *1 0,0
Rtopn_t128 topn__t128 topn 0.946391755384
* device instance topn_t129 r0 *1 0,0
Rtopn_t129 topn__t129 topn 1.04484078603
* device instance topn_t130 r0 *1 0,0
Rtopn_t130 topn__t130 topn 1.14331295021
* device instance topn_t131 r0 *1 0,0
Rtopn_t131 topn__t131 topn 1.24180274461
* device instance topn_t132 r0 *1 0,0
Rtopn_t132 topn__t132 topn 1.34030628268
* device instance topn_t133 r0 *1 0,0
Rtopn_t133 topn__t133 topn 0.569481836973
* device instance topn_t134 r0 *1 0,0
Rtopn_t134 topn__t134 topn 0.665278283355
* device instance topn_t135 r0 *1 0,0
Rtopn_t135 topn__t135 topn 0.784858639388
* device instance topn_t136 r0 *1 0,0
Rtopn_t136 topn__t136 topn 1.02757551171
* device instance topn_t137 r0 *1 0,0
Rtopn_t137 topn__t137 topn 1.50552836488
* device instance topn_t138 r0 *1 0,0
Rtopn_t138 topn__t138 topn 1.57530268834
* device instance topn_t139 r0 *1 0,0
Rtopn_t139 topn__t139 topn 1.47930965119
* device instance topn_t140 r0 *1 0,0
Rtopn_t140 topn__t140 topn 1.59994911583
* device instance topn_t141 r0 *1 0,0
Rtopn_t141 topn__t141 topn 1.08230447548
* device instance topn_t142 r0 *1 0,0
Rtopn_t142 topn__t142 topn 1.5265426046
* device instance topn_t143 r0 *1 0,0
Rtopn_t143 topn__t143 topn 1.42843768702
* device instance topn_t144 r0 *1 0,0
Rtopn_t144 topn__t144 topn 1.33040349075
* device instance topn_t145 r0 *1 0,0
Rtopn_t145 topn__t145 topn 1.2324568922
* device instance topn_t146 r0 *1 0,0
Rtopn_t146 topn__t146 topn 1.13462057735
* device instance topn_t147 r0 *1 0,0
Rtopn_t147 topn__t147 topn 1.03692576321
* device instance topn_t148 r0 *1 0,0
Rtopn_t148 topn__t148 topn 1.52049783502
* device instance topn_t149 r0 *1 0,0
Rtopn_t149 topn__t149 topn 1.42197593802
* device instance topn_t150 r0 *1 0,0
Rtopn_t150 topn__t150 topn 1.32346318075
* device instance topn_t151 r0 *1 0,0
Rtopn_t151 topn__t151 topn 1.22496176828
* device instance topn_t152 r0 *1 0,0
Rtopn_t152 topn__t152 topn 1.12647467666
* device instance topn_t153 r0 *1 0,0
Rtopn_t153 topn__t153 topn 1.02800602188
* device instance topn_t154 r0 *1 0,0
Rtopn_t154 topn__t154 topn 0.929561663019
* device instance topn_t155 r0 *1 0,0
Rtopn_t155 topn__t155 topn 0.831150233194
* device instance topn_t156 r0 *1 0,0
Rtopn_t156 topn__t156 topn 0.634487447536
* device instance topn_t157 r0 *1 0,0
Rtopn_t157 topn__t157 topn 0.536294795089
* device instance topn_t158 r0 *1 0,0
Rtopn_t158 topn__t158 topn 0.939416597011
* device instance topn_t159 r0 *1 0,0
Rtopn_t159 topn__t159 topn 0.842157566922
* device instance topn_t160 r0 *1 0,0
Rtopn_t160 topn__t160 topn 0.745246612045
* device instance topn_t161 r0 *1 0,0
Rtopn_t161 topn__t161 topn 0.648839717084
* device instance topn_t162 r0 *1 0,0
Rtopn_t162 topn__t162 topn 0.553200474172
* device instance topn_t163 r0 *1 0,0
Rtopn_t163 topn__t163 topn 0.989278263159
* device instance topn_t164 r0 *1 0,0
Rtopn_t164 topn__t164 topn 0.897439305325
* device instance topn_t165 r0 *1 0,0
Rtopn_t165 topn__t165 topn 0.807192945946
* device instance topn_t166 r0 *1 0,0
Rtopn_t166 topn__t166 topn 0.719139011377
* device instance topn_t167 r0 *1 0,0
Rtopn_t167 topn__t167 topn 0.634191377932
* device instance topn_t168 r0 *1 0,0
Rtopn_t168 topn__t168 topn 1.30090656108
* device instance topn_t169 r0 *1 0,0
Rtopn_t169 topn__t169 topn 1.20862390514
* device instance topn_t170 r0 *1 0,0
Rtopn_t170 topn__t170 topn 1.11741797369
* device instance topn_t171 r0 *1 0,0
Rtopn_t171 topn__t171 topn 0.732784999424
* device instance topn_t172 r0 *1 0,0
Rtopn_t172 topn__t172 topn 1.4457357223
* device instance topn_t173 r0 *1 0,0
Rtopn_t173 topn__t173 topn 1.54381776597
* device instance topn_t174 r0 *1 0,0
Rtopn_t174 topn__t174 topn 1.17623628314
* device instance topn_t175 r0 *1 0,0
Rtopn_t175 topn__t175 topn 1.27087290095
* device instance topn_t176 r0 *1 0,0
Rtopn_t176 topn__t176 topn 0.586852685096
* device instance topn_t177 r0 *1 0,0
Rtopn_t177 topn__t177 topn 0.677759756732
* device instance topn_t178 r0 *1 0,0
Rtopn_t178 topn__t178 topn 0.770556826033
* device instance topn_t179 r0 *1 0,0
Rtopn_t179 topn__t179 topn 0.623295872432
* device instance topn_t180 r0 *1 0,0
Rtopn_t180 topn__t180 topn 0.69727589835
* device instance topn_t181 r0 *1 0,0
Rtopn_t181 topn__t181 topn 0.776741226348
* device instance topn_t182 r0 *1 0,0
Rtopn_t182 topn__t182 topn 0.86017295206
* device instance topn_t183 r0 *1 0,0
Rtopn_t183 topn__t183 topn 1.05646912188
* device instance topn_t184 r0 *1 0,0
Rtopn_t184 topn__t184 topn 1.15250849091
* device instance topn_t185 r0 *1 0,0
Rtopn_t185 topn__t185 topn 1.24894433751
* device instance topn_t186 r0 *1 0,0
Rtopn_t186 topn__t186 topn 1.34569142646
* device instance topn_t187 r0 *1 0,0
Rtopn_t187 topn__t187 topn 1.44268714307
* device instance topn_t188 r0 *1 0,0
Rtopn_t188 topn__t188 topn 1.53988450565
* device instance topn_t189 r0 *1 0,0
Rtopn_t189 topn__t189 topn 0.589018447664
* device instance topn_t190 r0 *1 0,0
Rtopn_t190 topn__t190 topn 0.636996094652
* device instance topn_t191 r0 *1 0,0
Rtopn_t191 topn__t191 topn 0.721613635156
* device instance topn_t192 r0 *1 0,0
Rtopn_t192 topn__t192 topn 0.809398401742
* device instance topn_t193 r0 *1 0,0
Rtopn_t193 topn__t193 topn 0.513875922529
* device instance topn_t194 r0 *1 0,0
Rtopn_t194 topn__t194 topn 0.991078605721
* device instance topn_t195 r0 *1 0,0
Rtopn_t195 topn__t195 topn 1.083950321
* device instance topn_t196 r0 *1 0,0
Rtopn_t196 topn__t196 topn 1.17775087116
* device instance topn_t197 r0 *1 0,0
Rtopn_t197 topn__t197 topn 1.27227483317
* device instance topn_t198 r0 *1 0,0
Rtopn_t198 topn__t198 topn 1.3673721908
* device instance topn_t199 r0 *1 0,0
Rtopn_t199 topn__t199 topn 1.46293112814
* device instance topn_t200 r0 *1 0,0
Rtopn_t200 topn__t200 topn 1.55886676264
* device instance topn_t201 r0 *1 0,0
Rtopn_t201 topn__t201 topn 0.679635891879
* device instance topn_t202 r0 *1 0,0
Rtopn_t202 topn__t202 topn 0.695717354946
* device instance topn_t203 r0 *1 0,0
Rtopn_t203 topn__t203 topn 0.773941116503
* device instance topn_t204 r0 *1 0,0
Rtopn_t204 topn__t204 topn 0.856378646461
* device instance topn_t205 r0 *1 0,0
Rtopn_t205 topn__t205 topn 0.941924222468
* device instance topn_t206 r0 *1 0,0
Rtopn_t206 topn__t206 topn 1.02980358131
* device instance topn_t207 r0 *1 0,0
Rtopn_t207 topn__t207 topn 1.11946724461
* device instance topn_t208 r0 *1 0,0
Rtopn_t208 topn__t208 topn 1.21051878461
* device instance topn_t209 r0 *1 0,0
Rtopn_t209 topn__t209 topn 0.899423497303
* device instance topn_t210 r0 *1 0,0
Rtopn_t210 topn__t210 topn 1.48359001758
* device instance topn_t211 r0 *1 0,0
Rtopn_t211 topn__t211 topn 0.779633409731
* device instance topn_t212 r0 *1 0,0
Rtopn_t212 topn__t212 topn 0.898439051886
* device instance topn_t213 r0 *1 0,0
Rtopn_t213 topn__t213 topn 0.832003915924
* device instance topn_t214 r0 *1 0,0
Rtopn_t214 topn__t214 topn 0.90982549304
* device instance topn_t215 r0 *1 0,0
Rtopn_t215 topn__t215 topn 1.68881141245
* device instance topn_t216 r0 *1 0,0
Rtopn_t216 topn__t216 topn 1.60068294452
* device instance topn_t217 r0 *1 0,0
Rtopn_t217 topn__t217 topn 1.03766229238
* device instance topn_t218 r0 *1 0,0
Rtopn_t218 topn__t218 topn 1.51384448057
* device instance topn_t219 r0 *1 0,0
Rtopn_t219 topn__t219 topn 1.13529372814
* device instance topn_t220 r0 *1 0,0
Rtopn_t220 topn__t220 topn 1.23307663418
* device instance topn_t221 r0 *1 0,0
Rtopn_t221 topn__t221 topn 1.33097762671
* device instance topn_t222 r0 *1 0,0
Rtopn_t222 topn__t222 topn 1.42897243511
* device instance topn_t223 r0 *1 0,0
Rtopn_t223 topn__t223 topn 1.52704299818
* device instance topn_t224 r0 *1 0,0
Rtopn_t224 topn__t224 topn 1.42853129273
* device instance topn_t225 r0 *1 0,0
Rtopn_t225 topn__t225 topn 0.55699114106
* device instance topn_t226 r0 *1 0,0
Rtopn_t226 topn__t226 topn 1.26371147877
* device instance topn_t227 r0 *1 0,0
Rtopn_t227 topn__t227 topn 1.18501274504
* device instance topn_t228 r0 *1 0,0
Rtopn_t228 topn__t228 topn 1.10949584528
* device instance topn_t229 r0 *1 0,0
Rtopn_t229 topn__t229 topn 1.03785556602
* device instance topn_t230 r0 *1 0,0
Rtopn_t230 topn__t230 topn 0.97095038062
* device instance topn_t231 r0 *1 0,0
Rtopn_t231 topn__t231 topn 1.64819054577
* device instance topn_t232 r0 *1 0,0
Rtopn_t232 topn__t232 topn 1.55776570035
* device instance topn_t233 r0 *1 0,0
Rtopn_t233 topn__t233 topn 1.46839136462
* device instance topn_t234 r0 *1 0,0
Rtopn_t234 topn__t234 topn 1.38027161915
* device instance topn_t235 r0 *1 0,0
Rtopn_t235 topn__t235 topn 1.29366286413
* device instance topn_t236 r0 *1 0,0
Rtopn_t236 topn__t236 topn 1.20888989983
* device instance topn_t237 r0 *1 0,0
Rtopn_t237 topn__t237 topn 1.12636729988
* device instance topn_t238 r0 *1 0,0
Rtopn_t238 topn__t238 topn 1.04662749773
* device instance topn_t239 r0 *1 0,0
Rtopn_t239 topn__t239 topn 0.970356771633
* device instance topn_t240 r0 *1 0,0
Rtopn_t240 topn__t240 topn 0.501415833722
* device instance topn_t241 r0 *1 0,0
Rtopn_t241 topn__t241 topn 1.34503364929
* device instance topn_t242 r0 *1 0,0
Rtopn_t242 topn__t242 topn 1.04152971584
* device instance topn_t243 r0 *1 0,0
Rtopn_t243 topn__t243 topn 1.11293351272
* device instance topn_t244 r0 *1 0,0
Rtopn_t244 topn__t244 topn 1.18823195503
* device instance topn_t245 r0 *1 0,0
Rtopn_t245 topn__t245 topn 1.26673070328
* device instance topn_t246 r0 *1 0,0
Rtopn_t246 topn__t246 topn 1.3478707248
* device instance topn_t247 r0 *1 0,0
Rtopn_t247 topn__t247 topn 1.43120286031
* device instance topn_t248 r0 *1 0,0
Rtopn_t248 topn__t248 topn 1.51636574889
* device instance topn_t249 r0 *1 0,0
Rtopn_t249 topn__t249 topn 1.60306764109
* device instance topn_t250 r0 *1 0,0
Rtopn_t250 topn__t250 topn 1.69107183759
* device instance topn_t251 r0 *1 0,0
Rtopn_t251 topn__t251 topn 0.472791829379
* device instance topn_t252 r0 *1 0,0
Rtopn_t252 topn__t252 topn 0.449925643365
* device instance topn_t253 r0 *1 0,0
Rtopn_t253 topn__t253 topn 0.448075189725
* device instance topn_t254 r0 *1 0,0
Rtopn_t254 topn__t254 topn 0.467490093152
* device instance topn_t255 r0 *1 0,0
Rtopn_t255 topn__t255 topn 0.505727119306
* device instance topn_t256 r0 *1 0,0
Rtopn_t256 topn__t256 topn 0.558936643697
* device instance topn_t257 r0 *1 0,0
Rtopn_t257 topn__t257 topn 1.30266721172
* device instance topn_t258 r0 *1 0,0
Rtopn_t258 topn__t258 topn 0.707918822053
* device instance topn_t259 r0 *1 0,0
Rtopn_t259 topn__t259 topn 0.570258284828
* device instance topn_t260 r0 *1 0,0
Rtopn_t260 topn__t260 topn 0.786309298498
* device instance topn_t261 r0 *1 0,0
Rtopn_t261 topn__t261 topn 0.868822702081
* device instance topn_t262 r0 *1 0,0
Rtopn_t262 topn__t262 topn 1.41167682638
* device instance topn_t263 r0 *1 0,0
Rtopn_t263 topn__t263 topn 1.31851605499
* device instance topn_t264 r0 *1 0,0
Rtopn_t264 topn__t264 topn 1.22620350385
* device instance topn_t265 r0 *1 0,0
Rtopn_t265 topn__t265 topn 1.13494616563
* device instance topn_t266 r0 *1 0,0
Rtopn_t266 topn__t266 topn 1.04502051912
* device instance topn_t267 r0 *1 0,0
Rtopn_t267 topn__t267 topn 0.956802117657
* device instance topn_t268 r0 *1 0,0
Rtopn_t268 topn__t268 topn 0.870809979142
* device instance topn_t269 r0 *1 0,0
Rtopn_t269 topn__t269 topn 0.787773487528
* device instance topn_t270 r0 *1 0,0
Rtopn_t270 topn__t270 topn 0.708732273846
* device instance topn_t271 r0 *1 0,0
Rtopn_t271 topn__t271 topn 0.635179600418
* device instance topn_t272 r0 *1 0,0
Rtopn_t272 topn__t272 topn 0.56924698861
* device instance topn_t273 r0 *1 0,0
Rtopn_t273 topn__t273 topn 0.516113571322
* device instance topn_t274 r0 *1 0,0
Rtopn_t274 topn__t274 topn 1.39569528248
* device instance topn_t275 r0 *1 0,0
Rtopn_t275 topn__t275 topn 1.48943818235
* device instance topn_t276 r0 *1 0,0
Rtopn_t276 topn__t276 topn 0.772467230846
* device instance topn_t277 r0 *1 0,0
Rtopn_t277 topn__t277 topn 0.855720476793
* device instance topn_t278 r0 *1 0,0
Rtopn_t278 topn__t278 topn 1.58376898474
* device instance topn_t279 r0 *1 0,0
Rtopn_t279 topn__t279 topn 0.77220753676
* device instance topn_t280 r0 *1 0,0
Rtopn_t280 topn__t280 topn 0.762704773686
* device instance topn_t281 r0 *1 0,0
Rtopn_t281 topn__t281 topn 0.834674059525
* device instance topn_t282 r0 *1 0,0
Rtopn_t282 topn__t282 topn 0.911636067707
* device instance topn_t283 r0 *1 0,0
Rtopn_t283 topn__t283 topn 0.992429934404
* device instance topn_t284 r0 *1 0,0
Rtopn_t284 topn__t284 topn 1.07619298916
* device instance topn_t285 r0 *1 0,0
Rtopn_t285 topn__t285 topn 1.16228346181
* device instance topn_t286 r0 *1 0,0
Rtopn_t286 topn__t286 topn 1.25022064522
* device instance topn_t287 r0 *1 0,0
Rtopn_t287 topn__t287 topn 1.33964092141
* device instance topn_t288 r0 *1 0,0
Rtopn_t288 topn__t288 topn 1.43026614844
* device instance topn_t289 r0 *1 0,0
Rtopn_t289 topn__t289 topn 0.974876717682
* device instance topn_t290 r0 *1 0,0
Rtopn_t290 topn__t290 topn 1.61431723365
* device instance topn_t291 r0 *1 0,0
Rtopn_t291 topn__t291 topn 0.866106999503
* device instance topn_t292 r0 *1 0,0
Rtopn_t292 topn__t292 topn 0.835973579781
* device instance topn_t293 r0 *1 0,0
Rtopn_t293 topn__t293 topn 0.902116422604
* device instance topn_t294 r0 *1 0,0
Rtopn_t294 topn__t294 topn 0.973762586174
* device instance topn_t295 r0 *1 0,0
Rtopn_t295 topn__t295 topn 1.04978589674
* device instance topn_t296 r0 *1 0,0
Rtopn_t296 topn__t296 topn 1.12930270707
* device instance topn_t297 r0 *1 0,0
Rtopn_t297 topn__t297 topn 1.21162539586
* device instance topn_t298 r0 *1 0,0
Rtopn_t298 topn__t298 topn 1.29621947062
* device instance topn_t299 r0 *1 0,0
Rtopn_t299 topn__t299 topn 1.38266809199
* device instance topn_t300 r0 *1 0,0
Rtopn_t300 topn__t300 topn 1.47064424986
* device instance topn_t301 r0 *1 0,0
Rtopn_t301 topn__t301 topn 1.55988951121
* device instance topn_t302 r0 *1 0,0
Rtopn_t302 topn__t302 topn 1.65019798362
* device instance topn_t303 r0 *1 0,0
Rtopn_t303 topn__t303 topn 0.960945112795
* device instance topn_t304 r0 *1 0,0
Rtopn_t304 topn__t304 topn 0.914014442358
* device instance topn_t305 r0 *1 0,0
Rtopn_t305 topn__t305 topn 1.52188108369
* device instance topn_t306 r0 *1 0,0
Rtopn_t306 topn__t306 topn 1.62847488779
* device instance topn_t307 r0 *1 0,0
Rtopn_t307 topn__t307 topn 1.53580888928
* device instance topn_t308 r0 *1 0,0
Rtopn_t308 topn__t308 topn 1.44392685031
* device instance topn_t309 r0 *1 0,0
Rtopn_t309 topn__t309 topn 1.35298849743
* device instance topn_t310 r0 *1 0,0
Rtopn_t310 topn__t310 topn 1.26319765665
* device instance topn_t311 r0 *1 0,0
Rtopn_t311 topn__t311 topn 1.17481746915
* device instance topn_t312 r0 *1 0,0
Rtopn_t312 topn__t312 topn 1.08819169833
* device instance topn_t313 r0 *1 0,0
Rtopn_t313 topn__t313 topn 1.00377466559
* device instance topn_t314 r0 *1 0,0
Rtopn_t314 topn__t314 topn 0.922173143557
* device instance topn_t315 r0 *1 0,0
Rtopn_t315 topn__t315 topn 0.844203976879
* device instance topn_t316 r0 *1 0,0
Rtopn_t316 topn__t316 topn 0.770969988336
* device instance topn_t317 r0 *1 0,0
Rtopn_t317 topn__t317 topn 0.703950574765
* device instance topn_t318 r0 *1 0,0
Rtopn_t318 topn__t318 topn 0.645085591969
* device instance topn_t319 r0 *1 0,0
Rtopn_t319 topn__t319 topn 0.596792887592
* device instance topn_t320 r0 *1 0,0
Rtopn_t320 topn__t320 topn 0.56180548311
* device instance topn_t321 r0 *1 0,0
Rtopn_t321 topn__t321 topn 1.3952392144
* device instance topn_t322 r0 *1 0,0
Rtopn_t322 topn__t322 topn 0.541169716976
* device instance topn_t323 r0 *1 0,0
Rtopn_t323 topn__t323 topn 0.55735112283
* device instance topn_t324 r0 *1 0,0
Rtopn_t324 topn__t324 topn 0.589790815566
* device instance topn_t325 r0 *1 0,0
Rtopn_t325 topn__t325 topn 0.636005863646
* device instance topn_t326 r0 *1 0,0
Rtopn_t326 topn__t326 topn 0.693246732063
* device instance topn_t327 r0 *1 0,0
Rtopn_t327 topn__t327 topn 0.75902300683
* device instance topn_t328 r0 *1 0,0
Rtopn_t328 topn__t328 topn 0.831311096244
* device instance topn_t329 r0 *1 0,0
Rtopn_t329 topn__t329 topn 0.908558018532
* device instance topn_t330 r0 *1 0,0
Rtopn_t330 topn__t330 topn 0.989603217354
* device instance topn_t331 r0 *1 0,0
Rtopn_t331 topn__t331 topn 1.07358684
* device instance topn_t332 r0 *1 0,0
Rtopn_t332 topn__t332 topn 1.1598707681
* device instance topn_t333 r0 *1 0,0
Rtopn_t333 topn__t333 topn 1.24797797049
* device instance topn_t334 r0 *1 0,0
Rtopn_t334 topn__t334 topn 1.33754818658
* device instance topn_t335 r0 *1 0,0
Rtopn_t335 topn__t335 topn 1.42830620263
* device instance topn_t336 r0 *1 0,0
Rtopn_t336 topn__t336 topn 1.5200392712
* device instance topn_t337 r0 *1 0,0
Rtopn_t337 topn__t337 topn 0.542702839022
* device instance topn_t338 r0 *1 0,0
Rtopn_t338 topn__t338 topn 0.919815865162
* device instance topn_t339 r0 *1 0,0
Rtopn_t339 topn__t339 topn 0.982011638152
* device instance topn_t340 r0 *1 0,0
Rtopn_t340 topn__t340 topn 1.04979512744
* device instance topn_t341 r0 *1 0,0
Rtopn_t341 topn__t341 topn 1.12215421497
* device instance topn_t342 r0 *1 0,0
Rtopn_t342 topn__t342 topn 1.19826027023
* device instance topn_t343 r0 *1 0,0
Rtopn_t343 topn__t343 topn 1.27744377125
* device instance topn_t344 r0 *1 0,0
Rtopn_t344 topn__t344 topn 1.35916695908
* device instance topn_t345 r0 *1 0,0
Rtopn_t345 topn__t345 topn 1.44299839815
* device instance topn_t346 r0 *1 0,0
Rtopn_t346 topn__t346 topn 1.52859126386
* device instance topn_t347 r0 *1 0,0
Rtopn_t347 topn__t347 topn 0.810043184948
* device instance topn_t348 r0 *1 0,0
Rtopn_t348 topn__t348 topn 0.774286580676
* device instance topn_t349 r0 *1 0,0
Rtopn_t349 topn__t349 topn 0.749871173608
* device instance topn_t350 r0 *1 0,0
Rtopn_t350 topn__t350 topn 0.737923549875
* device instance topn_t351 r0 *1 0,0
Rtopn_t351 topn__t351 topn 0.73904862788
* device instance topn_t352 r0 *1 0,0
Rtopn_t352 topn__t352 topn 0.753187827663
* device instance topn_t353 r0 *1 0,0
Rtopn_t353 topn__t353 topn 1.61258100074
* device instance topn_t354 r0 *1 0,0
Rtopn_t354 topn__t354 topn 0.681151816662
* device instance topn_t355 r0 *1 0,0
Rtopn_t355 topn__t355 topn 0.653264774295
* device instance topn_t356 r0 *1 0,0
Rtopn_t356 topn__t356 topn 0.639514858144
* device instance topn_t357 r0 *1 0,0
Rtopn_t357 topn__t357 topn 0.640812736061
* device instance topn_t358 r0 *1 0,0
Rtopn_t358 topn__t358 topn 0.657069244499
* device instance topn_t359 r0 *1 0,0
Rtopn_t359 topn__t359 topn 0.687223647654
* device instance topn_t360 r0 *1 0,0
Rtopn_t360 topn__t360 topn 0.729554667027
* device instance topn_t361 r0 *1 0,0
Rtopn_t361 topn__t361 topn 0.782087592873
* device instance topn_t362 r0 *1 0,0
Rtopn_t362 topn__t362 topn 0.842917145472
* device instance topn_t363 r0 *1 0,0
Rtopn_t363 topn__t363 topn 0.910381758271
* device instance topn_t364 r0 *1 0,0
Rtopn_t364 topn__t364 topn 0.983116421343
* device instance topn_t365 r0 *1 0,0
Rtopn_t365 topn__t365 topn 1.06003687223
* device instance topn_t366 r0 *1 0,0
Rtopn_t366 topn__t366 topn 1.14029634899
* device instance topn_t367 r0 *1 0,0
Rtopn_t367 topn__t367 topn 1.22323778434
* device instance topn_t368 r0 *1 0,0
Rtopn_t368 topn__t368 topn 1.30835121851
* device instance topn_t369 r0 *1 0,0
Rtopn_t369 topn__t369 topn 0.721538668268
* device instance topn_t370 r0 *1 0,0
Rtopn_t370 topn__t370 topn 0.619607747498
* device instance topn_t371 r0 *1 0,0
Rtopn_t371 topn__t371 topn 0.553781374246
* device instance topn_t372 r0 *1 0,0
Rtopn_t372 topn__t372 topn 0.498869903504
* device instance topn_t373 r0 *1 0,0
Rtopn_t373 topn__t373 topn 0.458809188271
* device instance topn_t374 r0 *1 0,0
Rtopn_t374 topn__t374 topn 0.437696107271
* device instance topn_t375 r0 *1 0,0
Rtopn_t375 topn__t375 topn 0.438277553449
* device instance topn_t376 r0 *1 0,0
Rtopn_t376 topn__t376 topn 1.34772682076
* device instance topn_t377 r0 *1 0,0
Rtopn_t377 topn__t377 topn 1.2498082687
* device instance topn_t378 r0 *1 0,0
Rtopn_t378 topn__t378 topn 1.15200310508
* device instance topn_t379 r0 *1 0,0
Rtopn_t379 topn__t379 topn 1.05434288547
* device instance topn_t380 r0 *1 0,0
Rtopn_t380 topn__t380 topn 0.956871990735
* device instance topn_t381 r0 *1 0,0
Rtopn_t381 topn__t381 topn 0.859654822365
* device instance topn_t382 r0 *1 0,0
Rtopn_t382 topn__t382 topn 0.762788398598
* device instance topn_t383 r0 *1 0,0
Rtopn_t383 topn__t383 topn 0.666425681464
* device instance topn_t384 r0 *1 0,0
Rtopn_t384 topn__t384 topn 0.570821826188
* device instance topn_t385 r0 *1 0,0
Rtopn_t385 topn__t385 topn 0.864414781572
* device instance topn_t386 r0 *1 0,0
Rtopn_t386 topn__t386 topn 0.384159153612
* device instance topn_t387 r0 *1 0,0
Rtopn_t387 topn__t387 topn 0.295980717306
* device instance topn_t388 r0 *1 0,0
Rtopn_t388 topn__t388 topn 0.216952149538
* device instance topn_t389 r0 *1 0,0
Rtopn_t389 topn__t389 topn 0.161149637976
* device instance topn_t390 r0 *1 0,0
Rtopn_t390 topn__t390 topn 0.155908617174
* device instance topn_t391 r0 *1 0,0
Rtopn_t391 topn__t391 topn 0.205141678986
* device instance topn_t392 r0 *1 0,0
Rtopn_t392 topn__t392 topn 0.281595526356
* device instance topn_t393 r0 *1 0,0
Rtopn_t393 topn__t393 topn 0.368708954229
* device instance topn_t394 r0 *1 0,0
Rtopn_t394 topn__t394 topn 0.460471351826
* device instance topn_t395 r0 *1 0,0
Rtopn_t395 topn__t395 topn 0.554579804208
* device instance topn_t396 r0 *1 0,0
Rtopn_t396 topn__t396 topn 0.650016132935
* device instance topn_t397 r0 *1 0,0
Rtopn_t397 topn__t397 topn 0.746271068296
* device instance topn_t398 r0 *1 0,0
Rtopn_t398 topn__t398 topn 0.843064269278
* device instance topn_t399 r0 *1 0,0
Rtopn_t399 topn__t399 topn 0.940229513125
* device instance topn_t400 r0 *1 0,0
Rtopn_t400 topn__t400 topn 0.817191485427
* device instance topn_t401 r0 *1 0,0
Rtopn_t401 topn__t401 topn 0.476433884237
* device instance topn_t402 r0 *1 0,0
Rtopn_t402 topn__t402 topn 0.148783253297
* device instance topn_t403 r0 *1 0,0
Rtopn_t403 topn__t403 topn 0.243617299197
* device instance topn_t404 r0 *1 0,0
Rtopn_t404 topn__t404 topn 0.651185705171
* device instance topn_t405 r0 *1 0,0
Rtopn_t405 topn__t405 topn 1.50400521064
* device instance topn_t406 r0 *1 0,0
Rtopn_t406 topn__t406 topn 1.59851593343
* device instance topn_t407 r0 *1 0,0
Rtopn_t407 topn__t407 topn 1.4781040976
* device instance topn_t408 r0 *1 0,0
Rtopn_t408 topn__t408 topn 1.45842006757
* device instance topn_t409 r0 *1 0,0
Rtopn_t409 topn__t409 topn 1.55570260953
* device instance topn_t410 r0 *1 0,0
Rtopn_t410 topn__t410 topn 0.695346792161
* device instance topn_t411 r0 *1 0,0
Rtopn_t411 topn__t411 topn 0.604335610159
* device instance topn_t412 r0 *1 0,0
Rtopn_t412 topn__t412 topn 0.788181523185
* device instance topn_t413 r0 *1 0,0
Rtopn_t413 topn__t413 topn 1.38368090569
* device instance topn_t414 r0 *1 0,0
Rtopn_t414 topn__t414 topn 1.28849756456
* device instance topn_t415 r0 *1 0,0
Rtopn_t415 topn__t415 topn 1.19386616481
* device instance topn_t416 r0 *1 0,0
Rtopn_t416 topn__t416 topn 1.09992917295
* device instance topn_t417 r0 *1 0,0
Rtopn_t417 topn__t417 topn 0.495765590446
* device instance topn_t418 r0 *1 0,0
Rtopn_t418 topn__t418 topn 0.431056667254
* device instance topn_t419 r0 *1 0,0
Rtopn_t419 topn__t419 topn 0.381147609931
* device instance topn_t420 r0 *1 0,0
Rtopn_t420 topn__t420 topn 0.352383982591
* device instance topn_t421 r0 *1 0,0
Rtopn_t421 topn__t421 topn 0.350018231348
* device instance topn_t422 r0 *1 0,0
Rtopn_t422 topn__t422 topn 0.374550896173
* device instance topn_t423 r0 *1 0,0
Rtopn_t423 topn__t423 topn 0.066036693692
* device instance topn_t424 r0 *1 0,0
Rtopn_t424 topn__t424 topn 0.255642676942
* device instance topn_t425 r0 *1 0,0
Rtopn_t425 topn__t425 topn 0.25237168891
* device instance topn_t426 r0 *1 0,0
Rtopn_t426 topn__t426 topn 0.28542438738
* device instance topn_t427 r0 *1 0,0
Rtopn_t427 topn__t427 topn 0.344499655904
* device instance topn_t428 r0 *1 0,0
Rtopn_t428 topn__t428 topn 0.418724569834
* device instance topn_t429 r0 *1 0,0
Rtopn_t429 topn__t429 topn 0.421309038392
* device instance topn_t430 r0 *1 0,0
Rtopn_t430 topn__t430 topn 0.483892093649
* device instance topn_t431 r0 *1 0,0
Rtopn_t431 topn__t431 topn 0.432391290104
* device instance topn_t432 r0 *1 0,0
Rtopn_t432 topn__t432 topn 0.356354539007
* device instance topn_t433 r0 *1 0,0
Rtopn_t433 topn__t433 topn 0.631560876682
* device instance topn_t434 r0 *1 0,0
Rtopn_t434 topn__t434 topn 0.567123611444
* device instance topn_t435 r0 *1 0,0
Rtopn_t435 topn__t435 topn 0.513640497643
* device instance topn_t436 r0 *1 0,0
Rtopn_t436 topn__t436 topn 0.474827601807
* device instance topn_t437 r0 *1 0,0
Rtopn_t437 topn__t437 topn 0.454459307877
* device instance topn_t438 r0 *1 0,0
Rtopn_t438 topn__t438 topn 0.455019333714
* device instance topn_t439 r0 *1 0,0
Rtopn_t439 topn__t439 topn 0.294027562727
* device instance topn_t440 r0 *1 0,0
Rtopn_t440 topn__t440 topn 1.43882074169
* device instance topn_t441 r0 *1 0,0
Rtopn_t441 topn__t441 topn 1.53734402218
* device instance topn_t442 r0 *1 0,0
Rtopn_t442 topn__t442 topn 1.43864373463
* device instance topn_t443 r0 *1 0,0
Rtopn_t443 topn__t443 topn 1.53717836017
* device instance topn_t444 r0 *1 0,0
Rtopn_t444 topn__t444 topn 1.57417065121
* device instance topn_t445 r0 *1 0,0
Rtopn_t445 topn__t445 topn 1.44520717688
* device instance topn_t446 r0 *1 0,0
Rtopn_t446 topn__t446 topn 1.54332281131
* device instance topn_t447 r0 *1 0,0
Rtopn_t447 topn__t447 topn 1.31087917863
* device instance topn_t448 r0 *1 0,0
Rtopn_t448 topn__t448 topn 1.22594126572
* device instance topn_t449 r0 *1 0,0
Rtopn_t449 topn__t449 topn 1.14319599086
* device instance topn_t450 r0 *1 0,0
Rtopn_t450 topn__t450 topn 1.06315543571
* device instance topn_t451 r0 *1 0,0
Rtopn_t451 topn__t451 topn 0.986478184195
* device instance topn_t452 r0 *1 0,0
Rtopn_t452 topn__t452 topn 0.91401108077
* device instance topn_t453 r0 *1 0,0
Rtopn_t453 topn__t453 topn 0.846835653541
* device instance topn_t454 r0 *1 0,0
Rtopn_t454 topn__t454 topn 1.35505738664
* device instance topn_t455 r0 *1 0,0
Rtopn_t455 topn__t455 topn 1.26541335803
* device instance topn_t456 r0 *1 0,0
Rtopn_t456 topn__t456 topn 1.1771995297
* device instance topn_t457 r0 *1 0,0
Rtopn_t457 topn__t457 topn 1.09076295281
* device instance topn_t458 r0 *1 0,0
Rtopn_t458 topn__t458 topn 1.00656158589
* device instance topn_t459 r0 *1 0,0
Rtopn_t459 topn__t459 topn 0.925205897951
* device instance topn_t460 r0 *1 0,0
Rtopn_t460 topn__t460 topn 0.847515782439
* device instance topn_t461 r0 *1 0,0
Rtopn_t461 topn__t461 topn 0.774594971466
* device instance topn_t462 r0 *1 0,0
Rtopn_t462 topn__t462 topn 1.5310882486
* device instance topn_t463 r0 *1 0,0
Rtopn_t463 topn__t463 topn 1.44564323058
* device instance topn_t464 r0 *1 0,0
Rtopn_t464 topn__t464 topn 1.36197459437
* device instance topn_t465 r0 *1 0,0
Rtopn_t465 topn__t465 topn 1.36225972408
* device instance topn_t466 r0 *1 0,0
Rtopn_t466 topn__t466 topn 1.26546619116
* device instance topn_t467 r0 *1 0,0
Rtopn_t467 topn__t467 topn 1.16897182454
* device instance topn_t468 r0 *1 0,0
Rtopn_t468 topn__t468 topn 1.07285734961
* device instance topn_t469 r0 *1 0,0
Rtopn_t469 topn__t469 topn 0.977234863842
* device instance topn_t470 r0 *1 0,0
Rtopn_t470 topn__t470 topn 0.88226435158
* device instance topn_t471 r0 *1 0,0
Rtopn_t471 topn__t471 topn 1.44586562168
* device instance topn_t472 r0 *1 0,0
Rtopn_t472 topn__t472 topn 0.685994976162
* device instance topn_t473 r0 *1 0,0
Rtopn_t473 topn__t473 topn 0.726112498023
* device instance topn_t474 r0 *1 0,0
Rtopn_t474 topn__t474 topn 0.566769836668
* device instance topn_t475 r0 *1 0,0
Rtopn_t475 topn__t475 topn 0.821852722151
* device instance topn_t476 r0 *1 0,0
Rtopn_t476 topn__t476 topn 0.784517830658
* device instance topn_t477 r0 *1 0,0
Rtopn_t477 topn__t477 topn 0.758242623962
* device instance topn_t478 r0 *1 0,0
Rtopn_t478 topn__t478 topn 0.744199467497
* device instance topn_t479 r0 *1 0,0
Rtopn_t479 topn__t479 topn 0.743082188262
* device instance topn_t480 r0 *1 0,0
Rtopn_t480 topn__t480 topn 0.75494817707
* device instance topn_t481 r0 *1 0,0
Rtopn_t481 topn__t481 topn 0.779204518767
* device instance topn_t482 r0 *1 0,0
Rtopn_t482 topn__t482 topn 0.814745318816
* device instance topn_t483 r0 *1 0,0
Rtopn_t483 topn__t483 topn 0.547840321981
* device instance topn_t484 r0 *1 0,0
Rtopn_t484 topn__t484 topn 0.546321617252
* device instance topn_t485 r0 *1 0,0
Rtopn_t485 topn__t485 topn 0.562354799948
* device instance topn_t486 r0 *1 0,0
Rtopn_t486 topn__t486 topn 1.39761002264
* device instance topn_t487 r0 *1 0,0
Rtopn_t487 topn__t487 topn 0.640395272856
* device instance topn_t488 r0 *1 0,0
Rtopn_t488 topn__t488 topn 0.649413633882
* device instance topn_t489 r0 *1 0,0
Rtopn_t489 topn__t489 topn 0.60146853416
* device instance topn_t490 r0 *1 0,0
Rtopn_t490 topn__t490 topn 0.734078553126
* device instance topn_t491 r0 *1 0,0
Rtopn_t491 topn__t491 topn 0.69202431451
* device instance topn_t492 r0 *1 0,0
Rtopn_t492 topn__t492 topn 0.662088590783
* device instance topn_t493 r0 *1 0,0
Rtopn_t493 topn__t493 topn 0.645958414046
* device instance topn_t494 r0 *1 0,0
Rtopn_t494 topn__t494 topn 0.644670895702
* device instance topn_t495 r0 *1 0,0
Rtopn_t495 topn__t495 topn 1.28043061575
* device instance topn_t496 r0 *1 0,0
Rtopn_t496 topn__t496 topn 1.20144398465
* device instance topn_t497 r0 *1 0,0
Rtopn_t497 topn__t497 topn 1.12555322185
* device instance topn_t498 r0 *1 0,0
Rtopn_t498 topn__t498 topn 1.05342763522
* device instance topn_t499 r0 *1 0,0
Rtopn_t499 topn__t499 topn 0.985893924577
* device instance topn_t500 r0 *1 0,0
Rtopn_t500 topn__t500 topn 0.923959522304
* device instance topn_t501 r0 *1 0,0
Rtopn_t501 topn__t501 topn 1.48581985794
* device instance topn_t502 r0 *1 0,0
Rtopn_t502 topn__t502 topn 0.594521532858
* device instance topn_t503 r0 *1 0,0
Rtopn_t503 topn__t503 topn 1.57315718719
* device instance topn_t504 r0 *1 0,0
Rtopn_t504 topn__t504 topn 1.66374428666
* device instance topn_t505 r0 *1 0,0
Rtopn_t505 topn__t505 topn 1.61566563598
* device instance topn_t506 r0 *1 0,0
Rtopn_t506 topn__t506 topn 1.70399441404
* device instance topn_t507 r0 *1 0,0
Rtopn_t507 topn__t507 topn 1.00688096219
* device instance topn_t508 r0 *1 0,0
Rtopn_t508 topn__t508 topn 0.914992720726
* device instance topn_t509 r0 *1 0,0
Rtopn_t509 topn__t509 topn 0.824652294244
* device instance topn_t510 r0 *1 0,0
Rtopn_t510 topn__t510 topn 0.65831312862
* device instance topn_t511 r0 *1 0,0
Rtopn_t511 topn__t511 topn 0.736429531104
* device instance topn_t512 r0 *1 0,0
Rtopn_t512 topn__t512 topn 2.29549083234
* device instance topn_t513 r0 *1 0,0
Rtopn_t513 topn__t513 topn 2.21896652295
* device instance topn r0 *1 0,0
Ctopn topn vsubs 2.23477193e-13
* device instance topp_t0 r0 *1 0,0
Rtopp_t0 topp__t0 topp 1.58745075242
* device instance topp_t1 r0 *1 0,0
Rtopp_t1 topp__t1 topp 1.58951057708
* device instance topp_t2 r0 *1 0,0
Rtopp_t2 topp__t2 topp 1.46843544617
* device instance topp_t3 r0 *1 0,0
Rtopp_t3 topp__t3 topp 1.55227735463
* device instance topp_t4 r0 *1 0,0
Rtopp_t4 topp__t4 topp 1.18155804581
* device instance topp_t5 r0 *1 0,0
Rtopp_t5 topp__t5 topp 1.26467185592
* device instance topp_t6 r0 *1 0,0
Rtopp_t6 topp__t6 topp 0.508369453957
* device instance topp_t7 r0 *1 0,0
Rtopp_t7 topp__t7 topp 0.527841435552
* device instance topp_t8 r0 *1 0,0
Rtopp_t8 topp__t8 topp 0.561642774949
* device instance topp_t9 r0 *1 0,0
Rtopp_t9 topp__t9 topp 0.696664204074
* device instance topp_t10 r0 *1 0,0
Rtopp_t10 topp__t10 topp 0.687182799707
* device instance topp_t11 r0 *1 0,0
Rtopp_t11 topp__t11 topp 0.689745122045
* device instance topp_t12 r0 *1 0,0
Rtopp_t12 topp__t12 topp 0.70421971909
* device instance topp_t13 r0 *1 0,0
Rtopp_t13 topp__t13 topp 0.729898238333
* device instance topp_t14 r0 *1 0,0
Rtopp_t14 topp__t14 topp 0.76565423664
* device instance topp_t15 r0 *1 0,0
Rtopp_t15 topp__t15 topp 0.810154508749
* device instance topp_t16 r0 *1 0,0
Rtopp_t16 topp__t16 topp 0.607385856286
* device instance topp_t17 r0 *1 0,0
Rtopp_t17 topp__t17 topp 0.606928434253
* device instance topp_t18 r0 *1 0,0
Rtopp_t18 topp__t18 topp 0.596021233917
* device instance topp_t19 r0 *1 0,0
Rtopp_t19 topp__t19 topp 0.598973659231
* device instance topp_t20 r0 *1 0,0
Rtopp_t20 topp__t20 topp 0.615586325239
* device instance topp_t21 r0 *1 0,0
Rtopp_t21 topp__t21 topp 0.644804272154
* device instance topp_t22 r0 *1 0,0
Rtopp_t22 topp__t22 topp 0.6850164386
* device instance topp_t23 r0 *1 0,0
Rtopp_t23 topp__t23 topp 0.734419116795
* device instance topp_t24 r0 *1 0,0
Rtopp_t24 topp__t24 topp 0.791292805017
* device instance topp_t25 r0 *1 0,0
Rtopp_t25 topp__t25 topp 0.662602064876
* device instance topp_t26 r0 *1 0,0
Rtopp_t26 topp__t26 topp 0.725130581713
* device instance topp_t27 r0 *1 0,0
Rtopp_t27 topp__t27 topp 0.51771824535
* device instance topp_t28 r0 *1 0,0
Rtopp_t28 topp__t28 topp 0.504887481073
* device instance topp_t29 r0 *1 0,0
Rtopp_t29 topp__t29 topp 0.691753658473
* device instance topp_t30 r0 *1 0,0
Rtopp_t30 topp__t30 topp 0.429361368814
* device instance topp_t31 r0 *1 0,0
Rtopp_t31 topp__t31 topp 0.86204593393
* device instance topp_t32 r0 *1 0,0
Rtopp_t32 topp__t32 topp 1.20361200405
* device instance topp_t33 r0 *1 0,0
Rtopp_t33 topp__t33 topp 1.29176092603
* device instance topp_t34 r0 *1 0,0
Rtopp_t34 topp__t34 topp 1.38031143948
* device instance topp_t35 r0 *1 0,0
Rtopp_t35 topp__t35 topp 1.46919093248
* device instance topp_t36 r0 *1 0,0
Rtopp_t36 topp__t36 topp 1.45194314349
* device instance topp_t37 r0 *1 0,0
Rtopp_t37 topp__t37 topp 0.740412571759
* device instance topp_t38 r0 *1 0,0
Rtopp_t38 topp__t38 topp 0.827605267727
* device instance topp_t39 r0 *1 0,0
Rtopp_t39 topp__t39 topp 0.915586767115
* device instance topp_t40 r0 *1 0,0
Rtopp_t40 topp__t40 topp 1.00414975141
* device instance topp_t41 r0 *1 0,0
Rtopp_t41 topp__t41 topp 1.09315290083
* device instance topp_t42 r0 *1 0,0
Rtopp_t42 topp__t42 topp 1.4338663525
* device instance topp_t43 r0 *1 0,0
Rtopp_t43 topp__t43 topp 1.51961674213
* device instance topp_t44 r0 *1 0,0
Rtopp_t44 topp__t44 topp 1.34883628988
* device instance topp_t45 r0 *1 0,0
Rtopp_t45 topp__t45 topp 0.865625165672
* device instance topp_t46 r0 *1 0,0
Rtopp_t46 topp__t46 topp 0.941289875752
* device instance topp_t47 r0 *1 0,0
Rtopp_t47 topp__t47 topp 1.50774054416
* device instance topp_t48 r0 *1 0,0
Rtopp_t48 topp__t48 topp 1.09973309229
* device instance topp_t49 r0 *1 0,0
Rtopp_t49 topp__t49 topp 0.921757489896
* device instance topp_t50 r0 *1 0,0
Rtopp_t50 topp__t50 topp 0.993154858484
* device instance topp_t51 r0 *1 0,0
Rtopp_t51 topp__t51 topp 1.0675791408
* device instance topp_t52 r0 *1 0,0
Rtopp_t52 topp__t52 topp 1.14443995781
* device instance topp_t53 r0 *1 0,0
Rtopp_t53 topp__t53 topp 1.22327811979
* device instance topp_t54 r0 *1 0,0
Rtopp_t54 topp__t54 topp 1.30373495999
* device instance topp_t55 r0 *1 0,0
Rtopp_t55 topp__t55 topp 1.38552851997
* device instance topp_t56 r0 *1 0,0
Rtopp_t56 topp__t56 topp 0.983166190994
* device instance topp_t57 r0 *1 0,0
Rtopp_t57 topp__t57 topp 1.05039776364
* device instance topp_t58 r0 *1 0,0
Rtopp_t58 topp__t58 topp 1.12102814898
* device instance topp_t59 r0 *1 0,0
Rtopp_t59 topp__t59 topp 1.19445456421
* device instance topp_t60 r0 *1 0,0
Rtopp_t60 topp__t60 topp 1.2701922088
* device instance topp_t61 r0 *1 0,0
Rtopp_t61 topp__t61 topp 1.34785152552
* device instance topp_t62 r0 *1 0,0
Rtopp_t62 topp__t62 topp 1.42711883478
* device instance topp_t63 r0 *1 0,0
Rtopp_t63 topp__t63 topp 1.01950737081
* device instance topp_t64 r0 *1 0,0
Rtopp_t64 topp__t64 topp 1.23783730124
* device instance topp_t65 r0 *1 0,0
Rtopp_t65 topp__t65 topp 1.16302661592
* device instance topp_t66 r0 *1 0,0
Rtopp_t66 topp__t66 topp 1.09071975344
* device instance topp_t67 r0 *1 0,0
Rtopp_t67 topp__t67 topp 1.02144857821
* device instance topp_t68 r0 *1 0,0
Rtopp_t68 topp__t68 topp 0.955873297843
* device instance topp_t69 r0 *1 0,0
Rtopp_t69 topp__t69 topp 0.894806834641
* device instance topp_t70 r0 *1 0,0
Rtopp_t70 topp__t70 topp 0.839234012246
* device instance topp_t71 r0 *1 0,0
Rtopp_t71 topp__t71 topp 0.79031457629
* device instance topp_t72 r0 *1 0,0
Rtopp_t72 topp__t72 topp 0.749352705927
* device instance topp_t73 r0 *1 0,0
Rtopp_t73 topp__t73 topp 1.14459399913
* device instance topp_t74 r0 *1 0,0
Rtopp_t74 topp__t74 topp 1.05538438573
* device instance topp_t75 r0 *1 0,0
Rtopp_t75 topp__t75 topp 1.51663867067
* device instance topp_t76 r0 *1 0,0
Rtopp_t76 topp__t76 topp 1.43317368019
* device instance topp_t77 r0 *1 0,0
Rtopp_t77 topp__t77 topp 0.413799917841
* device instance topp_t78 r0 *1 0,0
Rtopp_t78 topp__t78 topp 1.26945717399
* device instance topp_t79 r0 *1 0,0
Rtopp_t79 topp__t79 topp 1.18964797121
* device instance topp_t80 r0 *1 0,0
Rtopp_t80 topp__t80 topp 1.11159885768
* device instance topp_t81 r0 *1 0,0
Rtopp_t81 topp__t81 topp 1.03570782154
* device instance topp_t82 r0 *1 0,0
Rtopp_t82 topp__t82 topp 0.962485485086
* device instance topp_t83 r0 *1 0,0
Rtopp_t83 topp__t83 topp 0.892588859776
* device instance topp_t84 r0 *1 0,0
Rtopp_t84 topp__t84 topp 0.8268617674
* device instance topp_t85 r0 *1 0,0
Rtopp_t85 topp__t85 topp 0.766377738701
* device instance topp_t86 r0 *1 0,0
Rtopp_t86 topp__t86 topp 0.712473326211
* device instance topp_t87 r0 *1 0,0
Rtopp_t87 topp__t87 topp 0.66674627029
* device instance topp_t88 r0 *1 0,0
Rtopp_t88 topp__t88 topp 0.966553633609
* device instance topp_t89 r0 *1 0,0
Rtopp_t89 topp__t89 topp 0.878216714623
* device instance topp_t90 r0 *1 0,0
Rtopp_t90 topp__t90 topp 1.48319348523
* device instance topp_t91 r0 *1 0,0
Rtopp_t91 topp__t91 topp 1.35071450869
* device instance topp_t92 r0 *1 0,0
Rtopp_t92 topp__t92 topp 0.920078802365
* device instance topp_t93 r0 *1 0,0
Rtopp_t93 topp__t93 topp 0.418041272098
* device instance topp_t94 r0 *1 0,0
Rtopp_t94 topp__t94 topp 0.441515101154
* device instance topp_t95 r0 *1 0,0
Rtopp_t95 topp__t95 topp 0.481416254517
* device instance topp_t96 r0 *1 0,0
Rtopp_t96 topp__t96 topp 0.534075445866
* device instance topp_t97 r0 *1 0,0
Rtopp_t97 topp__t97 topp 0.596121212371
* device instance topp_t98 r0 *1 0,0
Rtopp_t98 topp__t98 topp 0.66493109718
* device instance topp_t99 r0 *1 0,0
Rtopp_t99 topp__t99 topp 0.73861706882
* device instance topp_t100 r0 *1 0,0
Rtopp_t100 topp__t100 topp 0.81585901411
* device instance topp_t101 r0 *1 0,0
Rtopp_t101 topp__t101 topp 0.895737480323
* device instance topp_t102 r0 *1 0,0
Rtopp_t102 topp__t102 topp 0.977606404747
* device instance topp_t103 r0 *1 0,0
Rtopp_t103 topp__t103 topp 1.06100512616
* device instance topp_t104 r0 *1 0,0
Rtopp_t104 topp__t104 topp 1.14559958934
* device instance topp_t105 r0 *1 0,0
Rtopp_t105 topp__t105 topp 1.2311433331
* device instance topp_t106 r0 *1 0,0
Rtopp_t106 topp__t106 topp 1.31745145655
* device instance topp_t107 r0 *1 0,0
Rtopp_t107 topp__t107 topp 1.31472445993
* device instance topp_t108 r0 *1 0,0
Rtopp_t108 topp__t108 topp 1.49182909424
* device instance topp_t109 r0 *1 0,0
Rtopp_t109 topp__t109 topp 0.854146423997
* device instance topp_t110 r0 *1 0,0
Rtopp_t110 topp__t110 topp 0.654324093907
* device instance topp_t111 r0 *1 0,0
Rtopp_t111 topp__t111 topp 0.793244080275
* device instance topp_t112 r0 *1 0,0
Rtopp_t112 topp__t112 topp 0.378317981578
* device instance topp_t113 r0 *1 0,0
Rtopp_t113 topp__t113 topp 1.41377748023
* device instance topp_t114 r0 *1 0,0
Rtopp_t114 topp__t114 topp 1.3238431568
* device instance topp_t115 r0 *1 0,0
Rtopp_t115 topp__t115 topp 1.23410031611
* device instance topp_t116 r0 *1 0,0
Rtopp_t116 topp__t116 topp 1.55472561769
* device instance topp_t117 r0 *1 0,0
Rtopp_t117 topp__t117 topp 1.47341972517
* device instance topp_t118 r0 *1 0,0
Rtopp_t118 topp__t118 topp 1.39334438418
* device instance topp_t119 r0 *1 0,0
Rtopp_t119 topp__t119 topp 1.40438303902
* device instance topp_t120 r0 *1 0,0
Rtopp_t120 topp__t120 topp 0.826286361624
* device instance topp_t121 r0 *1 0,0
Rtopp_t121 topp__t121 topp 0.914394772707
* device instance topp_t122 r0 *1 0,0
Rtopp_t122 topp__t122 topp 1.00306300674
* device instance topp_t123 r0 *1 0,0
Rtopp_t123 topp__t123 topp 1.09215472202
* device instance topp_t124 r0 *1 0,0
Rtopp_t124 topp__t124 topp 1.18157412987
* device instance topp_t125 r0 *1 0,0
Rtopp_t125 topp__t125 topp 1.27125208284
* device instance topp_t126 r0 *1 0,0
Rtopp_t126 topp__t126 topp 1.05915319372
* device instance topp_t127 r0 *1 0,0
Rtopp_t127 topp__t127 topp 1.14388462229
* device instance topp_t128 r0 *1 0,0
Rtopp_t128 topp__t128 topp 1.40298443695
* device instance topp_t129 r0 *1 0,0
Rtopp_t129 topp__t129 topp 1.49051254824
* device instance topp_t130 r0 *1 0,0
Rtopp_t130 topp__t130 topp 1.22954768783
* device instance topp_t131 r0 *1 0,0
Rtopp_t131 topp__t131 topp 1.31596046688
* device instance topp_t132 r0 *1 0,0
Rtopp_t132 topp__t132 topp 0.813449163089
* device instance topp_t133 r0 *1 0,0
Rtopp_t133 topp__t133 topp 0.893543084401
* device instance topp_t134 r0 *1 0,0
Rtopp_t134 topp__t134 topp 1.36113747948
* device instance topp_t135 r0 *1 0,0
Rtopp_t135 topp__t135 topp 1.11595984191
* device instance topp_t136 r0 *1 0,0
Rtopp_t136 topp__t136 topp 1.06965597035
* device instance topp_t137 r0 *1 0,0
Rtopp_t137 topp__t137 topp 1.16080979598
* device instance topp_t138 r0 *1 0,0
Rtopp_t138 topp__t138 topp 1.06945202293
* device instance topp_t139 r0 *1 0,0
Rtopp_t139 topp__t139 topp 0.716357328303
* device instance topp_t140 r0 *1 0,0
Rtopp_t140 topp__t140 topp 0.806156017508
* device instance topp_t141 r0 *1 0,0
Rtopp_t141 topp__t141 topp 0.89624559888
* device instance topp_t142 r0 *1 0,0
Rtopp_t142 topp__t142 topp 0.986546384442
* device instance topp_t143 r0 *1 0,0
Rtopp_t143 topp__t143 topp 1.07700525068
* device instance topp_t144 r0 *1 0,0
Rtopp_t144 topp__t144 topp 1.1675854562
* device instance topp_t145 r0 *1 0,0
Rtopp_t145 topp__t145 topp 1.25826079621
* device instance topp_t146 r0 *1 0,0
Rtopp_t146 topp__t146 topp 1.34901208712
* device instance topp_t147 r0 *1 0,0
Rtopp_t147 topp__t147 topp 1.4398249676
* device instance topp_t148 r0 *1 0,0
Rtopp_t148 topp__t148 topp 1.16062186645
* device instance topp_t149 r0 *1 0,0
Rtopp_t149 topp__t149 topp 1.25180172177
* device instance topp_t150 r0 *1 0,0
Rtopp_t150 topp__t150 topp 1.34298954968
* device instance topp_t151 r0 *1 0,0
Rtopp_t151 topp__t151 topp 0.978517937272
* device instance topp_t152 r0 *1 0,0
Rtopp_t152 topp__t152 topp 0.334910626681
* device instance topp_t153 r0 *1 0,0
Rtopp_t153 topp__t153 topp 0.406989065735
* device instance topp_t154 r0 *1 0,0
Rtopp_t154 topp__t154 topp 0.402089170338
* device instance topp_t155 r0 *1 0,0
Rtopp_t155 topp__t155 topp 0.463843370834
* device instance topp_t156 r0 *1 0,0
Rtopp_t156 topp__t156 topp 0.534111028371
* device instance topp_t157 r0 *1 0,0
Rtopp_t157 topp__t157 topp 0.609956928632
* device instance topp_t158 r0 *1 0,0
Rtopp_t158 topp__t158 topp 0.530386832324
* device instance topp_t159 r0 *1 0,0
Rtopp_t159 topp__t159 topp 0.323531445097
* device instance topp_t160 r0 *1 0,0
Rtopp_t160 topp__t160 topp 0.424764399468
* device instance topp_t161 r0 *1 0,0
Rtopp_t161 topp__t161 topp 0.409028094427
* device instance topp_t162 r0 *1 0,0
Rtopp_t162 topp__t162 topp 0.413318418659
* device instance topp_t163 r0 *1 0,0
Rtopp_t163 topp__t163 topp 0.437045986794
* device instance topp_t164 r0 *1 0,0
Rtopp_t164 topp__t164 topp 0.592818783326
* device instance topp_t165 r0 *1 0,0
Rtopp_t165 topp__t165 topp 0.353340735461
* device instance topp_t166 r0 *1 0,0
Rtopp_t166 topp__t166 topp 0.33803147164
* device instance topp_t167 r0 *1 0,0
Rtopp_t167 topp__t167 topp 0.738938054681
* device instance topp_t168 r0 *1 0,0
Rtopp_t168 topp__t168 topp 0.485555370261
* device instance topp_t169 r0 *1 0,0
Rtopp_t169 topp__t169 topp 0.56792330622
* device instance topp_t170 r0 *1 0,0
Rtopp_t170 topp__t170 topp 0.66197203417
* device instance topp_t171 r0 *1 0,0
Rtopp_t171 topp__t171 topp 0.477320877544
* device instance topp_t172 r0 *1 0,0
Rtopp_t172 topp__t172 topp 1.45119177374
* device instance topp_t173 r0 *1 0,0
Rtopp_t173 topp__t173 topp 0.771712395711
* device instance topp_t174 r0 *1 0,0
Rtopp_t174 topp__t174 topp 0.85572175644
* device instance topp_t175 r0 *1 0,0
Rtopp_t175 topp__t175 topp 0.941078303539
* device instance topp_t176 r0 *1 0,0
Rtopp_t176 topp__t176 topp 1.02744633365
* device instance topp_t177 r0 *1 0,0
Rtopp_t177 topp__t177 topp 1.11459073649
* device instance topp_t178 r0 *1 0,0
Rtopp_t178 topp__t178 topp 1.20234271213
* device instance topp_t179 r0 *1 0,0
Rtopp_t179 topp__t179 topp 1.29057833205
* device instance topp_t180 r0 *1 0,0
Rtopp_t180 topp__t180 topp 1.37920477489
* device instance topp_t181 r0 *1 0,0
Rtopp_t181 topp__t181 topp 1.4681512651
* device instance topp_t182 r0 *1 0,0
Rtopp_t182 topp__t182 topp 0.975596172926
* device instance topp_t183 r0 *1 0,0
Rtopp_t183 topp__t183 topp 0.318032172578
* device instance topp_t184 r0 *1 0,0
Rtopp_t184 topp__t184 topp 0.178586326293
* device instance topp_t185 r0 *1 0,0
Rtopp_t185 topp__t185 topp 0.137011907927
* device instance topp_t186 r0 *1 0,0
Rtopp_t186 topp__t186 topp 0.689542794279
* device instance topp_t187 r0 *1 0,0
Rtopp_t187 topp__t187 topp 0.652655109612
* device instance topp_t188 r0 *1 0,0
Rtopp_t188 topp__t188 topp 0.626974533184
* device instance topp_t189 r0 *1 0,0
Rtopp_t189 topp__t189 topp 0.613909101266
* device instance topp_t190 r0 *1 0,0
Rtopp_t190 topp__t190 topp 0.735954335797
* device instance topp_t191 r0 *1 0,0
Rtopp_t191 topp__t191 topp 0.61426431621
* device instance topp_t192 r0 *1 0,0
Rtopp_t192 topp__t192 topp 0.322797648169
* device instance topp_t193 r0 *1 0,0
Rtopp_t193 topp__t193 topp 0.258719984817
* device instance topp_t194 r0 *1 0,0
Rtopp_t194 topp__t194 topp 0.328217084923
* device instance topp_t195 r0 *1 0,0
Rtopp_t195 topp__t195 topp 0.357636035943
* device instance topp_t196 r0 *1 0,0
Rtopp_t196 topp__t196 topp 0.405868894807
* device instance topp_t197 r0 *1 0,0
Rtopp_t197 topp__t197 topp 0.467123679057
* device instance topp_t198 r0 *1 0,0
Rtopp_t198 topp__t198 topp 0.536962242152
* device instance topp_t199 r0 *1 0,0
Rtopp_t199 topp__t199 topp 1.43418382946
* device instance topp_t200 r0 *1 0,0
Rtopp_t200 topp__t200 topp 0.231981071467
* device instance topp_t201 r0 *1 0,0
Rtopp_t201 topp__t201 topp 0.239464717007
* device instance topp_t202 r0 *1 0,0
Rtopp_t202 topp__t202 topp 0.342518809248
* device instance topp_t203 r0 *1 0,0
Rtopp_t203 topp__t203 topp 0.338151527614
* device instance topp_t204 r0 *1 0,0
Rtopp_t204 topp__t204 topp 0.409660136444
* device instance topp_t205 r0 *1 0,0
Rtopp_t205 topp__t205 topp 0.487796417937
* device instance topp_t206 r0 *1 0,0
Rtopp_t206 topp__t206 topp 0.278424909196
* device instance topp_t207 r0 *1 0,0
Rtopp_t207 topp__t207 topp 0.569840512346
* device instance topp_t208 r0 *1 0,0
Rtopp_t208 topp__t208 topp 1.18249682965
* device instance topp_t209 r0 *1 0,0
Rtopp_t209 topp__t209 topp 1.27210973814
* device instance topp_t210 r0 *1 0,0
Rtopp_t210 topp__t210 topp 1.36193853232
* device instance topp_t211 r0 *1 0,0
Rtopp_t211 topp__t211 topp 0.77368849065
* device instance topp_t212 r0 *1 0,0
Rtopp_t212 topp__t212 topp 0.857504275974
* device instance topp_t213 r0 *1 0,0
Rtopp_t213 topp__t213 topp 0.942699438984
* device instance topp_t214 r0 *1 0,0
Rtopp_t214 topp__t214 topp 1.02893140073
* device instance topp_t215 r0 *1 0,0
Rtopp_t215 topp__t215 topp 0.612455152362
* device instance topp_t216 r0 *1 0,0
Rtopp_t216 topp__t216 topp 1.2519759647
* device instance topp_t217 r0 *1 0,0
Rtopp_t217 topp__t217 topp 0.704950452989
* device instance topp_t218 r0 *1 0,0
Rtopp_t218 topp__t218 topp 0.796036961403
* device instance topp_t219 r0 *1 0,0
Rtopp_t219 topp__t219 topp 0.887154717548
* device instance topp_t220 r0 *1 0,0
Rtopp_t220 topp__t220 topp 0.978294990282
* device instance topp_t221 r0 *1 0,0
Rtopp_t221 topp__t221 topp 1.34315196315
* device instance topp_t222 r0 *1 0,0
Rtopp_t222 topp__t222 topp 1.43433591681
* device instance topp_t223 r0 *1 0,0
Rtopp_t223 topp__t223 topp 0.705259815049
* device instance topp_t224 r0 *1 0,0
Rtopp_t224 topp__t224 topp 0.796310937682
* device instance topp_t225 r0 *1 0,0
Rtopp_t225 topp__t225 topp 0.887400562553
* device instance topp_t226 r0 *1 0,0
Rtopp_t226 topp__t226 topp 0.149333171419
* device instance topp_t227 r0 *1 0,0
Rtopp_t227 topp__t227 topp 0.206100643996
* device instance topp_t228 r0 *1 0,0
Rtopp_t228 topp__t228 topp 0.538214878005
* device instance topp_t229 r0 *1 0,0
Rtopp_t229 topp__t229 topp 0.281608772985
* device instance topp_t230 r0 *1 0,0
Rtopp_t230 topp__t230 topp 0.251178861327
* device instance topp_t231 r0 *1 0,0
Rtopp_t231 topp__t231 topp 0.450446878941
* device instance topp_t232 r0 *1 0,0
Rtopp_t232 topp__t232 topp 0.432076046666
* device instance topp_t233 r0 *1 0,0
Rtopp_t233 topp__t233 topp 0.522936491614
* device instance topp_t234 r0 *1 0,0
Rtopp_t234 topp__t234 topp 0.364387805485
* device instance topp_t235 r0 *1 0,0
Rtopp_t235 topp__t235 topp 0.126951411362
* device instance topp_t236 r0 *1 0,0
Rtopp_t236 topp__t236 topp 0.0547343385998
* device instance topp_t237 r0 *1 0,0
Rtopp_t237 topp__t237 topp 0.0807711643734
* device instance topp_t238 r0 *1 0,0
Rtopp_t238 topp__t238 topp 0.163404591012
* device instance topp_t239 r0 *1 0,0
Rtopp_t239 topp__t239 topp 0.252045801255
* device instance topp_t240 r0 *1 0,0
Rtopp_t240 topp__t240 topp 0.342055635379
* device instance topp_t241 r0 *1 0,0
Rtopp_t241 topp__t241 topp 0.432580600184
* device instance topp_t242 r0 *1 0,0
Rtopp_t242 topp__t242 topp 0.523353455911
* device instance topp_t243 r0 *1 0,0
Rtopp_t243 topp__t243 topp 0.125221385131
* device instance topp_t244 r0 *1 0,0
Rtopp_t244 topp__t244 topp 0.0505923143298
* device instance topp_t245 r0 *1 0,0
Rtopp_t245 topp__t245 topp 0.0780238132978
* device instance topp_t246 r0 *1 0,0
Rtopp_t246 topp__t246 topp 0.162064168807
* device instance topp_t247 r0 *1 0,0
Rtopp_t247 topp__t247 topp 0.341417328414
* device instance topp_t248 r0 *1 0,0
Rtopp_t248 topp__t248 topp 1.39773275516
* device instance topp_t249 r0 *1 0,0
Rtopp_t249 topp__t249 topp 1.43148519648
* device instance topp_t250 r0 *1 0,0
Rtopp_t250 topp__t250 topp 1.34273743076
* device instance topp_t251 r0 *1 0,0
Rtopp_t251 topp__t251 topp 1.25434711877
* device instance topp_t252 r0 *1 0,0
Rtopp_t252 topp__t252 topp 1.16639552767
* device instance topp_t253 r0 *1 0,0
Rtopp_t253 topp__t253 topp 1.07898994703
* device instance topp_t254 r0 *1 0,0
Rtopp_t254 topp__t254 topp 0.992274675071
* device instance topp_t255 r0 *1 0,0
Rtopp_t255 topp__t255 topp 0.906447848465
* device instance topp_t256 r0 *1 0,0
Rtopp_t256 topp__t256 topp 0.821787879799
* device instance topp_t257 r0 *1 0,0
Rtopp_t257 topp__t257 topp 0.738696069422
* device instance topp_t258 r0 *1 0,0
Rtopp_t258 topp__t258 topp 0.657766974522
* device instance topp_t259 r0 *1 0,0
Rtopp_t259 topp__t259 topp 0.579906758678
* device instance topp_t260 r0 *1 0,0
Rtopp_t260 topp__t260 topp 0.506532576392
* device instance topp_t261 r0 *1 0,0
Rtopp_t261 topp__t261 topp 0.439894986707
* device instance topp_t262 r0 *1 0,0
Rtopp_t262 topp__t262 topp 0.454083854373
* device instance topp_t263 r0 *1 0,0
Rtopp_t263 topp__t263 topp 0.987209484007
* device instance topp_t264 r0 *1 0,0
Rtopp_t264 topp__t264 topp 1.16814579321
* device instance topp_t265 r0 *1 0,0
Rtopp_t265 topp__t265 topp 1.2587807704
* device instance topp_t266 r0 *1 0,0
Rtopp_t266 topp__t266 topp 1.34949709443
* device instance topp_t267 r0 *1 0,0
Rtopp_t267 topp__t267 topp 1.44027939442
* device instance topp_t268 r0 *1 0,0
Rtopp_t268 topp__t268 topp 0.717712179401
* device instance topp_t269 r0 *1 0,0
Rtopp_t269 topp__t269 topp 0.214211157667
* device instance topp_t270 r0 *1 0,0
Rtopp_t270 topp__t270 topp 0.630976927888
* device instance topp_t271 r0 *1 0,0
Rtopp_t271 topp__t271 topp 0.307448307854
* device instance topp_t272 r0 *1 0,0
Rtopp_t272 topp__t272 topp 0.545712324206
* device instance topp_t273 r0 *1 0,0
Rtopp_t273 topp__t273 topp 0.458469796473
* device instance topp_t274 r0 *1 0,0
Rtopp_t274 topp__t274 topp 0.213190418444
* device instance topp_t275 r0 *1 0,0
Rtopp_t275 topp__t275 topp 0.462732043684
* device instance topp_t276 r0 *1 0,0
Rtopp_t276 topp__t276 topp 0.3835216994
* device instance topp_t277 r0 *1 0,0
Rtopp_t277 topp__t277 topp 0.248320025694
* device instance topp_t278 r0 *1 0,0
Rtopp_t278 topp__t278 topp 0.310975545286
* device instance topp_t279 r0 *1 0,0
Rtopp_t279 topp__t279 topp 1.07761268861
* device instance topp_t280 r0 *1 0,0
Rtopp_t280 topp__t280 topp 1.31304978628
* device instance topp_t281 r0 *1 0,0
Rtopp_t281 topp__t281 topp 1.22930532166
* device instance topp_t282 r0 *1 0,0
Rtopp_t282 topp__t282 topp 1.1467049981
* device instance topp_t283 r0 *1 0,0
Rtopp_t283 topp__t283 topp 1.06551493545
* device instance topp_t284 r0 *1 0,0
Rtopp_t284 topp__t284 topp 0.986083540512
* device instance topp_t285 r0 *1 0,0
Rtopp_t285 topp__t285 topp 0.908872029642
* device instance topp_t286 r0 *1 0,0
Rtopp_t286 topp__t286 topp 0.834496812373
* device instance topp_t287 r0 *1 0,0
Rtopp_t287 topp__t287 topp 0.763786907227
* device instance topp_t288 r0 *1 0,0
Rtopp_t288 topp__t288 topp 0.697857360526
* device instance topp_t289 r0 *1 0,0
Rtopp_t289 topp__t289 topp 0.638191427259
* device instance topp_t290 r0 *1 0,0
Rtopp_t290 topp__t290 topp 0.586703201125
* device instance topp_t291 r0 *1 0,0
Rtopp_t291 topp__t291 topp 0.790539192729
* device instance topp_t292 r0 *1 0,0
Rtopp_t292 topp__t292 topp 0.703767560232
* device instance topp_t293 r0 *1 0,0
Rtopp_t293 topp__t293 topp 0.618283340085
* device instance topp_t294 r0 *1 0,0
Rtopp_t294 topp__t294 topp 1.45471025228
* device instance topp_t295 r0 *1 0,0
Rtopp_t295 topp__t295 topp 1.36747060601
* device instance topp_t296 r0 *1 0,0
Rtopp_t296 topp__t296 topp 1.28078832939
* device instance topp_t297 r0 *1 0,0
Rtopp_t297 topp__t297 topp 1.194784741
* device instance topp_t298 r0 *1 0,0
Rtopp_t298 topp__t298 topp 1.10961766214
* device instance topp_t299 r0 *1 0,0
Rtopp_t299 topp__t299 topp 1.02549552955
* device instance topp_t300 r0 *1 0,0
Rtopp_t300 topp__t300 topp 0.942698123648
* device instance topp_t301 r0 *1 0,0
Rtopp_t301 topp__t301 topp 0.861607433653
* device instance topp_t302 r0 *1 0,0
Rtopp_t302 topp__t302 topp 0.782754069501
* device instance topp_t303 r0 *1 0,0
Rtopp_t303 topp__t303 topp 0.706887150196
* device instance topp_t304 r0 *1 0,0
Rtopp_t304 topp__t304 topp 0.635077868534
* device instance topp_t305 r0 *1 0,0
Rtopp_t305 topp__t305 topp 0.568864923587
* device instance topp_t306 r0 *1 0,0
Rtopp_t306 topp__t306 topp 0.5104308471
* device instance topp_t307 r0 *1 0,0
Rtopp_t307 topp__t307 topp 0.534704352531
* device instance topp_t308 r0 *1 0,0
Rtopp_t308 topp__t308 topp 0.379519479133
* device instance topp_t309 r0 *1 0,0
Rtopp_t309 topp__t309 topp 1.40179620689
* device instance topp_t310 r0 *1 0,0
Rtopp_t310 topp__t310 topp 1.31104025334
* device instance topp_t311 r0 *1 0,0
Rtopp_t311 topp__t311 topp 1.22035627268
* device instance topp_t312 r0 *1 0,0
Rtopp_t312 topp__t312 topp 1.12976159648
* device instance topp_t313 r0 *1 0,0
Rtopp_t313 topp__t313 topp 1.03927957918
* device instance topp_t314 r0 *1 0,0
Rtopp_t314 topp__t314 topp 0.948942447515
* device instance topp_t315 r0 *1 0,0
Rtopp_t315 topp__t315 topp 0.858795924476
* device instance topp_t316 r0 *1 0,0
Rtopp_t316 topp__t316 topp 0.768907053741
* device instance topp_t317 r0 *1 0,0
Rtopp_t317 topp__t317 topp 0.679378113342
* device instance topp_t318 r0 *1 0,0
Rtopp_t318 topp__t318 topp 0.590372874275
* device instance topp_t319 r0 *1 0,0
Rtopp_t319 topp__t319 topp 0.502169878297
* device instance topp_t320 r0 *1 0,0
Rtopp_t320 topp__t320 topp 0.415280614591
* device instance topp_t321 r0 *1 0,0
Rtopp_t321 topp__t321 topp 0.330742100795
* device instance topp_t322 r0 *1 0,0
Rtopp_t322 topp__t322 topp 0.896975456838
* device instance topp_t323 r0 *1 0,0
Rtopp_t323 topp__t323 topp 0.806967360692
* device instance topp_t324 r0 *1 0,0
Rtopp_t324 topp__t324 topp 0.717270254836
* device instance topp_t325 r0 *1 0,0
Rtopp_t325 topp__t325 topp 0.250941490828
* device instance topp_t326 r0 *1 0,0
Rtopp_t326 topp__t326 topp 0.539429375881
* device instance topp_t327 r0 *1 0,0
Rtopp_t327 topp__t327 topp 0.451897319538
* device instance topp_t328 r0 *1 0,0
Rtopp_t328 topp__t328 topp 0.36617928593
* device instance topp_t329 r0 *1 0,0
Rtopp_t329 topp__t329 topp 0.283923048871
* device instance topp_t330 r0 *1 0,0
Rtopp_t330 topp__t330 topp 0.209251695605
* device instance topp_t331 r0 *1 0,0
Rtopp_t331 topp__t331 topp 0.153652831878
* device instance topp_t332 r0 *1 0,0
Rtopp_t332 topp__t332 topp 0.141707655304
* device instance topp_t333 r0 *1 0,0
Rtopp_t333 topp__t333 topp 0.182213810116
* device instance topp_t334 r0 *1 0,0
Rtopp_t334 topp__t334 topp 0.628017405746
* device instance topp_t335 r0 *1 0,0
Rtopp_t335 topp__t335 topp 1.51803693034
* device instance topp_t336 r0 *1 0,0
Rtopp_t336 topp__t336 topp 1.43219195493
* device instance topp_t337 r0 *1 0,0
Rtopp_t337 topp__t337 topp 1.34705620366
* device instance topp_t338 r0 *1 0,0
Rtopp_t338 topp__t338 topp 1.26277313168
* device instance topp_t339 r0 *1 0,0
Rtopp_t339 topp__t339 topp 1.1795255379
* device instance topp_t340 r0 *1 0,0
Rtopp_t340 topp__t340 topp 1.09754906642
* device instance topp_t341 r0 *1 0,0
Rtopp_t341 topp__t341 topp 1.01715109893
* device instance topp_t342 r0 *1 0,0
Rtopp_t342 topp__t342 topp 0.938737295048
* device instance topp_t343 r0 *1 0,0
Rtopp_t343 topp__t343 topp 0.862848773751
* device instance topp_t344 r0 *1 0,0
Rtopp_t344 topp__t344 topp 0.79021342042
* device instance topp_t345 r0 *1 0,0
Rtopp_t345 topp__t345 topp 0.721813992283
* device instance topp_t346 r0 *1 0,0
Rtopp_t346 topp__t346 topp 0.65897084556
* device instance topp_t347 r0 *1 0,0
Rtopp_t347 topp__t347 topp 0.603422453457
* device instance topp_t348 r0 *1 0,0
Rtopp_t348 topp__t348 topp 0.557354183238
* device instance topp_t349 r0 *1 0,0
Rtopp_t349 topp__t349 topp 0.523275892819
* device instance topp_t350 r0 *1 0,0
Rtopp_t350 topp__t350 topp 1.48157483562
* device instance topp_t351 r0 *1 0,0
Rtopp_t351 topp__t351 topp 0.500112434822
* device instance topp_t352 r0 *1 0,0
Rtopp_t352 topp__t352 topp 0.513062628233
* device instance topp_t353 r0 *1 0,0
Rtopp_t353 topp__t353 topp 0.541297533443
* device instance topp_t354 r0 *1 0,0
Rtopp_t354 topp__t354 topp 0.582599111852
* device instance topp_t355 r0 *1 0,0
Rtopp_t355 topp__t355 topp 0.634420504671
* device instance topp_t356 r0 *1 0,0
Rtopp_t356 topp__t356 topp 0.694410523078
* device instance topp_t357 r0 *1 0,0
Rtopp_t357 topp__t357 topp 0.760638888417
* device instance topp_t358 r0 *1 0,0
Rtopp_t358 topp__t358 topp 0.831616503432
* device instance topp_t359 r0 *1 0,0
Rtopp_t359 topp__t359 topp 0.906228141908
* device instance topp_t360 r0 *1 0,0
Rtopp_t360 topp__t360 topp 0.983647206974
* device instance topp_t361 r0 *1 0,0
Rtopp_t361 topp__t361 topp 1.06326062496
* device instance topp_t362 r0 *1 0,0
Rtopp_t362 topp__t362 topp 1.1446106026
* device instance topp_t363 r0 *1 0,0
Rtopp_t363 topp__t363 topp 1.22735188629
* device instance topp_t364 r0 *1 0,0
Rtopp_t364 topp__t364 topp 1.31122111795
* device instance topp_t365 r0 *1 0,0
Rtopp_t365 topp__t365 topp 1.39601501917
* device instance topp_t366 r0 *1 0,0
Rtopp_t366 topp__t366 topp 0.503627422443
* device instance topp_t367 r0 *1 0,0
Rtopp_t367 topp__t367 topp 1.30434085597
* device instance topp_t368 r0 *1 0,0
Rtopp_t368 topp__t368 topp 1.21315619562
* device instance topp_t369 r0 *1 0,0
Rtopp_t369 topp__t369 topp 1.12198029732
* device instance topp_t370 r0 *1 0,0
Rtopp_t370 topp__t370 topp 1.0308154861
* device instance topp_t371 r0 *1 0,0
Rtopp_t371 topp__t371 topp 0.939664988915
* device instance topp_t372 r0 *1 0,0
Rtopp_t372 topp__t372 topp 0.848533418666
* device instance topp_t373 r0 *1 0,0
Rtopp_t373 topp__t373 topp 0.757427607096
* device instance topp_t374 r0 *1 0,0
Rtopp_t374 topp__t374 topp 0.666358119621
* device instance topp_t375 r0 *1 0,0
Rtopp_t375 topp__t375 topp 0.575342205454
* device instance topp_t376 r0 *1 0,0
Rtopp_t376 topp__t376 topp 0.484410063238
* device instance topp_t377 r0 *1 0,0
Rtopp_t377 topp__t377 topp 0.393619755033
* device instance topp_t378 r0 *1 0,0
Rtopp_t378 topp__t378 topp 0.303098762676
* device instance topp_t379 r0 *1 0,0
Rtopp_t379 topp__t379 topp 0.90476176042
* device instance topp_t380 r0 *1 0,0
Rtopp_t380 topp__t380 topp 0.736626108762
* device instance topp_t381 r0 *1 0,0
Rtopp_t381 topp__t381 topp 1.45336008206
* device instance topp_t382 r0 *1 0,0
Rtopp_t382 topp__t382 topp 1.36603421199
* device instance topp_t383 r0 *1 0,0
Rtopp_t383 topp__t383 topp 1.27925460904
* device instance topp_t384 r0 *1 0,0
Rtopp_t384 topp__t384 topp 1.1931404726
* device instance topp_t385 r0 *1 0,0
Rtopp_t385 topp__t385 topp 1.10784699582
* device instance topp_t386 r0 *1 0,0
Rtopp_t386 topp__t386 topp 1.02357935264
* device instance topp_t387 r0 *1 0,0
Rtopp_t387 topp__t387 topp 1.41300581592
* device instance topp_t388 r0 *1 0,0
Rtopp_t388 topp__t388 topp 1.32301903843
* device instance topp_t389 r0 *1 0,0
Rtopp_t389 topp__t389 topp 1.23321622697
* device instance topp_t390 r0 *1 0,0
Rtopp_t390 topp__t390 topp 0.819927716641
* device instance topp_t391 r0 *1 0,0
Rtopp_t391 topp__t391 topp 0.626466624284
* device instance topp_t392 r0 *1 0,0
Rtopp_t392 topp__t392 topp 0.713138688594
* device instance topp_t393 r0 *1 0,0
Rtopp_t393 topp__t393 topp 0.631979041684
* device instance topp_t394 r0 *1 0,0
Rtopp_t394 topp__t394 topp 0.565403317388
* device instance topp_t395 r0 *1 0,0
Rtopp_t395 topp__t395 topp 1.05435045117
* device instance topp_t396 r0 *1 0,0
Rtopp_t396 topp__t396 topp 0.965424569233
* device instance topp_t397 r0 *1 0,0
Rtopp_t397 topp__t397 topp 0.876973927822
* device instance topp_t398 r0 *1 0,0
Rtopp_t398 topp__t398 topp 0.789158341195
* device instance topp_t399 r0 *1 0,0
Rtopp_t399 topp__t399 topp 0.70221609998
* device instance topp_t400 r0 *1 0,0
Rtopp_t400 topp__t400 topp 0.616516796903
* device instance topp_t401 r0 *1 0,0
Rtopp_t401 topp__t401 topp 1.39568885999
* device instance topp_t402 r0 *1 0,0
Rtopp_t402 topp__t402 topp 1.30450808128
* device instance topp_t403 r0 *1 0,0
Rtopp_t403 topp__t403 topp 1.21333598831
* device instance topp_t404 r0 *1 0,0
Rtopp_t404 topp__t404 topp 1.12217469814
* device instance topp_t405 r0 *1 0,0
Rtopp_t405 topp__t405 topp 1.03102707624
* device instance topp_t406 r0 *1 0,0
Rtopp_t406 topp__t406 topp 1.1436407194
* device instance topp_t407 r0 *1 0,0
Rtopp_t407 topp__t407 topp 0.84879045008
* device instance topp_t408 r0 *1 0,0
Rtopp_t408 topp__t408 topp 0.75771554395
* device instance topp_t409 r0 *1 0,0
Rtopp_t409 topp__t409 topp 0.666685389924
* device instance topp_t410 r0 *1 0,0
Rtopp_t410 topp__t410 topp 0.575721216328
* device instance topp_t411 r0 *1 0,0
Rtopp_t411 topp__t411 topp 0.484860160169
* device instance topp_t412 r0 *1 0,0
Rtopp_t412 topp__t412 topp 0.394173536789
* device instance topp_t413 r0 *1 0,0
Rtopp_t413 topp__t413 topp 0.303817585877
* device instance topp_t414 r0 *1 0,0
Rtopp_t414 topp__t414 topp 0.506570093568
* device instance topp_t415 r0 *1 0,0
Rtopp_t415 topp__t415 topp 0.43641005999
* device instance topp_t416 r0 *1 0,0
Rtopp_t416 topp__t416 topp 1.39553256084
* device instance topp_t417 r0 *1 0,0
Rtopp_t417 topp__t417 topp 0.254469453531
* device instance topp_t418 r0 *1 0,0
Rtopp_t418 topp__t418 topp 0.227230917253
* device instance topp_t419 r0 *1 0,0
Rtopp_t419 topp__t419 topp 0.274479693779
* device instance topp_t420 r0 *1 0,0
Rtopp_t420 topp__t420 topp 0.939897099126
* device instance topp_t421 r0 *1 0,0
Rtopp_t421 topp__t421 topp 1.43041812379
* device instance topp_t422 r0 *1 0,0
Rtopp_t422 topp__t422 topp 1.34159977232
* device instance topp_t423 r0 *1 0,0
Rtopp_t423 topp__t423 topp 1.2531292174
* device instance topp_t424 r0 *1 0,0
Rtopp_t424 topp__t424 topp 1.16508569132
* device instance topp_t425 r0 *1 0,0
Rtopp_t425 topp__t425 topp 1.07757387075
* device instance topp_t426 r0 *1 0,0
Rtopp_t426 topp__t426 topp 0.990734662722
* device instance topp_t427 r0 *1 0,0
Rtopp_t427 topp__t427 topp 1.4013293007
* device instance topp_t428 r0 *1 0,0
Rtopp_t428 topp__t428 topp 1.31054101394
* device instance topp_t429 r0 *1 0,0
Rtopp_t429 topp__t429 topp 1.21981991934
* device instance topp_t430 r0 *1 0,0
Rtopp_t430 topp__t430 topp 1.12918221215
* device instance topp_t431 r0 *1 0,0
Rtopp_t431 topp__t431 topp 1.03864972297
* device instance topp_t432 r0 *1 0,0
Rtopp_t432 topp__t432 topp 0.948252588732
* device instance topp_t433 r0 *1 0,0
Rtopp_t433 topp__t433 topp 0.704104433403
* device instance topp_t434 r0 *1 0,0
Rtopp_t434 topp__t434 topp 0.76805550622
* device instance topp_t435 r0 *1 0,0
Rtopp_t435 topp__t435 topp 0.678414198134
* device instance topp_t436 r0 *1 0,0
Rtopp_t436 topp__t436 topp 0.589263382556
* device instance topp_t437 r0 *1 0,0
Rtopp_t437 topp__t437 topp 0.500865041713
* device instance topp_t438 r0 *1 0,0
Rtopp_t438 topp__t438 topp 0.413701815559
* device instance topp_t439 r0 *1 0,0
Rtopp_t439 topp__t439 topp 0.328757571137
* device instance topp_t440 r0 *1 0,0
Rtopp_t440 topp__t440 topp 0.655441480151
* device instance topp_t441 r0 *1 0,0
Rtopp_t441 topp__t441 topp 0.577267693441
* device instance topp_t442 r0 *1 0,0
Rtopp_t442 topp__t442 topp 0.503509078446
* device instance topp_t443 r0 *1 0,0
Rtopp_t443 topp__t443 topp 0.940613290548
* device instance topp_t444 r0 *1 0,0
Rtopp_t444 topp__t444 topp 0.859325886816
* device instance topp_t445 r0 *1 0,0
Rtopp_t445 topp__t445 topp 0.780241977432
* device instance topp_t446 r0 *1 0,0
Rtopp_t446 topp__t446 topp 0.532660695802
* device instance topp_t447 r0 *1 0,0
Rtopp_t447 topp__t447 topp 0.451675568344
* device instance topp_t448 r0 *1 0,0
Rtopp_t448 topp__t448 topp 0.375423983547
* device instance topp_t449 r0 *1 0,0
Rtopp_t449 topp__t449 topp 0.858033590973
* device instance topp_t450 r0 *1 0,0
Rtopp_t450 topp__t450 topp 0.684984926911
* device instance topp_t451 r0 *1 0,0
Rtopp_t451 topp__t451 topp 1.14195944098
* device instance topp_t452 r0 *1 0,0
Rtopp_t452 topp__t452 topp 1.22095778231
* device instance topp_t453 r0 *1 0,0
Rtopp_t453 topp__t453 topp 1.30155806391
* device instance topp_t454 r0 *1 0,0
Rtopp_t454 topp__t454 topp 1.38348033143
* device instance topp_t455 r0 *1 0,0
Rtopp_t455 topp__t455 topp 1.466503054
* device instance topp_t456 r0 *1 0,0
Rtopp_t456 topp__t456 topp 1.55044946177
* device instance topp_t457 r0 *1 0,0
Rtopp_t457 topp__t457 topp 0.234865968007
* device instance topp_t458 r0 *1 0,0
Rtopp_t458 topp__t458 topp 1.01824025389
* device instance topp_t459 r0 *1 0,0
Rtopp_t459 topp__t459 topp 0.952444107672
* device instance topp_t460 r0 *1 0,0
Rtopp_t460 topp__t460 topp 0.891142686684
* device instance topp_t461 r0 *1 0,0
Rtopp_t461 topp__t461 topp 0.835326130334
* device instance topp_t462 r0 *1 0,0
Rtopp_t462 topp__t462 topp 0.786163561993
* device instance topp_t463 r0 *1 0,0
Rtopp_t463 topp__t463 topp 1.51476777269
* device instance topp_t464 r0 *1 0,0
Rtopp_t464 topp__t464 topp 1.4311936785
* device instance topp_t465 r0 *1 0,0
Rtopp_t465 topp__t465 topp 1.34861344788
* device instance topp_t466 r0 *1 0,0
Rtopp_t466 topp__t466 topp 1.26722139518
* device instance topp_t467 r0 *1 0,0
Rtopp_t467 topp__t467 topp 1.18726191012
* device instance topp_t468 r0 *1 0,0
Rtopp_t468 topp__t468 topp 1.10904489008
* device instance topp_t469 r0 *1 0,0
Rtopp_t469 topp__t469 topp 1.03296623344
* device instance topp_t470 r0 *1 0,0
Rtopp_t470 topp__t470 topp 0.9595347085
* device instance topp_t471 r0 *1 0,0
Rtopp_t471 topp__t471 topp 1.08771577043
* device instance topp_t472 r0 *1 0,0
Rtopp_t472 topp__t472 topp 0.823425121187
* device instance topp_t473 r0 *1 0,0
Rtopp_t473 topp__t473 topp 0.762668595257
* device instance topp_t474 r0 *1 0,0
Rtopp_t474 topp__t474 topp 0.70848203109
* device instance topp_t475 r0 *1 0,0
Rtopp_t475 topp__t475 topp 0.662479536862
* device instance topp_t476 r0 *1 0,0
Rtopp_t476 topp__t476 topp 0.744973485829
* device instance topp_t477 r0 *1 0,0
Rtopp_t477 topp__t477 topp 1.55261964531
* device instance topp_t478 r0 *1 0,0
Rtopp_t478 topp__t478 topp 1.47119737059
* device instance topp_t479 r0 *1 0,0
Rtopp_t479 topp__t479 topp 1.39099410122
* device instance topp_t480 r0 *1 0,0
Rtopp_t480 topp__t480 topp 1.31223337187
* device instance topp_t481 r0 *1 0,0
Rtopp_t481 topp__t481 topp 0.889406217884
* device instance topp_t482 r0 *1 0,0
Rtopp_t482 topp__t482 topp 0.725401581905
* device instance topp_t483 r0 *1 0,0
Rtopp_t483 topp__t483 topp 0.761368785015
* device instance topp_t484 r0 *1 0,0
Rtopp_t484 topp__t484 topp 0.806105665999
* device instance topp_t485 r0 *1 0,0
Rtopp_t485 topp__t485 topp 0.858241929129
* device instance topp_t486 r0 *1 0,0
Rtopp_t486 topp__t486 topp 0.916515695048
* device instance topp_t487 r0 *1 0,0
Rtopp_t487 topp__t487 topp 0.979832524375
* device instance topp_t488 r0 *1 0,0
Rtopp_t488 topp__t488 topp 1.04727812857
* device instance topp_t489 r0 *1 0,0
Rtopp_t489 topp__t489 topp 1.11810559766
* device instance topp_t490 r0 *1 0,0
Rtopp_t490 topp__t490 topp 1.19171209722
* device instance topp_t491 r0 *1 0,0
Rtopp_t491 topp__t491 topp 1.2676136099
* device instance topp_t492 r0 *1 0,0
Rtopp_t492 topp__t492 topp 1.34542177459
* device instance topp_t493 r0 *1 0,0
Rtopp_t493 topp__t493 topp 1.4248242647
* device instance topp_t494 r0 *1 0,0
Rtopp_t494 topp__t494 topp 1.50556885104
* device instance topp_t495 r0 *1 0,0
Rtopp_t495 topp__t495 topp 0.691951609542
* device instance topp_t496 r0 *1 0,0
Rtopp_t496 topp__t496 topp 0.699558024373
* device instance topp_t497 r0 *1 0,0
Rtopp_t497 topp__t497 topp 1.23519115972
* device instance topp_t498 r0 *1 0,0
Rtopp_t498 topp__t498 topp 1.06491960715
* device instance topp_t499 r0 *1 0,0
Rtopp_t499 topp__t499 topp 0.990295471435
* device instance topp_t500 r0 *1 0,0
Rtopp_t500 topp__t500 topp 0.918675904764
* device instance topp_t501 r0 *1 0,0
Rtopp_t501 topp__t501 topp 0.85081999356
* device instance topp_t502 r0 *1 0,0
Rtopp_t502 topp__t502 topp 0.787700990914
* device instance topp_t503 r0 *1 0,0
Rtopp_t503 topp__t503 topp 0.730547730767
* device instance topp_t504 r0 *1 0,0
Rtopp_t504 topp__t504 topp 0.680864207436
* device instance topp_t505 r0 *1 0,0
Rtopp_t505 topp__t505 topp 0.64039136253
* device instance topp_t506 r0 *1 0,0
Rtopp_t506 topp__t506 topp 0.610962414258
* device instance topp_t507 r0 *1 0,0
Rtopp_t507 topp__t507 topp 0.594220491288
* device instance topp_t508 r0 *1 0,0
Rtopp_t508 topp__t508 topp 0.591244331131
* device instance topp_t509 r0 *1 0,0
Rtopp_t509 topp__t509 topp 0.6022380527
* device instance topp_t510 r0 *1 0,0
Rtopp_t510 topp__t510 topp 1.16020986293
* device instance topp_t511 r0 *1 0,0
Rtopp_t511 topp__t511 topp 0.682404731023
* device instance topp_t512 r0 *1 0,0
Rtopp_t512 topp__t512 topp 5.03077510656
* device instance topp_t513 r0 *1 0,0
Rtopp_t513 topp__t513 topp 4.94430761921
* device instance topp r0 *1 0,0
Ctopp topp vsubs 2.3701441e-13
* device instance tp_gn_t0 r0 *1 0,0
Rtp_gn_t0 tp_gn__t0 tp_gn 31.7522969677
* device instance tp_gn_t1 r0 *1 0,0
Rtp_gn_t1 tp_gn__t1 tp_gn 100.696431059
* device instance tp_gn_t2 r0 *1 0,0
Rtp_gn_t2 tp_gn__t2 tp_gn 64.5097300968
* device instance tp_gn_t3 r0 *1 0,0
Rtp_gn_t3 tp_gn__t3 tp_gn 70.2913261279
* device instance tp_gn_t4 r0 *1 0,0
Rtp_gn_t4 tp_gn__t4 tp_gn 99.0585228122
* device instance tp_gn_t5 r0 *1 0,0
Rtp_gn_t5 tp_gn__t5 tp_gn 38.2150929367
* device instance tp_gn r0 *1 0,0
Ctp_gn tp_gn vsubs 4.986478e-15
* device instance vcm_t0 r0 *1 0,0
Rvcm_t0 vcm__t0 vcm 412.602375568
* device instance vcm_t1 r0 *1 0,0
Rvcm_t1 vcm__t1 vcm 147.734301397
* device instance vcm_t2 r0 *1 0,0
Rvcm_t2 vcm__t2 vcm 388.410016513
* device instance vcm_t3 r0 *1 0,0
Rvcm_t3 vcm__t3 vcm 366.314563362
* device instance vcm_t4 r0 *1 0,0
Rvcm_t4 vcm__t4 vcm 41.1736191558
* device instance vcm_t5 r0 *1 0,0
Rvcm_t5 vcm__t5 vcm 158.235399068
* device instance vcm_t6 r0 *1 0,0
Rvcm_t6 vcm__t6 vcm 255.51200792
* device instance vcm_t7 r0 *1 0,0
Rvcm_t7 vcm__t7 vcm 317.760002863
* device instance vcm_t8 r0 *1 0,0
Rvcm_t8 vcm__t8 vcm 153.969811947
* device instance vcm_t9 r0 *1 0,0
Rvcm_t9 vcm__t9 vcm 234.732755553
* device instance vcm_t10 r0 *1 0,0
Rvcm_t10 vcm__t10 vcm 315.65753736
* device instance vcm_t11 r0 *1 0,0
Rvcm_t11 vcm__t11 vcm 73.9012197258
* device instance vcm_t12 r0 *1 0,0
Rvcm_t12 vcm__t12 vcm 82.4204392372
* device instance vcm_t13 r0 *1 0,0
Rvcm_t13 vcm__t13 vcm 98.7160364331
* device instance vcm_t14 r0 *1 0,0
Rvcm_t14 vcm__t14 vcm 237.552531151
* device instance vcm_t15 r0 *1 0,0
Rvcm_t15 vcm__t15 vcm 91.7230468419
* device instance vcm_t16 r0 *1 0,0
Rvcm_t16 vcm__t16 vcm 172.076021226
* device instance vcm_t17 r0 *1 0,0
Rvcm_t17 vcm__t17 vcm 19.0664204109
* device instance vcm_t18 r0 *1 0,0
Rvcm_t18 vcm__t18 vcm 175.90308584
* device instance vcm_t19 r0 *1 0,0
Rvcm_t19 vcm__t19 vcm 333.836171006
* device instance vcm_t20 r0 *1 0,0
Rvcm_t20 vcm__t20 vcm 252.892561505
* device instance vcm_t21 r0 *1 0,0
Rvcm_t21 vcm__t21 vcm 335.824846608
* device instance vcm_t22 r0 *1 0,0
Rvcm_t22 vcm__t22 vcm 375.811834767
* device instance vcm_t23 r0 *1 0,0
Rvcm_t23 vcm__t23 vcm 50.3438780536
* device instance vcm_t24 r0 *1 0,0
Rvcm_t24 vcm__t24 vcm 353.64688687
* device instance vcm_t25 r0 *1 0,0
Rvcm_t25 vcm__t25 vcm 112.82832019
* device instance vcm_t26 r0 *1 0,0
Rvcm_t26 vcm__t26 vcm 57.8179802216
* device instance vcm_t27 r0 *1 0,0
Rvcm_t27 vcm__t27 vcm 377.089836369
* device instance vcm_t28 r0 *1 0,0
Rvcm_t28 vcm__t28 vcm 122.533693892
* device instance vcm_t29 r0 *1 0,0
Rvcm_t29 vcm__t29 vcm 130.987863576
* device instance vcm_t30 r0 *1 0,0
Rvcm_t30 vcm__t30 vcm 296.868788984
* device instance vcm_t31 r0 *1 0,0
Rvcm_t31 vcm__t31 vcm 217.285208603
* device instance vcm_t32 r0 *1 0,0
Rvcm_t32 vcm__t32 vcm 199.583426829
* device instance vcm_t33 r0 *1 0,0
Rvcm_t33 vcm__t33 vcm 69.4174499633
* device instance vcm_t34 r0 *1 0,0
Rvcm_t34 vcm__t34 vcm 278.926573161
* device instance vcm_t35 r0 *1 0,0
Rvcm_t35 vcm__t35 vcm 139.43491925
* device instance vcm_t36 r0 *1 0,0
Rvcm_t36 vcm__t36 vcm 211.963642108
* device instance vcm_t37 r0 *1 0,0
Rvcm_t37 vcm__t37 vcm 274.801304425
* device instance vcm_t38 r0 *1 0,0
Rvcm_t38 vcm__t38 vcm 193.776334889
* device instance vcm_t39 r0 *1 0,0
Rvcm_t39 vcm__t39 vcm 32.5367874101
* device instance vcm_t40 r0 *1 0,0
Rvcm_t40 vcm__t40 vcm 292.996248391
* device instance vcm_t41 r0 *1 0,0
Rvcm_t41 vcm__t41 vcm 374.048751356
* device instance vcm r0 *1 0,0
Cvcm vcm vsubs 2.71382523e-13
* device instance vdd_t0 r0 *1 0,0
Rvdd_t0 vdd__t0 vdd 216.30897829
* device instance vdd_t1 r0 *1 0,0
Rvdd_t1 vdd__t1 vdd 216.30897829
* device instance vdd_t2 r0 *1 0,0
Rvdd_t2 vdd__t2 vdd 203.665576581
* device instance vdd_t3 r0 *1 0,0
Rvdd_t3 vdd__t3 vdd 247.462427696
* device instance vdd_t4 r0 *1 0,0
Rvdd_t4 vdd__t4 vdd 233.926193941
* device instance vdd_t5 r0 *1 0,0
Rvdd_t5 vdd__t5 vdd 14.8596344983
* device instance vdd_t6 r0 *1 0,0
Rvdd_t6 vdd__t6 vdd 20.5092039028
* device instance vdd_t7 r0 *1 0,0
Rvdd_t7 vdd__t7 vdd 98.3678536467
* device instance vdd_t8 r0 *1 0,0
Rvdd_t8 vdd__t8 vdd 101.311032582
* device instance vdd_t9 r0 *1 0,0
Rvdd_t9 vdd__t9 vdd 104.256094112
* device instance vdd_t10 r0 *1 0,0
Rvdd_t10 vdd__t10 vdd 107.202883083
* device instance vdd_t11 r0 *1 0,0
Rvdd_t11 vdd__t11 vdd 54.9876416723
* device instance vdd_t12 r0 *1 0,0
Rvdd_t12 vdd__t12 vdd 15.1733813242
* device instance vdd_t13 r0 *1 0,0
Rvdd_t13 vdd__t13 vdd 197.729247134
* device instance vdd_t14 r0 *1 0,0
Rvdd_t14 vdd__t14 vdd 49.4634654791
* device instance vdd_t15 r0 *1 0,0
Rvdd_t15 vdd__t15 vdd 144.897405701
* device instance vdd_t16 r0 *1 0,0
Rvdd_t16 vdd__t16 vdd 147.858364257
* device instance vdd_t17 r0 *1 0,0
Rvdd_t17 vdd__t17 vdd 150.819928151
* device instance vdd_t18 r0 *1 0,0
Rvdd_t18 vdd__t18 vdd 59.6596703087
* device instance vdd_t19 r0 *1 0,0
Rvdd_t19 vdd__t19 vdd 95.239489394
* device instance vdd_t20 r0 *1 0,0
Rvdd_t20 vdd__t20 vdd 197.918270521
* device instance vdd_t21 r0 *1 0,0
Rvdd_t21 vdd__t21 vdd 200.886329976
* device instance vdd_t22 r0 *1 0,0
Rvdd_t22 vdd__t22 vdd 194.761456489
* device instance vdd_t23 r0 *1 0,0
Rvdd_t23 vdd__t23 vdd 16.0427992955
* device instance vdd_t24 r0 *1 0,0
Rvdd_t24 vdd__t24 vdd 99.3309144978
* device instance vdd_t25 r0 *1 0,0
Rvdd_t25 vdd__t25 vdd 102.246375323
* device instance vdd_t26 r0 *1 0,0
Rvdd_t26 vdd__t26 vdd 105.165246652
* device instance vdd_t27 r0 *1 0,0
Rvdd_t27 vdd__t27 vdd 108.087252187
* device instance vdd_t28 r0 *1 0,0
Rvdd_t28 vdd__t28 vdd 148.68859978
* device instance vdd_t29 r0 *1 0,0
Rvdd_t29 vdd__t29 vdd 151.637669901
* device instance vdd_t30 r0 *1 0,0
Rvdd_t30 vdd__t30 vdd 154.587785114
* device instance vdd_t31 r0 *1 0,0
Rvdd_t31 vdd__t31 vdd 157.538886707
* device instance vdd_t32 r0 *1 0,0
Rvdd_t32 vdd__t32 vdd 21.1605140096
* device instance vdd_t33 r0 *1 0,0
Rvdd_t33 vdd__t33 vdd 201.359662085
* device instance vdd_t34 r0 *1 0,0
Rvdd_t34 vdd__t34 vdd 204.32108659
* device instance vdd_t35 r0 *1 0,0
Rvdd_t35 vdd__t35 vdd 207.282938228
* device instance vdd_t36 r0 *1 0,0
Rvdd_t36 vdd__t36 vdd 56.8695332866
* device instance vdd_t37 r0 *1 0,0
Rvdd_t37 vdd__t37 vdd 54.0992469093
* device instance vdd_t38 r0 *1 0,0
Rvdd_t38 vdd__t38 vdd 52.3099662802
* device instance vdd_t39 r0 *1 0,0
Rvdd_t39 vdd__t39 vdd 55.1701719439
* device instance vdd_t40 r0 *1 0,0
Rvdd_t40 vdd__t40 vdd 58.0420564542
* device instance vdd_t41 r0 *1 0,0
Rvdd_t41 vdd__t41 vdd 51.3520239242
* device instance vdd_t42 r0 *1 0,0
Rvdd_t42 vdd__t42 vdd 198.398683841
* device instance vdd_t43 r0 *1 0,0
Rvdd_t43 vdd__t43 vdd 153.78206241
* device instance vdd_t44 r0 *1 0,0
Rvdd_t44 vdd__t44 vdd 52.1282439598
* device instance vdd_t45 r0 *1 0,0
Rvdd_t45 vdd__t45 vdd 49.2826951884
* device instance vdd_t46 r0 *1 0,0
Rvdd_t46 vdd__t46 vdd 46.4535404115
* device instance vdd_t47 r0 *1 0,0
Rvdd_t47 vdd__t47 vdd 15.1361527171
* device instance vdd_t48 r0 *1 0,0
Rvdd_t48 vdd__t48 vdd 148.046964713
* device instance vdd_t49 r0 *1 0,0
Rvdd_t49 vdd__t49 vdd 151.008565946
* device instance vdd_t50 r0 *1 0,0
Rvdd_t50 vdd__t50 vdd 153.970735409
* device instance vdd_t51 r0 *1 0,0
Rvdd_t51 vdd__t51 vdd 156.933440926
* device instance vdd_t52 r0 *1 0,0
Rvdd_t52 vdd__t52 vdd 203.854630757
* device instance vdd_t53 r0 *1 0,0
Rvdd_t53 vdd__t53 vdd 20.481676274
* device instance vdd_t54 r0 *1 0,0
Rvdd_t54 vdd__t54 vdd 48.459543546
* device instance vdd_t55 r0 *1 0,0
Rvdd_t55 vdd__t55 vdd 51.1779248207
* device instance vdd_t56 r0 *1 0,0
Rvdd_t56 vdd__t56 vdd 53.9235547999
* device instance vdd_t57 r0 *1 0,0
Rvdd_t57 vdd__t57 vdd 56.6924746381
* device instance vdd_t58 r0 *1 0,0
Rvdd_t58 vdd__t58 vdd 96.2338624599
* device instance vdd_t59 r0 *1 0,0
Rvdd_t59 vdd__t59 vdd 99.1453551555
* device instance vdd_t60 r0 *1 0,0
Rvdd_t60 vdd__t60 vdd 102.060588666
* device instance vdd_t61 r0 *1 0,0
Rvdd_t61 vdd__t61 vdd 104.97925135
* device instance vdd_t62 r0 *1 0,0
Rvdd_t62 vdd__t62 vdd 20.2781823973
* device instance vdd_t63 r0 *1 0,0
Rvdd_t63 vdd__t63 vdd 206.823162476
* device instance vdd_t64 r0 *1 0,0
Rvdd_t64 vdd__t64 vdd 98.1804741534
* device instance vdd_t65 r0 *1 0,0
Rvdd_t65 vdd__t65 vdd 204.132464414
* device instance vdd_t66 r0 *1 0,0
Rvdd_t66 vdd__t66 vdd 101.123527505
* device instance vdd_t67 r0 *1 0,0
Rvdd_t67 vdd__t67 vdd 201.171067749
* device instance vdd_t68 r0 *1 0,0
Rvdd_t68 vdd__t68 vdd 198.210118601
* device instance vdd_t69 r0 *1 0,0
Rvdd_t69 vdd__t69 vdd 195.24963733
* device instance vdd_t70 r0 *1 0,0
Rvdd_t70 vdd__t70 vdd 154.399866137
* device instance vdd_t71 r0 *1 0,0
Rvdd_t71 vdd__t71 vdd 151.449815686
* device instance vdd_t72 r0 *1 0,0
Rvdd_t72 vdd__t72 vdd 148.500814222
* device instance vdd_t73 r0 *1 0,0
Rvdd_t73 vdd__t73 vdd 145.552925505
* device instance vdd_t74 r0 *1 0,0
Rvdd_t74 vdd__t74 vdd 200.697290852
* device instance vdd_t75 r0 *1 0,0
Rvdd_t75 vdd__t75 vdd 104.068473949
* device instance vdd_t76 r0 *1 0,0
Rvdd_t76 vdd__t76 vdd 66.6050412888
* device instance vdd_t77 r0 *1 0,0
Rvdd_t77 vdd__t77 vdd 60.6591204368
* device instance vdd_t78 r0 *1 0,0
Rvdd_t78 vdd__t78 vdd 108.086247845
* device instance vdd_t79 r0 *1 0,0
Rvdd_t79 vdd__t79 vdd 63.6284981574
* device instance vdd_t80 r0 *1 0,0
Rvdd_t80 vdd__t80 vdd 112.992376321
* device instance vdd_t81 r0 *1 0,0
Rvdd_t81 vdd__t81 vdd 22.8800674776
* device instance vdd_t82 r0 *1 0,0
Rvdd_t82 vdd__t82 vdd 21.8692678148
* device instance vdd_t83 r0 *1 0,0
Rvdd_t83 vdd__t83 vdd 68.4221245133
* device instance vdd_t84 r0 *1 0,0
Rvdd_t84 vdd__t84 vdd 15.2613655
* device instance vdd_t85 r0 *1 0,0
Rvdd_t85 vdd__t85 vdd 65.528172381
* device instance vdd_t86 r0 *1 0,0
Rvdd_t86 vdd__t86 vdd 109.96810815
* device instance vdd_t87 r0 *1 0,0
Rvdd_t87 vdd__t87 vdd 62.6488985538
* device instance vdd_t88 r0 *1 0,0
Rvdd_t88 vdd__t88 vdd 59.786423761
* device instance vdd_t89 r0 *1 0,0
Rvdd_t89 vdd__t89 vdd 106.945226052
* device instance vdd_t90 r0 *1 0,0
Rvdd_t90 vdd__t90 vdd 16.6775864545
* device instance vdd_t91 r0 *1 0,0
Rvdd_t91 vdd__t91 vdd 18.4922514772
* device instance vdd_t92 r0 *1 0,0
Rvdd_t92 vdd__t92 vdd 20.60033255
* device instance vdd_t93 r0 *1 0,0
Rvdd_t93 vdd__t93 vdd 57.6980144225
* device instance vdd_t94 r0 *1 0,0
Rvdd_t94 vdd__t94 vdd 48.9303811462
* device instance vdd_t95 r0 *1 0,0
Rvdd_t95 vdd__t95 vdd 192.454250762
* device instance vdd_t96 r0 *1 0,0
Rvdd_t96 vdd__t96 vdd 195.484903935
* device instance vdd_t97 r0 *1 0,0
Rvdd_t97 vdd__t97 vdd 135.87204909
* device instance vdd_t98 r0 *1 0,0
Rvdd_t98 vdd__t98 vdd 138.904678179
* device instance vdd_t99 r0 *1 0,0
Rvdd_t99 vdd__t99 vdd 141.937994835
* device instance vdd_t100 r0 *1 0,0
Rvdd_t100 vdd__t100 vdd 144.971955899
* device instance vdd_t101 r0 *1 0,0
Rvdd_t101 vdd__t101 vdd 116.01792217
* device instance vdd_t102 r0 *1 0,0
Rvdd_t102 vdd__t102 vdd 185.735380482
* device instance vdd_t103 r0 *1 0,0
Rvdd_t103 vdd__t103 vdd 188.77542973
* device instance vdd_t104 r0 *1 0,0
Rvdd_t104 vdd__t104 vdd 191.815752842
* device instance vdd_t105 r0 *1 0,0
Rvdd_t105 vdd__t105 vdd 194.856336999
* device instance vdd_t106 r0 *1 0,0
Rvdd_t106 vdd__t106 vdd 139.785067935
* device instance vdd_t107 r0 *1 0,0
Rvdd_t107 vdd__t107 vdd 142.799684788
* device instance vdd_t108 r0 *1 0,0
Rvdd_t108 vdd__t108 vdd 145.815717929
* device instance vdd_t109 r0 *1 0,0
Rvdd_t109 vdd__t109 vdd 186.394707974
* device instance vdd_t110 r0 *1 0,0
Rvdd_t110 vdd__t110 vdd 136.771961021
* device instance vdd_t111 r0 *1 0,0
Rvdd_t111 vdd__t111 vdd 229.591965661
* device instance vdd_t112 r0 *1 0,0
Rvdd_t112 vdd__t112 vdd 243.197142814
* device instance vdd_t113 r0 *1 0,0
Rvdd_t113 vdd__t113 vdd 87.6482766423
* device instance vdd_t114 r0 *1 0,0
Rvdd_t114 vdd__t114 vdd 90.6106002827
* device instance vdd_t115 r0 *1 0,0
Rvdd_t115 vdd__t115 vdd 93.5784709777
* device instance vdd_t116 r0 *1 0,0
Rvdd_t116 vdd__t116 vdd 96.5513771999
* device instance vdd_t117 r0 *1 0,0
Rvdd_t117 vdd__t117 vdd 37.7436722245
* device instance vdd_t118 r0 *1 0,0
Rvdd_t118 vdd__t118 vdd 46.1971795815
* device instance vdd_t119 r0 *1 0,0
Rvdd_t119 vdd__t119 vdd 43.4606005879
* device instance vdd_t120 r0 *1 0,0
Rvdd_t120 vdd__t120 vdd 46.3554376668
* device instance vdd_t121 r0 *1 0,0
Rvdd_t121 vdd__t121 vdd 86.2372587722
* device instance vdd_t122 r0 *1 0,0
Rvdd_t122 vdd__t122 vdd 89.2464301009
* device instance vdd_t123 r0 *1 0,0
Rvdd_t123 vdd__t123 vdd 92.2581954771
* device instance vdd_t124 r0 *1 0,0
Rvdd_t124 vdd__t124 vdd 95.2723088907
* device instance vdd_t125 r0 *1 0,0
Rvdd_t125 vdd__t125 vdd 40.8649041455
* device instance vdd_t126 r0 *1 0,0
Rvdd_t126 vdd__t126 vdd 43.5059244838
* device instance vdd_t127 r0 *1 0,0
Rvdd_t127 vdd__t127 vdd 40.5882971725
* device instance vdd_t128 r0 *1 0,0
Rvdd_t128 vdd__t128 vdd 114.072927132
* device instance vdd_t129 r0 *1 0,0
Rvdd_t129 vdd__t129 vdd 189.424176038
* device instance vdd_t130 r0 *1 0,0
Rvdd_t130 vdd__t130 vdd 159.745139656
* device instance vdd_t131 r0 *1 0,0
Rvdd_t131 vdd__t131 vdd 162.782177621
* device instance vdd_t132 r0 *1 0,0
Rvdd_t132 vdd__t132 vdd 165.819642745
* device instance vdd_t133 r0 *1 0,0
Rvdd_t133 vdd__t133 vdd 160.51126204
* device instance vdd_t134 r0 *1 0,0
Rvdd_t134 vdd__t134 vdd 157.489448523
* device instance vdd_t135 r0 *1 0,0
Rvdd_t135 vdd__t135 vdd 210.241430244
* device instance vdd_t136 r0 *1 0,0
Rvdd_t136 vdd__t136 vdd 213.274991758
* device instance vdd_t137 r0 *1 0,0
Rvdd_t137 vdd__t137 vdd 117.070550791
* device instance vdd_t138 r0 *1 0,0
Rvdd_t138 vdd__t138 vdd 206.615413599
* device instance vdd_t139 r0 *1 0,0
Rvdd_t139 vdd__t139 vdd 209.657109093
* device instance vdd_t140 r0 *1 0,0
Rvdd_t140 vdd__t140 vdd 212.699004491
* device instance vdd_t141 r0 *1 0,0
Rvdd_t141 vdd__t141 vdd 215.741091337
* device instance vdd_t142 r0 *1 0,0
Rvdd_t142 vdd__t142 vdd 25.8791286369
* device instance vdd_t143 r0 *1 0,0
Rvdd_t143 vdd__t143 vdd 24.2346644814
* device instance vdd_t144 r0 *1 0,0
Rvdd_t144 vdd__t144 vdd 111.078082482
* device instance vdd_t145 r0 *1 0,0
Rvdd_t145 vdd__t145 vdd 207.208312417
* device instance vdd_t146 r0 *1 0,0
Rvdd_t146 vdd__t146 vdd 163.534072746
* device instance vdd_t147 r0 *1 0,0
Rvdd_t147 vdd__t147 vdd 166.557826348
* device instance vdd_t148 r0 *1 0,0
Rvdd_t148 vdd__t148 vdd 156.708553686
* device instance vdd_t149 r0 *1 0,0
Rvdd_t149 vdd__t149 vdd 66.6050412888
* device instance vdd_t150 r0 *1 0,0
Rvdd_t150 vdd__t150 vdd 60.6591204368
* device instance vdd_t151 r0 *1 0,0
Rvdd_t151 vdd__t151 vdd 108.086247845
* device instance vdd_t152 r0 *1 0,0
Rvdd_t152 vdd__t152 vdd 63.6284981574
* device instance vdd_t153 r0 *1 0,0
Rvdd_t153 vdd__t153 vdd 112.992376321
* device instance vdd_t154 r0 *1 0,0
Rvdd_t154 vdd__t154 vdd 22.8800674776
* device instance vdd_t155 r0 *1 0,0
Rvdd_t155 vdd__t155 vdd 21.8692678148
* device instance vdd_t156 r0 *1 0,0
Rvdd_t156 vdd__t156 vdd 68.4221245133
* device instance vdd_t157 r0 *1 0,0
Rvdd_t157 vdd__t157 vdd 15.2613655
* device instance vdd_t158 r0 *1 0,0
Rvdd_t158 vdd__t158 vdd 65.528172381
* device instance vdd_t159 r0 *1 0,0
Rvdd_t159 vdd__t159 vdd 109.96810815
* device instance vdd_t160 r0 *1 0,0
Rvdd_t160 vdd__t160 vdd 62.6488985538
* device instance vdd_t161 r0 *1 0,0
Rvdd_t161 vdd__t161 vdd 59.786423761
* device instance vdd_t162 r0 *1 0,0
Rvdd_t162 vdd__t162 vdd 106.945226052
* device instance vdd_t163 r0 *1 0,0
Rvdd_t163 vdd__t163 vdd 16.6775864545
* device instance vdd_t164 r0 *1 0,0
Rvdd_t164 vdd__t164 vdd 18.4922514772
* device instance vdd_t165 r0 *1 0,0
Rvdd_t165 vdd__t165 vdd 20.60033255
* device instance vdd_t166 r0 *1 0,0
Rvdd_t166 vdd__t166 vdd 57.6980144225
* device instance vdd_t167 r0 *1 0,0
Rvdd_t167 vdd__t167 vdd 48.9303811462
* device instance vdd_t168 r0 *1 0,0
Rvdd_t168 vdd__t168 vdd 192.454250762
* device instance vdd_t169 r0 *1 0,0
Rvdd_t169 vdd__t169 vdd 195.484903935
* device instance vdd_t170 r0 *1 0,0
Rvdd_t170 vdd__t170 vdd 135.87204909
* device instance vdd_t171 r0 *1 0,0
Rvdd_t171 vdd__t171 vdd 138.904678179
* device instance vdd_t172 r0 *1 0,0
Rvdd_t172 vdd__t172 vdd 141.937994835
* device instance vdd_t173 r0 *1 0,0
Rvdd_t173 vdd__t173 vdd 144.971955899
* device instance vdd_t174 r0 *1 0,0
Rvdd_t174 vdd__t174 vdd 116.01792217
* device instance vdd_t175 r0 *1 0,0
Rvdd_t175 vdd__t175 vdd 185.735380482
* device instance vdd_t176 r0 *1 0,0
Rvdd_t176 vdd__t176 vdd 188.77542973
* device instance vdd_t177 r0 *1 0,0
Rvdd_t177 vdd__t177 vdd 191.815752842
* device instance vdd_t178 r0 *1 0,0
Rvdd_t178 vdd__t178 vdd 194.856336999
* device instance vdd_t179 r0 *1 0,0
Rvdd_t179 vdd__t179 vdd 139.785067935
* device instance vdd_t180 r0 *1 0,0
Rvdd_t180 vdd__t180 vdd 142.799684788
* device instance vdd_t181 r0 *1 0,0
Rvdd_t181 vdd__t181 vdd 145.815717929
* device instance vdd_t182 r0 *1 0,0
Rvdd_t182 vdd__t182 vdd 186.394707974
* device instance vdd_t183 r0 *1 0,0
Rvdd_t183 vdd__t183 vdd 136.771961021
* device instance vdd_t184 r0 *1 0,0
Rvdd_t184 vdd__t184 vdd 229.591965661
* device instance vdd_t185 r0 *1 0,0
Rvdd_t185 vdd__t185 vdd 243.197142814
* device instance vdd_t186 r0 *1 0,0
Rvdd_t186 vdd__t186 vdd 87.6482766423
* device instance vdd_t187 r0 *1 0,0
Rvdd_t187 vdd__t187 vdd 90.6106002827
* device instance vdd_t188 r0 *1 0,0
Rvdd_t188 vdd__t188 vdd 93.5784709777
* device instance vdd_t189 r0 *1 0,0
Rvdd_t189 vdd__t189 vdd 96.5513771999
* device instance vdd_t190 r0 *1 0,0
Rvdd_t190 vdd__t190 vdd 37.7436722245
* device instance vdd_t191 r0 *1 0,0
Rvdd_t191 vdd__t191 vdd 46.1971795815
* device instance vdd_t192 r0 *1 0,0
Rvdd_t192 vdd__t192 vdd 43.4606005879
* device instance vdd_t193 r0 *1 0,0
Rvdd_t193 vdd__t193 vdd 46.3554376668
* device instance vdd_t194 r0 *1 0,0
Rvdd_t194 vdd__t194 vdd 86.2372587722
* device instance vdd_t195 r0 *1 0,0
Rvdd_t195 vdd__t195 vdd 89.2464301009
* device instance vdd_t196 r0 *1 0,0
Rvdd_t196 vdd__t196 vdd 92.2581954771
* device instance vdd_t197 r0 *1 0,0
Rvdd_t197 vdd__t197 vdd 95.2723088907
* device instance vdd_t198 r0 *1 0,0
Rvdd_t198 vdd__t198 vdd 40.8649041455
* device instance vdd_t199 r0 *1 0,0
Rvdd_t199 vdd__t199 vdd 43.5059244838
* device instance vdd_t200 r0 *1 0,0
Rvdd_t200 vdd__t200 vdd 40.5882971725
* device instance vdd_t201 r0 *1 0,0
Rvdd_t201 vdd__t201 vdd 114.072927132
* device instance vdd_t202 r0 *1 0,0
Rvdd_t202 vdd__t202 vdd 189.424176038
* device instance vdd_t203 r0 *1 0,0
Rvdd_t203 vdd__t203 vdd 159.745139656
* device instance vdd_t204 r0 *1 0,0
Rvdd_t204 vdd__t204 vdd 162.782177621
* device instance vdd_t205 r0 *1 0,0
Rvdd_t205 vdd__t205 vdd 165.819642745
* device instance vdd_t206 r0 *1 0,0
Rvdd_t206 vdd__t206 vdd 160.51126204
* device instance vdd_t207 r0 *1 0,0
Rvdd_t207 vdd__t207 vdd 157.489448523
* device instance vdd_t208 r0 *1 0,0
Rvdd_t208 vdd__t208 vdd 210.241430244
* device instance vdd_t209 r0 *1 0,0
Rvdd_t209 vdd__t209 vdd 213.274991758
* device instance vdd_t210 r0 *1 0,0
Rvdd_t210 vdd__t210 vdd 117.070550791
* device instance vdd_t211 r0 *1 0,0
Rvdd_t211 vdd__t211 vdd 206.615413599
* device instance vdd_t212 r0 *1 0,0
Rvdd_t212 vdd__t212 vdd 209.657109093
* device instance vdd_t213 r0 *1 0,0
Rvdd_t213 vdd__t213 vdd 212.699004491
* device instance vdd_t214 r0 *1 0,0
Rvdd_t214 vdd__t214 vdd 215.741091337
* device instance vdd_t215 r0 *1 0,0
Rvdd_t215 vdd__t215 vdd 25.8791286369
* device instance vdd_t216 r0 *1 0,0
Rvdd_t216 vdd__t216 vdd 24.2346644814
* device instance vdd_t217 r0 *1 0,0
Rvdd_t217 vdd__t217 vdd 111.078082482
* device instance vdd_t218 r0 *1 0,0
Rvdd_t218 vdd__t218 vdd 207.208312417
* device instance vdd_t219 r0 *1 0,0
Rvdd_t219 vdd__t219 vdd 163.534072746
* device instance vdd_t220 r0 *1 0,0
Rvdd_t220 vdd__t220 vdd 166.557826348
* device instance vdd_t221 r0 *1 0,0
Rvdd_t221 vdd__t221 vdd 156.708553686
* device instance vdd r0 *1 0,0
Cvdd vdd vsubs 3.8521339e-13
* device instance vref_t0 r0 *1 0,0
Rvref_t0 vref__t0 vref 41.8345661207
* device instance vref_t1 r0 *1 0,0
Rvref_t1 vref__t1 vref 200.385712152
* device instance vref_t2 r0 *1 0,0
Rvref_t2 vref__t2 vref 34.4306210191
* device instance vref_t3 r0 *1 0,0
Rvref_t3 vref__t3 vref 332.112288815
* device instance vref_t4 r0 *1 0,0
Rvref_t4 vref__t4 vref 244.210803651
* device instance vref_t5 r0 *1 0,0
Rvref_t5 vref__t5 vref 201.789734361
* device instance vref_t6 r0 *1 0,0
Rvref_t6 vref__t6 vref 289.11063533
* device instance vref_t7 r0 *1 0,0
Rvref_t7 vref__t7 vref 376.879832861
* device instance vref_t8 r0 *1 0,0
Rvref_t8 vref__t8 vref 115.93455358
* device instance vref_t9 r0 *1 0,0
Rvref_t9 vref__t9 vref 113.473157421
* device instance vref_t10 r0 *1 0,0
Rvref_t10 vref__t10 vref 71.2907024852
* device instance vref_t11 r0 *1 0,0
Rvref_t11 vref__t11 vref 288.132428238
* device instance vref_t12 r0 *1 0,0
Rvref_t12 vref__t12 vref 376.129957805
* device instance vref_t13 r0 *1 0,0
Rvref_t13 vref__t13 vref 75.146706645
* device instance vref_t14 r0 *1 0,0
Rvref_t14 vref__t14 vref 158.529210258
* device instance vref_t15 r0 *1 0,0
Rvref_t15 vref__t15 vref 156.738148663
* device instance vref_t16 r0 *1 0,0
Rvref_t16 vref__t16 vref 332.961312528
* device instance vref_t17 r0 *1 0,0
Rvref_t17 vref__t17 vref 245.364178067
* device instance vref_t18 r0 *1 0,0
Rvref_t18 vref__t18 vref 34.4306210191
* device instance vref_t19 r0 *1 0,0
Rvref_t19 vref__t19 vref 156.738148663
* device instance vref_t20 r0 *1 0,0
Rvref_t20 vref__t20 vref 75.146706645
* device instance vref_t21 r0 *1 0,0
Rvref_t21 vref__t21 vref 376.879832861
* device instance vref_t22 r0 *1 0,0
Rvref_t22 vref__t22 vref 158.529210258
* device instance vref_t23 r0 *1 0,0
Rvref_t23 vref__t23 vref 289.11063533
* device instance vref_t24 r0 *1 0,0
Rvref_t24 vref__t24 vref 113.473157421
* device instance vref_t25 r0 *1 0,0
Rvref_t25 vref__t25 vref 200.385712152
* device instance vref_t26 r0 *1 0,0
Rvref_t26 vref__t26 vref 376.129957805
* device instance vref_t27 r0 *1 0,0
Rvref_t27 vref__t27 vref 245.364178067
* device instance vref_t28 r0 *1 0,0
Rvref_t28 vref__t28 vref 332.961312528
* device instance vref_t29 r0 *1 0,0
Rvref_t29 vref__t29 vref 41.8345661207
* device instance vref_t30 r0 *1 0,0
Rvref_t30 vref__t30 vref 115.93455358
* device instance vref_t31 r0 *1 0,0
Rvref_t31 vref__t31 vref 288.132428238
* device instance vref_t32 r0 *1 0,0
Rvref_t32 vref__t32 vref 201.789734361
* device instance vref_t33 r0 *1 0,0
Rvref_t33 vref__t33 vref 332.112288815
* device instance vref_t34 r0 *1 0,0
Rvref_t34 vref__t34 vref 244.210803651
* device instance vref_t35 r0 *1 0,0
Rvref_t35 vref__t35 vref 71.2907024852
* device instance vref r0 *1 0,0
Cvref vref vsubs 1.80620176e-13
* device instance vss_t0 r0 *1 0,0
Rvss_t0 vss__t0 vss 43.0254325254
* device instance vss_t1 r0 *1 0,0
Rvss_t1 vss__t1 vss 25.2692841731
* device instance vss_t2 r0 *1 0,0
Rvss_t2 vss__t2 vss 24.0829707919
* device instance vss_t3 r0 *1 0,0
Rvss_t3 vss__t3 vss 15.9782441967
* device instance vss_t4 r0 *1 0,0
Rvss_t4 vss__t4 vss 14.3412587543
* device instance vss_t5 r0 *1 0,0
Rvss_t5 vss__t5 vss 33.8721253462
* device instance vss_t6 r0 *1 0,0
Rvss_t6 vss__t6 vss 6.00641199407
* device instance vss_t7 r0 *1 0,0
Rvss_t7 vss__t7 vss 25.5546661747
* device instance vss_t8 r0 *1 0,0
Rvss_t8 vss__t8 vss 35.2674248108
* device instance vss_t9 r0 *1 0,0
Rvss_t9 vss__t9 vss 7.11204792735
* device instance vss_t10 r0 *1 0,0
Rvss_t10 vss__t10 vss 45.0283816728
* device instance vss_t11 r0 *1 0,0
Rvss_t11 vss__t11 vss 15.5177333052
* device instance vss_t12 r0 *1 0,0
Rvss_t12 vss__t12 vss 4.93634854434
* device instance vss_t13 r0 *1 0,0
Rvss_t13 vss__t13 vss 35.0611895421
* device instance vss_t14 r0 *1 0,0
Rvss_t14 vss__t14 vss 6.23472354075
* device instance vss_t15 r0 *1 0,0
Rvss_t15 vss__t15 vss 14.8383268375
* device instance vss_t16 r0 *1 0,0
Rvss_t16 vss__t16 vss 44.8670359551
* device instance vss_t17 r0 *1 0,0
Rvss_t17 vss__t17 vss 34.0855558286
* device instance vss_t18 r0 *1 0,0
Rvss_t18 vss__t18 vss 24.3822419569
* device instance vss_t19 r0 *1 0,0
Rvss_t19 vss__t19 vss 20.5414026101
* device instance vss_t20 r0 *1 0,0
Rvss_t20 vss__t20 vss 9.86409936166
* device instance vss_t21 r0 *1 0,0
Rvss_t21 vss__t21 vss 40.0366016123
* device instance vss_t22 r0 *1 0,0
Rvss_t22 vss__t22 vss 10.9635314062
* device instance vss_t23 r0 *1 0,0
Rvss_t23 vss__t23 vss 20.5287332703
* device instance vss_t24 r0 *1 0,0
Rvss_t24 vss__t24 vss 38.8491169002
* device instance vss_t25 r0 *1 0,0
Rvss_t25 vss__t25 vss 29.0760328058
* device instance vss_t26 r0 *1 0,0
Rvss_t26 vss__t26 vss 19.3677935972
* device instance vss_t27 r0 *1 0,0
Rvss_t27 vss__t27 vss 3.53597191854
* device instance vss_t28 r0 *1 0,0
Rvss_t28 vss__t28 vss 9.83768899247
* device instance vss_t29 r0 *1 0,0
Rvss_t29 vss__t29 vss 19.3543560296
* device instance vss_t30 r0 *1 0,0
Rvss_t30 vss__t30 vss 30.2600788544
* device instance vss_t31 r0 *1 0,0
Rvss_t31 vss__t31 vss 38.8558131485
* device instance vss_t32 r0 *1 0,0
Rvss_t32 vss__t32 vss 3.46161319395
* device instance vss_t33 r0 *1 0,0
Rvss_t33 vss__t33 vss 29.0849792028
* device instance vss_t34 r0 *1 0,0
Rvss_t34 vss__t34 vss 40.0430992827
* device instance vss_t35 r0 *1 0,0
Rvss_t35 vss__t35 vss 30.2686752894
* device instance vss_t36 r0 *1 0,0
Rvss_t36 vss__t36 vss 10.9872358853
* device instance vss_t37 r0 *1 0,0
Rvss_t37 vss__t37 vss 26.0882576441
* device instance vss_t38 r0 *1 0,0
Rvss_t38 vss__t38 vss 9.02079652922
* device instance vss_t39 r0 *1 0,0
Rvss_t39 vss__t39 vss 27.872821836
* device instance vss_t40 r0 *1 0,0
Rvss_t40 vss__t40 vss 27.2778177452
* device instance vss_t41 r0 *1 0,0
Rvss_t41 vss__t41 vss 7.45687802907
* device instance vss_t42 r0 *1 0,0
Rvss_t42 vss__t42 vss 37.7621417869
* device instance vss_t43 r0 *1 0,0
Rvss_t43 vss__t43 vss 37.1673237018
* device instance vss_t44 r0 *1 0,0
Rvss_t44 vss__t44 vss 41.2388094979
* device instance vss_t45 r0 *1 0,0
Rvss_t45 vss__t45 vss 41.8342726454
* device instance vss_t46 r0 *1 0,0
Rvss_t46 vss__t46 vss 42.4298147475
* device instance vss_t47 r0 *1 0,0
Rvss_t47 vss__t47 vss 36.5726182101
* device instance vss_t48 r0 *1 0,0
Rvss_t48 vss__t48 vss 35.9780308951
* device instance vss_t49 r0 *1 0,0
Rvss_t49 vss__t49 vss 35.8684916478
* device instance vss_t50 r0 *1 0,0
Rvss_t50 vss__t50 vss 36.4648651271
* device instance vss_t51 r0 *1 0,0
Rvss_t51 vss__t51 vss 37.061299723
* device instance vss_t52 r0 *1 0,0
Rvss_t52 vss__t52 vss 37.6577925314
* device instance vss_t53 r0 *1 0,0
Rvss_t53 vss__t53 vss 26.6829596848
* device instance vss_t54 r0 *1 0,0
Rvss_t54 vss__t54 vss 16.3602962847
* device instance vss_t55 r0 *1 0,0
Rvss_t55 vss__t55 vss 41.1432788533
* device instance vss_t56 r0 *1 0,0
Rvss_t56 vss__t56 vss 23.3675814534
* device instance vss_t57 r0 *1 0,0
Rvss_t57 vss__t57 vss 47.9698269486
* device instance vss_t58 r0 *1 0,0
Rvss_t58 vss__t58 vss 50.6453681774
* device instance vss_t59 r0 *1 0,0
Rvss_t59 vss__t59 vss 22.773982711
* device instance vss_t60 r0 *1 0,0
Rvss_t60 vss__t60 vss 22.1806349509
* device instance vss_t61 r0 *1 0,0
Rvss_t61 vss__t61 vss 21.5875588683
* device instance vss_t62 r0 *1 0,0
Rvss_t62 vss__t62 vss 33.1387090816
* device instance vss_t63 r0 *1 0,0
Rvss_t63 vss__t63 vss 32.5427398987
* device instance vss_t64 r0 *1 0,0
Rvss_t64 vss__t64 vss 31.9468567061
* device instance vss_t65 r0 *1 0,0
Rvss_t65 vss__t65 vss 12.8157367347
* device instance vss_t66 r0 *1 0,0
Rvss_t66 vss__t66 vss 4.56337059148
* device instance vss_t67 r0 *1 0,0
Rvss_t67 vss__t67 vss 7.96737664094
* device instance vss_t68 r0 *1 0,0
Rvss_t68 vss__t68 vss 3.71203920726
* device instance vss_t69 r0 *1 0,0
Rvss_t69 vss__t69 vss 3.36607429808
* device instance vss_t70 r0 *1 0,0
Rvss_t70 vss__t70 vss 12.2490727869
* device instance vss_t71 r0 *1 0,0
Rvss_t71 vss__t71 vss 5.35671215911
* device instance vss_t72 r0 *1 0,0
Rvss_t72 vss__t72 vss 4.98135330356
* device instance vss_t73 r0 *1 0,0
Rvss_t73 vss__t73 vss 4.6528753558
* device instance vss_t74 r0 *1 0,0
Rvss_t74 vss__t74 vss 4.38183411148
* device instance vss_t75 r0 *1 0,0
Rvss_t75 vss__t75 vss 13.3851516514
* device instance vss_t76 r0 *1 0,0
Rvss_t76 vss__t76 vss 13.95698084
* device instance vss_t77 r0 *1 0,0
Rvss_t77 vss__t77 vss 13.6721359037
* device instance vss_t78 r0 *1 0,0
Rvss_t78 vss__t78 vss 13.0878673102
* device instance vss_t79 r0 *1 0,0
Rvss_t79 vss__t79 vss 12.5049227927
* device instance vss_t80 r0 *1 0,0
Rvss_t80 vss__t80 vss 11.9234965567
* device instance vss_t81 r0 *1 0,0
Rvss_t81 vss__t81 vss 4.11629283877
* device instance vss_t82 r0 *1 0,0
Rvss_t82 vss__t82 vss 6.90905318695
* device instance vss_t83 r0 *1 0,0
Rvss_t83 vss__t83 vss 8.48934649422
* device instance vss_t84 r0 *1 0,0
Rvss_t84 vss__t84 vss 28.0136433029
* device instance vss_t85 r0 *1 0,0
Rvss_t85 vss__t85 vss 27.4216949684
* device instance vss_t86 r0 *1 0,0
Rvss_t86 vss__t86 vss 18.1298833328
* device instance vss_t87 r0 *1 0,0
Rvss_t87 vss__t87 vss 17.5394514886
* device instance vss_t88 r0 *1 0,0
Rvss_t88 vss__t88 vss 16.9495693202
* device instance vss_t89 r0 *1 0,0
Rvss_t89 vss__t89 vss 8.57349147205
* device instance vss_t90 r0 *1 0,0
Rvss_t90 vss__t90 vss 8.01242721643
* device instance vss_t91 r0 *1 0,0
Rvss_t91 vss__t91 vss 7.45714935738
* device instance vss_t92 r0 *1 0,0
Rvss_t92 vss__t92 vss 26.8300270507
* device instance vss_t93 r0 *1 0,0
Rvss_t93 vss__t93 vss 26.2386585196
* device instance vss_t94 r0 *1 0,0
Rvss_t94 vss__t94 vss 33.257240619
* device instance vss_t95 r0 *1 0,0
Rvss_t95 vss__t95 vss 41.7401048606
* device instance vss_t96 r0 *1 0,0
Rvss_t96 vss__t96 vss 32.0697936913
* device instance vss_t97 r0 *1 0,0
Rvss_t97 vss__t97 vss 18.3456448145
* device instance vss_t98 r0 *1 0,0
Rvss_t98 vss__t98 vss 17.7623864534
* device instance vss_t99 r0 *1 0,0
Rvss_t99 vss__t99 vss 31.476328462
* device instance vss_t100 r0 *1 0,0
Rvss_t100 vss__t100 vss 17.1801604806
* device instance vss_t101 r0 *1 0,0
Rvss_t101 vss__t101 vss 16.5990755322
* device instance vss_t102 r0 *1 0,0
Rvss_t102 vss__t102 vss 23.5353750126
* device instance vss_t103 r0 *1 0,0
Rvss_t103 vss__t103 vss 22.9461173736
* device instance vss_t104 r0 *1 0,0
Rvss_t104 vss__t104 vss 22.3573384111
* device instance vss_t105 r0 *1 0,0
Rvss_t105 vss__t105 vss 21.7690769647
* device instance vss_t106 r0 *1 0,0
Rvss_t106 vss__t106 vss 31.3510644069
* device instance vss_t107 r0 *1 0,0
Rvss_t107 vss__t107 vss 42.9338774163
* device instance vss_t108 r0 *1 0,0
Rvss_t108 vss__t108 vss 42.3369716147
* device instance vss_t109 r0 *1 0,0
Rvss_t109 vss__t109 vss 32.6634342058
* device instance vss_t110 r0 *1 0,0
Rvss_t110 vss__t110 vss 43.0254325254
* device instance vss_t111 r0 *1 0,0
Rvss_t111 vss__t111 vss 42.4298147475
* device instance vss_t112 r0 *1 0,0
Rvss_t112 vss__t112 vss 41.8342726454
* device instance vss_t113 r0 *1 0,0
Rvss_t113 vss__t113 vss 41.2388094979
* device instance vss_t114 r0 *1 0,0
Rvss_t114 vss__t114 vss 33.257240619
* device instance vss_t115 r0 *1 0,0
Rvss_t115 vss__t115 vss 32.6634342058
* device instance vss_t116 r0 *1 0,0
Rvss_t116 vss__t116 vss 32.0697936913
* device instance vss_t117 r0 *1 0,0
Rvss_t117 vss__t117 vss 31.476328462
* device instance vss_t118 r0 *1 0,0
Rvss_t118 vss__t118 vss 23.5353750126
* device instance vss_t119 r0 *1 0,0
Rvss_t119 vss__t119 vss 22.9461173736
* device instance vss_t120 r0 *1 0,0
Rvss_t120 vss__t120 vss 22.3573384111
* device instance vss_t121 r0 *1 0,0
Rvss_t121 vss__t121 vss 21.7690769647
* device instance vss_t122 r0 *1 0,0
Rvss_t122 vss__t122 vss 13.95698084
* device instance vss_t123 r0 *1 0,0
Rvss_t123 vss__t123 vss 13.3851516514
* device instance vss_t124 r0 *1 0,0
Rvss_t124 vss__t124 vss 12.8157367347
* device instance vss_t125 r0 *1 0,0
Rvss_t125 vss__t125 vss 12.2490727869
* device instance vss_t126 r0 *1 0,0
Rvss_t126 vss__t126 vss 5.35671215911
* device instance vss_t127 r0 *1 0,0
Rvss_t127 vss__t127 vss 4.98135330356
* device instance vss_t128 r0 *1 0,0
Rvss_t128 vss__t128 vss 4.6528753558
* device instance vss_t129 r0 *1 0,0
Rvss_t129 vss__t129 vss 4.38183411148
* device instance vss_t130 r0 *1 0,0
Rvss_t130 vss__t130 vss 7.45687802907
* device instance vss_t131 r0 *1 0,0
Rvss_t131 vss__t131 vss 7.96737664094
* device instance vss_t132 r0 *1 0,0
Rvss_t132 vss__t132 vss 8.48934649422
* device instance vss_t133 r0 *1 0,0
Rvss_t133 vss__t133 vss 9.02079652922
* device instance vss_t134 r0 *1 0,0
Rvss_t134 vss__t134 vss 16.5990755322
* device instance vss_t135 r0 *1 0,0
Rvss_t135 vss__t135 vss 17.1801604806
* device instance vss_t136 r0 *1 0,0
Rvss_t136 vss__t136 vss 17.7623864534
* device instance vss_t137 r0 *1 0,0
Rvss_t137 vss__t137 vss 18.3456448145
* device instance vss_t138 r0 *1 0,0
Rvss_t138 vss__t138 vss 26.2386585196
* device instance vss_t139 r0 *1 0,0
Rvss_t139 vss__t139 vss 26.8300270507
* device instance vss_t140 r0 *1 0,0
Rvss_t140 vss__t140 vss 27.4216949684
* device instance vss_t141 r0 *1 0,0
Rvss_t141 vss__t141 vss 28.0136433029
* device instance vss_t142 r0 *1 0,0
Rvss_t142 vss__t142 vss 35.9780308951
* device instance vss_t143 r0 *1 0,0
Rvss_t143 vss__t143 vss 36.5726182101
* device instance vss_t144 r0 *1 0,0
Rvss_t144 vss__t144 vss 37.1673237018
* device instance vss_t145 r0 *1 0,0
Rvss_t145 vss__t145 vss 37.7621417869
* device instance vss_t146 r0 *1 0,0
Rvss_t146 vss__t146 vss 42.9338774163
* device instance vss_t147 r0 *1 0,0
Rvss_t147 vss__t147 vss 42.3369716147
* device instance vss_t148 r0 *1 0,0
Rvss_t148 vss__t148 vss 41.7401048606
* device instance vss_t149 r0 *1 0,0
Rvss_t149 vss__t149 vss 41.1432788533
* device instance vss_t150 r0 *1 0,0
Rvss_t150 vss__t150 vss 33.1387090816
* device instance vss_t151 r0 *1 0,0
Rvss_t151 vss__t151 vss 32.5427398987
* device instance vss_t152 r0 *1 0,0
Rvss_t152 vss__t152 vss 31.9468567061
* device instance vss_t153 r0 *1 0,0
Rvss_t153 vss__t153 vss 31.3510644069
* device instance vss_t154 r0 *1 0,0
Rvss_t154 vss__t154 vss 23.3675814534
* device instance vss_t155 r0 *1 0,0
Rvss_t155 vss__t155 vss 22.773982711
* device instance vss_t156 r0 *1 0,0
Rvss_t156 vss__t156 vss 22.1806349509
* device instance vss_t157 r0 *1 0,0
Rvss_t157 vss__t157 vss 21.5875588683
* device instance vss_t158 r0 *1 0,0
Rvss_t158 vss__t158 vss 13.6721359037
* device instance vss_t159 r0 *1 0,0
Rvss_t159 vss__t159 vss 13.0878673102
* device instance vss_t160 r0 *1 0,0
Rvss_t160 vss__t160 vss 12.5049227927
* device instance vss_t161 r0 *1 0,0
Rvss_t161 vss__t161 vss 11.9234965567
* device instance vss_t162 r0 *1 0,0
Rvss_t162 vss__t162 vss 4.56337059148
* device instance vss_t163 r0 *1 0,0
Rvss_t163 vss__t163 vss 4.11629283877
* device instance vss_t164 r0 *1 0,0
Rvss_t164 vss__t164 vss 3.71203920726
* device instance vss_t165 r0 *1 0,0
Rvss_t165 vss__t165 vss 3.36607429808
* device instance vss_t166 r0 *1 0,0
Rvss_t166 vss__t166 vss 6.90905318695
* device instance vss_t167 r0 *1 0,0
Rvss_t167 vss__t167 vss 7.45714935738
* device instance vss_t168 r0 *1 0,0
Rvss_t168 vss__t168 vss 8.01242721643
* device instance vss_t169 r0 *1 0,0
Rvss_t169 vss__t169 vss 8.57349147205
* device instance vss_t170 r0 *1 0,0
Rvss_t170 vss__t170 vss 16.3602962847
* device instance vss_t171 r0 *1 0,0
Rvss_t171 vss__t171 vss 16.9495693202
* device instance vss_t172 r0 *1 0,0
Rvss_t172 vss__t172 vss 17.5394514886
* device instance vss_t173 r0 *1 0,0
Rvss_t173 vss__t173 vss 18.1298833328
* device instance vss_t174 r0 *1 0,0
Rvss_t174 vss__t174 vss 26.0882576441
* device instance vss_t175 r0 *1 0,0
Rvss_t175 vss__t175 vss 26.6829596848
* device instance vss_t176 r0 *1 0,0
Rvss_t176 vss__t176 vss 27.2778177452
* device instance vss_t177 r0 *1 0,0
Rvss_t177 vss__t177 vss 27.872821836
* device instance vss_t178 r0 *1 0,0
Rvss_t178 vss__t178 vss 35.8684916478
* device instance vss_t179 r0 *1 0,0
Rvss_t179 vss__t179 vss 36.4648651271
* device instance vss_t180 r0 *1 0,0
Rvss_t180 vss__t180 vss 37.061299723
* device instance vss_t181 r0 *1 0,0
Rvss_t181 vss__t181 vss 37.6577925314
* device instance vss_t182 r0 *1 0,0
Rvss_t182 vss__t182 vss 47.9698269486
* device instance vss_t183 r0 *1 0,0
Rvss_t183 vss__t183 vss 50.6453681774
* device instance vss_t184 r0 *1 0,0
Rvss_t184 vss__t184 vss 40.5948652652
* device instance vss_t185 r0 *1 0,0
Rvss_t185 vss__t185 vss 40.0128862837
* device instance vss_t186 r0 *1 0,0
Rvss_t186 vss__t186 vss 39.4309692344
* device instance vss_t187 r0 *1 0,0
Rvss_t187 vss__t187 vss 38.8491169002
* device instance vss_t188 r0 *1 0,0
Rvss_t188 vss__t188 vss 30.8168462835
* device instance vss_t189 r0 *1 0,0
Rvss_t189 vss__t189 vss 30.2364287132
* device instance vss_t190 r0 *1 0,0
Rvss_t190 vss__t190 vss 29.6561546892
* device instance vss_t191 r0 *1 0,0
Rvss_t191 vss__t191 vss 29.0760328058
* device instance vss_t192 r0 *1 0,0
Rvss_t192 vss__t192 vss 21.0814268402
* device instance vss_t193 r0 *1 0,0
Rvss_t193 vss__t193 vss 20.5052624391
* device instance vss_t194 r0 *1 0,0
Rvss_t194 vss__t194 vss 19.9295584731
* device instance vss_t195 r0 *1 0,0
Rvss_t195 vss__t195 vss 19.3543560296
* device instance vss_t196 r0 *1 0,0
Rvss_t196 vss__t196 vss 11.4973350903
* device instance vss_t197 r0 *1 0,0
Rvss_t197 vss__t197 vss 10.9409125702
* device instance vss_t198 r0 *1 0,0
Rvss_t198 vss__t198 vss 10.3875264001
* device instance vss_t199 r0 *1 0,0
Rvss_t199 vss__t199 vss 9.83768899247
* device instance vss_t200 r0 *1 0,0
Rvss_t200 vss__t200 vss 3.60062279831
* device instance vss_t201 r0 *1 0,0
Rvss_t201 vss__t201 vss 3.45759480529
* device instance vss_t202 r0 *1 0,0
Rvss_t202 vss__t202 vss 3.40994461741
* device instance vss_t203 r0 *1 0,0
Rvss_t203 vss__t203 vss 3.46161319395
* device instance vss_t204 r0 *1 0,0
Rvss_t204 vss__t204 vss 9.31417568505
* device instance vss_t205 r0 *1 0,0
Rvss_t205 vss__t205 vss 9.86001874264
* device instance vss_t206 r0 *1 0,0
Rvss_t206 vss__t206 vss 10.4100121841
* device instance vss_t207 r0 *1 0,0
Rvss_t207 vss__t207 vss 10.9635314062
* device instance vss_t208 r0 *1 0,0
Rvss_t208 vss__t208 vss 18.8031078986
* device instance vss_t209 r0 *1 0,0
Rvss_t209 vss__t209 vss 19.3777860235
* device instance vss_t210 r0 *1 0,0
Rvss_t210 vss__t210 vss 19.9530097692
* device instance vss_t211 r0 *1 0,0
Rvss_t211 vss__t211 vss 20.5287332703
* device instance vss_t212 r0 *1 0,0
Rvss_t212 vss__t212 vss 28.5197033365
* device instance vss_t213 r0 *1 0,0
Rvss_t213 vss__t213 vss 29.0996705572
* device instance vss_t214 r0 *1 0,0
Rvss_t214 vss__t214 vss 29.6797988172
* device instance vss_t215 r0 *1 0,0
Rvss_t215 vss__t215 vss 30.2600788544
* device instance vss_t216 r0 *1 0,0
Rvss_t216 vss__t216 vss 38.2910394734
* device instance vss_t217 r0 *1 0,0
Rvss_t217 vss__t217 vss 38.8728269579
* device instance vss_t218 r0 *1 0,0
Rvss_t218 vss__t218 vss 39.4546819858
* device instance vss_t219 r0 *1 0,0
Rvss_t219 vss__t219 vss 40.0366016123
* device instance vss_t220 r0 *1 0,0
Rvss_t220 vss__t220 vss 40.6012735933
* device instance vss_t221 r0 *1 0,0
Rvss_t221 vss__t221 vss 40.0193878046
* device instance vss_t222 r0 *1 0,0
Rvss_t222 vss__t222 vss 39.437566688
* device instance vss_t223 r0 *1 0,0
Rvss_t223 vss__t223 vss 38.8558131485
* device instance vss_t224 r0 *1 0,0
Rvss_t224 vss__t224 vss 30.8252874498
* device instance vss_t225 r0 *1 0,0
Rvss_t225 vss__t225 vss 30.2450318702
* device instance vss_t226 r0 *1 0,0
Rvss_t226 vss__t226 vss 29.6649261326
* device instance vss_t227 r0 *1 0,0
Rvss_t227 vss__t227 vss 29.0849792028
* device instance vss_t228 r0 *1 0,0
Rvss_t228 vss__t228 vss 21.0937642237
* device instance vss_t229 r0 *1 0,0
Rvss_t229 vss__t229 vss 20.5179462716
* device instance vss_t230 r0 *1 0,0
Rvss_t230 vss__t230 vss 19.9426084662
* device instance vss_t231 r0 *1 0,0
Rvss_t231 vss__t231 vss 19.3677935972
* device instance vss_t232 r0 *1 0,0
Rvss_t232 vss__t232 vss 11.5199412187
* device instance vss_t233 r0 *1 0,0
Rvss_t233 vss__t233 vss 10.964665949
* device instance vss_t234 r0 *1 0,0
Rvss_t234 vss__t234 vss 10.4125422553
* device instance vss_t235 r0 *1 0,0
Rvss_t235 vss__t235 vss 9.86409936166
* device instance vss_t236 r0 *1 0,0
Rvss_t236 vss__t236 vss 3.67216775759
* device instance vss_t237 r0 *1 0,0
Rvss_t237 vss__t237 vss 3.53203812858
* device instance vss_t238 r0 *1 0,0
Rvss_t238 vss__t238 vss 3.48540582974
* device instance vss_t239 r0 *1 0,0
Rvss_t239 vss__t239 vss 3.53597191854
* device instance vss_t240 r0 *1 0,0
Rvss_t240 vss__t240 vss 9.34206616312
* device instance vss_t241 r0 *1 0,0
Rvss_t241 vss__t241 vss 9.88636946049
* device instance vss_t242 r0 *1 0,0
Rvss_t242 vss__t242 vss 10.434974134
* device instance vss_t243 r0 *1 0,0
Rvss_t243 vss__t243 vss 10.9872358853
* device instance vss_t244 r0 *1 0,0
Rvss_t244 vss__t244 vss 18.8169391281
* device instance vss_t245 r0 *1 0,0
Rvss_t245 vss__t245 vss 19.3912073548
* device instance vss_t246 r0 *1 0,0
Rvss_t246 vss__t246 vss 19.9660444344
* device instance vss_t247 r0 *1 0,0
Rvss_t247 vss__t247 vss 20.5414026101
* device instance vss_t248 r0 *1 0,0
Rvss_t248 vss__t248 vss 28.5288241942
* device instance vss_t249 r0 *1 0,0
Rvss_t249 vss__t249 vss 29.1086096892
* device instance vss_t250 r0 *1 0,0
Rvss_t250 vss__t250 vss 29.688563275
* device instance vss_t251 r0 *1 0,0
Rvss_t251 vss__t251 vss 30.2686752894
* device instance vss_t252 r0 *1 0,0
Rvss_t252 vss__t252 vss 38.2978332998
* device instance vss_t253 r0 *1 0,0
Rvss_t253 vss__t253 vss 38.8795191226
* device instance vss_t254 r0 *1 0,0
Rvss_t254 vss__t254 vss 39.4612754749
* device instance vss_t255 r0 *1 0,0
Rvss_t255 vss__t255 vss 40.0430992827
* device instance vss_t256 r0 *1 0,0
Rvss_t256 vss__t256 vss 48.674864774
* device instance vss_t257 r0 *1 0,0
Rvss_t257 vss__t257 vss 51.3450967388
* device instance vss r0 *1 0,0
Cvss vss vsubs 3.8814649e-13
* device instance cc__100__32 r0 *1 0,0
Ccc__100__32 \$100 \$32 1.0837e-17
* device instance cc__100__84 r0 *1 0,0
Ccc__100__84 \$100 \$84 1.0837e-17
* device instance cc__102__32 r0 *1 0,0
Ccc__102__32 \$102 \$32 1.0837e-17
* device instance cc__102__84 r0 *1 0,0
Ccc__102__84 \$102 \$84 1.0837e-17
* device instance cc__104__40 r0 *1 0,0
Ccc__104__40 \$104 \$40 1.0837e-17
* device instance cc__104__85 r0 *1 0,0
Ccc__104__85 \$104 \$85 1.0837e-17
* device instance cc__106__40 r0 *1 0,0
Ccc__106__40 \$106 \$40 1.0837e-17
* device instance cc__106__85 r0 *1 0,0
Ccc__106__85 \$106 \$85 1.0837e-17
* device instance cc__108__48 r0 *1 0,0
Ccc__108__48 \$108 \$48 1.0837e-17
* device instance cc__108__86 r0 *1 0,0
Ccc__108__86 \$108 \$86 1.0837e-17
* device instance cc__108_vcm r0 *1 0,0
Ccc__108_vcm \$108 vcm 2.1675e-17
* device instance cc__11__12 r0 *1 0,0
Ccc__11__12 \$11 \$12 1.0837e-17
* device instance cc__110__48 r0 *1 0,0
Ccc__110__48 \$110 \$48 1.0837e-17
* device instance cc__110__86 r0 *1 0,0
Ccc__110__86 \$110 \$86 1.0837e-17
* device instance cc__110_vcm r0 *1 0,0
Ccc__110_vcm \$110 vcm 2.1675e-17
* device instance cc__112__56 r0 *1 0,0
Ccc__112__56 \$112 \$56 1.0837e-17
* device instance cc__112__87 r0 *1 0,0
Ccc__112__87 \$112 \$87 1.0837e-17
* device instance cc__114__56 r0 *1 0,0
Ccc__114__56 \$114 \$56 1.0837e-17
* device instance cc__114__87 r0 *1 0,0
Ccc__114__87 \$114 \$87 1.0837e-17
* device instance cc__116__64 r0 *1 0,0
Ccc__116__64 \$116 \$64 1.0837e-17
* device instance cc__116__88 r0 *1 0,0
Ccc__116__88 \$116 \$88 1.0837e-17
* device instance cc__118__64 r0 *1 0,0
Ccc__118__64 \$118 \$64 1.0837e-17
* device instance cc__118__88 r0 *1 0,0
Ccc__118__88 \$118 \$88 1.0837e-17
* device instance cc__12__127 r0 *1 0,0
Ccc__12__127 \$12 \$127 1.0837e-17
* device instance cc__12__129 r0 *1 0,0
Ccc__12__129 \$12 \$129 1.0837e-17
* device instance cc__12__24 r0 *1 0,0
Ccc__12__24 \$12 \$24 1.614766e-15
* device instance cc__12__32 r0 *1 0,0
Ccc__12__32 \$12 \$32 8.88663e-16
* device instance cc__12__40 r0 *1 0,0
Ccc__12__40 \$12 \$40 5.52705e-16
* device instance cc__12__48 r0 *1 0,0
Ccc__12__48 \$12 \$48 3.79308e-16
* device instance cc__12__5 r0 *1 0,0
Ccc__12__5 \$12 \$5 1.0837e-17
* device instance cc__12__56 r0 *1 0,0
Ccc__12__56 \$12 \$56 2.92609e-16
* device instance cc__12__64 r0 *1 0,0
Ccc__12__64 \$12 \$64 2.49259e-16
* device instance cc__12__7 r0 *1 0,0
Ccc__12__7 \$12 \$7 1.0837e-17
* device instance cc__12__72 r0 *1 0,0
Ccc__12__72 \$12 \$72 2.0591e-16
* device instance cc__12__80 r0 *1 0,0
Ccc__12__80 \$12 \$80 9.7536e-17
* device instance cc__12__81 r0 *1 0,0
Ccc__12__81 \$12 \$81 1.0837e-17
* device instance cc__12__9 r0 *1 0,0
Ccc__12__9 \$12 \$9 1.0837e-17
* device instance cc__12__92 r0 *1 0,0
Ccc__12__92 \$12 \$92 1.0837e-17
* device instance cc__12__94 r0 *1 0,0
Ccc__12__94 \$12 \$94 1.0837e-17
* device instance cc__12_hi_256_n r0 *1 0,0
Ccc__12_hi_256_n \$12 hi_256_n 1.0837e-17
* device instance cc__12_hi_256_p r0 *1 0,0
Ccc__12_hi_256_p \$12 hi_256_p 1.0837e-17
* device instance cc__12_lo_256_n r0 *1 0,0
Ccc__12_lo_256_n \$12 lo_256_n 1.0837e-17
* device instance cc__12_lo_256_p r0 *1 0,0
Ccc__12_lo_256_p \$12 lo_256_p 1.0837e-17
* device instance cc__12_pinn r0 *1 0,0
Ccc__12_pinn \$12 vinn 1.0837e-17
* device instance cc__12_rel_256_n r0 *1 0,0
Ccc__12_rel_256_n \$12 rel_256_n 1.0837e-17
* device instance cc__12_rel_256_p r0 *1 0,0
Ccc__12_rel_256_p \$12 rel_256_p 1.0837e-17
* device instance cc__12_sel_in r0 *1 0,0
Ccc__12_sel_in \$12 sel_in 2.1675e-17
* device instance cc__12_topp r0 *1 0,0
Ccc__12_topp \$12 topp 4.2159087e-14
* device instance cc__12_vcm r0 *1 0,0
Ccc__12_vcm \$12 vcm 1.19211e-16
* device instance cc__12_vref r0 *1 0,0
Ccc__12_vref \$12 vref 1.0837e-17
* device instance cc__12_vss r0 *1 0,0
Ccc__12_vss \$12 vss 5.20075e-16
* device instance cc__120__72 r0 *1 0,0
Ccc__120__72 \$120 \$72 1.0837e-17
* device instance cc__120__89 r0 *1 0,0
Ccc__120__89 \$120 \$89 1.0837e-17
* device instance cc__122__72 r0 *1 0,0
Ccc__122__72 \$122 \$72 1.0837e-17
* device instance cc__122__89 r0 *1 0,0
Ccc__122__89 \$122 \$89 1.0837e-17
* device instance cc__124__80 r0 *1 0,0
Ccc__124__80 \$124 \$80 1.0837e-17
* device instance cc__124__90 r0 *1 0,0
Ccc__124__90 \$124 \$90 1.0837e-17
* device instance cc__126__80 r0 *1 0,0
Ccc__126__80 \$126 \$80 1.0837e-17
* device instance cc__126__90 r0 *1 0,0
Ccc__126__90 \$126 \$90 1.0837e-17
* device instance cc__127__81 r0 *1 0,0
Ccc__127__81 \$127 \$81 1.0837e-17
* device instance cc__129__81 r0 *1 0,0
Ccc__129__81 \$129 \$81 1.0837e-17
* device instance cc__130__24 r0 *1 0,0
Ccc__130__24 \$130 \$24 1.0837e-17
* device instance cc__130__83 r0 *1 0,0
Ccc__130__83 \$130 \$83 1.0837e-17
* device instance cc__132__24 r0 *1 0,0
Ccc__132__24 \$132 \$24 1.0837e-17
* device instance cc__132__83 r0 *1 0,0
Ccc__132__83 \$132 \$83 1.0837e-17
* device instance cc__133__32 r0 *1 0,0
Ccc__133__32 \$133 \$32 1.0837e-17
* device instance cc__133__84 r0 *1 0,0
Ccc__133__84 \$133 \$84 1.0837e-17
* device instance cc__135__32 r0 *1 0,0
Ccc__135__32 \$135 \$32 1.0837e-17
* device instance cc__135__84 r0 *1 0,0
Ccc__135__84 \$135 \$84 1.0837e-17
* device instance cc__136__40 r0 *1 0,0
Ccc__136__40 \$136 \$40 1.0837e-17
* device instance cc__136__85 r0 *1 0,0
Ccc__136__85 \$136 \$85 1.0837e-17
* device instance cc__138__40 r0 *1 0,0
Ccc__138__40 \$138 \$40 1.0837e-17
* device instance cc__138__85 r0 *1 0,0
Ccc__138__85 \$138 \$85 1.0837e-17
* device instance cc__139__48 r0 *1 0,0
Ccc__139__48 \$139 \$48 1.0837e-17
* device instance cc__139__86 r0 *1 0,0
Ccc__139__86 \$139 \$86 1.0837e-17
* device instance cc__139_vcm r0 *1 0,0
Ccc__139_vcm \$139 vcm 1.0837e-17
* device instance cc__141__48 r0 *1 0,0
Ccc__141__48 \$141 \$48 1.0837e-17
* device instance cc__141__86 r0 *1 0,0
Ccc__141__86 \$141 \$86 1.0837e-17
* device instance cc__141_vcm r0 *1 0,0
Ccc__141_vcm \$141 vcm 3.7724e-17
* device instance cc__142__56 r0 *1 0,0
Ccc__142__56 \$142 \$56 1.0837e-17
* device instance cc__142__87 r0 *1 0,0
Ccc__142__87 \$142 \$87 1.0837e-17
* device instance cc__144__56 r0 *1 0,0
Ccc__144__56 \$144 \$56 1.0837e-17
* device instance cc__144__87 r0 *1 0,0
Ccc__144__87 \$144 \$87 1.0837e-17
* device instance cc__145__64 r0 *1 0,0
Ccc__145__64 \$145 \$64 1.0837e-17
* device instance cc__145__88 r0 *1 0,0
Ccc__145__88 \$145 \$88 1.0837e-17
* device instance cc__147__64 r0 *1 0,0
Ccc__147__64 \$147 \$64 1.0837e-17
* device instance cc__147__88 r0 *1 0,0
Ccc__147__88 \$147 \$88 1.0837e-17
* device instance cc__148__72 r0 *1 0,0
Ccc__148__72 \$148 \$72 1.0837e-17
* device instance cc__148__89 r0 *1 0,0
Ccc__148__89 \$148 \$89 1.0837e-17
* device instance cc__150__72 r0 *1 0,0
Ccc__150__72 \$150 \$72 1.0837e-17
* device instance cc__150__89 r0 *1 0,0
Ccc__150__89 \$150 \$89 1.0837e-17
* device instance cc__151__80 r0 *1 0,0
Ccc__151__80 \$151 \$80 1.0837e-17
* device instance cc__151__90 r0 *1 0,0
Ccc__151__90 \$151 \$90 1.0837e-17
* device instance cc__153__80 r0 *1 0,0
Ccc__153__80 \$153 \$80 1.0837e-17
* device instance cc__153__90 r0 *1 0,0
Ccc__153__90 \$153 \$90 1.0837e-17
* device instance cc__17__24 r0 *1 0,0
Ccc__17__24 \$17 \$24 1.0837e-17
* device instance cc__19__24 r0 *1 0,0
Ccc__19__24 \$19 \$24 1.0837e-17
* device instance cc__21__24 r0 *1 0,0
Ccc__21__24 \$21 \$24 1.0837e-17
* device instance cc__23__24 r0 *1 0,0
Ccc__23__24 \$23 \$24 1.0837e-17
* device instance cc__24__32 r0 *1 0,0
Ccc__24__32 \$24 \$32 1.53635e-16
* device instance cc__24__40 r0 *1 0,0
Ccc__24__40 \$24 \$40 1.53635e-16
* device instance cc__24__48 r0 *1 0,0
Ccc__24__48 \$24 \$48 1.19211e-16
* device instance cc__24__56 r0 *1 0,0
Ccc__24__56 \$24 \$56 1.19211e-16
* device instance cc__24__64 r0 *1 0,0
Ccc__24__64 \$24 \$64 1.19211e-16
* device instance cc__24__72 r0 *1 0,0
Ccc__24__72 \$24 \$72 9.7536e-17
* device instance cc__24__80 r0 *1 0,0
Ccc__24__80 \$24 \$80 5.4187e-17
* device instance cc__24__81 r0 *1 0,0
Ccc__24__81 \$24 \$81 1.7212e-17
* device instance cc__24__83 r0 *1 0,0
Ccc__24__83 \$24 \$83 1.0837e-17
* device instance cc__24__96 r0 *1 0,0
Ccc__24__96 \$24 \$96 1.0837e-17
* device instance cc__24__98 r0 *1 0,0
Ccc__24__98 \$24 \$98 1.0837e-17
* device instance cc__24_hi_128_n r0 *1 0,0
Ccc__24_hi_128_n \$24 hi_128_n 1.0837e-17
* device instance cc__24_hi_128_p r0 *1 0,0
Ccc__24_hi_128_p \$24 hi_128_p 1.0837e-17
* device instance cc__24_lo_128_n r0 *1 0,0
Ccc__24_lo_128_n \$24 lo_128_n 1.0837e-17
* device instance cc__24_lo_128_p r0 *1 0,0
Ccc__24_lo_128_p \$24 lo_128_p 1.0837e-17
* device instance cc__24_pinn r0 *1 0,0
Ccc__24_pinn \$24 vinn 1.0837e-17
* device instance cc__24_rel_128_n r0 *1 0,0
Ccc__24_rel_128_n \$24 rel_128_n 1.0837e-17
* device instance cc__24_rel_128_p r0 *1 0,0
Ccc__24_rel_128_p \$24 rel_128_p 1.0837e-17
* device instance cc__24_sel_in r0 *1 0,0
Ccc__24_sel_in \$24 sel_in 2.1675e-17
* device instance cc__24_topp r0 *1 0,0
Ccc__24_topp \$24 topp 2.1079544e-14
* device instance cc__24_vcm r0 *1 0,0
Ccc__24_vcm \$24 vcm 6.5024e-17
* device instance cc__24_vdd r0 *1 0,0
Ccc__24_vdd \$24 vdd 1.0837e-17
* device instance cc__24_vref r0 *1 0,0
Ccc__24_vref \$24 vref 1.0837e-17
* device instance cc__24_vss r0 *1 0,0
Ccc__24_vss \$24 vss 5.20075e-16
* device instance cc__25__32 r0 *1 0,0
Ccc__25__32 \$25 \$32 1.0837e-17
* device instance cc__27__32 r0 *1 0,0
Ccc__27__32 \$27 \$32 1.0837e-17
* device instance cc__29__32 r0 *1 0,0
Ccc__29__32 \$29 \$32 1.0837e-17
* device instance cc__31__32 r0 *1 0,0
Ccc__31__32 \$31 \$32 1.0837e-17
* device instance cc__32__40 r0 *1 0,0
Ccc__32__40 \$32 \$40 1.10286e-16
* device instance cc__32__48 r0 *1 0,0
Ccc__32__48 \$32 \$48 1.10286e-16
* device instance cc__32__56 r0 *1 0,0
Ccc__32__56 \$32 \$56 1.10286e-16
* device instance cc__32__64 r0 *1 0,0
Ccc__32__64 \$32 \$64 7.5862e-17
* device instance cc__32__72 r0 *1 0,0
Ccc__32__72 \$32 \$72 5.4187e-17
* device instance cc__32__80 r0 *1 0,0
Ccc__32__80 \$32 \$80 3.2512e-17
* device instance cc__32__81 r0 *1 0,0
Ccc__32__81 \$32 \$81 1.7212e-17
* device instance cc__32__83 r0 *1 0,0
Ccc__32__83 \$32 \$83 1.7212e-17
* device instance cc__32__84 r0 *1 0,0
Ccc__32__84 \$32 \$84 1.0837e-17
* device instance cc__32_hi_64_n r0 *1 0,0
Ccc__32_hi_64_n \$32 hi_64_n 1.0837e-17
* device instance cc__32_hi_64_p r0 *1 0,0
Ccc__32_hi_64_p \$32 hi_64_p 1.0837e-17
* device instance cc__32_lo_64_n r0 *1 0,0
Ccc__32_lo_64_n \$32 lo_64_n 1.0837e-17
* device instance cc__32_lo_64_p r0 *1 0,0
Ccc__32_lo_64_p \$32 lo_64_p 1.0837e-17
* device instance cc__32_pinn r0 *1 0,0
Ccc__32_pinn \$32 vinn 1.0837e-17
* device instance cc__32_rel_64_n r0 *1 0,0
Ccc__32_rel_64_n \$32 rel_64_n 1.0837e-17
* device instance cc__32_rel_64_p r0 *1 0,0
Ccc__32_rel_64_p \$32 rel_64_p 1.0837e-17
* device instance cc__32_sel_in r0 *1 0,0
Ccc__32_sel_in \$32 sel_in 2.1675e-17
* device instance cc__32_topp r0 *1 0,0
Ccc__32_topp \$32 topp 1.0556984e-14
* device instance cc__32_vcm r0 *1 0,0
Ccc__32_vcm \$32 vcm 4.3349e-17
* device instance cc__32_vdd r0 *1 0,0
Ccc__32_vdd \$32 vdd 1.0837e-17
* device instance cc__32_vref r0 *1 0,0
Ccc__32_vref \$32 vref 1.0837e-17
* device instance cc__32_vss r0 *1 0,0
Ccc__32_vss \$32 vss 5.20075e-16
* device instance cc__33__40 r0 *1 0,0
Ccc__33__40 \$33 \$40 1.0837e-17
* device instance cc__35__40 r0 *1 0,0
Ccc__35__40 \$35 \$40 1.0837e-17
* device instance cc__37__40 r0 *1 0,0
Ccc__37__40 \$37 \$40 1.0837e-17
* device instance cc__39__40 r0 *1 0,0
Ccc__39__40 \$39 \$40 1.0837e-17
* device instance cc__40__48 r0 *1 0,0
Ccc__40__48 \$40 \$48 2.83684e-16
* device instance cc__40__56 r0 *1 0,0
Ccc__40__56 \$40 \$56 1.96985e-16
* device instance cc__40__64 r0 *1 0,0
Ccc__40__64 \$40 \$64 1.53635e-16
* device instance cc__40__72 r0 *1 0,0
Ccc__40__72 \$40 \$72 1.10286e-16
* device instance cc__40__80 r0 *1 0,0
Ccc__40__80 \$40 \$80 6.6937e-17
* device instance cc__40__81 r0 *1 0,0
Ccc__40__81 \$40 \$81 1.7212e-17
* device instance cc__40__83 r0 *1 0,0
Ccc__40__83 \$40 \$83 1.7212e-17
* device instance cc__40__84 r0 *1 0,0
Ccc__40__84 \$40 \$84 1.7212e-17
* device instance cc__40__85 r0 *1 0,0
Ccc__40__85 \$40 \$85 1.0837e-17
* device instance cc__40_hi_32_n r0 *1 0,0
Ccc__40_hi_32_n \$40 hi_32_n 1.0837e-17
* device instance cc__40_hi_32_p r0 *1 0,0
Ccc__40_hi_32_p \$40 hi_32_p 1.0837e-17
* device instance cc__40_lo_32_n r0 *1 0,0
Ccc__40_lo_32_n \$40 lo_32_n 1.0837e-17
* device instance cc__40_lo_32_p r0 *1 0,0
Ccc__40_lo_32_p \$40 lo_32_p 1.0837e-17
* device instance cc__40_pinn r0 *1 0,0
Ccc__40_pinn \$40 vinn 1.0837e-17
* device instance cc__40_rel_32_n r0 *1 0,0
Ccc__40_rel_32_n \$40 rel_32_n 1.0837e-17
* device instance cc__40_rel_32_p r0 *1 0,0
Ccc__40_rel_32_p \$40 rel_32_p 1.0837e-17
* device instance cc__40_sel_in r0 *1 0,0
Ccc__40_sel_in \$40 sel_in 2.1675e-17
* device instance cc__40_topp r0 *1 0,0
Ccc__40_topp \$40 topp 5.180063e-15
* device instance cc__40_vcm r0 *1 0,0
Ccc__40_vcm \$40 vcm 5.4187e-17
* device instance cc__40_vdd r0 *1 0,0
Ccc__40_vdd \$40 vdd 1.0837e-17
* device instance cc__40_vref r0 *1 0,0
Ccc__40_vref \$40 vref 1.0837e-17
* device instance cc__40_vss r0 *1 0,0
Ccc__40_vss \$40 vss 5.20075e-16
* device instance cc__41__48 r0 *1 0,0
Ccc__41__48 \$41 \$48 1.0837e-17
* device instance cc__41_vcm r0 *1 0,0
Ccc__41_vcm \$41 vcm 1.0837e-17
* device instance cc__43__48 r0 *1 0,0
Ccc__43__48 \$43 \$48 1.0837e-17
* device instance cc__43_vcm r0 *1 0,0
Ccc__43_vcm \$43 vcm 3.7724e-17
* device instance cc__45__48 r0 *1 0,0
Ccc__45__48 \$45 \$48 1.0837e-17
* device instance cc__45_vcm r0 *1 0,0
Ccc__45_vcm \$45 vcm 1.0837e-17
* device instance cc__47__48 r0 *1 0,0
Ccc__47__48 \$47 \$48 1.0837e-17
* device instance cc__47_vcm r0 *1 0,0
Ccc__47_vcm \$47 vcm 1.0837e-17
* device instance cc__48__56 r0 *1 0,0
Ccc__48__56 \$48 \$56 1.96985e-16
* device instance cc__48__64 r0 *1 0,0
Ccc__48__64 \$48 \$64 1.53635e-16
* device instance cc__48__72 r0 *1 0,0
Ccc__48__72 \$48 \$72 1.10286e-16
* device instance cc__48__80 r0 *1 0,0
Ccc__48__80 \$48 \$80 6.6937e-17
* device instance cc__48__81 r0 *1 0,0
Ccc__48__81 \$48 \$81 1.7212e-17
* device instance cc__48__83 r0 *1 0,0
Ccc__48__83 \$48 \$83 1.7212e-17
* device instance cc__48__84 r0 *1 0,0
Ccc__48__84 \$48 \$84 1.7212e-17
* device instance cc__48__85 r0 *1 0,0
Ccc__48__85 \$48 \$85 1.7212e-17
* device instance cc__48__86 r0 *1 0,0
Ccc__48__86 \$48 \$86 1.0837e-17
* device instance cc__48_hi_16_n r0 *1 0,0
Ccc__48_hi_16_n \$48 hi_16_n 1.0837e-17
* device instance cc__48_hi_16_p r0 *1 0,0
Ccc__48_hi_16_p \$48 hi_16_p 1.0837e-17
* device instance cc__48_lo_16_n r0 *1 0,0
Ccc__48_lo_16_n \$48 lo_16_n 1.0837e-17
* device instance cc__48_lo_16_p r0 *1 0,0
Ccc__48_lo_16_p \$48 lo_16_p 1.0837e-17
* device instance cc__48_pinn r0 *1 0,0
Ccc__48_pinn \$48 vinn 1.0837e-17
* device instance cc__48_rel_16_n r0 *1 0,0
Ccc__48_rel_16_n \$48 rel_16_n 1.0837e-17
* device instance cc__48_rel_16_p r0 *1 0,0
Ccc__48_rel_16_p \$48 rel_16_p 1.0837e-17
* device instance cc__48_sel_in r0 *1 0,0
Ccc__48_sel_in \$48 sel_in 2.1675e-17
* device instance cc__48_topp r0 *1 0,0
Ccc__48_topp \$48 topp 2.77493e-15
* device instance cc__48_vcm r0 *1 0,0
Ccc__48_vcm \$48 vcm 9.9449e-17
* device instance cc__48_vdd r0 *1 0,0
Ccc__48_vdd \$48 vdd 1.0837e-17
* device instance cc__48_vref r0 *1 0,0
Ccc__48_vref \$48 vref 1.0837e-17
* device instance cc__48_vss r0 *1 0,0
Ccc__48_vss \$48 vss 5.20075e-16
* device instance cc__49__56 r0 *1 0,0
Ccc__49__56 \$49 \$56 1.0837e-17
* device instance cc__51__56 r0 *1 0,0
Ccc__51__56 \$51 \$56 1.0837e-17
* device instance cc__53__56 r0 *1 0,0
Ccc__53__56 \$53 \$56 1.0837e-17
* device instance cc__55__56 r0 *1 0,0
Ccc__55__56 \$55 \$56 1.0837e-17
* device instance cc__56__64 r0 *1 0,0
Ccc__56__64 \$56 \$64 1.53635e-16
* device instance cc__56__72 r0 *1 0,0
Ccc__56__72 \$56 \$72 1.10286e-16
* device instance cc__56__80 r0 *1 0,0
Ccc__56__80 \$56 \$80 6.6937e-17
* device instance cc__56__81 r0 *1 0,0
Ccc__56__81 \$56 \$81 1.7212e-17
* device instance cc__56__83 r0 *1 0,0
Ccc__56__83 \$56 \$83 1.7212e-17
* device instance cc__56__84 r0 *1 0,0
Ccc__56__84 \$56 \$84 1.7212e-17
* device instance cc__56__85 r0 *1 0,0
Ccc__56__85 \$56 \$85 1.7212e-17
* device instance cc__56__86 r0 *1 0,0
Ccc__56__86 \$56 \$86 1.7212e-17
* device instance cc__56__87 r0 *1 0,0
Ccc__56__87 \$56 \$87 1.0837e-17
* device instance cc__56_hi_8_n r0 *1 0,0
Ccc__56_hi_8_n \$56 hi_8_n 1.0837e-17
* device instance cc__56_hi_8_p r0 *1 0,0
Ccc__56_hi_8_p \$56 hi_8_p 1.0837e-17
* device instance cc__56_lo_8_n r0 *1 0,0
Ccc__56_lo_8_n \$56 lo_8_n 1.0837e-17
* device instance cc__56_lo_8_p r0 *1 0,0
Ccc__56_lo_8_p \$56 lo_8_p 1.0837e-17
* device instance cc__56_pinn r0 *1 0,0
Ccc__56_pinn \$56 vinn 1.0837e-17
* device instance cc__56_rel_8_n r0 *1 0,0
Ccc__56_rel_8_n \$56 rel_8_n 1.0837e-17
* device instance cc__56_rel_8_p r0 *1 0,0
Ccc__56_rel_8_p \$56 rel_8_p 1.0837e-17
* device instance cc__56_sel_in r0 *1 0,0
Ccc__56_sel_in \$56 sel_in 2.1675e-17
* device instance cc__56_topp r0 *1 0,0
Ccc__56_topp \$56 topp 1.326814e-15
* device instance cc__56_vcm r0 *1 0,0
Ccc__56_vcm \$56 vcm 8.8611e-17
* device instance cc__56_vdd r0 *1 0,0
Ccc__56_vdd \$56 vdd 1.0837e-17
* device instance cc__56_vref r0 *1 0,0
Ccc__56_vref \$56 vref 1.0837e-17
* device instance cc__56_vss r0 *1 0,0
Ccc__56_vss \$56 vss 5.20075e-16
* device instance cc__57__64 r0 *1 0,0
Ccc__57__64 \$57 \$64 1.0837e-17
* device instance cc__59__64 r0 *1 0,0
Ccc__59__64 \$59 \$64 1.0837e-17
* device instance cc__61__64 r0 *1 0,0
Ccc__61__64 \$61 \$64 1.0837e-17
* device instance cc__63__64 r0 *1 0,0
Ccc__63__64 \$63 \$64 1.0837e-17
* device instance cc__64__72 r0 *1 0,0
Ccc__64__72 \$64 \$72 1.10286e-16
* device instance cc__64__80 r0 *1 0,0
Ccc__64__80 \$64 \$80 6.6937e-17
* device instance cc__64__81 r0 *1 0,0
Ccc__64__81 \$64 \$81 1.7212e-17
* device instance cc__64__83 r0 *1 0,0
Ccc__64__83 \$64 \$83 1.7212e-17
* device instance cc__64__84 r0 *1 0,0
Ccc__64__84 \$64 \$84 1.7212e-17
* device instance cc__64__85 r0 *1 0,0
Ccc__64__85 \$64 \$85 1.7212e-17
* device instance cc__64__86 r0 *1 0,0
Ccc__64__86 \$64 \$86 1.7212e-17
* device instance cc__64__87 r0 *1 0,0
Ccc__64__87 \$64 \$87 1.7212e-17
* device instance cc__64__88 r0 *1 0,0
Ccc__64__88 \$64 \$88 1.0837e-17
* device instance cc__64_hi_4_n r0 *1 0,0
Ccc__64_hi_4_n \$64 hi_4_n 1.0837e-17
* device instance cc__64_hi_4_p r0 *1 0,0
Ccc__64_hi_4_p \$64 hi_4_p 1.0837e-17
* device instance cc__64_lo_4_n r0 *1 0,0
Ccc__64_lo_4_n \$64 lo_4_n 1.0837e-17
* device instance cc__64_lo_4_p r0 *1 0,0
Ccc__64_lo_4_p \$64 lo_4_p 1.0837e-17
* device instance cc__64_pinn r0 *1 0,0
Ccc__64_pinn \$64 vinn 1.0837e-17
* device instance cc__64_rel_4_n r0 *1 0,0
Ccc__64_rel_4_n \$64 rel_4_n 1.0837e-17
* device instance cc__64_rel_4_p r0 *1 0,0
Ccc__64_rel_4_p \$64 rel_4_p 1.0837e-17
* device instance cc__64_sel_in r0 *1 0,0
Ccc__64_sel_in \$64 sel_in 2.1675e-17
* device instance cc__64_topp r0 *1 0,0
Ccc__64_topp \$64 topp 6.72013e-16
* device instance cc__64_vcm r0 *1 0,0
Ccc__64_vcm \$64 vcm 8.8611e-17
* device instance cc__64_vdd r0 *1 0,0
Ccc__64_vdd \$64 vdd 2.3587e-17
* device instance cc__64_vref r0 *1 0,0
Ccc__64_vref \$64 vref 1.0837e-17
* device instance cc__64_vss r0 *1 0,0
Ccc__64_vss \$64 vss 5.20075e-16
* device instance cc__65__72 r0 *1 0,0
Ccc__65__72 \$65 \$72 1.0837e-17
* device instance cc__67__72 r0 *1 0,0
Ccc__67__72 \$67 \$72 1.0837e-17
* device instance cc__69__72 r0 *1 0,0
Ccc__69__72 \$69 \$72 1.0837e-17
* device instance cc__71__72 r0 *1 0,0
Ccc__71__72 \$71 \$72 1.0837e-17
* device instance cc__72__80 r0 *1 0,0
Ccc__72__80 \$72 \$80 5.6099e-17
* device instance cc__72__81 r0 *1 0,0
Ccc__72__81 \$72 \$81 1.7212e-17
* device instance cc__72__83 r0 *1 0,0
Ccc__72__83 \$72 \$83 1.7212e-17
* device instance cc__72__84 r0 *1 0,0
Ccc__72__84 \$72 \$84 1.7212e-17
* device instance cc__72__85 r0 *1 0,0
Ccc__72__85 \$72 \$85 1.7212e-17
* device instance cc__72__86 r0 *1 0,0
Ccc__72__86 \$72 \$86 1.7212e-17
* device instance cc__72__87 r0 *1 0,0
Ccc__72__87 \$72 \$87 1.7212e-17
* device instance cc__72__88 r0 *1 0,0
Ccc__72__88 \$72 \$88 1.7212e-17
* device instance cc__72__89 r0 *1 0,0
Ccc__72__89 \$72 \$89 1.0837e-17
* device instance cc__72_hi_2_n r0 *1 0,0
Ccc__72_hi_2_n \$72 hi_2_n 1.0837e-17
* device instance cc__72_hi_2_p r0 *1 0,0
Ccc__72_hi_2_p \$72 hi_2_p 1.0837e-17
* device instance cc__72_lo_2_n r0 *1 0,0
Ccc__72_lo_2_n \$72 lo_2_n 1.0837e-17
* device instance cc__72_lo_2_p r0 *1 0,0
Ccc__72_lo_2_p \$72 lo_2_p 1.0837e-17
* device instance cc__72_pinn r0 *1 0,0
Ccc__72_pinn \$72 vinn 1.0837e-17
* device instance cc__72_rel_2_n r0 *1 0,0
Ccc__72_rel_2_n \$72 rel_2_n 1.0837e-17
* device instance cc__72_rel_2_p r0 *1 0,0
Ccc__72_rel_2_p \$72 rel_2_p 1.0837e-17
* device instance cc__72_sel_in r0 *1 0,0
Ccc__72_sel_in \$72 sel_in 2.1675e-17
* device instance cc__72_topn r0 *1 0,0
Ccc__72_topn \$72 topn 1.7212e-17
* device instance cc__72_topp r0 *1 0,0
Ccc__72_topp \$72 topp 3.44613e-16
* device instance cc__72_vcm r0 *1 0,0
Ccc__72_vcm \$72 vcm 6.6937e-17
* device instance cc__72_vdd r0 *1 0,0
Ccc__72_vdd \$72 vdd 1.0837e-17
* device instance cc__72_vref r0 *1 0,0
Ccc__72_vref \$72 vref 1.0837e-17
* device instance cc__72_vss r0 *1 0,0
Ccc__72_vss \$72 vss 5.20075e-16
* device instance cc__73__80 r0 *1 0,0
Ccc__73__80 \$73 \$80 1.0837e-17
* device instance cc__75__80 r0 *1 0,0
Ccc__75__80 \$75 \$80 1.0837e-17
* device instance cc__77__80 r0 *1 0,0
Ccc__77__80 \$77 \$80 1.0837e-17
* device instance cc__79__80 r0 *1 0,0
Ccc__79__80 \$79 \$80 1.0837e-17
* device instance cc__80__81 r0 *1 0,0
Ccc__80__81 \$80 \$81 1.7212e-17
* device instance cc__80__83 r0 *1 0,0
Ccc__80__83 \$80 \$83 1.7212e-17
* device instance cc__80__84 r0 *1 0,0
Ccc__80__84 \$80 \$84 1.7212e-17
* device instance cc__80__85 r0 *1 0,0
Ccc__80__85 \$80 \$85 1.7212e-17
* device instance cc__80__86 r0 *1 0,0
Ccc__80__86 \$80 \$86 1.7212e-17
* device instance cc__80__87 r0 *1 0,0
Ccc__80__87 \$80 \$87 1.7212e-17
* device instance cc__80__88 r0 *1 0,0
Ccc__80__88 \$80 \$88 1.7212e-17
* device instance cc__80__89 r0 *1 0,0
Ccc__80__89 \$80 \$89 1.7212e-17
* device instance cc__80__90 r0 *1 0,0
Ccc__80__90 \$80 \$90 4.5262e-17
* device instance cc__80_hi_1_n r0 *1 0,0
Ccc__80_hi_1_n \$80 hi_1_n 1.0837e-17
* device instance cc__80_hi_1_p r0 *1 0,0
Ccc__80_hi_1_p \$80 hi_1_p 1.0837e-17
* device instance cc__80_lo_1_n r0 *1 0,0
Ccc__80_lo_1_n \$80 lo_1_n 1.0837e-17
* device instance cc__80_lo_1_p r0 *1 0,0
Ccc__80_lo_1_p \$80 lo_1_p 1.0837e-17
* device instance cc__80_pinn r0 *1 0,0
Ccc__80_pinn \$80 vinn 1.0837e-17
* device instance cc__80_rel_1_n r0 *1 0,0
Ccc__80_rel_1_n \$80 rel_1_n 1.0837e-17
* device instance cc__80_rel_1_p r0 *1 0,0
Ccc__80_rel_1_p \$80 rel_1_p 1.0837e-17
* device instance cc__80_sel_in r0 *1 0,0
Ccc__80_sel_in \$80 sel_in 2.1675e-17
* device instance cc__80_topn r0 *1 0,0
Ccc__80_topn \$80 topn 1.7212e-17
* device instance cc__80_topp r0 *1 0,0
Ccc__80_topp \$80 topp 1.80912e-16
* device instance cc__80_vcm r0 *1 0,0
Ccc__80_vcm \$80 vcm 5.6099e-17
* device instance cc__80_vdd r0 *1 0,0
Ccc__80_vdd \$80 vdd 1.0837e-17
* device instance cc__80_vref r0 *1 0,0
Ccc__80_vref \$80 vref 1.0837e-17
* device instance cc__80_vss r0 *1 0,0
Ccc__80_vss \$80 vss 5.20075e-16
* device instance cc__81__83 r0 *1 0,0
Ccc__81__83 \$81 \$83 1.614766e-15
* device instance cc__81__84 r0 *1 0,0
Ccc__81__84 \$81 \$84 8.88663e-16
* device instance cc__81__85 r0 *1 0,0
Ccc__81__85 \$81 \$85 5.52705e-16
* device instance cc__81__86 r0 *1 0,0
Ccc__81__86 \$81 \$86 3.79308e-16
* device instance cc__81__87 r0 *1 0,0
Ccc__81__87 \$81 \$87 2.92609e-16
* device instance cc__81__88 r0 *1 0,0
Ccc__81__88 \$81 \$88 2.49259e-16
* device instance cc__81__89 r0 *1 0,0
Ccc__81__89 \$81 \$89 2.0591e-16
* device instance cc__81__90 r0 *1 0,0
Ccc__81__90 \$81 \$90 9.7536e-17
* device instance cc__81__92 r0 *1 0,0
Ccc__81__92 \$81 \$92 1.0837e-17
* device instance cc__81__94 r0 *1 0,0
Ccc__81__94 \$81 \$94 1.0837e-17
* device instance cc__81_lo_256_n r0 *1 0,0
Ccc__81_lo_256_n \$81 lo_256_n 6.924e-18
* device instance cc__81_sel_in r0 *1 0,0
Ccc__81_sel_in \$81 sel_in 1.0837e-17
* device instance cc__81_topn r0 *1 0,0
Ccc__81_topn \$81 topn 4.2159087e-14
* device instance cc__81_topp r0 *1 0,0
Ccc__81_topp \$81 topp 1.7212e-17
* device instance cc__81_vcm r0 *1 0,0
Ccc__81_vcm \$81 vcm 1.25586e-16
* device instance cc__81_vdd r0 *1 0,0
Ccc__81_vdd \$81 vdd 1.275e-17
* device instance cc__81_vss r0 *1 0,0
Ccc__81_vss \$81 vss 1.0837e-17
* device instance cc__83__84 r0 *1 0,0
Ccc__83__84 \$83 \$84 1.19211e-16
* device instance cc__83__85 r0 *1 0,0
Ccc__83__85 \$83 \$85 1.19211e-16
* device instance cc__83__86 r0 *1 0,0
Ccc__83__86 \$83 \$86 1.19211e-16
* device instance cc__83__87 r0 *1 0,0
Ccc__83__87 \$83 \$87 1.19211e-16
* device instance cc__83__88 r0 *1 0,0
Ccc__83__88 \$83 \$88 1.19211e-16
* device instance cc__83__89 r0 *1 0,0
Ccc__83__89 \$83 \$89 9.7536e-17
* device instance cc__83__90 r0 *1 0,0
Ccc__83__90 \$83 \$90 5.4187e-17
* device instance cc__83__96 r0 *1 0,0
Ccc__83__96 \$83 \$96 1.0837e-17
* device instance cc__83__98 r0 *1 0,0
Ccc__83__98 \$83 \$98 1.0837e-17
* device instance cc__83_lo_128_n r0 *1 0,0
Ccc__83_lo_128_n \$83 lo_128_n 6.924e-18
* device instance cc__83_sel_in r0 *1 0,0
Ccc__83_sel_in \$83 sel_in 1.0837e-17
* device instance cc__83_topn r0 *1 0,0
Ccc__83_topn \$83 topn 2.1079544e-14
* device instance cc__83_topp r0 *1 0,0
Ccc__83_topp \$83 topp 1.7212e-17
* device instance cc__83_vcm r0 *1 0,0
Ccc__83_vcm \$83 vcm 7.1399e-17
* device instance cc__83_vss r0 *1 0,0
Ccc__83_vss \$83 vss 1.0837e-17
* device instance cc__84__85 r0 *1 0,0
Ccc__84__85 \$84 \$85 7.5862e-17
* device instance cc__84__86 r0 *1 0,0
Ccc__84__86 \$84 \$86 7.5862e-17
* device instance cc__84__87 r0 *1 0,0
Ccc__84__87 \$84 \$87 7.5862e-17
* device instance cc__84__88 r0 *1 0,0
Ccc__84__88 \$84 \$88 7.5862e-17
* device instance cc__84__89 r0 *1 0,0
Ccc__84__89 \$84 \$89 5.4187e-17
* device instance cc__84__90 r0 *1 0,0
Ccc__84__90 \$84 \$90 3.2512e-17
* device instance cc__84_lo_64_n r0 *1 0,0
Ccc__84_lo_64_n \$84 lo_64_n 6.924e-18
* device instance cc__84_sel_in r0 *1 0,0
Ccc__84_sel_in \$84 sel_in 1.0837e-17
* device instance cc__84_topn r0 *1 0,0
Ccc__84_topn \$84 topn 1.0539772e-14
* device instance cc__84_topp r0 *1 0,0
Ccc__84_topp \$84 topp 1.7212e-17
* device instance cc__84_vcm r0 *1 0,0
Ccc__84_vcm \$84 vcm 4.9724e-17
* device instance cc__84_vdd r0 *1 0,0
Ccc__84_vdd \$84 vdd 1.275e-17
* device instance cc__84_vss r0 *1 0,0
Ccc__84_vss \$84 vss 1.0837e-17
* device instance cc__85__86 r0 *1 0,0
Ccc__85__86 \$85 \$86 2.49259e-16
* device instance cc__85__87 r0 *1 0,0
Ccc__85__87 \$85 \$87 1.6256e-16
* device instance cc__85__88 r0 *1 0,0
Ccc__85__88 \$85 \$88 1.19211e-16
* device instance cc__85__89 r0 *1 0,0
Ccc__85__89 \$85 \$89 7.5862e-17
* device instance cc__85__90 r0 *1 0,0
Ccc__85__90 \$85 \$90 3.2512e-17
* device instance cc__85_lo_32_n r0 *1 0,0
Ccc__85_lo_32_n \$85 lo_32_n 6.924e-18
* device instance cc__85_sel_in r0 *1 0,0
Ccc__85_sel_in \$85 sel_in 1.0837e-17
* device instance cc__85_topn r0 *1 0,0
Ccc__85_topn \$85 topn 5.162851e-15
* device instance cc__85_topp r0 *1 0,0
Ccc__85_topp \$85 topp 1.7212e-17
* device instance cc__85_vcm r0 *1 0,0
Ccc__85_vcm \$85 vcm 6.0562e-17
* device instance cc__85_vss r0 *1 0,0
Ccc__85_vss \$85 vss 1.0837e-17
* device instance cc__86__87 r0 *1 0,0
Ccc__86__87 \$86 \$87 1.6256e-16
* device instance cc__86__88 r0 *1 0,0
Ccc__86__88 \$86 \$88 1.19211e-16
* device instance cc__86__89 r0 *1 0,0
Ccc__86__89 \$86 \$89 7.5862e-17
* device instance cc__86__90 r0 *1 0,0
Ccc__86__90 \$86 \$90 3.2512e-17
* device instance cc__86_lo_16_n r0 *1 0,0
Ccc__86_lo_16_n \$86 lo_16_n 6.924e-18
* device instance cc__86_sel_in r0 *1 0,0
Ccc__86_sel_in \$86 sel_in 1.0837e-17
* device instance cc__86_topn r0 *1 0,0
Ccc__86_topn \$86 topn 2.757718e-15
* device instance cc__86_topp r0 *1 0,0
Ccc__86_topp \$86 topp 1.7212e-17
* device instance cc__86_vcm r0 *1 0,0
Ccc__86_vcm \$86 vcm 6.5024e-17
* device instance cc__86_vss r0 *1 0,0
Ccc__86_vss \$86 vss 1.0837e-17
* device instance cc__87__88 r0 *1 0,0
Ccc__87__88 \$87 \$88 2.1389e-16
* device instance cc__87__89 r0 *1 0,0
Ccc__87__89 \$87 \$89 7.5862e-17
* device instance cc__87__90 r0 *1 0,0
Ccc__87__90 \$87 \$90 3.2512e-17
* device instance cc__87_lo_8_n r0 *1 0,0
Ccc__87_lo_8_n \$87 lo_8_n 6.924e-18
* device instance cc__87_sel_in r0 *1 0,0
Ccc__87_sel_in \$87 sel_in 1.0837e-17
* device instance cc__87_topn r0 *1 0,0
Ccc__87_topn \$87 topn 1.309601e-15
* device instance cc__87_topp r0 *1 0,0
Ccc__87_topp \$87 topp 1.7212e-17
* device instance cc__87_vcm r0 *1 0,0
Ccc__87_vcm \$87 vcm 6.0562e-17
* device instance cc__87_vdd r0 *1 0,0
Ccc__87_vdd \$87 vdd 1.275e-17
* device instance cc__87_vss r0 *1 0,0
Ccc__87_vss \$87 vss 1.0837e-17
* device instance cc__88__89 r0 *1 0,0
Ccc__88__89 \$88 \$89 7.5862e-17
* device instance cc__88__90 r0 *1 0,0
Ccc__88__90 \$88 \$90 3.2512e-17
* device instance cc__88_lo_4_n r0 *1 0,0
Ccc__88_lo_4_n \$88 lo_4_n 6.924e-18
* device instance cc__88_sel_in r0 *1 0,0
Ccc__88_sel_in \$88 sel_in 1.0837e-17
* device instance cc__88_topn r0 *1 0,0
Ccc__88_topn \$88 topn 6.72013e-16
* device instance cc__88_topp r0 *1 0,0
Ccc__88_topp \$88 topp 1.7212e-17
* device instance cc__88_vcm r0 *1 0,0
Ccc__88_vcm \$88 vcm 6.0562e-17
* device instance cc__88_vss r0 *1 0,0
Ccc__88_vss \$88 vss 1.0837e-17
* device instance cc__89__90 r0 *1 0,0
Ccc__89__90 \$89 \$90 2.1675e-17
* device instance cc__89_lo_2_n r0 *1 0,0
Ccc__89_lo_2_n \$89 lo_2_n 6.924e-18
* device instance cc__89_sel_in r0 *1 0,0
Ccc__89_sel_in \$89 sel_in 1.0837e-17
* device instance cc__89_topn r0 *1 0,0
Ccc__89_topn \$89 topn 3.44613e-16
* device instance cc__89_topp r0 *1 0,0
Ccc__89_topp \$89 topp 1.7212e-17
* device instance cc__89_vcm r0 *1 0,0
Ccc__89_vcm \$89 vcm 3.8887e-17
* device instance cc__89_vdd r0 *1 0,0
Ccc__89_vdd \$89 vdd 1.275e-17
* device instance cc__89_vss r0 *1 0,0
Ccc__89_vss \$89 vss 1.0837e-17
* device instance cc__90_lo_1_n r0 *1 0,0
Ccc__90_lo_1_n \$90 lo_1_n 6.924e-18
* device instance cc__90_sel_in r0 *1 0,0
Ccc__90_sel_in \$90 sel_in 1.0837e-17
* device instance cc__90_topn r0 *1 0,0
Ccc__90_topn \$90 topn 1.80912e-16
* device instance cc__90_topp r0 *1 0,0
Ccc__90_topp \$90 topp 1.7212e-17
* device instance cc__90_vcm r0 *1 0,0
Ccc__90_vcm \$90 vcm 2.805e-17
* device instance cc__90_vdd r0 *1 0,0
Ccc__90_vdd \$90 vdd 5.194e-18
* device instance cc__90_vss r0 *1 0,0
Ccc__90_vss \$90 vss 1.0837e-17
* device instance cc_hi_16_n_vcm r0 *1 0,0
Ccc_hi_16_n_vcm hi_16_n vcm 1.0837e-17
* device instance cc_hi_16_p_vcm r0 *1 0,0
Ccc_hi_16_p_vcm hi_16_p vcm 1.0837e-17
* device instance cc_lo_16_n_vcm r0 *1 0,0
Ccc_lo_16_n_vcm lo_16_n vcm 1.0837e-17
* device instance cc_lo_16_p_vcm r0 *1 0,0
Ccc_lo_16_p_vcm lo_16_p vcm 1.0837e-17
* device instance cc_pinn_vcm r0 *1 0,0
Ccc_pinn_vcm vinn vcm 2.1675e-17
* device instance cc_pinp_vcm r0 *1 0,0
Ccc_pinp_vcm vinp vcm 1.0837e-17
* device instance cc_rel_16_n_vcm r0 *1 0,0
Ccc_rel_16_n_vcm rel_16_n vcm 1e-19
* device instance cc_rel_16_p_vcm r0 *1 0,0
Ccc_rel_16_p_vcm rel_16_p vcm 1e-19
* device instance cc_sel_in_vcm r0 *1 0,0
Ccc_sel_in_vcm sel_in vcm 3.2512e-17
* device instance cc_topn_topp r0 *1 0,0
Ccc_topn_topp topn topp 5.318e-18
* device instance cc_topn_vcm r0 *1 0,0
Ccc_topn_vcm topn vcm 1.74538e-16
* device instance cc_topn_vdd r0 *1 0,0
Ccc_topn_vdd topn vdd 2.3587e-17
* device instance cc_topn_vss r0 *1 0,0
Ccc_topn_vss topn vss 2.3587e-17
* device instance cc_topp_vcm r0 *1 0,0
Ccc_topp_vcm topp vcm 2.19799e-16
* device instance cc_topp_vdd r0 *1 0,0
Ccc_topp_vdd topp vdd 3.4425e-17
* device instance cc_topp_vss r0 *1 0,0
Ccc_topp_vss topp vss 2.3587e-17
* device instance cc_vcm_vdd r0 *1 0,0
Ccc_vcm_vdd vcm vdd 6.042e-17
* device instance cc_vcm_vref r0 *1 0,0
Ccc_vcm_vref vcm vref 1.0837e-17
* device instance cc_vcm_vss r0 *1 0,0
Ccc_vcm_vss vcm vss 5.6595e-17
* device instance cc_vdd_vss r0 *1 0,0
Ccc_vdd_vss vdd vss 3.2111e-17
* device instance vsubs_dctie r0 *1 0,0
Rvsubs_dctie vsubs 0 1e+12
.ENDS ADC_TOP

* ================= extracted core se (single-ended) ==================
vsestart se_start 0 dc 0
vsemode se_mode 0 dc 0
xsectrl clk se_start se_mode se_cmp se_samp_tp_n se_sel_in_n se_drdy se_c9
+ se_c8 se_c7 se_c6 se_c5 se_c4 se_c3 se_c2 se_c1 se_c0 se_rel_n_256p
+ se_sel_hi_n_256p se_sel_lo_n_256p se_rel_n_128p se_sel_hi_n_128p
+ se_sel_lo_n_128p se_rel_n_64p se_sel_hi_n_64p se_sel_lo_n_64p
+ se_rel_n_32p se_sel_hi_n_32p se_sel_lo_n_32p se_rel_n_16p
+ se_sel_hi_n_16p se_sel_lo_n_16p se_rel_n_8p se_sel_hi_n_8p
+ se_sel_lo_n_8p se_rel_n_4p se_sel_hi_n_4p se_sel_lo_n_4p se_rel_n_2p
+ se_sel_hi_n_2p se_sel_lo_n_2p se_rel_n_1p se_sel_hi_n_1p se_sel_lo_n_1p
+ se_rel_n_256n se_sel_hi_n_256n se_sel_lo_n_256n se_rel_n_128n
+ se_sel_hi_n_128n se_sel_lo_n_128n se_rel_n_64n se_sel_hi_n_64n
+ se_sel_lo_n_64n se_rel_n_32n se_sel_hi_n_32n se_sel_lo_n_32n
+ se_rel_n_16n se_sel_hi_n_16n se_sel_lo_n_16n se_rel_n_8n se_sel_hi_n_8n
+ se_sel_lo_n_8n se_rel_n_4n se_sel_hi_n_4n se_sel_lo_n_4n se_rel_n_2n
+ se_sel_hi_n_2n se_sel_lo_n_2n se_rel_n_1n se_sel_hi_n_1n se_sel_lo_n_1n
+ sar_ctrl_a
* Input drive network (DR-0013), same R_s/C_pin gen_adc_top._core()
* uses for the schematic core -- the drive contract is unchanged by
* which core sits behind it.
Rsesp se_vinp se_pinp 25
Csexp se_pinp 0 1n
Rsesn se_vinn se_pinn 25
Csexn se_pinn 0 1n
* ADC_TOP: both CDAC array sides (four-leg bottom-plate switches, local
* drivers) and the per-side top-plate V_cm switch (DR-0014), all in ONE
* flat extracted instance, PMOS-body-remediated and MiM-mapped to the
* native PDK subckt (layout/adc-top/parasitics/remediate_extracted.py).
* Comparator and controller stay schematic-level (Scope item 0).
Xdut se_sel_hi_n_128n se_sel_hi_n_128p se_sel_hi_n_16n se_sel_hi_n_16p
+ se_sel_hi_n_1n se_sel_hi_n_1p se_sel_hi_n_256n se_sel_hi_n_256p
+ se_sel_hi_n_2n se_sel_hi_n_2p se_sel_hi_n_32n se_sel_hi_n_32p
+ se_sel_hi_n_4n se_sel_hi_n_4p se_sel_hi_n_64n se_sel_hi_n_64p
+ se_sel_hi_n_8n se_sel_hi_n_8p se_sel_lo_n_128n se_sel_lo_n_128p
+ se_sel_lo_n_16n se_sel_lo_n_16p se_sel_lo_n_1n se_sel_lo_n_1p
+ se_sel_lo_n_256n se_sel_lo_n_256p se_sel_lo_n_2n se_sel_lo_n_2p
+ se_sel_lo_n_32n se_sel_lo_n_32p se_sel_lo_n_4n se_sel_lo_n_4p
+ se_sel_lo_n_64n se_sel_lo_n_64p se_sel_lo_n_8n se_sel_lo_n_8p
+ se_rel_n_128n se_rel_n_128p se_rel_n_16n se_rel_n_16p se_rel_n_1n
+ se_rel_n_1p se_rel_n_256n se_rel_n_256p se_rel_n_2n se_rel_n_2p
+ se_rel_n_32n se_rel_n_32p se_rel_n_4n se_rel_n_4p se_rel_n_64n
+ se_rel_n_64p se_rel_n_8n se_rel_n_8p se_sel_in_n se_topn se_topp
+ se_samp_tp_n vcmn vddd vrefn 0 se_pinp se_pinn ADC_TOP
iseb vddc se_ibias dc 10u
Xsecmp se_topp se_topn cmpclk se_ibias se_cmp se_cmpb vddc 0 comparator
bsecode se_code 0 V =
+ (512)*(v(se_c9)>vth ? 1 : 0) + (256)*(v(se_c8)>vth ? 1 : 0) + (128)*(v(se_c7)>vth ? 1 : 0) + (64)*(v(se_c6)>vth ? 1 : 0) + (32)*(v(se_c5)>vth ? 1 : 0) + (16)*(v(se_c4)>vth ? 1 : 0) + (8)*(v(se_c3)>vth ? 1 : 0) + (4)*(v(se_c2)>vth ? 1 : 0) + (2)*(v(se_c1)>vth ? 1 : 0) + (1)*(v(se_c0)>vth ? 1 : 0)

* ---- vddt topology tie ---------------------------------------------
* The extracted core merges the top-plate switch onto its single vdd
* pin (see the header), so NO device is left on vddt -- `_preamble()`'s
* `vddt` source would otherwise be the node's only connection, which
* ngspice flags as a topology warning. vddt is therefore tied to vddd
* through 1 Gohm. Both rails are driven by ideal sources at the SAME
* {vdd_val}, so this tie carries identically 0 A at every corner and
* every timepoint: p_trk_* is exactly 0 on the extracted side, and
* that 0 means 'this block is inside p_cdac_*', not 'this block draws
* no power'. Disclosed here rather than left as an unexplained zero.
Rsetrktie vddt vddd 1G
