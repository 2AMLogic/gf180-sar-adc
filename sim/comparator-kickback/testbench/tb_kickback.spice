* tb_kickback -- charge kicked back into the CDAC top plate by a
* comparator decision, over PVT.
*
* Netlist FRAGMENT. The harness supplies the models, the corner .lib
* sections, .temp, the .control block and .end (sim/harness/README.md).
* Parameters provided by the harness: vdd_val, vdd_nom, temp_c.
*
* WHY THIS IS NOT AN ORDINARY DISTURBANCE MEASUREMENT. In a SAR ADC the
* comparator's input is still the CDAC top plate under DR-0014 bottom-plate
* sampling (C_side = 512 x 35.6528 fF = 18.254 pF per side,
* spec/cdac-sizing-memo.md S5.2; DR-0019 resize physically implemented by
* #202) -- but what it holds changed. The input is sampled on the BOTTOM
* plates; the per-side top-plate V_cm switch (adc_tp_sw) opens at the edge
* into ph3 -- the sampling instant, one bit cycle before the bottom plates
* leave V_in -- and from that edge until the next sample the top plate is a
* floating, high-impedance node whose charge encodes the sampled input plus
* every DAC step. Charge injected by a comparator decision does not settle
* out: there is no path to discharge it before the next trial, so it is
* ADDED to the quantity being converted. spec/prior-art-survey.md
* S3.3/S3.6 makes this the primary risk to retire for a StrongARM-class
* comparator at 3.3 V, where the regenerating nodes swing 2.75x a 1.2 V
* design's.
*
* WHAT IS MEASURED. Each instance's inputs are FLOATING top plates:
* C_top = 18.254 pF to ground (the built DR-0019 array alone; C_par, the
* 57-160 fF of comparator input + adc_tp_sw off-state load measured on the
* same node by sim/top-plate-cpar/records/20261105-061018-e5489fc.md, is
* <= 0.9 % of the node and is deliberately NOT modelled -- its omission
* makes the residual conservative, see spec/comparator-budget-memo.md S5.1),
* biased through 1 Gohm (tau = 18.3 ms, i.e. five orders of magnitude
* slower than the 62.5 ns bit cycle, so the bias network sets the operating
* point and then observes rather than restores). Under DR-0014 every bit
* trial's top-plate common mode sits at V_cm (the input is differential
* about V_cm and the DAC legs move complementarily), so the fixed-CM
* excitation below is the converter's actual operating condition, not an
* approximation. The top-plate voltages are read just before the strobe and
* again at the end of the bit cycle, and the difference is split into:
*
*   DIFFERENTIAL kickback -- changes the residue directly, 1:1 with LSB.
*   COMMON-MODE kickback  -- rejected by the differential comparator to
*                            first order; reported because it moves the
*                            input common mode DR-0006 relies on being
*                            stable.
*
* And, most importantly:
*
*   SIGNAL-DEPENDENT kickback -- the SPREAD of the differential kickback
*   across the residue range a real conversion presents. Per
*   spec/prior-art-survey.md S3.1 a kickback that is the SAME at every
*   code is just another static offset, removable digitally with the
*   comparator's own offset; only the part that VARIES with the residue
*   is a linearity error. That part is the number the budget memo
*   compares against an LSB. Under DR-0014 the residue a trial presents
*   spans +/-1.65 V differential at trial 1 down to +/-half-LSB at the
*   last trial, so the deck samples three points across that range --
*   half-LSB, 100 mV, and the 1.65 V first-trial worst case -- and the
*   signal-dependent metric is the max-minus-min spread of the
*   differential kick across all three (this supersedes the two-point
*   100 mV-vs-half-LSB difference the pre-DR-0014 deck reported; DR-0014
*   finding 3's input-capacitance balance peak sits at v_p = v_n, exactly
*   where DR-0014 pins every trial, so whether the old pair was the worst
*   pair was a measurement question, answered by the third point).
*
* Instance A sits at a half-LSB residue (the accuracy-critical late
* trials), instance B at +100 mV (an early trial), instance C at +1.65 V
* (the first trial's worst case). Two clock cycles are applied so a kick
* that partially recovers within one cycle can be distinguished from one
* that persists.

.param ib=10u
.param vcm=1.65
.param dv_small=1.6113m
.param dv_big=100m
.param dv_fs=1.65
* 512 x 35.6528 fF (C_UNIT_FF, design/adc-top/gen_adc_top.py) = the built
* per-side DR-0019 array; spec/cdac-sizing-memo.md S5.2.
.param ctop=18.254p
.param rbias=1g
.param tclk=62.5n
.param thi=31.25n

vsup vdd 0 dc {vdd_val}
vclk clk 0 pulse(0 {vdd_val} 10n 0.2n 0.2n {thi-0.2n} {tclk})

* The SR latch's hold state is metastable at DC; steer the operating
* point to a definite (wrong-polarity) state so the strobe has to flip
* it, exactly as in sim/comparator-regeneration/.
.nodeset v(douta)=0 v(doutba)='vdd_val' v(doutb)=0 v(doutbb)='vdd_val' v(doutc)=0 v(doutbc)='vdd_val'

* --- A: half-LSB residue on floating 18.254 pF top plates ---------------
vsa_p sa_p 0 dc 'vcm+dv_small/2'
vsa_n sa_n 0 dc 'vcm-dv_small/2'
Rpa sa_p tpa {rbias}
Rna sa_n tna {rbias}
Cpa tpa 0 {ctop}
Cna tna 0 {ctop}
iba vdd ibna dc {ib}
Xa  tpa tna clk ibna douta doutba vdd 0 comparator

* --- B: +100 mV residue, same network ---------------------------------
vsb_p sb_p 0 dc 'vcm+dv_big/2'
vsb_n sb_n 0 dc 'vcm-dv_big/2'
Rpb sb_p tpb {rbias}
Rnb sb_n tnb {rbias}
Cpb tpb 0 {ctop}
Cnb tnb 0 {ctop}
ibb vdd ibnb dc {ib}
Xb  tpb tnb clk ibnb doutb doutbb vdd 0 comparator

* --- C: +1.65 V residue (first-trial worst case), same network ---------
vsc_p sc_p 0 dc 'vcm+dv_fs/2'
vsc_n sc_n 0 dc 'vcm-dv_fs/2'
Rpc sc_p tpc {rbias}
Rnc sc_n tnc {rbias}
Cpc tpc 0 {ctop}
Cnc tnc 0 {ctop}
ibc vdd ibnc dc {ib}
Xc  tpc tnc clk ibnc doutc doutbc vdd 0 comparator

* --- Supply-normalized decision probes --------------------------------
* Only used for the polarity checks; the kickback numbers themselves are
* absolute voltages on the top plates and must NOT be normalized.
Bdan dan 0 v = v(douta)/v(vdd)
Bdbn dbn 0 v = v(doutb)/v(vdd)
Bdcn dcn 0 v = v(doutc)/v(vdd)

* --- COMPARATOR-NETLIST-BEGIN (verbatim-copied into every testbench) ---
.subckt preamp vinp vinn ibias pop pon vdd vss
* 1:1 NMOS current mirror; ibias is forced into the diode branch.
Xmb  ibias ibias vss vss nfet_03v3 w=20u l=2u
Xmt  ptail ibias vss vss nfet_03v3 w=20u l=2u
* Input pair. The device whose gate is vinp drives the INVERTING node
* pon, so v(pop) - v(pon) = +A_v * (v(vinp) - v(vinn)).
Xmip pon vinp ptail vss nfet_03v3 w=40u l=1u
Xmin pop vinn ptail vss nfet_03v3 w=40u l=1u
* Unsalicided 1 kohm/sq p+ poly loads, 150 squares = 150 kohm nominal.
* Third terminal is the substrate/body contact. `ppolyf_u_1k`, not the
* 2 kohm/sq `ppolyf_u_2k` an earlier revision assumed: issue #118 drew
* SAB(49/0)+RES_MK(110/5)+Resistor(62/0) markers over the load-resistor
* bodies so `klt extract`'s gf180mcu deck recognises them as real devices
* instead of a Poly2 short, and at this repo's pinned klt commit that
* marker geometry can only select `ppolyf_u_1k` (1000 ohm/sq) -- the
* `_2k`/`_3k` flavours share the identical drawn geometry and are chosen by
* a build-time deck option this curated deck does not implement
* (`2AMLogic/klayout-tools#595`, open). `r_length` is doubled (75u -> 150u)
* at the same `r_width=1u` to preserve the 150 kohm target at the new
* sheet-rho -- see layout/adc-top/README.md "Resistors".
Xrlp vdd pop vss ppolyf_u_1k r_width=1u r_length=150u
Xrln vdd pon vss ppolyf_u_1k r_width=1u r_length=150u
.ends preamp

.subckt sarlatch inp inn clk outp outn vdd vss
* clk low  -> tail off; outp/outn/dip/din precharged to vdd
* clk high -> tail on; the input pair discharges dip/din at rates set by
*             v(inp)/v(inn), then the cross-coupled pairs regenerate.
Xmlt ltail clk   vss   vss nfet_03v3 w=16u l=0.35u
Xmlp dip   inp   ltail vss nfet_03v3 w=8u  l=0.5u
Xmln din   inn   ltail vss nfet_03v3 w=8u  l=0.5u
Xmnp outn  outp  dip   vss nfet_03v3 w=6u  l=0.35u
Xmnn outp  outn  din   vss nfet_03v3 w=6u  l=0.35u
Xmpp outn  outp  vdd   vdd pfet_03v3 w=8u  l=0.35u
Xmpn outp  outn  vdd   vdd pfet_03v3 w=8u  l=0.35u
Xmrp outn  clk   vdd   vdd pfet_03v3 w=4u  l=0.35u
Xmrn outp  clk   vdd   vdd pfet_03v3 w=4u  l=0.35u
Xmrd dip   clk   vdd   vdd pfet_03v3 w=2u  l=0.35u
Xmre din   clk   vdd   vdd pfet_03v3 w=2u  l=0.35u
.ends sarlatch

* Minimum-ish isolation inverter. Deliberately small: it is the only
* thing the regeneration nodes drive, so its gate capacitance is added
* directly to the latch's own output nodes and shows up as regeneration
* time.
.subckt inv a y vdd vss
Xp y a vdd vdd pfet_03v3 w=2u   l=0.35u
Xn y a vss vss nfet_03v3 w=1u   l=0.35u
.ends inv

.subckt nor2 a b y vdd vss
Xp1 ps a vdd vdd pfet_03v3 w=8u l=0.35u
Xp2 y  b ps  vdd pfet_03v3 w=8u l=0.35u
Xn1 y  a vss vss nfet_03v3 w=4u l=0.35u
Xn2 y  b vss vss nfet_03v3 w=4u l=0.35u
.ends nor2

.subckt comparator vinp vinn clk ibias dout doutb vdd vss
Xpre preamp_in1 preamp_in2 ibias pop pon vdd vss preamp
Xlat pop pon clk outp outn vdd vss sarlatch
* THE ISOLATION INVERTERS ARE NOT OPTIONAL -- they fix a measured
* hysteresis defect. Both StrongARM outputs precharge HIGH, so the
* decision arrives as an active-low pulse on exactly one of them, and
* the obvious way to hold it is a NAND SR latch wired straight to
* outp/outn. That circuit was built first and MEASURED: after deciding
* one way it would not flip back until the input reached ~10 mV of the
* opposite polarity -- about 3 LSB of hysteresis, which in a SAR (where
* the same comparator makes ten successive decisions on a shrinking
* residue) is a code-dependent error, not an offset.
*
* The cause is that a NAND SR latch's HELD STATE loads the two
* regeneration nodes asymmetrically. Wired directly, the node driving
* the NAND whose output is LOW sees that output swing when it falls
* (Miller-multiplied C_gd, ~26 fF against a regeneration node of a few
* tens of fF), while its twin drives a NAND whose output is already
* HIGH and stays there. The latch is therefore biased toward keeping
* the answer it already holds.
*
* Interposing one small inverter per side removes the coupling: the
* inverters are identical, both of their inputs precharge to V_DD, and
* neither loading depends on what the SR latch is holding. The SR latch
* becomes NOR-type because the inverters make the decision pulses
* active-HIGH. dout goes HIGH when outn falls, i.e. when
* v(vinp) > v(vinn), exactly as before.
Xis outn sset vdd vss inv
Xir outp srst vdd vss inv
Xno1 srst doutb dout  vdd vss nor2
Xno2 sset dout  doutb vdd vss nor2
* Input pass-through (zero-volt sources) so a testbench can probe the
* current the comparator draws from each CDAC top plate directly.
Vpp preamp_in1 vinp dc 0
Vpn preamp_in2 vinn dc 0
.ends comparator
* --- COMPARATOR-NETLIST-END ---
