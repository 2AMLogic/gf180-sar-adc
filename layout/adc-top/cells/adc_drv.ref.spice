* Flat LVS reference for ADC_DRV.
*
* GENERATED by layout/adc-top/cells/gen_adc_cells.py from
* design/adc-top/adc_top.spice's `.subckt adc_drv` -- do not
* edit. See layout/adc-top/lib/netlist.py for why the layout and this
* reference are derived from the same parsed design netlist, and what
* that does and does not let LVS prove.
*
* Deliberate, documented choices behind the statements below -- made by
* the generator (`build`) and `klt extract`'s gf180mcu ExtractionDeck,
* and explained in layout/adc-top/README.md:
*   - the substrate: DR-0049's `Pplus`-marked substrate-tie strip is
*     routed to the labelled `vss` trunk, so the deck's `vsubs` global
*     merges into `vss` and no `vsubs` pin appears;
*
* Runnable by hand:  klt lvs layout/adc-top/cells/adc_drv.lvs.json --format json
.SUBCKT ADC_DRV a vdd vss y
MXp y a vdd vdd pfet L=0.35U W=8U
MXn y a vss vss nfet L=0.35U W=4U
.ENDS ADC_DRV
