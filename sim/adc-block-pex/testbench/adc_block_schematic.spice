* ==================================================================
* adc_block_schematic.spice -- issue #428: the SCHEMATIC-side `ADC_BLOCK`
* subcircuit `klt pex` diffs the extracted layout against.
*
* Why this file exists. `klt pex` re-runs ONE testbench twice and changes
* only its single `.include` line between the two runs, so the schematic
* DUT and the extracted DUT must define the same top-level `.subckt` name
* with the same pin list in the same order (the gap 2AMLogic/
* klayout-tools#1030 named). The extracted side is `ADC_BLOCK`, the
* LVS-clean block `layout/adc-top/adc_block.gds` draws; the schematic
* library (`design/adc-top/adc_top.spice`) has every piece of it but no
* subckt at that boundary, because every schematic testbench wires the
* pieces inline (`gen_adc_top.py::_core()`). This file is that boundary,
* written down once, as pure wiring -- no device is added, removed or
* resized here:
*
*   * two `adc_tp_sw` top-plate V_cm switches, one per side, on the SAME
*     `tp_gn` control (DR-0014; `_core()` drives both from one net too);
*   * two `adc_cdac_side` arrays, `p` and `n`, whose bottom-plate legs are
*     the block's `rel_<w>_<s>` / `hi_<w>_<s>` / `lo_<w>_<s>` pins and
*     whose fourth (input) leg is the one broadcast `sel_in` pin;
*   * the `comparator` from `design/comparator/comparator.spice`, inputs on
*     the top plates (`topp` -> `vinp`, as in `_core()`).
*
* The mapping is the same one `layout/adc-top/parasitics/
* gen_extracted_core_tb.py`'s module docstring tabulates for the
* extracted `ADC_BLOCK`, read in the opposite direction.
*
* PIN LIST. Byte-for-byte the order `klt extract --pins <this list>`
* writes for `ADC_BLOCK` (alphabetical). The extracted layout additionally
* labels the comparator's two load-resistor terminals `XCMP.pon` /
* `XCMP.pop` (an LVS-disambiguation label, issue #118 -- not a port); the
* runner passes `--pins` so `klt extract` keeps those two as internal nodes
* instead of promoting them, which is exactly where the schematic has them
* (inside `comparator`'s `preamp`). `run_pex_adc_block.py` checks this
* header against the extracted netlist's header before it trusts a delta.
*
* NOT self-contained on purpose: the runner composes it after
* `design/adc-top/adc_top.spice`, `design/comparator/comparator.spice`
* (both read directly from `design/`, never copied) and the harness's
* `mim_cap_<density>` aliases (`sim/harness/runner.py`), so nothing here can
* drift from the design it claims to stand for.
* ==================================================================
.subckt ADC_BLOCK cmpclk dout doutb hi_128_n hi_128_p hi_16_n hi_16_p hi_1_n
+ hi_1_p hi_256_n hi_256_p hi_2_n hi_2_p hi_32_n hi_32_p hi_4_n hi_4_p hi_64_n
+ hi_64_p hi_8_n hi_8_p ibias lo_128_n lo_128_p lo_16_n lo_16_p lo_1_n lo_1_p
+ lo_256_n lo_256_p lo_2_n lo_2_p lo_32_n lo_32_p lo_4_n lo_4_p lo_64_n lo_64_p
+ lo_8_n lo_8_p pinn pinp rel_128_n rel_128_p rel_16_n rel_16_p rel_1_n rel_1_p
+ rel_256_n rel_256_p rel_2_n rel_2_p rel_32_n rel_32_p rel_4_n rel_4_p
+ rel_64_n rel_64_p rel_8_n rel_8_p sel_in topn topp tp_gn vcm vdd vref vss
XTSWP topp vcm tp_gn vdd vss adc_tp_sw
XTSWN topn vcm tp_gn vdd vss adc_tp_sw
XARRP topp pinp vref vcm vss vdd sel_in
+ rel_256_p hi_256_p lo_256_p rel_128_p hi_128_p lo_128_p
+ rel_64_p hi_64_p lo_64_p rel_32_p hi_32_p lo_32_p
+ rel_16_p hi_16_p lo_16_p rel_8_p hi_8_p lo_8_p
+ rel_4_p hi_4_p lo_4_p rel_2_p hi_2_p lo_2_p
+ rel_1_p hi_1_p lo_1_p adc_cdac_side
XARRN topn pinn vref vcm vss vdd sel_in
+ rel_256_n hi_256_n lo_256_n rel_128_n hi_128_n lo_128_n
+ rel_64_n hi_64_n lo_64_n rel_32_n hi_32_n lo_32_n
+ rel_16_n hi_16_n lo_16_n rel_8_n hi_8_n lo_8_n
+ rel_4_n hi_4_n lo_4_n rel_2_n hi_2_n lo_2_n
+ rel_1_n hi_1_n lo_1_n adc_cdac_side
XCMP topp topn cmpclk ibias dout doutb vdd vss comparator
.ends ADC_BLOCK
