* ==================================================================
* tb_adc_enob_fft_extracted -- dynamic performance (coherent-sampling
* FFT) of the extracted, PMOS-body-remediated, MiM-mapped ADC_TOP core
* over the PVT grid (issue #89 Scope item 1). GENERATED by
* layout/adc-top/parasitics/gen_extracted_enob_fft_tb.py -- do not
* edit.
*
* Reuses sim/adc-enob-fft/testbench/tb.json UNMODIFIED (via
* `run_corners.py --netlist ... --netlist-provenance extracted`): the
* coherent sine, the per-sample `meas`, and the coverage-witness /
* vref-droop checks are byte-for-byte ports of
* design/adc-top/gen_adc_top.py's fft_netlist()/_core(), tagged
* `se_*` to match that manifest's measure expressions exactly. The
* ONLY thing that differs from the schematic deck is the analog core
* itself: one extracted ADC_TOP instance (both CDAC array sides +
* the per-side top-plate V_cm switch, PMOS-body-remediated to vdd,
* MiM-mapped to the native PDK subckt) in place of two adc_cdac_side
* instances + two adc_tp_sw instances. Comparator and rung-1
* controller stay schematic-level (issue #89 Scope item 0). See
* gen_extracted_enob_fft_tb.py's module docstring for the full
* rationale.
* ==================================================================

* ---- ratiometric rails --------------------------------------------
* V_REF = V_DD. README.md note [c] makes V_REF <= V_DD a hard
* condition of the ratified spec, so a fixed 3.3 V reference is not
* legal at the 2.97 V corner; taking V_REF = V_DD keeps the deck legal
* at every point of the supply axis, and every figure below is in LSB
* of whatever full scale that point has.
.param vref={vdd_val}
.param vcm={vdd_val/2}
.param vth={vdd_val/2}
.param lsb={vdd_val/1024}

* ---- clocks --------------------------------------------------------
* DR-0003: one external clock pin at 16 x f_s. The comparator strobe
* is the same clock shifted half a bit cycle, so the CDAC settles in
* the first 31.25 ns and the comparator decides in the second -- the
* split spec/prior-art-survey.md Sec 1.4 allocates and
* sim/comparator-regeneration/ measured 863 ps of worst-case decision
* delay against.
vclk clk 0 pulse(0 {vdd_val} 0 100p 100p 31.25n 62.5n)
vcmpclk cmpclk 0 pulse(0 {vdd_val} 31.25n 100p 100p 31.25n 62.5n)
vcmpclkb cmpclkb 0 pulse({vdd_val} 0 31.25n 100p 100p 31.25n 62.5n)

* ---- supplies, split per block so power is attributable -----------
vddt vddt 0 dc {vdd_val}
vddd vddd 0 dc {vdd_val}
vddc vddc 0 dc {vdd_val}

* ---- reference network, DR-0002 -----------------------------------
* DR-0002 specifies an EXTERNAL V_REF pin with an effective source
* impedance <= 240 ohm IN THE SWITCHING BAND and >= 40 nF of external
* decoupling. Both halves of that sentence are modelled: the inductor
* in parallel with the 240 ohm makes the network 240 ohm at the
* switching band and DC-accurate below it, which is what an external
* reference buffer behind a decoupling capacitor actually is. A bare
* 240 ohm series resistor would instead assert a DC offset DR-0002
* never specified -- and, with 40 nF, a 9.6 us settling tail that
* would dominate any run shorter than ~50 us.
vrefs vrefs 0 dc {vref}
rref vrefs vrefn 240
lref vrefs vrefn 2.3873u
cref vrefn 0 40n
* V_cm generation is explicitly unbudgeted work (DR-0011
* Consequences: 'a new, currently-unbudgeted deliverable for a future
* issue'), so there is no ratified envelope to model it against and it
* is an IDEAL source here. That is a stated assumption of every record
* this deck produces, not a measured result -- see the known-
* limitations section of spec/testbench-suite-memo.md.
vcms vcmn 0 dc {vcm}

* ---- near-full-scale sine -- identical to gen_adc_top.fft_netlist()
* Amplitude and coherence rationale are unchanged by which core sits
* behind the input drive network; see fft_netlist()'s own comments
* for the full derivation.
vsein se_vinp 0 sin({vcm} {vref/2*0.94} 484375.000000 0.000002000 0 0)
vsevinn se_vinn 0 dc {vcm}

* ---- library: comparator + SAR controller + extracted core -------
* --- COMPARATOR-NETLIST-BEGIN (verbatim-copied into every testbench) ---
.subckt preamp vinp vinn ibias pop pon vdd vss
* 1:1 NMOS current mirror; ibias is forced into the diode branch.
Xmb  ibias ibias vss vss nfet_03v3 w=20u l=2u
Xmt  ptail ibias vss vss nfet_03v3 w=20u l=2u
* Input pair. The device whose gate is vinp drives the INVERTING node
* pon, so v(pop) - v(pon) = +A_v * (v(vinp) - v(vinn)).
Xmip pon vinp ptail vss nfet_03v3 w=40u l=1u
Xmin pop vinn ptail vss nfet_03v3 w=40u l=1u
* Unsalicided 1 kohm/sq p+ poly loads, 150 squares = 150 kohm nominal.
* Third terminal is the substrate/body contact. `ppolyf_u_1k`, not the
* 2 kohm/sq `ppolyf_u_2k` an earlier revision assumed: issue #118 drew
* SAB(49/0)+RES_MK(110/5)+Resistor(62/0) markers over the load-resistor
* bodies so `klt extract`'s gf180mcu deck recognises them as real devices
* instead of a Poly2 short, and at this repo's pinned klt commit that
* marker geometry can only select `ppolyf_u_1k` (1000 ohm/sq) -- the
* `_2k`/`_3k` flavours share the identical drawn geometry and are chosen by
* a build-time deck option this curated deck does not implement
* (`2AMLogic/klayout-tools#595`, open). `r_length` is doubled (75u -> 150u)
* at the same `r_width=1u` to preserve the 150 kohm target at the new
* sheet-rho -- see layout/adc-top/README.md "Resistors".
Xrlp vdd pop vss ppolyf_u_1k r_width=1u r_length=150u
Xrln vdd pon vss ppolyf_u_1k r_width=1u r_length=150u
.ends preamp

.subckt sarlatch inp inn clk outp outn vdd vss
* clk low  -> tail off; outp/outn/dip/din precharged to vdd
* clk high -> tail on; the input pair discharges dip/din at rates set by
*             v(inp)/v(inn), then the cross-coupled pairs regenerate.
Xmlt ltail clk   vss   vss nfet_03v3 w=16u l=0.35u
Xmlp dip   inp   ltail vss nfet_03v3 w=8u  l=0.5u
Xmln din   inn   ltail vss nfet_03v3 w=8u  l=0.5u
Xmnp outn  outp  dip   vss nfet_03v3 w=6u  l=0.35u
Xmnn outp  outn  din   vss nfet_03v3 w=6u  l=0.35u
Xmpp outn  outp  vdd   vdd pfet_03v3 w=8u  l=0.35u
Xmpn outp  outn  vdd   vdd pfet_03v3 w=8u  l=0.35u
Xmrp outn  clk   vdd   vdd pfet_03v3 w=4u  l=0.35u
Xmrn outp  clk   vdd   vdd pfet_03v3 w=4u  l=0.35u
Xmrd dip   clk   vdd   vdd pfet_03v3 w=2u  l=0.35u
Xmre din   clk   vdd   vdd pfet_03v3 w=2u  l=0.35u
.ends sarlatch

* Minimum-ish isolation inverter. Deliberately small: it is the only
* thing the regeneration nodes drive, so its gate capacitance is added
* directly to the latch's own output nodes and shows up as regeneration
* time.
.subckt inv a y vdd vss
Xp y a vdd vdd pfet_03v3 w=2u   l=0.35u
Xn y a vss vss nfet_03v3 w=1u   l=0.35u
.ends inv

.subckt nor2 a b y vdd vss
Xp1 ps a vdd vdd pfet_03v3 w=8u l=0.35u
Xp2 y  b ps  vdd pfet_03v3 w=8u l=0.35u
Xn1 y  a vss vss nfet_03v3 w=4u l=0.35u
Xn2 y  b vss vss nfet_03v3 w=4u l=0.35u
.ends nor2

.subckt comparator vinp vinn clk ibias dout doutb vdd vss
Xpre preamp_in1 preamp_in2 ibias pop pon vdd vss preamp
Xlat pop pon clk outp outn vdd vss sarlatch
* THE ISOLATION INVERTERS ARE NOT OPTIONAL -- they fix a measured
* hysteresis defect. Both StrongARM outputs precharge HIGH, so the
* decision arrives as an active-low pulse on exactly one of them, and
* the obvious way to hold it is a NAND SR latch wired straight to
* outp/outn. That circuit was built first and MEASURED: after deciding
* one way it would not flip back until the input reached ~10 mV of the
* opposite polarity -- about 3 LSB of hysteresis, which in a SAR (where
* the same comparator makes ten successive decisions on a shrinking
* residue) is a code-dependent error, not an offset.
*
* The cause is that a NAND SR latch's HELD STATE loads the two
* regeneration nodes asymmetrically. Wired directly, the node driving
* the NAND whose output is LOW sees that output swing when it falls
* (Miller-multiplied C_gd, ~26 fF against a regeneration node of a few
* tens of fF), while its twin drives a NAND whose output is already
* HIGH and stays there. The latch is therefore biased toward keeping
* the answer it already holds.
*
* Interposing one small inverter per side removes the coupling: the
* inverters are identical, both of their inputs precharge to V_DD, and
* neither loading depends on what the SR latch is holding. The SR latch
* becomes NOR-type because the inverters make the decision pulses
* active-HIGH. dout goes HIGH when outn falls, i.e. when
* v(vinp) > v(vinn), exactly as before.
Xis outn sset vdd vss inv
Xir outp srst vdd vss inv
Xno1 srst doutb dout  vdd vss nor2
Xno2 sset dout  doutb vdd vss nor2
* Input pass-through (zero-volt sources) so a testbench can probe the
* current the comparator draws from each CDAC top plate directly.
Vpp preamp_in1 vinp dc 0
Vpn preamp_in2 vinn dc 0
.ends comparator
* --- COMPARATOR-NETLIST-END ---

* ------------------------------------------------------------------
* sar_ctrl.spice -- synchronous SAR control logic, rung-1 abstraction
*
* GENERATED by design/sar-logic/gen_sar_logic.py -- do not edit.
*
* Ideal XSPICE event-driven digital primitives (digital.cm: d_dff,
* d_and, d_or, d_inverter) plus adc_bridge/dac_bridge at the analog
* boundary. This is rung 1 of the fidelity ladder in DR-0010: it fixes
* the SEQUENCING and the SWITCH DECODE, and deliberately says nothing
* about gf180mcu gate delay (rung 3 / sim/sar-logic-cell-delay/ owns
* that).
*
* Conversion, M = 16 clocks (DR-0003), with DR-0014's TWO-PHASE
* BOTTOM-PLATE sample laid inside the same 4-clock sample window:
*   ph0..ph2   acquire  samp_tp and samp_bp both asserted: the top
*                       plate is held at Vcm by its own switch and
*                       every bottom plate tracks V_in through the
*                       cell's fourth leg
*   ph2->ph3   THE SAMPLING INSTANT -- samp_tp falls, the top-plate
*                       switch opens and the top node floats
*   ph3        the bottom plates stay on V_in one more clock
*   ph3->ph4   samp_bp falls a full bit cycle after the sampling
*                       instant: the bottom plates leave V_in for Vcm
*                       onto a node that is ALREADY isolated, which
*                       is the whole reason bottom-plate sampling is
*                       worth a fourth leg (DR-0014, README note [d])
*   ph4        trial 1  free MSB -- no array switching at all, the
*                       comparator decides the sign of the sampled
*                       residue (DR-0014 keeps DR-0011's free MSB)
*   ph5..ph13  trials 2..10, weights 256,128,...,1 engaged in turn
*   ph14       output register loads the 10 decisions
*   ph15       drdy asserted; array released back to Vcm
*
* Switch decode per weight w and side s -- FOUR one-hot legs per cell
* now, not three -- from the slice's own engage flag `eng`, the
* direction bit `dir` (= the decision of the PREVIOUS trial, which is
* also that trial's output bit) and the shared sample control `smp`:
*   in  = smp                      bottom plate on V_in (DR-0014)
*   rel = !eng & !smp              bottom plate parked at Vcm
*   p-side:  hi = eng &  dir       -> V_REF      lo = eng & !dir -> GND
*   n-side:  hi = eng & !dir       -> V_REF      lo = eng &  dir -> GND
*   n-side is additionally gated by `mode` (1 = differential): in
*   single-ended mode every n-side cell stays released to Vcm for the
*   whole conversion, per DR-0011 -- driving it too would double every
*   step and cost a bit of resolution. The `in` leg is NOT mode-gated:
*   both sides must acquire their own input pin, and DR-0011's mode
*   rule is about bit trials, not about the sample phase.
*   `eng` is zero for the whole sample window, so exactly one of the
*   four legs conducts at every instant -- the invariant
*   sim/sar-logic-functional/ measures directly as sw_conflict_*.
*
* Sign convention, RE-DERIVED FOR DR-0014 and the one place the
* superseded record's decode could not simply be carried forward.
* Sampling on the bottom plate INVERTS the residue with respect to the
* input: after the sample, top_p - top_n = -k*(V_inp - V_inn). The
* comparator is wired conventionally (cmp = 1 when top_p > top_n), so
* the controller inverts it ONCE at its own boundary --
*
*     dec = !cmp    = 1 when the sampled input is ABOVE the DAC's
*                     current estimate, i.e. 'add this weight'
*
* -- and `dir` therefore still holds the OUTPUT BIT of its position,
* exactly as under DR-0011, at the cost of the hi/lo assignment above
* being the mirror of DR-0011's. Inverting only one of the two would
* either diverge (right code polarity, wrong feedback direction) or
* emit the one's complement of the code (right feedback, wrong bits);
* both were checked against the closed loop before this form was
* chosen, and sim/sar-logic-functional/ falsifies either error on
* every one of the 1024 codes in both modes.
* ------------------------------------------------------------------

* --- ideal digital primitives -------------------------------------
.model sarl_dff d_dff(clk_delay=0.5n set_delay=0.5n
+ reset_delay=0.5n ic=0 rise_delay=0.5n fall_delay=0.5n)
.model sarl_dff1 d_dff(clk_delay=0.5n set_delay=0.5n
+ reset_delay=0.5n ic=1 rise_delay=0.5n fall_delay=0.5n)
.model sarl_and d_and(rise_delay=0.2n fall_delay=0.2n input_load=0)
.model sarl_or d_or(rise_delay=0.2n fall_delay=0.2n input_load=0)
.model sarl_inv d_inverter(rise_delay=0.2n fall_delay=0.2n
+ input_load=0)

* --- enabled bit register -----------------------------------------
* Captures `d` on the clock edge that ENDS the phase in which `en` is
* asserted, and holds otherwise. Written as an explicit D-mux rather
* than a gated clock: gating the clock with a phase signal that itself
* changes one gate delay after the clock edge creates a spurious
* rising edge on the gated clock, which is a real bug in a real
* implementation, not just in this model.
.subckt sar_bitreg clk d en q qb
a_inv en enb sarl_inv
a_sel [en d] dsel sarl_and
a_hold [enb q] dhold sarl_and
a_mux [dsel dhold] dnext sarl_or
a_ff dnext clk NULL NULL q qb sarl_dff
.ends sar_bitreg

* --- one bit slice: engage flag + direction bit + switch decode -----
* `arm`     one-hot phase pulse of the trial BEFORE this slice's own
*           trial: the slice engages on the edge entering its trial,
*           and the direction bit captures the decision made during
*           `arm` (which is also this bit position's output bit).
* `endconv` forces the engage flag low on the edge leaving the last
*           trial, releasing the whole array back to Vcm for the next
*           sample phase.
* `dec`     the comparator decision in OUTPUT-BIT polarity (= !cmp;
*           see the sign-convention note in the header).
* `smpb`    the inverse of the shared bottom-plate sample control,
*           distributed already-inverted so that all four legs of the
*           cell come out at the SAME logic depth. That is not
*           cosmetic: `rel` and the V_in leg are complementary during
*           the sample window, so a one-gate depth difference between
*           them opens a window in which a cell drives V_in and Vcm at
*           once -- which is exactly what the one-hot invariant is
*           there to catch, and it would catch this generator.
.subckt sar_slice clk dec mode arm endconv smpb dir dirb
+ rel_p hi_p lo_p rel_n hi_n lo_n
a_set [arm eng] eng_set sarl_or
a_ninv endconv nend sarl_inv
a_keep [eng_set nend] eng_d sarl_and
a_ff eng_d clk NULL NULL eng engb sarl_dff
xdir clk dec arm dir dirb sar_bitreg
* p side: always driven
a_relp [engb smpb] rel_p sarl_and
a_hip [eng dir] hi_p sarl_and
a_lop [eng dirb] lo_p sarl_and
* n side: driven only in differential mode (DR-0011). `engnb` is built
* as !eng | !mode rather than as an inverter on `engn`, so that it
* lands at the same depth as `engn` and rel_n/hi_n/lo_n switch
* together -- the same delay-balance argument as `smpb` above.
a_engn [eng mode] engn sarl_and
a_modeb mode modeb sarl_inv
a_engnb [engb modeb] engnb sarl_or
a_reln [engnb smpb] rel_n sarl_and
a_hin [engn dirb] hi_n sarl_and
a_lon [engn dir] lo_n sarl_and
.ends sar_slice

* --- 16-phase one-hot sequencer ------------------------------------
* A one-hot ring, seeded by ph15's ic=1 so the very first clock edge
* enters ph0 (sample) with exactly one token in the ring. `start`
* forces a synchronous restart: it sets stage 0 and clears every other
* stage on the same edge, so an asserted `start` cannot inject a
* SECOND token alongside the circulating one.
.subckt sar_seq clk start ph0 ph1 ph2 ph3 ph4 ph5 ph6 ph7 ph8 ph9 ph10 ph11 ph12 ph13 ph14 ph15
a_nstart start nstart sarl_inv
a_d0 [ph15 start] d0 sarl_or
a_ff0 d0 clk NULL NULL ph0 ph0b sarl_dff
a_d1 [ph0 nstart] d1 sarl_and
a_ff1 d1 clk NULL NULL ph1 ph1b sarl_dff
a_d2 [ph1 nstart] d2 sarl_and
a_ff2 d2 clk NULL NULL ph2 ph2b sarl_dff
a_d3 [ph2 nstart] d3 sarl_and
a_ff3 d3 clk NULL NULL ph3 ph3b sarl_dff
a_d4 [ph3 nstart] d4 sarl_and
a_ff4 d4 clk NULL NULL ph4 ph4b sarl_dff
a_d5 [ph4 nstart] d5 sarl_and
a_ff5 d5 clk NULL NULL ph5 ph5b sarl_dff
a_d6 [ph5 nstart] d6 sarl_and
a_ff6 d6 clk NULL NULL ph6 ph6b sarl_dff
a_d7 [ph6 nstart] d7 sarl_and
a_ff7 d7 clk NULL NULL ph7 ph7b sarl_dff
a_d8 [ph7 nstart] d8 sarl_and
a_ff8 d8 clk NULL NULL ph8 ph8b sarl_dff
a_d9 [ph8 nstart] d9 sarl_and
a_ff9 d9 clk NULL NULL ph9 ph9b sarl_dff
a_d10 [ph9 nstart] d10 sarl_and
a_ff10 d10 clk NULL NULL ph10 ph10b sarl_dff
a_d11 [ph10 nstart] d11 sarl_and
a_ff11 d11 clk NULL NULL ph11 ph11b sarl_dff
a_d12 [ph11 nstart] d12 sarl_and
a_ff12 d12 clk NULL NULL ph12 ph12b sarl_dff
a_d13 [ph12 nstart] d13 sarl_and
a_ff13 d13 clk NULL NULL ph13 ph13b sarl_dff
a_d14 [ph13 nstart] d14 sarl_and
a_ff14 d14 clk NULL NULL ph14 ph14b sarl_dff
a_d15 [ph14 nstart] d15 sarl_and
a_ff15 d15 clk NULL NULL ph15 ph15b sarl_dff1
.ends sar_seq

* --- digital top ----------------------------------------------------
.subckt sar_ctrl clk start mode cmp samp_tp samp_bp drdy b9 b8 b7 b6 b5 b4
+ b3 b2 b1 b0 rel_256p hi_256p lo_256p rel_128p hi_128p lo_128p rel_64p
+ hi_64p lo_64p rel_32p hi_32p lo_32p rel_16p hi_16p lo_16p rel_8p hi_8p
+ lo_8p rel_4p hi_4p lo_4p rel_2p hi_2p lo_2p rel_1p hi_1p lo_1p rel_256n
+ hi_256n lo_256n rel_128n hi_128n lo_128n rel_64n hi_64n lo_64n rel_32n
+ hi_32n lo_32n rel_16n hi_16n lo_16n rel_8n hi_8n lo_8n rel_4n hi_4n
+ lo_4n rel_2n hi_2n lo_2n rel_1n hi_1n lo_1n
xseq clk start ph0 ph1 ph2 ph3 ph4 ph5 ph6 ph7 ph8 ph9 ph10 ph11 ph12 ph13 ph14 ph15 sar_seq
* ---- DR-0014's two-phase sample ----------------------------------
* `samp_tp` closes the top-plate switch for ph0..ph2 and opens it on
* the edge into ph3: THAT edge is the sampling instant. `samp_bp`
* keeps every bottom plate on V_in for the whole 4-clock window, so
* the input legs turn off one full clock LATER, onto a top node that
* is already floating. Both are one-hot phase ORs off the same ring:
* one external clock, rising edges only (DR-0008), no gated or
* inverted clock anywhere in the sample path.
* `samp_bp` is emitted through smpb -> inverter rather than straight
* off the OR so that it lands at the SAME logic depth as each cell's
* `rel`, which is AND(engb, smpb). Those two legs are complementary
* across the sample boundary, so a one-gate depth difference would
* leave every cell driving V_in and V_cm together for 0.2 ns.
a_samp4 [ph0 ph1 ph2 ph3] samp4 sarl_or
a_samptp [ph0 ph1 ph2] samp_tp sarl_or
a_smpb samp4 smpb sarl_inv
a_sampbp smpb samp_bp sarl_inv
* The comparator decision, inverted once here into output-bit
* polarity: bottom-plate sampling inverts the residue with respect to
* the input (DR-0014). See the header's sign-convention note.
a_dec cmp dec sarl_inv
a_drdy ph15 drdy_n sarl_inv
a_drdy2 drdy_n drdy sarl_inv
xs256 clk dec mode ph4 ph13 smpb q9 q9b rel_256p hi_256p lo_256p rel_256n hi_256n lo_256n sar_slice
xs128 clk dec mode ph5 ph13 smpb q8 q8b rel_128p hi_128p lo_128p rel_128n hi_128n lo_128n sar_slice
xs64 clk dec mode ph6 ph13 smpb q7 q7b rel_64p hi_64p lo_64p rel_64n hi_64n lo_64n sar_slice
xs32 clk dec mode ph7 ph13 smpb q6 q6b rel_32p hi_32p lo_32p rel_32n hi_32n lo_32n sar_slice
xs16 clk dec mode ph8 ph13 smpb q5 q5b rel_16p hi_16p lo_16p rel_16n hi_16n lo_16n sar_slice
xs8 clk dec mode ph9 ph13 smpb q4 q4b rel_8p hi_8p lo_8p rel_8n hi_8n lo_8n sar_slice
xs4 clk dec mode ph10 ph13 smpb q3 q3b rel_4p hi_4p lo_4p rel_4n hi_4n lo_4n sar_slice
xs2 clk dec mode ph11 ph13 smpb q2 q2b rel_2p hi_2p lo_2p rel_2n hi_2n lo_2n sar_slice
xs1 clk dec mode ph12 ph13 smpb q1 q1b rel_1p hi_1p lo_1p rel_1n hi_1n lo_1n sar_slice
xb0 clk dec ph13 q0 q0b sar_bitreg
* 10-bit parallel output register (DR-0005: in scope, SPI deferred)
xo9 clk q9 ph14 b9 b9b sar_bitreg
xo8 clk q8 ph14 b8 b8b sar_bitreg
xo7 clk q7 ph14 b7 b7b sar_bitreg
xo6 clk q6 ph14 b6 b6b sar_bitreg
xo5 clk q5 ph14 b5 b5b sar_bitreg
xo4 clk q4 ph14 b4 b4b sar_bitreg
xo3 clk q3 ph14 b3 b3b sar_bitreg
xo2 clk q2 ph14 b2 b2b sar_bitreg
xo1 clk q1 ph14 b1 b1b sar_bitreg
xo0 clk q0 ph14 b0 b0b sar_bitreg
.ends sar_ctrl

* --- analog-boundary wrapper ----------------------------------------
* Presents the controller at the analog boundary with the port names
* design/cdac/cdac_array.sch uses, so the two connect directly. Only
* the NMOS-gate (active-high) half of each T-gate leg is routed out of
* the controller; `sar_tgate_drv` below makes the PMOS gate locally at
* the cell. Bridges are VECTOR instances on purpose: 54 scalar
* dac_bridges would put 54 separate sources in the analog matrix.
* DR-0014's two additions ride on the SCALAR bridge group with drdy
* and the code bits, not on the 54-wide array bus: `sel_in_n` is one
* broadcast net feeding every cell's fourth leg and `samp_tp_n` is the
* per-side top-plate switch, so the array control bus grows from 54 to
* 55 wires, not to 72.
.subckt sar_ctrl_a clk start mode cmp samp_tp_n sel_in_n drdy c9 c8 c7 c6
+ c5 c4 c3 c2 c1 c0 rel_n_256p sel_hi_n_256p sel_lo_n_256p rel_n_128p
+ sel_hi_n_128p sel_lo_n_128p rel_n_64p sel_hi_n_64p sel_lo_n_64p
+ rel_n_32p sel_hi_n_32p sel_lo_n_32p rel_n_16p sel_hi_n_16p sel_lo_n_16p
+ rel_n_8p sel_hi_n_8p sel_lo_n_8p rel_n_4p sel_hi_n_4p sel_lo_n_4p
+ rel_n_2p sel_hi_n_2p sel_lo_n_2p rel_n_1p sel_hi_n_1p sel_lo_n_1p
+ rel_n_256n sel_hi_n_256n sel_lo_n_256n rel_n_128n sel_hi_n_128n
+ sel_lo_n_128n rel_n_64n sel_hi_n_64n sel_lo_n_64n rel_n_32n sel_hi_n_32n
+ sel_lo_n_32n rel_n_16n sel_hi_n_16n sel_lo_n_16n rel_n_8n sel_hi_n_8n
+ sel_lo_n_8n rel_n_4n sel_hi_n_4n sel_lo_n_4n rel_n_2n sel_hi_n_2n
+ sel_lo_n_2n rel_n_1n sel_hi_n_1n sel_lo_n_1n
a_in [clk start mode cmp] [dclk dstart dmode dcmp] sarl_adc
xctrl dclk dstart dmode dcmp dsamp_tp dsamp_bp ddrdy db9 db8 db7 db6 db5
+ db4 db3 db2 db1 db0 drel_256p dhi_256p dlo_256p drel_128p dhi_128p
+ dlo_128p drel_64p dhi_64p dlo_64p drel_32p dhi_32p dlo_32p drel_16p
+ dhi_16p dlo_16p drel_8p dhi_8p dlo_8p drel_4p dhi_4p dlo_4p drel_2p
+ dhi_2p dlo_2p drel_1p dhi_1p dlo_1p drel_256n dhi_256n dlo_256n
+ drel_128n dhi_128n dlo_128n drel_64n dhi_64n dlo_64n drel_32n dhi_32n
+ dlo_32n drel_16n dhi_16n dlo_16n drel_8n dhi_8n dlo_8n drel_4n dhi_4n
+ dlo_4n drel_2n dhi_2n dlo_2n drel_1n dhi_1n dlo_1n sar_ctrl
a_dout [dsamp_tp dsamp_bp ddrdy db9 db8 db7 db6 db5 db4 db3 db2 db1 db0]
+ [samp_tp_n sel_in_n drdy c9 c8 c7 c6 c5 c4 c3 c2 c1 c0] sarl_dac
a_gn [drel_256p dhi_256p dlo_256p drel_128p dhi_128p dlo_128p drel_64p dhi_64p dlo_64p drel_32p dhi_32p dlo_32p drel_16p dhi_16p dlo_16p drel_8p dhi_8p dlo_8p drel_4p dhi_4p dlo_4p drel_2p dhi_2p dlo_2p drel_1p dhi_1p dlo_1p drel_256n dhi_256n dlo_256n drel_128n dhi_128n dlo_128n drel_64n dhi_64n dlo_64n drel_32n dhi_32n dlo_32n drel_16n dhi_16n dlo_16n drel_8n dhi_8n dlo_8n drel_4n dhi_4n dlo_4n drel_2n dhi_2n dlo_2n drel_1n dhi_1n dlo_1n]
+ [rel_n_256p sel_hi_n_256p sel_lo_n_256p rel_n_128p sel_hi_n_128p sel_lo_n_128p rel_n_64p sel_hi_n_64p sel_lo_n_64p rel_n_32p sel_hi_n_32p sel_lo_n_32p rel_n_16p sel_hi_n_16p sel_lo_n_16p rel_n_8p sel_hi_n_8p sel_lo_n_8p rel_n_4p sel_hi_n_4p sel_lo_n_4p rel_n_2p sel_hi_n_2p sel_lo_n_2p rel_n_1p sel_hi_n_1p sel_lo_n_1p rel_n_256n sel_hi_n_256n sel_lo_n_256n rel_n_128n sel_hi_n_128n sel_lo_n_128n rel_n_64n sel_hi_n_64n sel_lo_n_64n rel_n_32n sel_hi_n_32n sel_lo_n_32n rel_n_16n sel_hi_n_16n sel_lo_n_16n rel_n_8n sel_hi_n_8n sel_lo_n_8n rel_n_4n sel_hi_n_4n sel_lo_n_4n rel_n_2n sel_hi_n_2n sel_lo_n_2n rel_n_1n sel_hi_n_1n sel_lo_n_1n] sarl_dac
.ends sar_ctrl_a

* --- local T-gate driver -------------------------------------------
* One per T-gate leg, placed with the CDAC cell (#15/#16), not with
* the controller: `gn` is the controller's active-high control and
* `gp` the complementary PMOS gate. Modelled as an ideal inverter at
* rung 1; at rung 3 it is one standard-cell inverter.
.subckt sar_tgate_drv gn gp
a_adc gn dgn sarl_adc
a_inv dgn dgp sarl_inv
a_dac dgp gp sarl_dac
.ends sar_tgate_drv

* Bridge models. Thresholds and rails track the PVT point's supply, so
* the supply axis of the corner grid actually moves something in this
* otherwise PVT-invariant model.
.model sarl_adc adc_bridge(in_low={vdd_val*0.4} in_high={vdd_val*0.6})
.model sarl_dac dac_bridge(out_low=0 out_high={vdd_val}
+ out_undef={vdd_val/2} t_rise=0.3n t_fall=0.3n)

* REMEDIATED extracted core -- NOT raw `klt extract` output.
* Produced by layout/adc-top/parasitics/remediate_extracted.py:
*   - 148 PMOS body terminals retied to 'vdd'
*     (local remediation of the klt PMOS-body gap; upstream klayout-tools#555).
*   - input rails pinp/pinn promoted to pins vinp/vinn (sampled-input port gap).
*   - 1024 MiM caps left as native PDK 'cap_mim_2f0_m4m5_noshield' subckt calls.
* See remediate_extracted.py's module docstring for provenance.
* cell ADC_TOP
* pin hi_128_n
* pin hi_128_p
* pin hi_16_n
* pin hi_16_p
* pin hi_1_n
* pin hi_1_p
* pin hi_256_n
* pin hi_256_p
* pin hi_2_n
* pin hi_2_p
* pin hi_32_n
* pin hi_32_p
* pin hi_4_n
* pin hi_4_p
* pin hi_64_n
* pin hi_64_p
* pin hi_8_n
* pin hi_8_p
* pin lo_128_n
* pin lo_128_p
* pin lo_16_n
* pin lo_16_p
* pin lo_1_n
* pin lo_1_p
* pin lo_256_n
* pin lo_256_p
* pin lo_2_n
* pin lo_2_p
* pin lo_32_n
* pin lo_32_p
* pin lo_4_n
* pin lo_4_p
* pin lo_64_n
* pin lo_64_p
* pin lo_8_n
* pin lo_8_p
* pin pinn
* pin pinp
* pin rel_128_n
* pin rel_128_p
* pin rel_16_n
* pin rel_16_p
* pin rel_1_n
* pin rel_1_p
* pin rel_256_n
* pin rel_256_p
* pin rel_2_n
* pin rel_2_p
* pin rel_32_n
* pin rel_32_p
* pin rel_4_n
* pin rel_4_p
* pin rel_64_n
* pin rel_64_p
* pin rel_8_n
* pin rel_8_p
* pin sel_in
* pin topn
* pin topp
* pin tp_gn
* pin vcm
* pin vdd
* pin vref
* pin vss
* pin vsubs
.SUBCKT ADC_TOP hi_128_n hi_128_p hi_16_n hi_16_p hi_1_n hi_1_p hi_256_n hi_256_p hi_2_n hi_2_p hi_32_n hi_32_p hi_4_n hi_4_p hi_64_n hi_64_p hi_8_n hi_8_p lo_128_n lo_128_p lo_16_n lo_16_p lo_1_n lo_1_p lo_256_n lo_256_p lo_2_n lo_2_p lo_32_n lo_32_p lo_4_n lo_4_p lo_64_n lo_64_p lo_8_n lo_8_p rel_128_n rel_128_p rel_16_n rel_16_p rel_1_n rel_1_p rel_256_n rel_256_p rel_2_n rel_2_p rel_32_n rel_32_p rel_4_n rel_4_p rel_64_n rel_64_p rel_8_n rel_8_p sel_in topn topp tp_gn vcm vdd vref vss vsubs vinp vinn
* device instance $1 r0 *1 1.275,2 nfet
X$1 \$65 sel_in vss vsubs nfet_03v3 L=0.35U W=4U
* device instance $2 r0 *1 4.225,2 nfet
X$2 \$27 rel_256_p vss vsubs nfet_03v3 L=0.35U W=4U
* device instance $3 r0 *1 7.175,2 nfet
X$3 \$29 hi_256_p vss vsubs nfet_03v3 L=0.35U W=4U
* device instance $4 r0 *1 10.125,2 nfet
X$4 \$9 lo_256_p vss vsubs nfet_03v3 L=0.35U W=4U
* device instance $5 r0 *1 13.04,5 nfet
X$5 vinp sel_in \$10 vsubs nfet_03v3 L=0.28U W=10U
* device instance $6 r0 *1 15.92,5 nfet
X$6 vcm rel_256_p \$10 vsubs nfet_03v3 L=0.28U W=10U
* device instance $7 r0 *1 18.8,5 nfet
X$7 vref hi_256_p \$10 vsubs nfet_03v3 L=0.28U W=10U
* device instance $8 r0 *1 21.68,5 nfet
X$8 vss lo_256_p \$10 vsubs nfet_03v3 L=0.28U W=10U
* device instance $9 r0 *1 49.715,2 nfet
X$9 \$67 sel_in vss vsubs nfet_03v3 L=0.35U W=4U
* device instance $10 r0 *1 52.665,2 nfet
X$10 \$31 rel_128_p vss vsubs nfet_03v3 L=0.35U W=4U
* device instance $11 r0 *1 55.615,2 nfet
X$11 \$33 hi_128_p vss vsubs nfet_03v3 L=0.35U W=4U
* device instance $12 r0 *1 58.565,2 nfet
X$12 \$11 lo_128_p vss vsubs nfet_03v3 L=0.35U W=4U
* device instance $13 r0 *1 61.48,5 nfet
X$13 vinp sel_in \$12 vsubs nfet_03v3 L=0.28U W=10U
* device instance $14 r0 *1 64.36,5 nfet
X$14 vcm rel_128_p \$12 vsubs nfet_03v3 L=0.28U W=10U
* device instance $15 r0 *1 67.24,5 nfet
X$15 vref hi_128_p \$12 vsubs nfet_03v3 L=0.28U W=10U
* device instance $16 r0 *1 70.12,5 nfet
X$16 vss lo_128_p \$12 vsubs nfet_03v3 L=0.28U W=10U
* device instance $17 r0 *1 98.155,2 nfet
X$17 \$69 sel_in vss vsubs nfet_03v3 L=0.35U W=4U
* device instance $18 r0 *1 101.105,2 nfet
X$18 \$35 rel_64_p vss vsubs nfet_03v3 L=0.35U W=4U
* device instance $19 r0 *1 104.055,2 nfet
X$19 \$37 hi_64_p vss vsubs nfet_03v3 L=0.35U W=4U
* device instance $20 r0 *1 107.005,2 nfet
X$20 \$13 lo_64_p vss vsubs nfet_03v3 L=0.35U W=4U
* device instance $21 r0 *1 109.92,5 nfet
X$21 vinp sel_in \$14 vsubs nfet_03v3 L=0.28U W=10U
* device instance $22 r0 *1 112.8,5 nfet
X$22 vcm rel_64_p \$14 vsubs nfet_03v3 L=0.28U W=10U
* device instance $23 r0 *1 115.68,5 nfet
X$23 vref hi_64_p \$14 vsubs nfet_03v3 L=0.28U W=10U
* device instance $24 r0 *1 118.56,5 nfet
X$24 vss lo_64_p \$14 vsubs nfet_03v3 L=0.28U W=10U
* device instance $25 r0 *1 146.595,2 nfet
X$25 \$71 sel_in vss vsubs nfet_03v3 L=0.35U W=4U
* device instance $26 r0 *1 149.545,2 nfet
X$26 \$39 rel_32_p vss vsubs nfet_03v3 L=0.35U W=4U
* device instance $27 r0 *1 152.495,2 nfet
X$27 \$41 hi_32_p vss vsubs nfet_03v3 L=0.35U W=4U
* device instance $28 r0 *1 155.445,2 nfet
X$28 \$15 lo_32_p vss vsubs nfet_03v3 L=0.35U W=4U
* device instance $29 r0 *1 158.36,5 nfet
X$29 vinp sel_in \$16 vsubs nfet_03v3 L=0.28U W=10U
* device instance $30 r0 *1 161.24,5 nfet
X$30 vcm rel_32_p \$16 vsubs nfet_03v3 L=0.28U W=10U
* device instance $31 r0 *1 164.12,5 nfet
X$31 vref hi_32_p \$16 vsubs nfet_03v3 L=0.28U W=10U
* device instance $32 r0 *1 167,5 nfet
X$32 vss lo_32_p \$16 vsubs nfet_03v3 L=0.28U W=10U
* device instance $33 r0 *1 195.035,2 nfet
X$33 \$73 sel_in vss vsubs nfet_03v3 L=0.35U W=4U
* device instance $34 r0 *1 197.985,2 nfet
X$34 \$43 rel_16_p vss vsubs nfet_03v3 L=0.35U W=4U
* device instance $35 r0 *1 200.935,2 nfet
X$35 \$45 hi_16_p vss vsubs nfet_03v3 L=0.35U W=4U
* device instance $36 r0 *1 203.885,2 nfet
X$36 \$17 lo_16_p vss vsubs nfet_03v3 L=0.35U W=4U
* device instance $37 r0 *1 206.8,5 nfet
X$37 vinp sel_in \$18 vsubs nfet_03v3 L=0.28U W=10U
* device instance $38 r0 *1 209.68,5 nfet
X$38 vcm rel_16_p \$18 vsubs nfet_03v3 L=0.28U W=10U
* device instance $39 r0 *1 212.56,5 nfet
X$39 vref hi_16_p \$18 vsubs nfet_03v3 L=0.28U W=10U
* device instance $40 r0 *1 215.44,5 nfet
X$40 vss lo_16_p \$18 vsubs nfet_03v3 L=0.28U W=10U
* device instance $41 r0 *1 243.475,2 nfet
X$41 \$75 sel_in vss vsubs nfet_03v3 L=0.35U W=4U
* device instance $42 r0 *1 246.425,2 nfet
X$42 \$47 rel_8_p vss vsubs nfet_03v3 L=0.35U W=4U
* device instance $43 r0 *1 249.375,2 nfet
X$43 \$49 hi_8_p vss vsubs nfet_03v3 L=0.35U W=4U
* device instance $44 r0 *1 252.325,2 nfet
X$44 \$19 lo_8_p vss vsubs nfet_03v3 L=0.35U W=4U
* device instance $45 r0 *1 255.24,5 nfet
X$45 vinp sel_in \$20 vsubs nfet_03v3 L=0.28U W=10U
* device instance $46 r0 *1 258.12,5 nfet
X$46 vcm rel_8_p \$20 vsubs nfet_03v3 L=0.28U W=10U
* device instance $47 r0 *1 261,5 nfet
X$47 vref hi_8_p \$20 vsubs nfet_03v3 L=0.28U W=10U
* device instance $48 r0 *1 263.88,5 nfet
X$48 vss lo_8_p \$20 vsubs nfet_03v3 L=0.28U W=10U
* device instance $49 r0 *1 291.915,2 nfet
X$49 \$77 sel_in vss vsubs nfet_03v3 L=0.35U W=4U
* device instance $50 r0 *1 294.865,2 nfet
X$50 \$51 rel_4_p vss vsubs nfet_03v3 L=0.35U W=4U
* device instance $51 r0 *1 297.815,2 nfet
X$51 \$53 hi_4_p vss vsubs nfet_03v3 L=0.35U W=4U
* device instance $52 r0 *1 300.765,2 nfet
X$52 \$21 lo_4_p vss vsubs nfet_03v3 L=0.35U W=4U
* device instance $53 r0 *1 303.68,5 nfet
X$53 vinp sel_in \$22 vsubs nfet_03v3 L=0.28U W=10U
* device instance $54 r0 *1 306.56,5 nfet
X$54 vcm rel_4_p \$22 vsubs nfet_03v3 L=0.28U W=10U
* device instance $55 r0 *1 309.44,5 nfet
X$55 vref hi_4_p \$22 vsubs nfet_03v3 L=0.28U W=10U
* device instance $56 r0 *1 312.32,5 nfet
X$56 vss lo_4_p \$22 vsubs nfet_03v3 L=0.28U W=10U
* device instance $57 r0 *1 340.355,2 nfet
X$57 \$79 sel_in vss vsubs nfet_03v3 L=0.35U W=4U
* device instance $58 r0 *1 343.305,2 nfet
X$58 \$55 rel_2_p vss vsubs nfet_03v3 L=0.35U W=4U
* device instance $59 r0 *1 346.255,2 nfet
X$59 \$57 hi_2_p vss vsubs nfet_03v3 L=0.35U W=4U
* device instance $60 r0 *1 349.205,2 nfet
X$60 \$23 lo_2_p vss vsubs nfet_03v3 L=0.35U W=4U
* device instance $61 r0 *1 352.12,5 nfet
X$61 vinp sel_in \$24 vsubs nfet_03v3 L=0.28U W=10U
* device instance $62 r0 *1 355,5 nfet
X$62 vcm rel_2_p \$24 vsubs nfet_03v3 L=0.28U W=10U
* device instance $63 r0 *1 357.88,5 nfet
X$63 vref hi_2_p \$24 vsubs nfet_03v3 L=0.28U W=10U
* device instance $64 r0 *1 360.76,5 nfet
X$64 vss lo_2_p \$24 vsubs nfet_03v3 L=0.28U W=10U
* device instance $65 r0 *1 388.795,2 nfet
X$65 \$81 sel_in vss vsubs nfet_03v3 L=0.35U W=4U
* device instance $66 r0 *1 391.745,2 nfet
X$66 \$59 rel_1_p vss vsubs nfet_03v3 L=0.35U W=4U
* device instance $67 r0 *1 394.695,2 nfet
X$67 \$61 hi_1_p vss vsubs nfet_03v3 L=0.35U W=4U
* device instance $68 r0 *1 397.645,2 nfet
X$68 \$25 lo_1_p vss vsubs nfet_03v3 L=0.35U W=4U
* device instance $69 r0 *1 400.56,5 nfet
X$69 vinp sel_in \$26 vsubs nfet_03v3 L=0.28U W=10U
* device instance $70 r0 *1 403.44,5 nfet
X$70 vcm rel_1_p \$26 vsubs nfet_03v3 L=0.28U W=10U
* device instance $71 r0 *1 406.32,5 nfet
X$71 vref hi_1_p \$26 vsubs nfet_03v3 L=0.28U W=10U
* device instance $72 r0 *1 409.2,5 nfet
X$72 vss lo_1_p \$26 vsubs nfet_03v3 L=0.28U W=10U
* device instance $73 r0 *1 1.275,35.15 nfet
X$73 \$83 sel_in vss vsubs nfet_03v3 L=0.35U W=4U
* device instance $74 r0 *1 4.225,35.15 nfet
X$74 \$85 rel_256_n vss vsubs nfet_03v3 L=0.35U W=4U
* device instance $75 r0 *1 7.175,35.15 nfet
X$75 \$87 hi_256_n vss vsubs nfet_03v3 L=0.35U W=4U
* device instance $76 r0 *1 10.125,35.15 nfet
X$76 \$89 lo_256_n vss vsubs nfet_03v3 L=0.35U W=4U
* device instance $77 r0 *1 13.04,38.15 nfet
X$77 vinn sel_in \$90 vsubs nfet_03v3 L=0.28U W=10U
* device instance $78 r0 *1 15.92,38.15 nfet
X$78 vcm rel_256_n \$90 vsubs nfet_03v3 L=0.28U W=10U
* device instance $79 r0 *1 18.8,38.15 nfet
X$79 vref hi_256_n \$90 vsubs nfet_03v3 L=0.28U W=10U
* device instance $80 r0 *1 21.68,38.15 nfet
X$80 vss lo_256_n \$90 vsubs nfet_03v3 L=0.28U W=10U
* device instance $81 r0 *1 49.715,35.15 nfet
X$81 \$92 sel_in vss vsubs nfet_03v3 L=0.35U W=4U
* device instance $82 r0 *1 52.665,35.15 nfet
X$82 \$94 rel_128_n vss vsubs nfet_03v3 L=0.35U W=4U
* device instance $83 r0 *1 55.615,35.15 nfet
X$83 \$96 hi_128_n vss vsubs nfet_03v3 L=0.35U W=4U
* device instance $84 r0 *1 58.565,35.15 nfet
X$84 \$98 lo_128_n vss vsubs nfet_03v3 L=0.35U W=4U
* device instance $85 r0 *1 61.48,38.15 nfet
X$85 vinn sel_in \$99 vsubs nfet_03v3 L=0.28U W=10U
* device instance $86 r0 *1 64.36,38.15 nfet
X$86 vcm rel_128_n \$99 vsubs nfet_03v3 L=0.28U W=10U
* device instance $87 r0 *1 67.24,38.15 nfet
X$87 vref hi_128_n \$99 vsubs nfet_03v3 L=0.28U W=10U
* device instance $88 r0 *1 70.12,38.15 nfet
X$88 vss lo_128_n \$99 vsubs nfet_03v3 L=0.28U W=10U
* device instance $89 r0 *1 98.155,35.15 nfet
X$89 \$100 sel_in vss vsubs nfet_03v3 L=0.35U W=4U
* device instance $90 r0 *1 101.105,35.15 nfet
X$90 \$102 rel_64_n vss vsubs nfet_03v3 L=0.35U W=4U
* device instance $91 r0 *1 104.055,35.15 nfet
X$91 \$104 hi_64_n vss vsubs nfet_03v3 L=0.35U W=4U
* device instance $92 r0 *1 107.005,35.15 nfet
X$92 \$106 lo_64_n vss vsubs nfet_03v3 L=0.35U W=4U
* device instance $93 r0 *1 109.92,38.15 nfet
X$93 vinn sel_in \$107 vsubs nfet_03v3 L=0.28U W=10U
* device instance $94 r0 *1 112.8,38.15 nfet
X$94 vcm rel_64_n \$107 vsubs nfet_03v3 L=0.28U W=10U
* device instance $95 r0 *1 115.68,38.15 nfet
X$95 vref hi_64_n \$107 vsubs nfet_03v3 L=0.28U W=10U
* device instance $96 r0 *1 118.56,38.15 nfet
X$96 vss lo_64_n \$107 vsubs nfet_03v3 L=0.28U W=10U
* device instance $97 r0 *1 146.595,35.15 nfet
X$97 \$108 sel_in vss vsubs nfet_03v3 L=0.35U W=4U
* device instance $98 r0 *1 149.545,35.15 nfet
X$98 \$110 rel_32_n vss vsubs nfet_03v3 L=0.35U W=4U
* device instance $99 r0 *1 152.495,35.15 nfet
X$99 \$112 hi_32_n vss vsubs nfet_03v3 L=0.35U W=4U
* device instance $100 r0 *1 155.445,35.15 nfet
X$100 \$114 lo_32_n vss vsubs nfet_03v3 L=0.35U W=4U
* device instance $101 r0 *1 158.36,38.15 nfet
X$101 vinn sel_in \$115 vsubs nfet_03v3 L=0.28U W=10U
* device instance $102 r0 *1 161.24,38.15 nfet
X$102 vcm rel_32_n \$115 vsubs nfet_03v3 L=0.28U W=10U
* device instance $103 r0 *1 164.12,38.15 nfet
X$103 vref hi_32_n \$115 vsubs nfet_03v3 L=0.28U W=10U
* device instance $104 r0 *1 167,38.15 nfet
X$104 vss lo_32_n \$115 vsubs nfet_03v3 L=0.28U W=10U
* device instance $105 r0 *1 195.035,35.15 nfet
X$105 \$116 sel_in vss vsubs nfet_03v3 L=0.35U W=4U
* device instance $106 r0 *1 197.985,35.15 nfet
X$106 \$118 rel_16_n vss vsubs nfet_03v3 L=0.35U W=4U
* device instance $107 r0 *1 200.935,35.15 nfet
X$107 \$120 hi_16_n vss vsubs nfet_03v3 L=0.35U W=4U
* device instance $108 r0 *1 203.885,35.15 nfet
X$108 \$122 lo_16_n vss vsubs nfet_03v3 L=0.35U W=4U
* device instance $109 r0 *1 206.8,38.15 nfet
X$109 vinn sel_in \$123 vsubs nfet_03v3 L=0.28U W=10U
* device instance $110 r0 *1 209.68,38.15 nfet
X$110 vcm rel_16_n \$123 vsubs nfet_03v3 L=0.28U W=10U
* device instance $111 r0 *1 212.56,38.15 nfet
X$111 vref hi_16_n \$123 vsubs nfet_03v3 L=0.28U W=10U
* device instance $112 r0 *1 215.44,38.15 nfet
X$112 vss lo_16_n \$123 vsubs nfet_03v3 L=0.28U W=10U
* device instance $113 r0 *1 243.475,35.15 nfet
X$113 \$124 sel_in vss vsubs nfet_03v3 L=0.35U W=4U
* device instance $114 r0 *1 246.425,35.15 nfet
X$114 \$126 rel_8_n vss vsubs nfet_03v3 L=0.35U W=4U
* device instance $115 r0 *1 249.375,35.15 nfet
X$115 \$128 hi_8_n vss vsubs nfet_03v3 L=0.35U W=4U
* device instance $116 r0 *1 252.325,35.15 nfet
X$116 \$130 lo_8_n vss vsubs nfet_03v3 L=0.35U W=4U
* device instance $117 r0 *1 255.24,38.15 nfet
X$117 vinn sel_in \$131 vsubs nfet_03v3 L=0.28U W=10U
* device instance $118 r0 *1 258.12,38.15 nfet
X$118 vcm rel_8_n \$131 vsubs nfet_03v3 L=0.28U W=10U
* device instance $119 r0 *1 261,38.15 nfet
X$119 vref hi_8_n \$131 vsubs nfet_03v3 L=0.28U W=10U
* device instance $120 r0 *1 263.88,38.15 nfet
X$120 vss lo_8_n \$131 vsubs nfet_03v3 L=0.28U W=10U
* device instance $121 r0 *1 291.915,35.15 nfet
X$121 \$132 sel_in vss vsubs nfet_03v3 L=0.35U W=4U
* device instance $122 r0 *1 294.865,35.15 nfet
X$122 \$134 rel_4_n vss vsubs nfet_03v3 L=0.35U W=4U
* device instance $123 r0 *1 297.815,35.15 nfet
X$123 \$136 hi_4_n vss vsubs nfet_03v3 L=0.35U W=4U
* device instance $124 r0 *1 300.765,35.15 nfet
X$124 \$138 lo_4_n vss vsubs nfet_03v3 L=0.35U W=4U
* device instance $125 r0 *1 303.68,38.15 nfet
X$125 vinn sel_in \$139 vsubs nfet_03v3 L=0.28U W=10U
* device instance $126 r0 *1 306.56,38.15 nfet
X$126 vcm rel_4_n \$139 vsubs nfet_03v3 L=0.28U W=10U
* device instance $127 r0 *1 309.44,38.15 nfet
X$127 vref hi_4_n \$139 vsubs nfet_03v3 L=0.28U W=10U
* device instance $128 r0 *1 312.32,38.15 nfet
X$128 vss lo_4_n \$139 vsubs nfet_03v3 L=0.28U W=10U
* device instance $129 r0 *1 340.355,35.15 nfet
X$129 \$140 sel_in vss vsubs nfet_03v3 L=0.35U W=4U
* device instance $130 r0 *1 343.305,35.15 nfet
X$130 \$142 rel_2_n vss vsubs nfet_03v3 L=0.35U W=4U
* device instance $131 r0 *1 346.255,35.15 nfet
X$131 \$144 hi_2_n vss vsubs nfet_03v3 L=0.35U W=4U
* device instance $132 r0 *1 349.205,35.15 nfet
X$132 \$146 lo_2_n vss vsubs nfet_03v3 L=0.35U W=4U
* device instance $133 r0 *1 352.12,38.15 nfet
X$133 vinn sel_in \$147 vsubs nfet_03v3 L=0.28U W=10U
* device instance $134 r0 *1 355,38.15 nfet
X$134 vcm rel_2_n \$147 vsubs nfet_03v3 L=0.28U W=10U
* device instance $135 r0 *1 356.627,68.3 nfet
X$135 \$166 tp_gn vss vsubs nfet_03v3 L=0.35U W=4U
* device instance $136 r0 *1 357.88,38.15 nfet
X$136 vref hi_2_n \$147 vsubs nfet_03v3 L=0.28U W=10U
* device instance $137 r0 *1 359.542,71.3 nfet
X$137 vcm tp_gn topp vsubs nfet_03v3 L=0.28U W=10U
* device instance $138 r0 *1 360.76,38.15 nfet
X$138 vss lo_2_n \$147 vsubs nfet_03v3 L=0.28U W=10U
* device instance $139 r0 *1 370.087,68.3 nfet
X$139 \$167 tp_gn vss vsubs nfet_03v3 L=0.35U W=4U
* device instance $140 r0 *1 373.002,71.3 nfet
X$140 vcm tp_gn topn vsubs nfet_03v3 L=0.28U W=10U
* device instance $141 r0 *1 388.795,35.15 nfet
X$141 \$148 sel_in vss vsubs nfet_03v3 L=0.35U W=4U
* device instance $142 r0 *1 391.745,35.15 nfet
X$142 \$150 rel_1_n vss vsubs nfet_03v3 L=0.35U W=4U
* device instance $143 r0 *1 394.695,35.15 nfet
X$143 \$152 hi_1_n vss vsubs nfet_03v3 L=0.35U W=4U
* device instance $144 r0 *1 397.645,35.15 nfet
X$144 \$154 lo_1_n vss vsubs nfet_03v3 L=0.35U W=4U
* device instance $145 r0 *1 400.56,38.15 nfet
X$145 vinn sel_in \$155 vsubs nfet_03v3 L=0.28U W=10U
* device instance $146 r0 *1 403.44,38.15 nfet
X$146 vcm rel_1_n \$155 vsubs nfet_03v3 L=0.28U W=10U
* device instance $147 r0 *1 406.32,38.15 nfet
X$147 vref hi_1_n \$155 vsubs nfet_03v3 L=0.28U W=10U
* device instance $148 r0 *1 409.2,38.15 nfet
X$148 vss lo_1_n \$155 vsubs nfet_03v3 L=0.28U W=10U
* device instance $149 r0 *1 25.495,4 pfet
X$149 \$65 sel_in vdd vdd pfet_03v3 L=0.35U W=8U
* device instance $150 r0 *1 28.445,4 pfet
X$150 \$27 rel_256_p vdd vdd pfet_03v3 L=0.35U W=8U
* device instance $151 r0 *1 31.395,4 pfet
X$151 \$29 hi_256_p vdd vdd pfet_03v3 L=0.35U W=8U
* device instance $152 r0 *1 34.345,4 pfet
X$152 \$9 lo_256_p vdd vdd pfet_03v3 L=0.35U W=8U
* device instance $153 r0 *1 37.26,10 pfet
X$153 vinp \$65 \$10 vdd pfet_03v3 L=0.28U W=20U
* device instance $154 r0 *1 40.14,10 pfet
X$154 vcm \$27 \$10 vdd pfet_03v3 L=0.28U W=20U
* device instance $155 r0 *1 43.02,10 pfet
X$155 vref \$29 \$10 vdd pfet_03v3 L=0.28U W=20U
* device instance $156 r0 *1 45.9,10 pfet
X$156 vss \$9 \$10 vdd pfet_03v3 L=0.28U W=20U
* device instance $157 r0 *1 73.935,4 pfet
X$157 \$67 sel_in vdd vdd pfet_03v3 L=0.35U W=8U
* device instance $158 r0 *1 76.885,4 pfet
X$158 \$31 rel_128_p vdd vdd pfet_03v3 L=0.35U W=8U
* device instance $159 r0 *1 79.835,4 pfet
X$159 \$33 hi_128_p vdd vdd pfet_03v3 L=0.35U W=8U
* device instance $160 r0 *1 82.785,4 pfet
X$160 \$11 lo_128_p vdd vdd pfet_03v3 L=0.35U W=8U
* device instance $161 r0 *1 85.7,10 pfet
X$161 vinp \$67 \$12 vdd pfet_03v3 L=0.28U W=20U
* device instance $162 r0 *1 88.58,10 pfet
X$162 vcm \$31 \$12 vdd pfet_03v3 L=0.28U W=20U
* device instance $163 r0 *1 91.46,10 pfet
X$163 vref \$33 \$12 vdd pfet_03v3 L=0.28U W=20U
* device instance $164 r0 *1 94.34,10 pfet
X$164 vss \$11 \$12 vdd pfet_03v3 L=0.28U W=20U
* device instance $165 r0 *1 122.375,4 pfet
X$165 \$69 sel_in vdd vdd pfet_03v3 L=0.35U W=8U
* device instance $166 r0 *1 125.325,4 pfet
X$166 \$35 rel_64_p vdd vdd pfet_03v3 L=0.35U W=8U
* device instance $167 r0 *1 128.275,4 pfet
X$167 \$37 hi_64_p vdd vdd pfet_03v3 L=0.35U W=8U
* device instance $168 r0 *1 131.225,4 pfet
X$168 \$13 lo_64_p vdd vdd pfet_03v3 L=0.35U W=8U
* device instance $169 r0 *1 134.14,10 pfet
X$169 vinp \$69 \$14 vdd pfet_03v3 L=0.28U W=20U
* device instance $170 r0 *1 137.02,10 pfet
X$170 vcm \$35 \$14 vdd pfet_03v3 L=0.28U W=20U
* device instance $171 r0 *1 139.9,10 pfet
X$171 vref \$37 \$14 vdd pfet_03v3 L=0.28U W=20U
* device instance $172 r0 *1 142.78,10 pfet
X$172 vss \$13 \$14 vdd pfet_03v3 L=0.28U W=20U
* device instance $173 r0 *1 170.815,4 pfet
X$173 \$71 sel_in vdd vdd pfet_03v3 L=0.35U W=8U
* device instance $174 r0 *1 173.765,4 pfet
X$174 \$39 rel_32_p vdd vdd pfet_03v3 L=0.35U W=8U
* device instance $175 r0 *1 176.715,4 pfet
X$175 \$41 hi_32_p vdd vdd pfet_03v3 L=0.35U W=8U
* device instance $176 r0 *1 179.665,4 pfet
X$176 \$15 lo_32_p vdd vdd pfet_03v3 L=0.35U W=8U
* device instance $177 r0 *1 182.58,10 pfet
X$177 vinp \$71 \$16 vdd pfet_03v3 L=0.28U W=20U
* device instance $178 r0 *1 185.46,10 pfet
X$178 vcm \$39 \$16 vdd pfet_03v3 L=0.28U W=20U
* device instance $179 r0 *1 188.34,10 pfet
X$179 vref \$41 \$16 vdd pfet_03v3 L=0.28U W=20U
* device instance $180 r0 *1 191.22,10 pfet
X$180 vss \$15 \$16 vdd pfet_03v3 L=0.28U W=20U
* device instance $181 r0 *1 219.255,4 pfet
X$181 \$73 sel_in vdd vdd pfet_03v3 L=0.35U W=8U
* device instance $182 r0 *1 222.205,4 pfet
X$182 \$43 rel_16_p vdd vdd pfet_03v3 L=0.35U W=8U
* device instance $183 r0 *1 225.155,4 pfet
X$183 \$45 hi_16_p vdd vdd pfet_03v3 L=0.35U W=8U
* device instance $184 r0 *1 228.105,4 pfet
X$184 \$17 lo_16_p vdd vdd pfet_03v3 L=0.35U W=8U
* device instance $185 r0 *1 231.02,10 pfet
X$185 vinp \$73 \$18 vdd pfet_03v3 L=0.28U W=20U
* device instance $186 r0 *1 233.9,10 pfet
X$186 vcm \$43 \$18 vdd pfet_03v3 L=0.28U W=20U
* device instance $187 r0 *1 236.78,10 pfet
X$187 vref \$45 \$18 vdd pfet_03v3 L=0.28U W=20U
* device instance $188 r0 *1 239.66,10 pfet
X$188 vss \$17 \$18 vdd pfet_03v3 L=0.28U W=20U
* device instance $189 r0 *1 267.695,4 pfet
X$189 \$75 sel_in vdd vdd pfet_03v3 L=0.35U W=8U
* device instance $190 r0 *1 270.645,4 pfet
X$190 \$47 rel_8_p vdd vdd pfet_03v3 L=0.35U W=8U
* device instance $191 r0 *1 273.595,4 pfet
X$191 \$49 hi_8_p vdd vdd pfet_03v3 L=0.35U W=8U
* device instance $192 r0 *1 276.545,4 pfet
X$192 \$19 lo_8_p vdd vdd pfet_03v3 L=0.35U W=8U
* device instance $193 r0 *1 279.46,10 pfet
X$193 vinp \$75 \$20 vdd pfet_03v3 L=0.28U W=20U
* device instance $194 r0 *1 282.34,10 pfet
X$194 vcm \$47 \$20 vdd pfet_03v3 L=0.28U W=20U
* device instance $195 r0 *1 285.22,10 pfet
X$195 vref \$49 \$20 vdd pfet_03v3 L=0.28U W=20U
* device instance $196 r0 *1 288.1,10 pfet
X$196 vss \$19 \$20 vdd pfet_03v3 L=0.28U W=20U
* device instance $197 r0 *1 316.135,4 pfet
X$197 \$77 sel_in vdd vdd pfet_03v3 L=0.35U W=8U
* device instance $198 r0 *1 319.085,4 pfet
X$198 \$51 rel_4_p vdd vdd pfet_03v3 L=0.35U W=8U
* device instance $199 r0 *1 322.035,4 pfet
X$199 \$53 hi_4_p vdd vdd pfet_03v3 L=0.35U W=8U
* device instance $200 r0 *1 324.985,4 pfet
X$200 \$21 lo_4_p vdd vdd pfet_03v3 L=0.35U W=8U
* device instance $201 r0 *1 327.9,10 pfet
X$201 vinp \$77 \$22 vdd pfet_03v3 L=0.28U W=20U
* device instance $202 r0 *1 330.78,10 pfet
X$202 vcm \$51 \$22 vdd pfet_03v3 L=0.28U W=20U
* device instance $203 r0 *1 333.66,10 pfet
X$203 vref \$53 \$22 vdd pfet_03v3 L=0.28U W=20U
* device instance $204 r0 *1 336.54,10 pfet
X$204 vss \$21 \$22 vdd pfet_03v3 L=0.28U W=20U
* device instance $205 r0 *1 364.575,4 pfet
X$205 \$79 sel_in vdd vdd pfet_03v3 L=0.35U W=8U
* device instance $206 r0 *1 367.525,4 pfet
X$206 \$55 rel_2_p vdd vdd pfet_03v3 L=0.35U W=8U
* device instance $207 r0 *1 370.475,4 pfet
X$207 \$57 hi_2_p vdd vdd pfet_03v3 L=0.35U W=8U
* device instance $208 r0 *1 373.425,4 pfet
X$208 \$23 lo_2_p vdd vdd pfet_03v3 L=0.35U W=8U
* device instance $209 r0 *1 376.34,10 pfet
X$209 vinp \$79 \$24 vdd pfet_03v3 L=0.28U W=20U
* device instance $210 r0 *1 379.22,10 pfet
X$210 vcm \$55 \$24 vdd pfet_03v3 L=0.28U W=20U
* device instance $211 r0 *1 382.1,10 pfet
X$211 vref \$57 \$24 vdd pfet_03v3 L=0.28U W=20U
* device instance $212 r0 *1 384.98,10 pfet
X$212 vss \$23 \$24 vdd pfet_03v3 L=0.28U W=20U
* device instance $213 r0 *1 413.015,4 pfet
X$213 \$81 sel_in vdd vdd pfet_03v3 L=0.35U W=8U
* device instance $214 r0 *1 415.965,4 pfet
X$214 \$59 rel_1_p vdd vdd pfet_03v3 L=0.35U W=8U
* device instance $215 r0 *1 418.915,4 pfet
X$215 \$61 hi_1_p vdd vdd pfet_03v3 L=0.35U W=8U
* device instance $216 r0 *1 421.865,4 pfet
X$216 \$25 lo_1_p vdd vdd pfet_03v3 L=0.35U W=8U
* device instance $217 r0 *1 424.78,10 pfet
X$217 vinp \$81 \$26 vdd pfet_03v3 L=0.28U W=20U
* device instance $218 r0 *1 427.66,10 pfet
X$218 vcm \$59 \$26 vdd pfet_03v3 L=0.28U W=20U
* device instance $219 r0 *1 430.54,10 pfet
X$219 vref \$61 \$26 vdd pfet_03v3 L=0.28U W=20U
* device instance $220 r0 *1 433.42,10 pfet
X$220 vss \$25 \$26 vdd pfet_03v3 L=0.28U W=20U
* device instance $221 r0 *1 25.495,37.15 pfet
X$221 \$83 sel_in vdd vdd pfet_03v3 L=0.35U W=8U
* device instance $222 r0 *1 28.445,37.15 pfet
X$222 \$85 rel_256_n vdd vdd pfet_03v3 L=0.35U W=8U
* device instance $223 r0 *1 31.395,37.15 pfet
X$223 \$87 hi_256_n vdd vdd pfet_03v3 L=0.35U W=8U
* device instance $224 r0 *1 34.345,37.15 pfet
X$224 \$89 lo_256_n vdd vdd pfet_03v3 L=0.35U W=8U
* device instance $225 r0 *1 37.26,43.15 pfet
X$225 vinn \$83 \$90 vdd pfet_03v3 L=0.28U W=20U
* device instance $226 r0 *1 40.14,43.15 pfet
X$226 vcm \$85 \$90 vdd pfet_03v3 L=0.28U W=20U
* device instance $227 r0 *1 43.02,43.15 pfet
X$227 vref \$87 \$90 vdd pfet_03v3 L=0.28U W=20U
* device instance $228 r0 *1 45.9,43.15 pfet
X$228 vss \$89 \$90 vdd pfet_03v3 L=0.28U W=20U
* device instance $229 r0 *1 73.935,37.15 pfet
X$229 \$92 sel_in vdd vdd pfet_03v3 L=0.35U W=8U
* device instance $230 r0 *1 76.885,37.15 pfet
X$230 \$94 rel_128_n vdd vdd pfet_03v3 L=0.35U W=8U
* device instance $231 r0 *1 79.835,37.15 pfet
X$231 \$96 hi_128_n vdd vdd pfet_03v3 L=0.35U W=8U
* device instance $232 r0 *1 82.785,37.15 pfet
X$232 \$98 lo_128_n vdd vdd pfet_03v3 L=0.35U W=8U
* device instance $233 r0 *1 85.7,43.15 pfet
X$233 vinn \$92 \$99 vdd pfet_03v3 L=0.28U W=20U
* device instance $234 r0 *1 88.58,43.15 pfet
X$234 vcm \$94 \$99 vdd pfet_03v3 L=0.28U W=20U
* device instance $235 r0 *1 91.46,43.15 pfet
X$235 vref \$96 \$99 vdd pfet_03v3 L=0.28U W=20U
* device instance $236 r0 *1 94.34,43.15 pfet
X$236 vss \$98 \$99 vdd pfet_03v3 L=0.28U W=20U
* device instance $237 r0 *1 122.375,37.15 pfet
X$237 \$100 sel_in vdd vdd pfet_03v3 L=0.35U W=8U
* device instance $238 r0 *1 125.325,37.15 pfet
X$238 \$102 rel_64_n vdd vdd pfet_03v3 L=0.35U W=8U
* device instance $239 r0 *1 128.275,37.15 pfet
X$239 \$104 hi_64_n vdd vdd pfet_03v3 L=0.35U W=8U
* device instance $240 r0 *1 131.225,37.15 pfet
X$240 \$106 lo_64_n vdd vdd pfet_03v3 L=0.35U W=8U
* device instance $241 r0 *1 134.14,43.15 pfet
X$241 vinn \$100 \$107 vdd pfet_03v3 L=0.28U W=20U
* device instance $242 r0 *1 137.02,43.15 pfet
X$242 vcm \$102 \$107 vdd pfet_03v3 L=0.28U W=20U
* device instance $243 r0 *1 139.9,43.15 pfet
X$243 vref \$104 \$107 vdd pfet_03v3 L=0.28U W=20U
* device instance $244 r0 *1 142.78,43.15 pfet
X$244 vss \$106 \$107 vdd pfet_03v3 L=0.28U W=20U
* device instance $245 r0 *1 170.815,37.15 pfet
X$245 \$108 sel_in vdd vdd pfet_03v3 L=0.35U W=8U
* device instance $246 r0 *1 173.765,37.15 pfet
X$246 \$110 rel_32_n vdd vdd pfet_03v3 L=0.35U W=8U
* device instance $247 r0 *1 176.715,37.15 pfet
X$247 \$112 hi_32_n vdd vdd pfet_03v3 L=0.35U W=8U
* device instance $248 r0 *1 179.665,37.15 pfet
X$248 \$114 lo_32_n vdd vdd pfet_03v3 L=0.35U W=8U
* device instance $249 r0 *1 182.58,43.15 pfet
X$249 vinn \$108 \$115 vdd pfet_03v3 L=0.28U W=20U
* device instance $250 r0 *1 185.46,43.15 pfet
X$250 vcm \$110 \$115 vdd pfet_03v3 L=0.28U W=20U
* device instance $251 r0 *1 188.34,43.15 pfet
X$251 vref \$112 \$115 vdd pfet_03v3 L=0.28U W=20U
* device instance $252 r0 *1 191.22,43.15 pfet
X$252 vss \$114 \$115 vdd pfet_03v3 L=0.28U W=20U
* device instance $253 r0 *1 219.255,37.15 pfet
X$253 \$116 sel_in vdd vdd pfet_03v3 L=0.35U W=8U
* device instance $254 r0 *1 222.205,37.15 pfet
X$254 \$118 rel_16_n vdd vdd pfet_03v3 L=0.35U W=8U
* device instance $255 r0 *1 225.155,37.15 pfet
X$255 \$120 hi_16_n vdd vdd pfet_03v3 L=0.35U W=8U
* device instance $256 r0 *1 228.105,37.15 pfet
X$256 \$122 lo_16_n vdd vdd pfet_03v3 L=0.35U W=8U
* device instance $257 r0 *1 231.02,43.15 pfet
X$257 vinn \$116 \$123 vdd pfet_03v3 L=0.28U W=20U
* device instance $258 r0 *1 233.9,43.15 pfet
X$258 vcm \$118 \$123 vdd pfet_03v3 L=0.28U W=20U
* device instance $259 r0 *1 236.78,43.15 pfet
X$259 vref \$120 \$123 vdd pfet_03v3 L=0.28U W=20U
* device instance $260 r0 *1 239.66,43.15 pfet
X$260 vss \$122 \$123 vdd pfet_03v3 L=0.28U W=20U
* device instance $261 r0 *1 267.695,37.15 pfet
X$261 \$124 sel_in vdd vdd pfet_03v3 L=0.35U W=8U
* device instance $262 r0 *1 270.645,37.15 pfet
X$262 \$126 rel_8_n vdd vdd pfet_03v3 L=0.35U W=8U
* device instance $263 r0 *1 273.595,37.15 pfet
X$263 \$128 hi_8_n vdd vdd pfet_03v3 L=0.35U W=8U
* device instance $264 r0 *1 276.545,37.15 pfet
X$264 \$130 lo_8_n vdd vdd pfet_03v3 L=0.35U W=8U
* device instance $265 r0 *1 279.46,43.15 pfet
X$265 vinn \$124 \$131 vdd pfet_03v3 L=0.28U W=20U
* device instance $266 r0 *1 282.34,43.15 pfet
X$266 vcm \$126 \$131 vdd pfet_03v3 L=0.28U W=20U
* device instance $267 r0 *1 285.22,43.15 pfet
X$267 vref \$128 \$131 vdd pfet_03v3 L=0.28U W=20U
* device instance $268 r0 *1 288.1,43.15 pfet
X$268 vss \$130 \$131 vdd pfet_03v3 L=0.28U W=20U
* device instance $269 r0 *1 316.135,37.15 pfet
X$269 \$132 sel_in vdd vdd pfet_03v3 L=0.35U W=8U
* device instance $270 r0 *1 319.085,37.15 pfet
X$270 \$134 rel_4_n vdd vdd pfet_03v3 L=0.35U W=8U
* device instance $271 r0 *1 322.035,37.15 pfet
X$271 \$136 hi_4_n vdd vdd pfet_03v3 L=0.35U W=8U
* device instance $272 r0 *1 324.985,37.15 pfet
X$272 \$138 lo_4_n vdd vdd pfet_03v3 L=0.35U W=8U
* device instance $273 r0 *1 327.9,43.15 pfet
X$273 vinn \$132 \$139 vdd pfet_03v3 L=0.28U W=20U
* device instance $274 r0 *1 330.78,43.15 pfet
X$274 vcm \$134 \$139 vdd pfet_03v3 L=0.28U W=20U
* device instance $275 r0 *1 333.66,43.15 pfet
X$275 vref \$136 \$139 vdd pfet_03v3 L=0.28U W=20U
* device instance $276 r0 *1 336.54,43.15 pfet
X$276 vss \$138 \$139 vdd pfet_03v3 L=0.28U W=20U
* device instance $277 r0 *1 364.575,37.15 pfet
X$277 \$140 sel_in vdd vdd pfet_03v3 L=0.35U W=8U
* device instance $278 r0 *1 367.525,37.15 pfet
X$278 \$142 rel_2_n vdd vdd pfet_03v3 L=0.35U W=8U
* device instance $279 r0 *1 370.475,37.15 pfet
X$279 \$144 hi_2_n vdd vdd pfet_03v3 L=0.35U W=8U
* device instance $280 r0 *1 373.425,37.15 pfet
X$280 \$146 lo_2_n vdd vdd pfet_03v3 L=0.35U W=8U
* device instance $281 r0 *1 376.34,43.15 pfet
X$281 vinn \$140 \$147 vdd pfet_03v3 L=0.28U W=20U
* device instance $282 r0 *1 379.22,43.15 pfet
X$282 vcm \$142 \$147 vdd pfet_03v3 L=0.28U W=20U
* device instance $283 r0 *1 382.1,43.15 pfet
X$283 vref \$144 \$147 vdd pfet_03v3 L=0.28U W=20U
* device instance $284 r0 *1 384.98,43.15 pfet
X$284 vss \$146 \$147 vdd pfet_03v3 L=0.28U W=20U
* device instance $285 r0 *1 413.015,37.15 pfet
X$285 \$148 sel_in vdd vdd pfet_03v3 L=0.35U W=8U
* device instance $286 r0 *1 415.965,37.15 pfet
X$286 \$150 rel_1_n vdd vdd pfet_03v3 L=0.35U W=8U
* device instance $287 r0 *1 418.915,37.15 pfet
X$287 \$152 hi_1_n vdd vdd pfet_03v3 L=0.35U W=8U
* device instance $288 r0 *1 421.865,37.15 pfet
X$288 \$154 lo_1_n vdd vdd pfet_03v3 L=0.35U W=8U
* device instance $289 r0 *1 424.78,43.15 pfet
X$289 vinn \$148 \$155 vdd pfet_03v3 L=0.28U W=20U
* device instance $290 r0 *1 427.66,43.15 pfet
X$290 vcm \$150 \$155 vdd pfet_03v3 L=0.28U W=20U
* device instance $291 r0 *1 430.54,43.15 pfet
X$291 vref \$152 \$155 vdd pfet_03v3 L=0.28U W=20U
* device instance $292 r0 *1 433.42,43.15 pfet
X$292 vss \$154 \$155 vdd pfet_03v3 L=0.28U W=20U
* device instance $293 r0 *1 363.357,70.3 pfet
X$293 \$166 tp_gn vdd vdd pfet_03v3 L=0.35U W=8U
* device instance $294 r0 *1 366.272,76.3 pfet
X$294 vcm \$166 topp vdd pfet_03v3 L=0.28U W=20U
* device instance $295 r0 *1 376.817,70.3 pfet
X$295 \$167 tp_gn vdd vdd pfet_03v3 L=0.35U W=8U
* device instance $296 r0 *1 379.732,76.3 pfet
X$296 vcm \$167 topn vdd pfet_03v3 L=0.28U W=20U
* device instance $297 r0 *1 1.957,68.257 cap_mim_2f0_m4m5_noshield
X$297 \$10 topp cap_mim_2f0_m4m5_noshield c_length=2.714U c_width=2.714U
* device instance $298 r0 *1 7.071,68.257 cap_mim_2f0_m4m5_noshield
X$298 \$24 topp cap_mim_2f0_m4m5_noshield c_length=2.714U c_width=2.714U
* device instance $299 r0 *1 12.185,68.257 cap_mim_2f0_m4m5_noshield
X$299 \$10 topp cap_mim_2f0_m4m5_noshield c_length=2.714U c_width=2.714U
* device instance $300 r0 *1 17.299,68.257 cap_mim_2f0_m4m5_noshield
X$300 \$22 topp cap_mim_2f0_m4m5_noshield c_length=2.714U c_width=2.714U
* device instance $301 r0 *1 22.413,68.257 cap_mim_2f0_m4m5_noshield
X$301 \$10 topp cap_mim_2f0_m4m5_noshield c_length=2.714U c_width=2.714U
* device instance $302 r0 *1 27.527,68.257 cap_mim_2f0_m4m5_noshield
X$302 \$20 topp cap_mim_2f0_m4m5_noshield c_length=2.714U c_width=2.714U
* device instance $303 r0 *1 32.641,68.257 cap_mim_2f0_m4m5_noshield
X$303 \$10 topp cap_mim_2f0_m4m5_noshield c_length=2.714U c_width=2.714U
* device instance $304 r0 *1 37.755,68.257 cap_mim_2f0_m4m5_noshield
X$304 \$20 topp cap_mim_2f0_m4m5_noshield c_length=2.714U c_width=2.714U
* device instance $305 r0 *1 42.869,68.257 cap_mim_2f0_m4m5_noshield
X$305 \$10 topp cap_mim_2f0_m4m5_noshield c_length=2.714U c_width=2.714U
* device instance $306 r0 *1 47.983,68.257 cap_mim_2f0_m4m5_noshield
X$306 \$18 topp cap_mim_2f0_m4m5_noshield c_length=2.714U c_width=2.714U
* device instance $307 r0 *1 53.097,68.257 cap_mim_2f0_m4m5_noshield
X$307 \$10 topp cap_mim_2f0_m4m5_noshield c_length=2.714U c_width=2.714U
* device instance $308 r0 *1 58.211,68.257 cap_mim_2f0_m4m5_noshield
X$308 \$18 topp cap_mim_2f0_m4m5_noshield c_length=2.714U c_width=2.714U
* device instance $309 r0 *1 63.325,68.257 cap_mim_2f0_m4m5_noshield
X$309 \$10 topp cap_mim_2f0_m4m5_noshield c_length=2.714U c_width=2.714U
* device instance $310 r0 *1 68.439,68.257 cap_mim_2f0_m4m5_noshield
X$310 \$18 topp cap_mim_2f0_m4m5_noshield c_length=2.714U c_width=2.714U
* device instance $311 r0 *1 73.553,68.257 cap_mim_2f0_m4m5_noshield
X$311 \$10 topp cap_mim_2f0_m4m5_noshield c_length=2.714U c_width=2.714U
* device instance $312 r0 *1 78.667,68.257 cap_mim_2f0_m4m5_noshield
X$312 \$18 topp cap_mim_2f0_m4m5_noshield c_length=2.714U c_width=2.714U
* device instance $313 r0 *1 83.781,68.257 cap_mim_2f0_m4m5_noshield
X$313 \$10 topp cap_mim_2f0_m4m5_noshield c_length=2.714U c_width=2.714U
* device instance $314 r0 *1 88.895,68.257 cap_mim_2f0_m4m5_noshield
X$314 \$16 topp cap_mim_2f0_m4m5_noshield c_length=2.714U c_width=2.714U
* device instance $315 r0 *1 94.009,68.257 cap_mim_2f0_m4m5_noshield
X$315 \$10 topp cap_mim_2f0_m4m5_noshield c_length=2.714U c_width=2.714U
* device instance $316 r0 *1 99.123,68.257 cap_mim_2f0_m4m5_noshield
X$316 \$16 topp cap_mim_2f0_m4m5_noshield c_length=2.714U c_width=2.714U
* device instance $317 r0 *1 104.237,68.257 cap_mim_2f0_m4m5_noshield
X$317 \$10 topp cap_mim_2f0_m4m5_noshield c_length=2.714U c_width=2.714U
* device instance $318 r0 *1 109.351,68.257 cap_mim_2f0_m4m5_noshield
X$318 \$16 topp cap_mim_2f0_m4m5_noshield c_length=2.714U c_width=2.714U
* device instance $319 r0 *1 114.465,68.257 cap_mim_2f0_m4m5_noshield
X$319 \$10 topp cap_mim_2f0_m4m5_noshield c_length=2.714U c_width=2.714U
* device instance $320 r0 *1 119.579,68.257 cap_mim_2f0_m4m5_noshield
X$320 \$16 topp cap_mim_2f0_m4m5_noshield c_length=2.714U c_width=2.714U
* device instance $321 r0 *1 124.693,68.257 cap_mim_2f0_m4m5_noshield
X$321 \$10 topp cap_mim_2f0_m4m5_noshield c_length=2.714U c_width=2.714U
* device instance $322 r0 *1 129.807,68.257 cap_mim_2f0_m4m5_noshield
X$322 \$16 topp cap_mim_2f0_m4m5_noshield c_length=2.714U c_width=2.714U
* device instance $323 r0 *1 134.921,68.257 cap_mim_2f0_m4m5_noshield
X$323 \$10 topp cap_mim_2f0_m4m5_noshield c_length=2.714U c_width=2.714U
* device instance $324 r0 *1 140.035,68.257 cap_mim_2f0_m4m5_noshield
X$324 \$16 topp cap_mim_2f0_m4m5_noshield c_length=2.714U c_width=2.714U
* device instance $325 r0 *1 145.149,68.257 cap_mim_2f0_m4m5_noshield
X$325 \$10 topp cap_mim_2f0_m4m5_noshield c_length=2.714U c_width=2.714U
* device instance $326 r0 *1 150.263,68.257 cap_mim_2f0_m4m5_noshield
X$326 \$16 topp cap_mim_2f0_m4m5_noshield c_length=2.714U c_width=2.714U
* device instance $327 r0 *1 155.377,68.257 cap_mim_2f0_m4m5_noshield
X$327 \$10 topp cap_mim_2f0_m4m5_noshield c_length=2.714U c_width=2.714U
* device instance $328 r0 *1 160.491,68.257 cap_mim_2f0_m4m5_noshield
X$328 \$16 topp cap_mim_2f0_m4m5_noshield c_length=2.714U c_width=2.714U
* device instance $329 r0 *1 179.633,68.257 cap_mim_2f0_m4m5_noshield
X$329 \$90 topn cap_mim_2f0_m4m5_noshield c_length=2.714U c_width=2.714U
* device instance $330 r0 *1 184.747,68.257 cap_mim_2f0_m4m5_noshield
X$330 \$147 topn cap_mim_2f0_m4m5_noshield c_length=2.714U c_width=2.714U
* device instance $331 r0 *1 189.861,68.257 cap_mim_2f0_m4m5_noshield
X$331 \$90 topn cap_mim_2f0_m4m5_noshield c_length=2.714U c_width=2.714U
* device instance $332 r0 *1 194.975,68.257 cap_mim_2f0_m4m5_noshield
X$332 \$139 topn cap_mim_2f0_m4m5_noshield c_length=2.714U c_width=2.714U
* device instance $333 r0 *1 200.089,68.257 cap_mim_2f0_m4m5_noshield
X$333 \$90 topn cap_mim_2f0_m4m5_noshield c_length=2.714U c_width=2.714U
* device instance $334 r0 *1 205.203,68.257 cap_mim_2f0_m4m5_noshield
X$334 \$131 topn cap_mim_2f0_m4m5_noshield c_length=2.714U c_width=2.714U
* device instance $335 r0 *1 210.317,68.257 cap_mim_2f0_m4m5_noshield
X$335 \$90 topn cap_mim_2f0_m4m5_noshield c_length=2.714U c_width=2.714U
* device instance $336 r0 *1 215.431,68.257 cap_mim_2f0_m4m5_noshield
X$336 \$131 topn cap_mim_2f0_m4m5_noshield c_length=2.714U c_width=2.714U
* device instance $337 r0 *1 220.545,68.257 cap_mim_2f0_m4m5_noshield
X$337 \$90 topn cap_mim_2f0_m4m5_noshield c_length=2.714U c_width=2.714U
* device instance $338 r0 *1 225.659,68.257 cap_mim_2f0_m4m5_noshield
X$338 \$123 topn cap_mim_2f0_m4m5_noshield c_length=2.714U c_width=2.714U
* device instance $339 r0 *1 230.773,68.257 cap_mim_2f0_m4m5_noshield
X$339 \$90 topn cap_mim_2f0_m4m5_noshield c_length=2.714U c_width=2.714U
* device instance $340 r0 *1 235.887,68.257 cap_mim_2f0_m4m5_noshield
X$340 \$123 topn cap_mim_2f0_m4m5_noshield c_length=2.714U c_width=2.714U
* device instance $341 r0 *1 241.001,68.257 cap_mim_2f0_m4m5_noshield
X$341 \$90 topn cap_mim_2f0_m4m5_noshield c_length=2.714U c_width=2.714U
* device instance $342 r0 *1 246.115,68.257 cap_mim_2f0_m4m5_noshield
X$342 \$123 topn cap_mim_2f0_m4m5_noshield c_length=2.714U c_width=2.714U
* device instance $343 r0 *1 251.229,68.257 cap_mim_2f0_m4m5_noshield
X$343 \$90 topn cap_mim_2f0_m4m5_noshield c_length=2.714U c_width=2.714U
* device instance $344 r0 *1 256.343,68.257 cap_mim_2f0_m4m5_noshield
X$344 \$123 topn cap_mim_2f0_m4m5_noshield c_length=2.714U c_width=2.714U
* device instance $345 r0 *1 261.457,68.257 cap_mim_2f0_m4m5_noshield
X$345 \$90 topn cap_mim_2f0_m4m5_noshield c_length=2.714U c_width=2.714U
* device instance $346 r0 *1 266.571,68.257 cap_mim_2f0_m4m5_noshield
X$346 \$115 topn cap_mim_2f0_m4m5_noshield c_length=2.714U c_width=2.714U
* device instance $347 r0 *1 271.685,68.257 cap_mim_2f0_m4m5_noshield
X$347 \$90 topn cap_mim_2f0_m4m5_noshield c_length=2.714U c_width=2.714U
* device instance $348 r0 *1 276.799,68.257 cap_mim_2f0_m4m5_noshield
X$348 \$115 topn cap_mim_2f0_m4m5_noshield c_length=2.714U c_width=2.714U
* device instance $349 r0 *1 281.913,68.257 cap_mim_2f0_m4m5_noshield
X$349 \$90 topn cap_mim_2f0_m4m5_noshield c_length=2.714U c_width=2.714U
* device instance $350 r0 *1 287.027,68.257 cap_mim_2f0_m4m5_noshield
X$350 \$115 topn cap_mim_2f0_m4m5_noshield c_length=2.714U c_width=2.714U
* device instance $351 r0 *1 292.141,68.257 cap_mim_2f0_m4m5_noshield
X$351 \$90 topn cap_mim_2f0_m4m5_noshield c_length=2.714U c_width=2.714U
* device instance $352 r0 *1 297.255,68.257 cap_mim_2f0_m4m5_noshield
X$352 \$115 topn cap_mim_2f0_m4m5_noshield c_length=2.714U c_width=2.714U
* device instance $353 r0 *1 302.369,68.257 cap_mim_2f0_m4m5_noshield
X$353 \$90 topn cap_mim_2f0_m4m5_noshield c_length=2.714U c_width=2.714U
* device instance $354 r0 *1 307.483,68.257 cap_mim_2f0_m4m5_noshield
X$354 \$115 topn cap_mim_2f0_m4m5_noshield c_length=2.714U c_width=2.714U
* device instance $355 r0 *1 312.597,68.257 cap_mim_2f0_m4m5_noshield
X$355 \$90 topn cap_mim_2f0_m4m5_noshield c_length=2.714U c_width=2.714U
* device instance $356 r0 *1 317.711,68.257 cap_mim_2f0_m4m5_noshield
X$356 \$115 topn cap_mim_2f0_m4m5_noshield c_length=2.714U c_width=2.714U
* device instance $357 r0 *1 322.825,68.257 cap_mim_2f0_m4m5_noshield
X$357 \$90 topn cap_mim_2f0_m4m5_noshield c_length=2.714U c_width=2.714U
* device instance $358 r0 *1 327.939,68.257 cap_mim_2f0_m4m5_noshield
X$358 \$115 topn cap_mim_2f0_m4m5_noshield c_length=2.714U c_width=2.714U
* device instance $359 r0 *1 333.053,68.257 cap_mim_2f0_m4m5_noshield
X$359 \$90 topn cap_mim_2f0_m4m5_noshield c_length=2.714U c_width=2.714U
* device instance $360 r0 *1 338.167,68.257 cap_mim_2f0_m4m5_noshield
X$360 \$115 topn cap_mim_2f0_m4m5_noshield c_length=2.714U c_width=2.714U
* device instance $361 r0 *1 1.957,73.371 cap_mim_2f0_m4m5_noshield
X$361 \$10 topp cap_mim_2f0_m4m5_noshield c_length=2.714U c_width=2.714U
* device instance $362 r0 *1 7.071,73.371 cap_mim_2f0_m4m5_noshield
X$362 \$14 topp cap_mim_2f0_m4m5_noshield c_length=2.714U c_width=2.714U
* device instance $363 r0 *1 12.185,73.371 cap_mim_2f0_m4m5_noshield
X$363 \$10 topp cap_mim_2f0_m4m5_noshield c_length=2.714U c_width=2.714U
* device instance $364 r0 *1 17.299,73.371 cap_mim_2f0_m4m5_noshield
X$364 \$14 topp cap_mim_2f0_m4m5_noshield c_length=2.714U c_width=2.714U
* device instance $365 r0 *1 22.413,73.371 cap_mim_2f0_m4m5_noshield
X$365 \$10 topp cap_mim_2f0_m4m5_noshield c_length=2.714U c_width=2.714U
* device instance $366 r0 *1 27.527,73.371 cap_mim_2f0_m4m5_noshield
X$366 \$14 topp cap_mim_2f0_m4m5_noshield c_length=2.714U c_width=2.714U
* device instance $367 r0 *1 32.641,73.371 cap_mim_2f0_m4m5_noshield
X$367 \$10 topp cap_mim_2f0_m4m5_noshield c_length=2.714U c_width=2.714U
* device instance $368 r0 *1 37.755,73.371 cap_mim_2f0_m4m5_noshield
X$368 \$14 topp cap_mim_2f0_m4m5_noshield c_length=2.714U c_width=2.714U
* device instance $369 r0 *1 42.869,73.371 cap_mim_2f0_m4m5_noshield
X$369 \$10 topp cap_mim_2f0_m4m5_noshield c_length=2.714U c_width=2.714U
* device instance $370 r0 *1 47.983,73.371 cap_mim_2f0_m4m5_noshield
X$370 \$14 topp cap_mim_2f0_m4m5_noshield c_length=2.714U c_width=2.714U
* device instance $371 r0 *1 53.097,73.371 cap_mim_2f0_m4m5_noshield
X$371 \$10 topp cap_mim_2f0_m4m5_noshield c_length=2.714U c_width=2.714U
* device instance $372 r0 *1 58.211,73.371 cap_mim_2f0_m4m5_noshield
X$372 \$14 topp cap_mim_2f0_m4m5_noshield c_length=2.714U c_width=2.714U
* device instance $373 r0 *1 63.325,73.371 cap_mim_2f0_m4m5_noshield
X$373 \$10 topp cap_mim_2f0_m4m5_noshield c_length=2.714U c_width=2.714U
* device instance $374 r0 *1 68.439,73.371 cap_mim_2f0_m4m5_noshield
X$374 \$14 topp cap_mim_2f0_m4m5_noshield c_length=2.714U c_width=2.714U
* device instance $375 r0 *1 73.553,73.371 cap_mim_2f0_m4m5_noshield
X$375 \$10 topp cap_mim_2f0_m4m5_noshield c_length=2.714U c_width=2.714U
* device instance $376 r0 *1 78.667,73.371 cap_mim_2f0_m4m5_noshield
X$376 \$14 topp cap_mim_2f0_m4m5_noshield c_length=2.714U c_width=2.714U
* device instance $377 r0 *1 83.781,73.371 cap_mim_2f0_m4m5_noshield
X$377 \$10 topp cap_mim_2f0_m4m5_noshield c_length=2.714U c_width=2.714U
* device instance $378 r0 *1 88.895,73.371 cap_mim_2f0_m4m5_noshield
X$378 \$14 topp cap_mim_2f0_m4m5_noshield c_length=2.714U c_width=2.714U
* device instance $379 r0 *1 94.009,73.371 cap_mim_2f0_m4m5_noshield
X$379 \$10 topp cap_mim_2f0_m4m5_noshield c_length=2.714U c_width=2.714U
* device instance $380 r0 *1 99.123,73.371 cap_mim_2f0_m4m5_noshield
X$380 \$14 topp cap_mim_2f0_m4m5_noshield c_length=2.714U c_width=2.714U
* device instance $381 r0 *1 104.237,73.371 cap_mim_2f0_m4m5_noshield
X$381 \$10 topp cap_mim_2f0_m4m5_noshield c_length=2.714U c_width=2.714U
* device instance $382 r0 *1 109.351,73.371 cap_mim_2f0_m4m5_noshield
X$382 \$14 topp cap_mim_2f0_m4m5_noshield c_length=2.714U c_width=2.714U
* device instance $383 r0 *1 114.465,73.371 cap_mim_2f0_m4m5_noshield
X$383 \$10 topp cap_mim_2f0_m4m5_noshield c_length=2.714U c_width=2.714U
* device instance $384 r0 *1 119.579,73.371 cap_mim_2f0_m4m5_noshield
X$384 \$14 topp cap_mim_2f0_m4m5_noshield c_length=2.714U c_width=2.714U
* device instance $385 r0 *1 124.693,73.371 cap_mim_2f0_m4m5_noshield
X$385 \$10 topp cap_mim_2f0_m4m5_noshield c_length=2.714U c_width=2.714U
* device instance $386 r0 *1 129.807,73.371 cap_mim_2f0_m4m5_noshield
X$386 \$14 topp cap_mim_2f0_m4m5_noshield c_length=2.714U c_width=2.714U
* device instance $387 r0 *1 134.921,73.371 cap_mim_2f0_m4m5_noshield
X$387 \$10 topp cap_mim_2f0_m4m5_noshield c_length=2.714U c_width=2.714U
* device instance $388 r0 *1 140.035,73.371 cap_mim_2f0_m4m5_noshield
X$388 \$14 topp cap_mim_2f0_m4m5_noshield c_length=2.714U c_width=2.714U
* device instance $389 r0 *1 145.149,73.371 cap_mim_2f0_m4m5_noshield
X$389 \$10 topp cap_mim_2f0_m4m5_noshield c_length=2.714U c_width=2.714U
* device instance $390 r0 *1 150.263,73.371 cap_mim_2f0_m4m5_noshield
X$390 \$14 topp cap_mim_2f0_m4m5_noshield c_length=2.714U c_width=2.714U
* device instance $391 r0 *1 155.377,73.371 cap_mim_2f0_m4m5_noshield
X$391 \$10 topp cap_mim_2f0_m4m5_noshield c_length=2.714U c_width=2.714U
* device instance $392 r0 *1 160.491,73.371 cap_mim_2f0_m4m5_noshield
X$392 \$14 topp cap_mim_2f0_m4m5_noshield c_length=2.714U c_width=2.714U
* device instance $393 r0 *1 179.633,73.371 cap_mim_2f0_m4m5_noshield
X$393 \$90 topn cap_mim_2f0_m4m5_noshield c_length=2.714U c_width=2.714U
* device instance $394 r0 *1 184.747,73.371 cap_mim_2f0_m4m5_noshield
X$394 \$107 topn cap_mim_2f0_m4m5_noshield c_length=2.714U c_width=2.714U
* device instance $395 r0 *1 189.861,73.371 cap_mim_2f0_m4m5_noshield
X$395 \$90 topn cap_mim_2f0_m4m5_noshield c_length=2.714U c_width=2.714U
* device instance $396 r0 *1 194.975,73.371 cap_mim_2f0_m4m5_noshield
X$396 \$107 topn cap_mim_2f0_m4m5_noshield c_length=2.714U c_width=2.714U
* device instance $397 r0 *1 200.089,73.371 cap_mim_2f0_m4m5_noshield
X$397 \$90 topn cap_mim_2f0_m4m5_noshield c_length=2.714U c_width=2.714U
* device instance $398 r0 *1 205.203,73.371 cap_mim_2f0_m4m5_noshield
X$398 \$107 topn cap_mim_2f0_m4m5_noshield c_length=2.714U c_width=2.714U
* device instance $399 r0 *1 210.317,73.371 cap_mim_2f0_m4m5_noshield
X$399 \$90 topn cap_mim_2f0_m4m5_noshield c_length=2.714U c_width=2.714U
* device instance $400 r0 *1 215.431,73.371 cap_mim_2f0_m4m5_noshield
X$400 \$107 topn cap_mim_2f0_m4m5_noshield c_length=2.714U c_width=2.714U
* device instance $401 r0 *1 220.545,73.371 cap_mim_2f0_m4m5_noshield
X$401 \$90 topn cap_mim_2f0_m4m5_noshield c_length=2.714U c_width=2.714U
* device instance $402 r0 *1 225.659,73.371 cap_mim_2f0_m4m5_noshield
X$402 \$107 topn cap_mim_2f0_m4m5_noshield c_length=2.714U c_width=2.714U
* device instance $403 r0 *1 230.773,73.371 cap_mim_2f0_m4m5_noshield
X$403 \$90 topn cap_mim_2f0_m4m5_noshield c_length=2.714U c_width=2.714U
* device instance $404 r0 *1 235.887,73.371 cap_mim_2f0_m4m5_noshield
X$404 \$107 topn cap_mim_2f0_m4m5_noshield c_length=2.714U c_width=2.714U
* device instance $405 r0 *1 241.001,73.371 cap_mim_2f0_m4m5_noshield
X$405 \$90 topn cap_mim_2f0_m4m5_noshield c_length=2.714U c_width=2.714U
* device instance $406 r0 *1 246.115,73.371 cap_mim_2f0_m4m5_noshield
X$406 \$107 topn cap_mim_2f0_m4m5_noshield c_length=2.714U c_width=2.714U
* device instance $407 r0 *1 251.229,73.371 cap_mim_2f0_m4m5_noshield
X$407 \$90 topn cap_mim_2f0_m4m5_noshield c_length=2.714U c_width=2.714U
* device instance $408 r0 *1 256.343,73.371 cap_mim_2f0_m4m5_noshield
X$408 \$107 topn cap_mim_2f0_m4m5_noshield c_length=2.714U c_width=2.714U
* device instance $409 r0 *1 261.457,73.371 cap_mim_2f0_m4m5_noshield
X$409 \$90 topn cap_mim_2f0_m4m5_noshield c_length=2.714U c_width=2.714U
* device instance $410 r0 *1 266.571,73.371 cap_mim_2f0_m4m5_noshield
X$410 \$107 topn cap_mim_2f0_m4m5_noshield c_length=2.714U c_width=2.714U
* device instance $411 r0 *1 271.685,73.371 cap_mim_2f0_m4m5_noshield
X$411 \$90 topn cap_mim_2f0_m4m5_noshield c_length=2.714U c_width=2.714U
* device instance $412 r0 *1 276.799,73.371 cap_mim_2f0_m4m5_noshield
X$412 \$107 topn cap_mim_2f0_m4m5_noshield c_length=2.714U c_width=2.714U
* device instance $413 r0 *1 281.913,73.371 cap_mim_2f0_m4m5_noshield
X$413 \$90 topn cap_mim_2f0_m4m5_noshield c_length=2.714U c_width=2.714U
* device instance $414 r0 *1 287.027,73.371 cap_mim_2f0_m4m5_noshield
X$414 \$107 topn cap_mim_2f0_m4m5_noshield c_length=2.714U c_width=2.714U
* device instance $415 r0 *1 292.141,73.371 cap_mim_2f0_m4m5_noshield
X$415 \$90 topn cap_mim_2f0_m4m5_noshield c_length=2.714U c_width=2.714U
* device instance $416 r0 *1 297.255,73.371 cap_mim_2f0_m4m5_noshield
X$416 \$107 topn cap_mim_2f0_m4m5_noshield c_length=2.714U c_width=2.714U
* device instance $417 r0 *1 302.369,73.371 cap_mim_2f0_m4m5_noshield
X$417 \$90 topn cap_mim_2f0_m4m5_noshield c_length=2.714U c_width=2.714U
* device instance $418 r0 *1 307.483,73.371 cap_mim_2f0_m4m5_noshield
X$418 \$107 topn cap_mim_2f0_m4m5_noshield c_length=2.714U c_width=2.714U
* device instance $419 r0 *1 312.597,73.371 cap_mim_2f0_m4m5_noshield
X$419 \$90 topn cap_mim_2f0_m4m5_noshield c_length=2.714U c_width=2.714U
* device instance $420 r0 *1 317.711,73.371 cap_mim_2f0_m4m5_noshield
X$420 \$107 topn cap_mim_2f0_m4m5_noshield c_length=2.714U c_width=2.714U
* device instance $421 r0 *1 322.825,73.371 cap_mim_2f0_m4m5_noshield
X$421 \$90 topn cap_mim_2f0_m4m5_noshield c_length=2.714U c_width=2.714U
* device instance $422 r0 *1 327.939,73.371 cap_mim_2f0_m4m5_noshield
X$422 \$107 topn cap_mim_2f0_m4m5_noshield c_length=2.714U c_width=2.714U
* device instance $423 r0 *1 333.053,73.371 cap_mim_2f0_m4m5_noshield
X$423 \$90 topn cap_mim_2f0_m4m5_noshield c_length=2.714U c_width=2.714U
* device instance $424 r0 *1 338.167,73.371 cap_mim_2f0_m4m5_noshield
X$424 \$107 topn cap_mim_2f0_m4m5_noshield c_length=2.714U c_width=2.714U
* device instance $425 r0 *1 1.957,78.485 cap_mim_2f0_m4m5_noshield
X$425 \$10 topp cap_mim_2f0_m4m5_noshield c_length=2.714U c_width=2.714U
* device instance $426 r0 *1 7.071,78.485 cap_mim_2f0_m4m5_noshield
X$426 \$12 topp cap_mim_2f0_m4m5_noshield c_length=2.714U c_width=2.714U
* device instance $427 r0 *1 12.185,78.485 cap_mim_2f0_m4m5_noshield
X$427 \$10 topp cap_mim_2f0_m4m5_noshield c_length=2.714U c_width=2.714U
* device instance $428 r0 *1 17.299,78.485 cap_mim_2f0_m4m5_noshield
X$428 \$12 topp cap_mim_2f0_m4m5_noshield c_length=2.714U c_width=2.714U
* device instance $429 r0 *1 22.413,78.485 cap_mim_2f0_m4m5_noshield
X$429 \$10 topp cap_mim_2f0_m4m5_noshield c_length=2.714U c_width=2.714U
* device instance $430 r0 *1 27.527,78.485 cap_mim_2f0_m4m5_noshield
X$430 \$12 topp cap_mim_2f0_m4m5_noshield c_length=2.714U c_width=2.714U
* device instance $431 r0 *1 32.641,78.485 cap_mim_2f0_m4m5_noshield
X$431 \$10 topp cap_mim_2f0_m4m5_noshield c_length=2.714U c_width=2.714U
* device instance $432 r0 *1 37.755,78.485 cap_mim_2f0_m4m5_noshield
X$432 \$12 topp cap_mim_2f0_m4m5_noshield c_length=2.714U c_width=2.714U
* device instance $433 r0 *1 42.869,78.485 cap_mim_2f0_m4m5_noshield
X$433 \$10 topp cap_mim_2f0_m4m5_noshield c_length=2.714U c_width=2.714U
* device instance $434 r0 *1 47.983,78.485 cap_mim_2f0_m4m5_noshield
X$434 \$12 topp cap_mim_2f0_m4m5_noshield c_length=2.714U c_width=2.714U
* device instance $435 r0 *1 53.097,78.485 cap_mim_2f0_m4m5_noshield
X$435 \$10 topp cap_mim_2f0_m4m5_noshield c_length=2.714U c_width=2.714U
* device instance $436 r0 *1 58.211,78.485 cap_mim_2f0_m4m5_noshield
X$436 \$12 topp cap_mim_2f0_m4m5_noshield c_length=2.714U c_width=2.714U
* device instance $437 r0 *1 63.325,78.485 cap_mim_2f0_m4m5_noshield
X$437 \$10 topp cap_mim_2f0_m4m5_noshield c_length=2.714U c_width=2.714U
* device instance $438 r0 *1 68.439,78.485 cap_mim_2f0_m4m5_noshield
X$438 \$12 topp cap_mim_2f0_m4m5_noshield c_length=2.714U c_width=2.714U
* device instance $439 r0 *1 73.553,78.485 cap_mim_2f0_m4m5_noshield
X$439 \$10 topp cap_mim_2f0_m4m5_noshield c_length=2.714U c_width=2.714U
* device instance $440 r0 *1 78.667,78.485 cap_mim_2f0_m4m5_noshield
X$440 \$12 topp cap_mim_2f0_m4m5_noshield c_length=2.714U c_width=2.714U
* device instance $441 r0 *1 83.781,78.485 cap_mim_2f0_m4m5_noshield
X$441 \$10 topp cap_mim_2f0_m4m5_noshield c_length=2.714U c_width=2.714U
* device instance $442 r0 *1 88.895,78.485 cap_mim_2f0_m4m5_noshield
X$442 \$12 topp cap_mim_2f0_m4m5_noshield c_length=2.714U c_width=2.714U
* device instance $443 r0 *1 94.009,78.485 cap_mim_2f0_m4m5_noshield
X$443 \$10 topp cap_mim_2f0_m4m5_noshield c_length=2.714U c_width=2.714U
* device instance $444 r0 *1 99.123,78.485 cap_mim_2f0_m4m5_noshield
X$444 \$12 topp cap_mim_2f0_m4m5_noshield c_length=2.714U c_width=2.714U
* device instance $445 r0 *1 104.237,78.485 cap_mim_2f0_m4m5_noshield
X$445 \$10 topp cap_mim_2f0_m4m5_noshield c_length=2.714U c_width=2.714U
* device instance $446 r0 *1 109.351,78.485 cap_mim_2f0_m4m5_noshield
X$446 \$12 topp cap_mim_2f0_m4m5_noshield c_length=2.714U c_width=2.714U
* device instance $447 r0 *1 114.465,78.485 cap_mim_2f0_m4m5_noshield
X$447 \$10 topp cap_mim_2f0_m4m5_noshield c_length=2.714U c_width=2.714U
* device instance $448 r0 *1 119.579,78.485 cap_mim_2f0_m4m5_noshield
X$448 \$12 topp cap_mim_2f0_m4m5_noshield c_length=2.714U c_width=2.714U
* device instance $449 r0 *1 124.693,78.485 cap_mim_2f0_m4m5_noshield
X$449 \$10 topp cap_mim_2f0_m4m5_noshield c_length=2.714U c_width=2.714U
* device instance $450 r0 *1 129.807,78.485 cap_mim_2f0_m4m5_noshield
X$450 \$12 topp cap_mim_2f0_m4m5_noshield c_length=2.714U c_width=2.714U
* device instance $451 r0 *1 134.921,78.485 cap_mim_2f0_m4m5_noshield
X$451 \$10 topp cap_mim_2f0_m4m5_noshield c_length=2.714U c_width=2.714U
* device instance $452 r0 *1 140.035,78.485 cap_mim_2f0_m4m5_noshield
X$452 \$12 topp cap_mim_2f0_m4m5_noshield c_length=2.714U c_width=2.714U
* device instance $453 r0 *1 145.149,78.485 cap_mim_2f0_m4m5_noshield
X$453 \$10 topp cap_mim_2f0_m4m5_noshield c_length=2.714U c_width=2.714U
* device instance $454 r0 *1 150.263,78.485 cap_mim_2f0_m4m5_noshield
X$454 \$12 topp cap_mim_2f0_m4m5_noshield c_length=2.714U c_width=2.714U
* device instance $455 r0 *1 155.377,78.485 cap_mim_2f0_m4m5_noshield
X$455 \$10 topp cap_mim_2f0_m4m5_noshield c_length=2.714U c_width=2.714U
* device instance $456 r0 *1 160.491,78.485 cap_mim_2f0_m4m5_noshield
X$456 \$12 topp cap_mim_2f0_m4m5_noshield c_length=2.714U c_width=2.714U
* device instance $457 r0 *1 179.633,78.485 cap_mim_2f0_m4m5_noshield
X$457 \$90 topn cap_mim_2f0_m4m5_noshield c_length=2.714U c_width=2.714U
* device instance $458 r0 *1 184.747,78.485 cap_mim_2f0_m4m5_noshield
X$458 \$99 topn cap_mim_2f0_m4m5_noshield c_length=2.714U c_width=2.714U
* device instance $459 r0 *1 189.861,78.485 cap_mim_2f0_m4m5_noshield
X$459 \$90 topn cap_mim_2f0_m4m5_noshield c_length=2.714U c_width=2.714U
* device instance $460 r0 *1 194.975,78.485 cap_mim_2f0_m4m5_noshield
X$460 \$99 topn cap_mim_2f0_m4m5_noshield c_length=2.714U c_width=2.714U
* device instance $461 r0 *1 200.089,78.485 cap_mim_2f0_m4m5_noshield
X$461 \$90 topn cap_mim_2f0_m4m5_noshield c_length=2.714U c_width=2.714U
* device instance $462 r0 *1 205.203,78.485 cap_mim_2f0_m4m5_noshield
X$462 \$99 topn cap_mim_2f0_m4m5_noshield c_length=2.714U c_width=2.714U
* device instance $463 r0 *1 210.317,78.485 cap_mim_2f0_m4m5_noshield
X$463 \$90 topn cap_mim_2f0_m4m5_noshield c_length=2.714U c_width=2.714U
* device instance $464 r0 *1 215.431,78.485 cap_mim_2f0_m4m5_noshield
X$464 \$99 topn cap_mim_2f0_m4m5_noshield c_length=2.714U c_width=2.714U
* device instance $465 r0 *1 220.545,78.485 cap_mim_2f0_m4m5_noshield
X$465 \$90 topn cap_mim_2f0_m4m5_noshield c_length=2.714U c_width=2.714U
* device instance $466 r0 *1 225.659,78.485 cap_mim_2f0_m4m5_noshield
X$466 \$99 topn cap_mim_2f0_m4m5_noshield c_length=2.714U c_width=2.714U
* device instance $467 r0 *1 230.773,78.485 cap_mim_2f0_m4m5_noshield
X$467 \$90 topn cap_mim_2f0_m4m5_noshield c_length=2.714U c_width=2.714U
* device instance $468 r0 *1 235.887,78.485 cap_mim_2f0_m4m5_noshield
X$468 \$99 topn cap_mim_2f0_m4m5_noshield c_length=2.714U c_width=2.714U
* device instance $469 r0 *1 241.001,78.485 cap_mim_2f0_m4m5_noshield
X$469 \$90 topn cap_mim_2f0_m4m5_noshield c_length=2.714U c_width=2.714U
* device instance $470 r0 *1 246.115,78.485 cap_mim_2f0_m4m5_noshield
X$470 \$99 topn cap_mim_2f0_m4m5_noshield c_length=2.714U c_width=2.714U
* device instance $471 r0 *1 251.229,78.485 cap_mim_2f0_m4m5_noshield
X$471 \$90 topn cap_mim_2f0_m4m5_noshield c_length=2.714U c_width=2.714U
* device instance $472 r0 *1 256.343,78.485 cap_mim_2f0_m4m5_noshield
X$472 \$99 topn cap_mim_2f0_m4m5_noshield c_length=2.714U c_width=2.714U
* device instance $473 r0 *1 261.457,78.485 cap_mim_2f0_m4m5_noshield
X$473 \$90 topn cap_mim_2f0_m4m5_noshield c_length=2.714U c_width=2.714U
* device instance $474 r0 *1 266.571,78.485 cap_mim_2f0_m4m5_noshield
X$474 \$99 topn cap_mim_2f0_m4m5_noshield c_length=2.714U c_width=2.714U
* device instance $475 r0 *1 271.685,78.485 cap_mim_2f0_m4m5_noshield
X$475 \$90 topn cap_mim_2f0_m4m5_noshield c_length=2.714U c_width=2.714U
* device instance $476 r0 *1 276.799,78.485 cap_mim_2f0_m4m5_noshield
X$476 \$99 topn cap_mim_2f0_m4m5_noshield c_length=2.714U c_width=2.714U
* device instance $477 r0 *1 281.913,78.485 cap_mim_2f0_m4m5_noshield
X$477 \$90 topn cap_mim_2f0_m4m5_noshield c_length=2.714U c_width=2.714U
* device instance $478 r0 *1 287.027,78.485 cap_mim_2f0_m4m5_noshield
X$478 \$99 topn cap_mim_2f0_m4m5_noshield c_length=2.714U c_width=2.714U
* device instance $479 r0 *1 292.141,78.485 cap_mim_2f0_m4m5_noshield
X$479 \$90 topn cap_mim_2f0_m4m5_noshield c_length=2.714U c_width=2.714U
* device instance $480 r0 *1 297.255,78.485 cap_mim_2f0_m4m5_noshield
X$480 \$99 topn cap_mim_2f0_m4m5_noshield c_length=2.714U c_width=2.714U
* device instance $481 r0 *1 302.369,78.485 cap_mim_2f0_m4m5_noshield
X$481 \$90 topn cap_mim_2f0_m4m5_noshield c_length=2.714U c_width=2.714U
* device instance $482 r0 *1 307.483,78.485 cap_mim_2f0_m4m5_noshield
X$482 \$99 topn cap_mim_2f0_m4m5_noshield c_length=2.714U c_width=2.714U
* device instance $483 r0 *1 312.597,78.485 cap_mim_2f0_m4m5_noshield
X$483 \$90 topn cap_mim_2f0_m4m5_noshield c_length=2.714U c_width=2.714U
* device instance $484 r0 *1 317.711,78.485 cap_mim_2f0_m4m5_noshield
X$484 \$99 topn cap_mim_2f0_m4m5_noshield c_length=2.714U c_width=2.714U
* device instance $485 r0 *1 322.825,78.485 cap_mim_2f0_m4m5_noshield
X$485 \$90 topn cap_mim_2f0_m4m5_noshield c_length=2.714U c_width=2.714U
* device instance $486 r0 *1 327.939,78.485 cap_mim_2f0_m4m5_noshield
X$486 \$99 topn cap_mim_2f0_m4m5_noshield c_length=2.714U c_width=2.714U
* device instance $487 r0 *1 333.053,78.485 cap_mim_2f0_m4m5_noshield
X$487 \$90 topn cap_mim_2f0_m4m5_noshield c_length=2.714U c_width=2.714U
* device instance $488 r0 *1 338.167,78.485 cap_mim_2f0_m4m5_noshield
X$488 \$99 topn cap_mim_2f0_m4m5_noshield c_length=2.714U c_width=2.714U
* device instance $489 r0 *1 1.957,83.599 cap_mim_2f0_m4m5_noshield
X$489 \$10 topp cap_mim_2f0_m4m5_noshield c_length=2.714U c_width=2.714U
* device instance $490 r0 *1 7.071,83.599 cap_mim_2f0_m4m5_noshield
X$490 \$12 topp cap_mim_2f0_m4m5_noshield c_length=2.714U c_width=2.714U
* device instance $491 r0 *1 12.185,83.599 cap_mim_2f0_m4m5_noshield
X$491 \$10 topp cap_mim_2f0_m4m5_noshield c_length=2.714U c_width=2.714U
* device instance $492 r0 *1 17.299,83.599 cap_mim_2f0_m4m5_noshield
X$492 \$12 topp cap_mim_2f0_m4m5_noshield c_length=2.714U c_width=2.714U
* device instance $493 r0 *1 22.413,83.599 cap_mim_2f0_m4m5_noshield
X$493 \$10 topp cap_mim_2f0_m4m5_noshield c_length=2.714U c_width=2.714U
* device instance $494 r0 *1 27.527,83.599 cap_mim_2f0_m4m5_noshield
X$494 \$12 topp cap_mim_2f0_m4m5_noshield c_length=2.714U c_width=2.714U
* device instance $495 r0 *1 32.641,83.599 cap_mim_2f0_m4m5_noshield
X$495 \$10 topp cap_mim_2f0_m4m5_noshield c_length=2.714U c_width=2.714U
* device instance $496 r0 *1 37.755,83.599 cap_mim_2f0_m4m5_noshield
X$496 \$12 topp cap_mim_2f0_m4m5_noshield c_length=2.714U c_width=2.714U
* device instance $497 r0 *1 42.869,83.599 cap_mim_2f0_m4m5_noshield
X$497 \$10 topp cap_mim_2f0_m4m5_noshield c_length=2.714U c_width=2.714U
* device instance $498 r0 *1 47.983,83.599 cap_mim_2f0_m4m5_noshield
X$498 \$12 topp cap_mim_2f0_m4m5_noshield c_length=2.714U c_width=2.714U
* device instance $499 r0 *1 53.097,83.599 cap_mim_2f0_m4m5_noshield
X$499 \$10 topp cap_mim_2f0_m4m5_noshield c_length=2.714U c_width=2.714U
* device instance $500 r0 *1 58.211,83.599 cap_mim_2f0_m4m5_noshield
X$500 \$12 topp cap_mim_2f0_m4m5_noshield c_length=2.714U c_width=2.714U
* device instance $501 r0 *1 63.325,83.599 cap_mim_2f0_m4m5_noshield
X$501 \$10 topp cap_mim_2f0_m4m5_noshield c_length=2.714U c_width=2.714U
* device instance $502 r0 *1 68.439,83.599 cap_mim_2f0_m4m5_noshield
X$502 \$12 topp cap_mim_2f0_m4m5_noshield c_length=2.714U c_width=2.714U
* device instance $503 r0 *1 73.553,83.599 cap_mim_2f0_m4m5_noshield
X$503 \$10 topp cap_mim_2f0_m4m5_noshield c_length=2.714U c_width=2.714U
* device instance $504 r0 *1 78.667,83.599 cap_mim_2f0_m4m5_noshield
X$504 \$12 topp cap_mim_2f0_m4m5_noshield c_length=2.714U c_width=2.714U
* device instance $505 r0 *1 83.781,83.599 cap_mim_2f0_m4m5_noshield
X$505 \$10 topp cap_mim_2f0_m4m5_noshield c_length=2.714U c_width=2.714U
* device instance $506 r0 *1 88.895,83.599 cap_mim_2f0_m4m5_noshield
X$506 \$12 topp cap_mim_2f0_m4m5_noshield c_length=2.714U c_width=2.714U
* device instance $507 r0 *1 94.009,83.599 cap_mim_2f0_m4m5_noshield
X$507 \$10 topp cap_mim_2f0_m4m5_noshield c_length=2.714U c_width=2.714U
* device instance $508 r0 *1 99.123,83.599 cap_mim_2f0_m4m5_noshield
X$508 \$12 topp cap_mim_2f0_m4m5_noshield c_length=2.714U c_width=2.714U
* device instance $509 r0 *1 104.237,83.599 cap_mim_2f0_m4m5_noshield
X$509 \$10 topp cap_mim_2f0_m4m5_noshield c_length=2.714U c_width=2.714U
* device instance $510 r0 *1 109.351,83.599 cap_mim_2f0_m4m5_noshield
X$510 \$12 topp cap_mim_2f0_m4m5_noshield c_length=2.714U c_width=2.714U
* device instance $511 r0 *1 114.465,83.599 cap_mim_2f0_m4m5_noshield
X$511 \$10 topp cap_mim_2f0_m4m5_noshield c_length=2.714U c_width=2.714U
* device instance $512 r0 *1 119.579,83.599 cap_mim_2f0_m4m5_noshield
X$512 \$12 topp cap_mim_2f0_m4m5_noshield c_length=2.714U c_width=2.714U
* device instance $513 r0 *1 124.693,83.599 cap_mim_2f0_m4m5_noshield
X$513 \$10 topp cap_mim_2f0_m4m5_noshield c_length=2.714U c_width=2.714U
* device instance $514 r0 *1 129.807,83.599 cap_mim_2f0_m4m5_noshield
X$514 \$12 topp cap_mim_2f0_m4m5_noshield c_length=2.714U c_width=2.714U
* device instance $515 r0 *1 134.921,83.599 cap_mim_2f0_m4m5_noshield
X$515 \$10 topp cap_mim_2f0_m4m5_noshield c_length=2.714U c_width=2.714U
* device instance $516 r0 *1 140.035,83.599 cap_mim_2f0_m4m5_noshield
X$516 \$12 topp cap_mim_2f0_m4m5_noshield c_length=2.714U c_width=2.714U
* device instance $517 r0 *1 145.149,83.599 cap_mim_2f0_m4m5_noshield
X$517 \$10 topp cap_mim_2f0_m4m5_noshield c_length=2.714U c_width=2.714U
* device instance $518 r0 *1 150.263,83.599 cap_mim_2f0_m4m5_noshield
X$518 \$12 topp cap_mim_2f0_m4m5_noshield c_length=2.714U c_width=2.714U
* device instance $519 r0 *1 155.377,83.599 cap_mim_2f0_m4m5_noshield
X$519 \$10 topp cap_mim_2f0_m4m5_noshield c_length=2.714U c_width=2.714U
* device instance $520 r0 *1 160.491,83.599 cap_mim_2f0_m4m5_noshield
X$520 \$12 topp cap_mim_2f0_m4m5_noshield c_length=2.714U c_width=2.714U
* device instance $521 r0 *1 179.633,83.599 cap_mim_2f0_m4m5_noshield
X$521 \$90 topn cap_mim_2f0_m4m5_noshield c_length=2.714U c_width=2.714U
* device instance $522 r0 *1 184.747,83.599 cap_mim_2f0_m4m5_noshield
X$522 \$99 topn cap_mim_2f0_m4m5_noshield c_length=2.714U c_width=2.714U
* device instance $523 r0 *1 189.861,83.599 cap_mim_2f0_m4m5_noshield
X$523 \$90 topn cap_mim_2f0_m4m5_noshield c_length=2.714U c_width=2.714U
* device instance $524 r0 *1 194.975,83.599 cap_mim_2f0_m4m5_noshield
X$524 \$99 topn cap_mim_2f0_m4m5_noshield c_length=2.714U c_width=2.714U
* device instance $525 r0 *1 200.089,83.599 cap_mim_2f0_m4m5_noshield
X$525 \$90 topn cap_mim_2f0_m4m5_noshield c_length=2.714U c_width=2.714U
* device instance $526 r0 *1 205.203,83.599 cap_mim_2f0_m4m5_noshield
X$526 \$99 topn cap_mim_2f0_m4m5_noshield c_length=2.714U c_width=2.714U
* device instance $527 r0 *1 210.317,83.599 cap_mim_2f0_m4m5_noshield
X$527 \$90 topn cap_mim_2f0_m4m5_noshield c_length=2.714U c_width=2.714U
* device instance $528 r0 *1 215.431,83.599 cap_mim_2f0_m4m5_noshield
X$528 \$99 topn cap_mim_2f0_m4m5_noshield c_length=2.714U c_width=2.714U
* device instance $529 r0 *1 220.545,83.599 cap_mim_2f0_m4m5_noshield
X$529 \$90 topn cap_mim_2f0_m4m5_noshield c_length=2.714U c_width=2.714U
* device instance $530 r0 *1 225.659,83.599 cap_mim_2f0_m4m5_noshield
X$530 \$99 topn cap_mim_2f0_m4m5_noshield c_length=2.714U c_width=2.714U
* device instance $531 r0 *1 230.773,83.599 cap_mim_2f0_m4m5_noshield
X$531 \$90 topn cap_mim_2f0_m4m5_noshield c_length=2.714U c_width=2.714U
* device instance $532 r0 *1 235.887,83.599 cap_mim_2f0_m4m5_noshield
X$532 \$99 topn cap_mim_2f0_m4m5_noshield c_length=2.714U c_width=2.714U
* device instance $533 r0 *1 241.001,83.599 cap_mim_2f0_m4m5_noshield
X$533 \$90 topn cap_mim_2f0_m4m5_noshield c_length=2.714U c_width=2.714U
* device instance $534 r0 *1 246.115,83.599 cap_mim_2f0_m4m5_noshield
X$534 \$99 topn cap_mim_2f0_m4m5_noshield c_length=2.714U c_width=2.714U
* device instance $535 r0 *1 251.229,83.599 cap_mim_2f0_m4m5_noshield
X$535 \$90 topn cap_mim_2f0_m4m5_noshield c_length=2.714U c_width=2.714U
* device instance $536 r0 *1 256.343,83.599 cap_mim_2f0_m4m5_noshield
X$536 \$99 topn cap_mim_2f0_m4m5_noshield c_length=2.714U c_width=2.714U
* device instance $537 r0 *1 261.457,83.599 cap_mim_2f0_m4m5_noshield
X$537 \$90 topn cap_mim_2f0_m4m5_noshield c_length=2.714U c_width=2.714U
* device instance $538 r0 *1 266.571,83.599 cap_mim_2f0_m4m5_noshield
X$538 \$99 topn cap_mim_2f0_m4m5_noshield c_length=2.714U c_width=2.714U
* device instance $539 r0 *1 271.685,83.599 cap_mim_2f0_m4m5_noshield
X$539 \$90 topn cap_mim_2f0_m4m5_noshield c_length=2.714U c_width=2.714U
* device instance $540 r0 *1 276.799,83.599 cap_mim_2f0_m4m5_noshield
X$540 \$99 topn cap_mim_2f0_m4m5_noshield c_length=2.714U c_width=2.714U
* device instance $541 r0 *1 281.913,83.599 cap_mim_2f0_m4m5_noshield
X$541 \$90 topn cap_mim_2f0_m4m5_noshield c_length=2.714U c_width=2.714U
* device instance $542 r0 *1 287.027,83.599 cap_mim_2f0_m4m5_noshield
X$542 \$99 topn cap_mim_2f0_m4m5_noshield c_length=2.714U c_width=2.714U
* device instance $543 r0 *1 292.141,83.599 cap_mim_2f0_m4m5_noshield
X$543 \$90 topn cap_mim_2f0_m4m5_noshield c_length=2.714U c_width=2.714U
* device instance $544 r0 *1 297.255,83.599 cap_mim_2f0_m4m5_noshield
X$544 \$99 topn cap_mim_2f0_m4m5_noshield c_length=2.714U c_width=2.714U
* device instance $545 r0 *1 302.369,83.599 cap_mim_2f0_m4m5_noshield
X$545 \$90 topn cap_mim_2f0_m4m5_noshield c_length=2.714U c_width=2.714U
* device instance $546 r0 *1 307.483,83.599 cap_mim_2f0_m4m5_noshield
X$546 \$99 topn cap_mim_2f0_m4m5_noshield c_length=2.714U c_width=2.714U
* device instance $547 r0 *1 312.597,83.599 cap_mim_2f0_m4m5_noshield
X$547 \$90 topn cap_mim_2f0_m4m5_noshield c_length=2.714U c_width=2.714U
* device instance $548 r0 *1 317.711,83.599 cap_mim_2f0_m4m5_noshield
X$548 \$99 topn cap_mim_2f0_m4m5_noshield c_length=2.714U c_width=2.714U
* device instance $549 r0 *1 322.825,83.599 cap_mim_2f0_m4m5_noshield
X$549 \$90 topn cap_mim_2f0_m4m5_noshield c_length=2.714U c_width=2.714U
* device instance $550 r0 *1 327.939,83.599 cap_mim_2f0_m4m5_noshield
X$550 \$99 topn cap_mim_2f0_m4m5_noshield c_length=2.714U c_width=2.714U
* device instance $551 r0 *1 333.053,83.599 cap_mim_2f0_m4m5_noshield
X$551 \$90 topn cap_mim_2f0_m4m5_noshield c_length=2.714U c_width=2.714U
* device instance $552 r0 *1 338.167,83.599 cap_mim_2f0_m4m5_noshield
X$552 \$99 topn cap_mim_2f0_m4m5_noshield c_length=2.714U c_width=2.714U
* device instance $553 r0 *1 1.957,88.713 cap_mim_2f0_m4m5_noshield
X$553 \$12 topp cap_mim_2f0_m4m5_noshield c_length=2.714U c_width=2.714U
* device instance $554 r0 *1 7.071,88.713 cap_mim_2f0_m4m5_noshield
X$554 \$10 topp cap_mim_2f0_m4m5_noshield c_length=2.714U c_width=2.714U
* device instance $555 r0 *1 12.185,88.713 cap_mim_2f0_m4m5_noshield
X$555 \$12 topp cap_mim_2f0_m4m5_noshield c_length=2.714U c_width=2.714U
* device instance $556 r0 *1 17.299,88.713 cap_mim_2f0_m4m5_noshield
X$556 \$10 topp cap_mim_2f0_m4m5_noshield c_length=2.714U c_width=2.714U
* device instance $557 r0 *1 22.413,88.713 cap_mim_2f0_m4m5_noshield
X$557 \$12 topp cap_mim_2f0_m4m5_noshield c_length=2.714U c_width=2.714U
* device instance $558 r0 *1 27.527,88.713 cap_mim_2f0_m4m5_noshield
X$558 \$10 topp cap_mim_2f0_m4m5_noshield c_length=2.714U c_width=2.714U
* device instance $559 r0 *1 32.641,88.713 cap_mim_2f0_m4m5_noshield
X$559 \$12 topp cap_mim_2f0_m4m5_noshield c_length=2.714U c_width=2.714U
* device instance $560 r0 *1 37.755,88.713 cap_mim_2f0_m4m5_noshield
X$560 \$10 topp cap_mim_2f0_m4m5_noshield c_length=2.714U c_width=2.714U
* device instance $561 r0 *1 42.869,88.713 cap_mim_2f0_m4m5_noshield
X$561 \$12 topp cap_mim_2f0_m4m5_noshield c_length=2.714U c_width=2.714U
* device instance $562 r0 *1 47.983,88.713 cap_mim_2f0_m4m5_noshield
X$562 \$10 topp cap_mim_2f0_m4m5_noshield c_length=2.714U c_width=2.714U
* device instance $563 r0 *1 53.097,88.713 cap_mim_2f0_m4m5_noshield
X$563 \$12 topp cap_mim_2f0_m4m5_noshield c_length=2.714U c_width=2.714U
* device instance $564 r0 *1 58.211,88.713 cap_mim_2f0_m4m5_noshield
X$564 \$10 topp cap_mim_2f0_m4m5_noshield c_length=2.714U c_width=2.714U
* device instance $565 r0 *1 63.325,88.713 cap_mim_2f0_m4m5_noshield
X$565 \$12 topp cap_mim_2f0_m4m5_noshield c_length=2.714U c_width=2.714U
* device instance $566 r0 *1 68.439,88.713 cap_mim_2f0_m4m5_noshield
X$566 \$10 topp cap_mim_2f0_m4m5_noshield c_length=2.714U c_width=2.714U
* device instance $567 r0 *1 73.553,88.713 cap_mim_2f0_m4m5_noshield
X$567 \$12 topp cap_mim_2f0_m4m5_noshield c_length=2.714U c_width=2.714U
* device instance $568 r0 *1 78.667,88.713 cap_mim_2f0_m4m5_noshield
X$568 \$10 topp cap_mim_2f0_m4m5_noshield c_length=2.714U c_width=2.714U
* device instance $569 r0 *1 83.781,88.713 cap_mim_2f0_m4m5_noshield
X$569 \$12 topp cap_mim_2f0_m4m5_noshield c_length=2.714U c_width=2.714U
* device instance $570 r0 *1 88.895,88.713 cap_mim_2f0_m4m5_noshield
X$570 \$10 topp cap_mim_2f0_m4m5_noshield c_length=2.714U c_width=2.714U
* device instance $571 r0 *1 94.009,88.713 cap_mim_2f0_m4m5_noshield
X$571 \$12 topp cap_mim_2f0_m4m5_noshield c_length=2.714U c_width=2.714U
* device instance $572 r0 *1 99.123,88.713 cap_mim_2f0_m4m5_noshield
X$572 \$10 topp cap_mim_2f0_m4m5_noshield c_length=2.714U c_width=2.714U
* device instance $573 r0 *1 104.237,88.713 cap_mim_2f0_m4m5_noshield
X$573 \$12 topp cap_mim_2f0_m4m5_noshield c_length=2.714U c_width=2.714U
* device instance $574 r0 *1 109.351,88.713 cap_mim_2f0_m4m5_noshield
X$574 \$10 topp cap_mim_2f0_m4m5_noshield c_length=2.714U c_width=2.714U
* device instance $575 r0 *1 114.465,88.713 cap_mim_2f0_m4m5_noshield
X$575 \$12 topp cap_mim_2f0_m4m5_noshield c_length=2.714U c_width=2.714U
* device instance $576 r0 *1 119.579,88.713 cap_mim_2f0_m4m5_noshield
X$576 \$10 topp cap_mim_2f0_m4m5_noshield c_length=2.714U c_width=2.714U
* device instance $577 r0 *1 124.693,88.713 cap_mim_2f0_m4m5_noshield
X$577 \$12 topp cap_mim_2f0_m4m5_noshield c_length=2.714U c_width=2.714U
* device instance $578 r0 *1 129.807,88.713 cap_mim_2f0_m4m5_noshield
X$578 \$10 topp cap_mim_2f0_m4m5_noshield c_length=2.714U c_width=2.714U
* device instance $579 r0 *1 134.921,88.713 cap_mim_2f0_m4m5_noshield
X$579 \$12 topp cap_mim_2f0_m4m5_noshield c_length=2.714U c_width=2.714U
* device instance $580 r0 *1 140.035,88.713 cap_mim_2f0_m4m5_noshield
X$580 \$10 topp cap_mim_2f0_m4m5_noshield c_length=2.714U c_width=2.714U
* device instance $581 r0 *1 145.149,88.713 cap_mim_2f0_m4m5_noshield
X$581 \$12 topp cap_mim_2f0_m4m5_noshield c_length=2.714U c_width=2.714U
* device instance $582 r0 *1 150.263,88.713 cap_mim_2f0_m4m5_noshield
X$582 \$10 topp cap_mim_2f0_m4m5_noshield c_length=2.714U c_width=2.714U
* device instance $583 r0 *1 155.377,88.713 cap_mim_2f0_m4m5_noshield
X$583 \$12 topp cap_mim_2f0_m4m5_noshield c_length=2.714U c_width=2.714U
* device instance $584 r0 *1 160.491,88.713 cap_mim_2f0_m4m5_noshield
X$584 \$10 topp cap_mim_2f0_m4m5_noshield c_length=2.714U c_width=2.714U
* device instance $585 r0 *1 179.633,88.713 cap_mim_2f0_m4m5_noshield
X$585 \$99 topn cap_mim_2f0_m4m5_noshield c_length=2.714U c_width=2.714U
* device instance $586 r0 *1 184.747,88.713 cap_mim_2f0_m4m5_noshield
X$586 \$90 topn cap_mim_2f0_m4m5_noshield c_length=2.714U c_width=2.714U
* device instance $587 r0 *1 189.861,88.713 cap_mim_2f0_m4m5_noshield
X$587 \$99 topn cap_mim_2f0_m4m5_noshield c_length=2.714U c_width=2.714U
* device instance $588 r0 *1 194.975,88.713 cap_mim_2f0_m4m5_noshield
X$588 \$90 topn cap_mim_2f0_m4m5_noshield c_length=2.714U c_width=2.714U
* device instance $589 r0 *1 200.089,88.713 cap_mim_2f0_m4m5_noshield
X$589 \$99 topn cap_mim_2f0_m4m5_noshield c_length=2.714U c_width=2.714U
* device instance $590 r0 *1 205.203,88.713 cap_mim_2f0_m4m5_noshield
X$590 \$90 topn cap_mim_2f0_m4m5_noshield c_length=2.714U c_width=2.714U
* device instance $591 r0 *1 210.317,88.713 cap_mim_2f0_m4m5_noshield
X$591 \$99 topn cap_mim_2f0_m4m5_noshield c_length=2.714U c_width=2.714U
* device instance $592 r0 *1 215.431,88.713 cap_mim_2f0_m4m5_noshield
X$592 \$90 topn cap_mim_2f0_m4m5_noshield c_length=2.714U c_width=2.714U
* device instance $593 r0 *1 220.545,88.713 cap_mim_2f0_m4m5_noshield
X$593 \$99 topn cap_mim_2f0_m4m5_noshield c_length=2.714U c_width=2.714U
* device instance $594 r0 *1 225.659,88.713 cap_mim_2f0_m4m5_noshield
X$594 \$90 topn cap_mim_2f0_m4m5_noshield c_length=2.714U c_width=2.714U
* device instance $595 r0 *1 230.773,88.713 cap_mim_2f0_m4m5_noshield
X$595 \$99 topn cap_mim_2f0_m4m5_noshield c_length=2.714U c_width=2.714U
* device instance $596 r0 *1 235.887,88.713 cap_mim_2f0_m4m5_noshield
X$596 \$90 topn cap_mim_2f0_m4m5_noshield c_length=2.714U c_width=2.714U
* device instance $597 r0 *1 241.001,88.713 cap_mim_2f0_m4m5_noshield
X$597 \$99 topn cap_mim_2f0_m4m5_noshield c_length=2.714U c_width=2.714U
* device instance $598 r0 *1 246.115,88.713 cap_mim_2f0_m4m5_noshield
X$598 \$90 topn cap_mim_2f0_m4m5_noshield c_length=2.714U c_width=2.714U
* device instance $599 r0 *1 251.229,88.713 cap_mim_2f0_m4m5_noshield
X$599 \$99 topn cap_mim_2f0_m4m5_noshield c_length=2.714U c_width=2.714U
* device instance $600 r0 *1 256.343,88.713 cap_mim_2f0_m4m5_noshield
X$600 \$90 topn cap_mim_2f0_m4m5_noshield c_length=2.714U c_width=2.714U
* device instance $601 r0 *1 261.457,88.713 cap_mim_2f0_m4m5_noshield
X$601 \$99 topn cap_mim_2f0_m4m5_noshield c_length=2.714U c_width=2.714U
* device instance $602 r0 *1 266.571,88.713 cap_mim_2f0_m4m5_noshield
X$602 \$90 topn cap_mim_2f0_m4m5_noshield c_length=2.714U c_width=2.714U
* device instance $603 r0 *1 271.685,88.713 cap_mim_2f0_m4m5_noshield
X$603 \$99 topn cap_mim_2f0_m4m5_noshield c_length=2.714U c_width=2.714U
* device instance $604 r0 *1 276.799,88.713 cap_mim_2f0_m4m5_noshield
X$604 \$90 topn cap_mim_2f0_m4m5_noshield c_length=2.714U c_width=2.714U
* device instance $605 r0 *1 281.913,88.713 cap_mim_2f0_m4m5_noshield
X$605 \$99 topn cap_mim_2f0_m4m5_noshield c_length=2.714U c_width=2.714U
* device instance $606 r0 *1 287.027,88.713 cap_mim_2f0_m4m5_noshield
X$606 \$90 topn cap_mim_2f0_m4m5_noshield c_length=2.714U c_width=2.714U
* device instance $607 r0 *1 292.141,88.713 cap_mim_2f0_m4m5_noshield
X$607 \$99 topn cap_mim_2f0_m4m5_noshield c_length=2.714U c_width=2.714U
* device instance $608 r0 *1 297.255,88.713 cap_mim_2f0_m4m5_noshield
X$608 \$90 topn cap_mim_2f0_m4m5_noshield c_length=2.714U c_width=2.714U
* device instance $609 r0 *1 302.369,88.713 cap_mim_2f0_m4m5_noshield
X$609 \$99 topn cap_mim_2f0_m4m5_noshield c_length=2.714U c_width=2.714U
* device instance $610 r0 *1 307.483,88.713 cap_mim_2f0_m4m5_noshield
X$610 \$90 topn cap_mim_2f0_m4m5_noshield c_length=2.714U c_width=2.714U
* device instance $611 r0 *1 312.597,88.713 cap_mim_2f0_m4m5_noshield
X$611 \$99 topn cap_mim_2f0_m4m5_noshield c_length=2.714U c_width=2.714U
* device instance $612 r0 *1 317.711,88.713 cap_mim_2f0_m4m5_noshield
X$612 \$90 topn cap_mim_2f0_m4m5_noshield c_length=2.714U c_width=2.714U
* device instance $613 r0 *1 322.825,88.713 cap_mim_2f0_m4m5_noshield
X$613 \$99 topn cap_mim_2f0_m4m5_noshield c_length=2.714U c_width=2.714U
* device instance $614 r0 *1 327.939,88.713 cap_mim_2f0_m4m5_noshield
X$614 \$90 topn cap_mim_2f0_m4m5_noshield c_length=2.714U c_width=2.714U
* device instance $615 r0 *1 333.053,88.713 cap_mim_2f0_m4m5_noshield
X$615 \$99 topn cap_mim_2f0_m4m5_noshield c_length=2.714U c_width=2.714U
* device instance $616 r0 *1 338.167,88.713 cap_mim_2f0_m4m5_noshield
X$616 \$90 topn cap_mim_2f0_m4m5_noshield c_length=2.714U c_width=2.714U
* device instance $617 r0 *1 1.957,93.827 cap_mim_2f0_m4m5_noshield
X$617 \$12 topp cap_mim_2f0_m4m5_noshield c_length=2.714U c_width=2.714U
* device instance $618 r0 *1 7.071,93.827 cap_mim_2f0_m4m5_noshield
X$618 \$10 topp cap_mim_2f0_m4m5_noshield c_length=2.714U c_width=2.714U
* device instance $619 r0 *1 12.185,93.827 cap_mim_2f0_m4m5_noshield
X$619 \$12 topp cap_mim_2f0_m4m5_noshield c_length=2.714U c_width=2.714U
* device instance $620 r0 *1 17.299,93.827 cap_mim_2f0_m4m5_noshield
X$620 \$10 topp cap_mim_2f0_m4m5_noshield c_length=2.714U c_width=2.714U
* device instance $621 r0 *1 22.413,93.827 cap_mim_2f0_m4m5_noshield
X$621 \$12 topp cap_mim_2f0_m4m5_noshield c_length=2.714U c_width=2.714U
* device instance $622 r0 *1 27.527,93.827 cap_mim_2f0_m4m5_noshield
X$622 \$10 topp cap_mim_2f0_m4m5_noshield c_length=2.714U c_width=2.714U
* device instance $623 r0 *1 32.641,93.827 cap_mim_2f0_m4m5_noshield
X$623 \$12 topp cap_mim_2f0_m4m5_noshield c_length=2.714U c_width=2.714U
* device instance $624 r0 *1 37.755,93.827 cap_mim_2f0_m4m5_noshield
X$624 \$10 topp cap_mim_2f0_m4m5_noshield c_length=2.714U c_width=2.714U
* device instance $625 r0 *1 42.869,93.827 cap_mim_2f0_m4m5_noshield
X$625 \$12 topp cap_mim_2f0_m4m5_noshield c_length=2.714U c_width=2.714U
* device instance $626 r0 *1 47.983,93.827 cap_mim_2f0_m4m5_noshield
X$626 \$10 topp cap_mim_2f0_m4m5_noshield c_length=2.714U c_width=2.714U
* device instance $627 r0 *1 53.097,93.827 cap_mim_2f0_m4m5_noshield
X$627 \$12 topp cap_mim_2f0_m4m5_noshield c_length=2.714U c_width=2.714U
* device instance $628 r0 *1 58.211,93.827 cap_mim_2f0_m4m5_noshield
X$628 \$10 topp cap_mim_2f0_m4m5_noshield c_length=2.714U c_width=2.714U
* device instance $629 r0 *1 63.325,93.827 cap_mim_2f0_m4m5_noshield
X$629 \$12 topp cap_mim_2f0_m4m5_noshield c_length=2.714U c_width=2.714U
* device instance $630 r0 *1 68.439,93.827 cap_mim_2f0_m4m5_noshield
X$630 \$10 topp cap_mim_2f0_m4m5_noshield c_length=2.714U c_width=2.714U
* device instance $631 r0 *1 73.553,93.827 cap_mim_2f0_m4m5_noshield
X$631 \$12 topp cap_mim_2f0_m4m5_noshield c_length=2.714U c_width=2.714U
* device instance $632 r0 *1 78.667,93.827 cap_mim_2f0_m4m5_noshield
X$632 \$10 topp cap_mim_2f0_m4m5_noshield c_length=2.714U c_width=2.714U
* device instance $633 r0 *1 83.781,93.827 cap_mim_2f0_m4m5_noshield
X$633 \$12 topp cap_mim_2f0_m4m5_noshield c_length=2.714U c_width=2.714U
* device instance $634 r0 *1 88.895,93.827 cap_mim_2f0_m4m5_noshield
X$634 \$10 topp cap_mim_2f0_m4m5_noshield c_length=2.714U c_width=2.714U
* device instance $635 r0 *1 94.009,93.827 cap_mim_2f0_m4m5_noshield
X$635 \$12 topp cap_mim_2f0_m4m5_noshield c_length=2.714U c_width=2.714U
* device instance $636 r0 *1 99.123,93.827 cap_mim_2f0_m4m5_noshield
X$636 \$10 topp cap_mim_2f0_m4m5_noshield c_length=2.714U c_width=2.714U
* device instance $637 r0 *1 104.237,93.827 cap_mim_2f0_m4m5_noshield
X$637 \$12 topp cap_mim_2f0_m4m5_noshield c_length=2.714U c_width=2.714U
* device instance $638 r0 *1 109.351,93.827 cap_mim_2f0_m4m5_noshield
X$638 \$10 topp cap_mim_2f0_m4m5_noshield c_length=2.714U c_width=2.714U
* device instance $639 r0 *1 114.465,93.827 cap_mim_2f0_m4m5_noshield
X$639 \$12 topp cap_mim_2f0_m4m5_noshield c_length=2.714U c_width=2.714U
* device instance $640 r0 *1 119.579,93.827 cap_mim_2f0_m4m5_noshield
X$640 \$10 topp cap_mim_2f0_m4m5_noshield c_length=2.714U c_width=2.714U
* device instance $641 r0 *1 124.693,93.827 cap_mim_2f0_m4m5_noshield
X$641 \$12 topp cap_mim_2f0_m4m5_noshield c_length=2.714U c_width=2.714U
* device instance $642 r0 *1 129.807,93.827 cap_mim_2f0_m4m5_noshield
X$642 \$10 topp cap_mim_2f0_m4m5_noshield c_length=2.714U c_width=2.714U
* device instance $643 r0 *1 134.921,93.827 cap_mim_2f0_m4m5_noshield
X$643 \$12 topp cap_mim_2f0_m4m5_noshield c_length=2.714U c_width=2.714U
* device instance $644 r0 *1 140.035,93.827 cap_mim_2f0_m4m5_noshield
X$644 \$10 topp cap_mim_2f0_m4m5_noshield c_length=2.714U c_width=2.714U
* device instance $645 r0 *1 145.149,93.827 cap_mim_2f0_m4m5_noshield
X$645 \$12 topp cap_mim_2f0_m4m5_noshield c_length=2.714U c_width=2.714U
* device instance $646 r0 *1 150.263,93.827 cap_mim_2f0_m4m5_noshield
X$646 \$10 topp cap_mim_2f0_m4m5_noshield c_length=2.714U c_width=2.714U
* device instance $647 r0 *1 155.377,93.827 cap_mim_2f0_m4m5_noshield
X$647 \$12 topp cap_mim_2f0_m4m5_noshield c_length=2.714U c_width=2.714U
* device instance $648 r0 *1 160.491,93.827 cap_mim_2f0_m4m5_noshield
X$648 \$10 topp cap_mim_2f0_m4m5_noshield c_length=2.714U c_width=2.714U
* device instance $649 r0 *1 179.633,93.827 cap_mim_2f0_m4m5_noshield
X$649 \$99 topn cap_mim_2f0_m4m5_noshield c_length=2.714U c_width=2.714U
* device instance $650 r0 *1 184.747,93.827 cap_mim_2f0_m4m5_noshield
X$650 \$90 topn cap_mim_2f0_m4m5_noshield c_length=2.714U c_width=2.714U
* device instance $651 r0 *1 189.861,93.827 cap_mim_2f0_m4m5_noshield
X$651 \$99 topn cap_mim_2f0_m4m5_noshield c_length=2.714U c_width=2.714U
* device instance $652 r0 *1 194.975,93.827 cap_mim_2f0_m4m5_noshield
X$652 \$90 topn cap_mim_2f0_m4m5_noshield c_length=2.714U c_width=2.714U
* device instance $653 r0 *1 200.089,93.827 cap_mim_2f0_m4m5_noshield
X$653 \$99 topn cap_mim_2f0_m4m5_noshield c_length=2.714U c_width=2.714U
* device instance $654 r0 *1 205.203,93.827 cap_mim_2f0_m4m5_noshield
X$654 \$90 topn cap_mim_2f0_m4m5_noshield c_length=2.714U c_width=2.714U
* device instance $655 r0 *1 210.317,93.827 cap_mim_2f0_m4m5_noshield
X$655 \$99 topn cap_mim_2f0_m4m5_noshield c_length=2.714U c_width=2.714U
* device instance $656 r0 *1 215.431,93.827 cap_mim_2f0_m4m5_noshield
X$656 \$90 topn cap_mim_2f0_m4m5_noshield c_length=2.714U c_width=2.714U
* device instance $657 r0 *1 220.545,93.827 cap_mim_2f0_m4m5_noshield
X$657 \$99 topn cap_mim_2f0_m4m5_noshield c_length=2.714U c_width=2.714U
* device instance $658 r0 *1 225.659,93.827 cap_mim_2f0_m4m5_noshield
X$658 \$90 topn cap_mim_2f0_m4m5_noshield c_length=2.714U c_width=2.714U
* device instance $659 r0 *1 230.773,93.827 cap_mim_2f0_m4m5_noshield
X$659 \$99 topn cap_mim_2f0_m4m5_noshield c_length=2.714U c_width=2.714U
* device instance $660 r0 *1 235.887,93.827 cap_mim_2f0_m4m5_noshield
X$660 \$90 topn cap_mim_2f0_m4m5_noshield c_length=2.714U c_width=2.714U
* device instance $661 r0 *1 241.001,93.827 cap_mim_2f0_m4m5_noshield
X$661 \$99 topn cap_mim_2f0_m4m5_noshield c_length=2.714U c_width=2.714U
* device instance $662 r0 *1 246.115,93.827 cap_mim_2f0_m4m5_noshield
X$662 \$90 topn cap_mim_2f0_m4m5_noshield c_length=2.714U c_width=2.714U
* device instance $663 r0 *1 251.229,93.827 cap_mim_2f0_m4m5_noshield
X$663 \$99 topn cap_mim_2f0_m4m5_noshield c_length=2.714U c_width=2.714U
* device instance $664 r0 *1 256.343,93.827 cap_mim_2f0_m4m5_noshield
X$664 \$90 topn cap_mim_2f0_m4m5_noshield c_length=2.714U c_width=2.714U
* device instance $665 r0 *1 261.457,93.827 cap_mim_2f0_m4m5_noshield
X$665 \$99 topn cap_mim_2f0_m4m5_noshield c_length=2.714U c_width=2.714U
* device instance $666 r0 *1 266.571,93.827 cap_mim_2f0_m4m5_noshield
X$666 \$90 topn cap_mim_2f0_m4m5_noshield c_length=2.714U c_width=2.714U
* device instance $667 r0 *1 271.685,93.827 cap_mim_2f0_m4m5_noshield
X$667 \$99 topn cap_mim_2f0_m4m5_noshield c_length=2.714U c_width=2.714U
* device instance $668 r0 *1 276.799,93.827 cap_mim_2f0_m4m5_noshield
X$668 \$90 topn cap_mim_2f0_m4m5_noshield c_length=2.714U c_width=2.714U
* device instance $669 r0 *1 281.913,93.827 cap_mim_2f0_m4m5_noshield
X$669 \$99 topn cap_mim_2f0_m4m5_noshield c_length=2.714U c_width=2.714U
* device instance $670 r0 *1 287.027,93.827 cap_mim_2f0_m4m5_noshield
X$670 \$90 topn cap_mim_2f0_m4m5_noshield c_length=2.714U c_width=2.714U
* device instance $671 r0 *1 292.141,93.827 cap_mim_2f0_m4m5_noshield
X$671 \$99 topn cap_mim_2f0_m4m5_noshield c_length=2.714U c_width=2.714U
* device instance $672 r0 *1 297.255,93.827 cap_mim_2f0_m4m5_noshield
X$672 \$90 topn cap_mim_2f0_m4m5_noshield c_length=2.714U c_width=2.714U
* device instance $673 r0 *1 302.369,93.827 cap_mim_2f0_m4m5_noshield
X$673 \$99 topn cap_mim_2f0_m4m5_noshield c_length=2.714U c_width=2.714U
* device instance $674 r0 *1 307.483,93.827 cap_mim_2f0_m4m5_noshield
X$674 \$90 topn cap_mim_2f0_m4m5_noshield c_length=2.714U c_width=2.714U
* device instance $675 r0 *1 312.597,93.827 cap_mim_2f0_m4m5_noshield
X$675 \$99 topn cap_mim_2f0_m4m5_noshield c_length=2.714U c_width=2.714U
* device instance $676 r0 *1 317.711,93.827 cap_mim_2f0_m4m5_noshield
X$676 \$90 topn cap_mim_2f0_m4m5_noshield c_length=2.714U c_width=2.714U
* device instance $677 r0 *1 322.825,93.827 cap_mim_2f0_m4m5_noshield
X$677 \$99 topn cap_mim_2f0_m4m5_noshield c_length=2.714U c_width=2.714U
* device instance $678 r0 *1 327.939,93.827 cap_mim_2f0_m4m5_noshield
X$678 \$90 topn cap_mim_2f0_m4m5_noshield c_length=2.714U c_width=2.714U
* device instance $679 r0 *1 333.053,93.827 cap_mim_2f0_m4m5_noshield
X$679 \$99 topn cap_mim_2f0_m4m5_noshield c_length=2.714U c_width=2.714U
* device instance $680 r0 *1 338.167,93.827 cap_mim_2f0_m4m5_noshield
X$680 \$90 topn cap_mim_2f0_m4m5_noshield c_length=2.714U c_width=2.714U
* device instance $681 r0 *1 1.957,98.941 cap_mim_2f0_m4m5_noshield
X$681 \$14 topp cap_mim_2f0_m4m5_noshield c_length=2.714U c_width=2.714U
* device instance $682 r0 *1 7.071,98.941 cap_mim_2f0_m4m5_noshield
X$682 \$10 topp cap_mim_2f0_m4m5_noshield c_length=2.714U c_width=2.714U
* device instance $683 r0 *1 12.185,98.941 cap_mim_2f0_m4m5_noshield
X$683 \$14 topp cap_mim_2f0_m4m5_noshield c_length=2.714U c_width=2.714U
* device instance $684 r0 *1 17.299,98.941 cap_mim_2f0_m4m5_noshield
X$684 \$10 topp cap_mim_2f0_m4m5_noshield c_length=2.714U c_width=2.714U
* device instance $685 r0 *1 22.413,98.941 cap_mim_2f0_m4m5_noshield
X$685 \$14 topp cap_mim_2f0_m4m5_noshield c_length=2.714U c_width=2.714U
* device instance $686 r0 *1 27.527,98.941 cap_mim_2f0_m4m5_noshield
X$686 \$10 topp cap_mim_2f0_m4m5_noshield c_length=2.714U c_width=2.714U
* device instance $687 r0 *1 32.641,98.941 cap_mim_2f0_m4m5_noshield
X$687 \$14 topp cap_mim_2f0_m4m5_noshield c_length=2.714U c_width=2.714U
* device instance $688 r0 *1 37.755,98.941 cap_mim_2f0_m4m5_noshield
X$688 \$10 topp cap_mim_2f0_m4m5_noshield c_length=2.714U c_width=2.714U
* device instance $689 r0 *1 42.869,98.941 cap_mim_2f0_m4m5_noshield
X$689 \$14 topp cap_mim_2f0_m4m5_noshield c_length=2.714U c_width=2.714U
* device instance $690 r0 *1 47.983,98.941 cap_mim_2f0_m4m5_noshield
X$690 \$10 topp cap_mim_2f0_m4m5_noshield c_length=2.714U c_width=2.714U
* device instance $691 r0 *1 53.097,98.941 cap_mim_2f0_m4m5_noshield
X$691 \$14 topp cap_mim_2f0_m4m5_noshield c_length=2.714U c_width=2.714U
* device instance $692 r0 *1 58.211,98.941 cap_mim_2f0_m4m5_noshield
X$692 \$10 topp cap_mim_2f0_m4m5_noshield c_length=2.714U c_width=2.714U
* device instance $693 r0 *1 63.325,98.941 cap_mim_2f0_m4m5_noshield
X$693 \$14 topp cap_mim_2f0_m4m5_noshield c_length=2.714U c_width=2.714U
* device instance $694 r0 *1 68.439,98.941 cap_mim_2f0_m4m5_noshield
X$694 \$10 topp cap_mim_2f0_m4m5_noshield c_length=2.714U c_width=2.714U
* device instance $695 r0 *1 73.553,98.941 cap_mim_2f0_m4m5_noshield
X$695 \$14 topp cap_mim_2f0_m4m5_noshield c_length=2.714U c_width=2.714U
* device instance $696 r0 *1 78.667,98.941 cap_mim_2f0_m4m5_noshield
X$696 \$10 topp cap_mim_2f0_m4m5_noshield c_length=2.714U c_width=2.714U
* device instance $697 r0 *1 83.781,98.941 cap_mim_2f0_m4m5_noshield
X$697 \$14 topp cap_mim_2f0_m4m5_noshield c_length=2.714U c_width=2.714U
* device instance $698 r0 *1 88.895,98.941 cap_mim_2f0_m4m5_noshield
X$698 \$10 topp cap_mim_2f0_m4m5_noshield c_length=2.714U c_width=2.714U
* device instance $699 r0 *1 94.009,98.941 cap_mim_2f0_m4m5_noshield
X$699 \$14 topp cap_mim_2f0_m4m5_noshield c_length=2.714U c_width=2.714U
* device instance $700 r0 *1 99.123,98.941 cap_mim_2f0_m4m5_noshield
X$700 \$10 topp cap_mim_2f0_m4m5_noshield c_length=2.714U c_width=2.714U
* device instance $701 r0 *1 104.237,98.941 cap_mim_2f0_m4m5_noshield
X$701 \$14 topp cap_mim_2f0_m4m5_noshield c_length=2.714U c_width=2.714U
* device instance $702 r0 *1 109.351,98.941 cap_mim_2f0_m4m5_noshield
X$702 \$10 topp cap_mim_2f0_m4m5_noshield c_length=2.714U c_width=2.714U
* device instance $703 r0 *1 114.465,98.941 cap_mim_2f0_m4m5_noshield
X$703 \$14 topp cap_mim_2f0_m4m5_noshield c_length=2.714U c_width=2.714U
* device instance $704 r0 *1 119.579,98.941 cap_mim_2f0_m4m5_noshield
X$704 \$10 topp cap_mim_2f0_m4m5_noshield c_length=2.714U c_width=2.714U
* device instance $705 r0 *1 124.693,98.941 cap_mim_2f0_m4m5_noshield
X$705 \$14 topp cap_mim_2f0_m4m5_noshield c_length=2.714U c_width=2.714U
* device instance $706 r0 *1 129.807,98.941 cap_mim_2f0_m4m5_noshield
X$706 \$10 topp cap_mim_2f0_m4m5_noshield c_length=2.714U c_width=2.714U
* device instance $707 r0 *1 134.921,98.941 cap_mim_2f0_m4m5_noshield
X$707 \$14 topp cap_mim_2f0_m4m5_noshield c_length=2.714U c_width=2.714U
* device instance $708 r0 *1 140.035,98.941 cap_mim_2f0_m4m5_noshield
X$708 \$10 topp cap_mim_2f0_m4m5_noshield c_length=2.714U c_width=2.714U
* device instance $709 r0 *1 145.149,98.941 cap_mim_2f0_m4m5_noshield
X$709 \$14 topp cap_mim_2f0_m4m5_noshield c_length=2.714U c_width=2.714U
* device instance $710 r0 *1 150.263,98.941 cap_mim_2f0_m4m5_noshield
X$710 \$10 topp cap_mim_2f0_m4m5_noshield c_length=2.714U c_width=2.714U
* device instance $711 r0 *1 155.377,98.941 cap_mim_2f0_m4m5_noshield
X$711 \$14 topp cap_mim_2f0_m4m5_noshield c_length=2.714U c_width=2.714U
* device instance $712 r0 *1 160.491,98.941 cap_mim_2f0_m4m5_noshield
X$712 \$10 topp cap_mim_2f0_m4m5_noshield c_length=2.714U c_width=2.714U
* device instance $713 r0 *1 179.633,98.941 cap_mim_2f0_m4m5_noshield
X$713 \$107 topn cap_mim_2f0_m4m5_noshield c_length=2.714U c_width=2.714U
* device instance $714 r0 *1 184.747,98.941 cap_mim_2f0_m4m5_noshield
X$714 \$90 topn cap_mim_2f0_m4m5_noshield c_length=2.714U c_width=2.714U
* device instance $715 r0 *1 189.861,98.941 cap_mim_2f0_m4m5_noshield
X$715 \$107 topn cap_mim_2f0_m4m5_noshield c_length=2.714U c_width=2.714U
* device instance $716 r0 *1 194.975,98.941 cap_mim_2f0_m4m5_noshield
X$716 \$90 topn cap_mim_2f0_m4m5_noshield c_length=2.714U c_width=2.714U
* device instance $717 r0 *1 200.089,98.941 cap_mim_2f0_m4m5_noshield
X$717 \$107 topn cap_mim_2f0_m4m5_noshield c_length=2.714U c_width=2.714U
* device instance $718 r0 *1 205.203,98.941 cap_mim_2f0_m4m5_noshield
X$718 \$90 topn cap_mim_2f0_m4m5_noshield c_length=2.714U c_width=2.714U
* device instance $719 r0 *1 210.317,98.941 cap_mim_2f0_m4m5_noshield
X$719 \$107 topn cap_mim_2f0_m4m5_noshield c_length=2.714U c_width=2.714U
* device instance $720 r0 *1 215.431,98.941 cap_mim_2f0_m4m5_noshield
X$720 \$90 topn cap_mim_2f0_m4m5_noshield c_length=2.714U c_width=2.714U
* device instance $721 r0 *1 220.545,98.941 cap_mim_2f0_m4m5_noshield
X$721 \$107 topn cap_mim_2f0_m4m5_noshield c_length=2.714U c_width=2.714U
* device instance $722 r0 *1 225.659,98.941 cap_mim_2f0_m4m5_noshield
X$722 \$90 topn cap_mim_2f0_m4m5_noshield c_length=2.714U c_width=2.714U
* device instance $723 r0 *1 230.773,98.941 cap_mim_2f0_m4m5_noshield
X$723 \$107 topn cap_mim_2f0_m4m5_noshield c_length=2.714U c_width=2.714U
* device instance $724 r0 *1 235.887,98.941 cap_mim_2f0_m4m5_noshield
X$724 \$90 topn cap_mim_2f0_m4m5_noshield c_length=2.714U c_width=2.714U
* device instance $725 r0 *1 241.001,98.941 cap_mim_2f0_m4m5_noshield
X$725 \$107 topn cap_mim_2f0_m4m5_noshield c_length=2.714U c_width=2.714U
* device instance $726 r0 *1 246.115,98.941 cap_mim_2f0_m4m5_noshield
X$726 \$90 topn cap_mim_2f0_m4m5_noshield c_length=2.714U c_width=2.714U
* device instance $727 r0 *1 251.229,98.941 cap_mim_2f0_m4m5_noshield
X$727 \$107 topn cap_mim_2f0_m4m5_noshield c_length=2.714U c_width=2.714U
* device instance $728 r0 *1 256.343,98.941 cap_mim_2f0_m4m5_noshield
X$728 \$90 topn cap_mim_2f0_m4m5_noshield c_length=2.714U c_width=2.714U
* device instance $729 r0 *1 261.457,98.941 cap_mim_2f0_m4m5_noshield
X$729 \$107 topn cap_mim_2f0_m4m5_noshield c_length=2.714U c_width=2.714U
* device instance $730 r0 *1 266.571,98.941 cap_mim_2f0_m4m5_noshield
X$730 \$90 topn cap_mim_2f0_m4m5_noshield c_length=2.714U c_width=2.714U
* device instance $731 r0 *1 271.685,98.941 cap_mim_2f0_m4m5_noshield
X$731 \$107 topn cap_mim_2f0_m4m5_noshield c_length=2.714U c_width=2.714U
* device instance $732 r0 *1 276.799,98.941 cap_mim_2f0_m4m5_noshield
X$732 \$90 topn cap_mim_2f0_m4m5_noshield c_length=2.714U c_width=2.714U
* device instance $733 r0 *1 281.913,98.941 cap_mim_2f0_m4m5_noshield
X$733 \$107 topn cap_mim_2f0_m4m5_noshield c_length=2.714U c_width=2.714U
* device instance $734 r0 *1 287.027,98.941 cap_mim_2f0_m4m5_noshield
X$734 \$90 topn cap_mim_2f0_m4m5_noshield c_length=2.714U c_width=2.714U
* device instance $735 r0 *1 292.141,98.941 cap_mim_2f0_m4m5_noshield
X$735 \$107 topn cap_mim_2f0_m4m5_noshield c_length=2.714U c_width=2.714U
* device instance $736 r0 *1 297.255,98.941 cap_mim_2f0_m4m5_noshield
X$736 \$90 topn cap_mim_2f0_m4m5_noshield c_length=2.714U c_width=2.714U
* device instance $737 r0 *1 302.369,98.941 cap_mim_2f0_m4m5_noshield
X$737 \$107 topn cap_mim_2f0_m4m5_noshield c_length=2.714U c_width=2.714U
* device instance $738 r0 *1 307.483,98.941 cap_mim_2f0_m4m5_noshield
X$738 \$90 topn cap_mim_2f0_m4m5_noshield c_length=2.714U c_width=2.714U
* device instance $739 r0 *1 312.597,98.941 cap_mim_2f0_m4m5_noshield
X$739 \$107 topn cap_mim_2f0_m4m5_noshield c_length=2.714U c_width=2.714U
* device instance $740 r0 *1 317.711,98.941 cap_mim_2f0_m4m5_noshield
X$740 \$90 topn cap_mim_2f0_m4m5_noshield c_length=2.714U c_width=2.714U
* device instance $741 r0 *1 322.825,98.941 cap_mim_2f0_m4m5_noshield
X$741 \$107 topn cap_mim_2f0_m4m5_noshield c_length=2.714U c_width=2.714U
* device instance $742 r0 *1 327.939,98.941 cap_mim_2f0_m4m5_noshield
X$742 \$90 topn cap_mim_2f0_m4m5_noshield c_length=2.714U c_width=2.714U
* device instance $743 r0 *1 333.053,98.941 cap_mim_2f0_m4m5_noshield
X$743 \$107 topn cap_mim_2f0_m4m5_noshield c_length=2.714U c_width=2.714U
* device instance $744 r0 *1 338.167,98.941 cap_mim_2f0_m4m5_noshield
X$744 \$90 topn cap_mim_2f0_m4m5_noshield c_length=2.714U c_width=2.714U
* device instance $745 r0 *1 1.957,104.055 cap_mim_2f0_m4m5_noshield
X$745 \$16 topp cap_mim_2f0_m4m5_noshield c_length=2.714U c_width=2.714U
* device instance $746 r0 *1 7.071,104.055 cap_mim_2f0_m4m5_noshield
X$746 \$10 topp cap_mim_2f0_m4m5_noshield c_length=2.714U c_width=2.714U
* device instance $747 r0 *1 12.185,104.055 cap_mim_2f0_m4m5_noshield
X$747 \$16 topp cap_mim_2f0_m4m5_noshield c_length=2.714U c_width=2.714U
* device instance $748 r0 *1 17.299,104.055 cap_mim_2f0_m4m5_noshield
X$748 \$10 topp cap_mim_2f0_m4m5_noshield c_length=2.714U c_width=2.714U
* device instance $749 r0 *1 22.413,104.055 cap_mim_2f0_m4m5_noshield
X$749 \$16 topp cap_mim_2f0_m4m5_noshield c_length=2.714U c_width=2.714U
* device instance $750 r0 *1 27.527,104.055 cap_mim_2f0_m4m5_noshield
X$750 \$10 topp cap_mim_2f0_m4m5_noshield c_length=2.714U c_width=2.714U
* device instance $751 r0 *1 32.641,104.055 cap_mim_2f0_m4m5_noshield
X$751 \$16 topp cap_mim_2f0_m4m5_noshield c_length=2.714U c_width=2.714U
* device instance $752 r0 *1 37.755,104.055 cap_mim_2f0_m4m5_noshield
X$752 \$10 topp cap_mim_2f0_m4m5_noshield c_length=2.714U c_width=2.714U
* device instance $753 r0 *1 42.869,104.055 cap_mim_2f0_m4m5_noshield
X$753 \$16 topp cap_mim_2f0_m4m5_noshield c_length=2.714U c_width=2.714U
* device instance $754 r0 *1 47.983,104.055 cap_mim_2f0_m4m5_noshield
X$754 \$10 topp cap_mim_2f0_m4m5_noshield c_length=2.714U c_width=2.714U
* device instance $755 r0 *1 53.097,104.055 cap_mim_2f0_m4m5_noshield
X$755 \$16 topp cap_mim_2f0_m4m5_noshield c_length=2.714U c_width=2.714U
* device instance $756 r0 *1 58.211,104.055 cap_mim_2f0_m4m5_noshield
X$756 \$10 topp cap_mim_2f0_m4m5_noshield c_length=2.714U c_width=2.714U
* device instance $757 r0 *1 63.325,104.055 cap_mim_2f0_m4m5_noshield
X$757 \$16 topp cap_mim_2f0_m4m5_noshield c_length=2.714U c_width=2.714U
* device instance $758 r0 *1 68.439,104.055 cap_mim_2f0_m4m5_noshield
X$758 \$10 topp cap_mim_2f0_m4m5_noshield c_length=2.714U c_width=2.714U
* device instance $759 r0 *1 73.553,104.055 cap_mim_2f0_m4m5_noshield
X$759 \$16 topp cap_mim_2f0_m4m5_noshield c_length=2.714U c_width=2.714U
* device instance $760 r0 *1 78.667,104.055 cap_mim_2f0_m4m5_noshield
X$760 \$10 topp cap_mim_2f0_m4m5_noshield c_length=2.714U c_width=2.714U
* device instance $761 r0 *1 83.781,104.055 cap_mim_2f0_m4m5_noshield
X$761 \$18 topp cap_mim_2f0_m4m5_noshield c_length=2.714U c_width=2.714U
* device instance $762 r0 *1 88.895,104.055 cap_mim_2f0_m4m5_noshield
X$762 \$10 topp cap_mim_2f0_m4m5_noshield c_length=2.714U c_width=2.714U
* device instance $763 r0 *1 94.009,104.055 cap_mim_2f0_m4m5_noshield
X$763 \$18 topp cap_mim_2f0_m4m5_noshield c_length=2.714U c_width=2.714U
* device instance $764 r0 *1 99.123,104.055 cap_mim_2f0_m4m5_noshield
X$764 \$10 topp cap_mim_2f0_m4m5_noshield c_length=2.714U c_width=2.714U
* device instance $765 r0 *1 104.237,104.055 cap_mim_2f0_m4m5_noshield
X$765 \$18 topp cap_mim_2f0_m4m5_noshield c_length=2.714U c_width=2.714U
* device instance $766 r0 *1 109.351,104.055 cap_mim_2f0_m4m5_noshield
X$766 \$10 topp cap_mim_2f0_m4m5_noshield c_length=2.714U c_width=2.714U
* device instance $767 r0 *1 114.465,104.055 cap_mim_2f0_m4m5_noshield
X$767 \$18 topp cap_mim_2f0_m4m5_noshield c_length=2.714U c_width=2.714U
* device instance $768 r0 *1 119.579,104.055 cap_mim_2f0_m4m5_noshield
X$768 \$10 topp cap_mim_2f0_m4m5_noshield c_length=2.714U c_width=2.714U
* device instance $769 r0 *1 124.693,104.055 cap_mim_2f0_m4m5_noshield
X$769 \$20 topp cap_mim_2f0_m4m5_noshield c_length=2.714U c_width=2.714U
* device instance $770 r0 *1 129.807,104.055 cap_mim_2f0_m4m5_noshield
X$770 \$10 topp cap_mim_2f0_m4m5_noshield c_length=2.714U c_width=2.714U
* device instance $771 r0 *1 134.921,104.055 cap_mim_2f0_m4m5_noshield
X$771 \$20 topp cap_mim_2f0_m4m5_noshield c_length=2.714U c_width=2.714U
* device instance $772 r0 *1 140.035,104.055 cap_mim_2f0_m4m5_noshield
X$772 \$10 topp cap_mim_2f0_m4m5_noshield c_length=2.714U c_width=2.714U
* device instance $773 r0 *1 145.149,104.055 cap_mim_2f0_m4m5_noshield
X$773 \$22 topp cap_mim_2f0_m4m5_noshield c_length=2.714U c_width=2.714U
* device instance $774 r0 *1 150.263,104.055 cap_mim_2f0_m4m5_noshield
X$774 \$10 topp cap_mim_2f0_m4m5_noshield c_length=2.714U c_width=2.714U
* device instance $775 r0 *1 155.377,104.055 cap_mim_2f0_m4m5_noshield
X$775 \$26 topp cap_mim_2f0_m4m5_noshield c_length=2.714U c_width=2.714U
* device instance $776 r0 *1 160.491,104.055 cap_mim_2f0_m4m5_noshield
X$776 \$10 topp cap_mim_2f0_m4m5_noshield c_length=2.714U c_width=2.714U
* device instance $777 r0 *1 179.633,104.055 cap_mim_2f0_m4m5_noshield
X$777 \$115 topn cap_mim_2f0_m4m5_noshield c_length=2.714U c_width=2.714U
* device instance $778 r0 *1 184.747,104.055 cap_mim_2f0_m4m5_noshield
X$778 \$90 topn cap_mim_2f0_m4m5_noshield c_length=2.714U c_width=2.714U
* device instance $779 r0 *1 189.861,104.055 cap_mim_2f0_m4m5_noshield
X$779 \$115 topn cap_mim_2f0_m4m5_noshield c_length=2.714U c_width=2.714U
* device instance $780 r0 *1 194.975,104.055 cap_mim_2f0_m4m5_noshield
X$780 \$90 topn cap_mim_2f0_m4m5_noshield c_length=2.714U c_width=2.714U
* device instance $781 r0 *1 200.089,104.055 cap_mim_2f0_m4m5_noshield
X$781 \$115 topn cap_mim_2f0_m4m5_noshield c_length=2.714U c_width=2.714U
* device instance $782 r0 *1 205.203,104.055 cap_mim_2f0_m4m5_noshield
X$782 \$90 topn cap_mim_2f0_m4m5_noshield c_length=2.714U c_width=2.714U
* device instance $783 r0 *1 210.317,104.055 cap_mim_2f0_m4m5_noshield
X$783 \$115 topn cap_mim_2f0_m4m5_noshield c_length=2.714U c_width=2.714U
* device instance $784 r0 *1 215.431,104.055 cap_mim_2f0_m4m5_noshield
X$784 \$90 topn cap_mim_2f0_m4m5_noshield c_length=2.714U c_width=2.714U
* device instance $785 r0 *1 220.545,104.055 cap_mim_2f0_m4m5_noshield
X$785 \$115 topn cap_mim_2f0_m4m5_noshield c_length=2.714U c_width=2.714U
* device instance $786 r0 *1 225.659,104.055 cap_mim_2f0_m4m5_noshield
X$786 \$90 topn cap_mim_2f0_m4m5_noshield c_length=2.714U c_width=2.714U
* device instance $787 r0 *1 230.773,104.055 cap_mim_2f0_m4m5_noshield
X$787 \$115 topn cap_mim_2f0_m4m5_noshield c_length=2.714U c_width=2.714U
* device instance $788 r0 *1 235.887,104.055 cap_mim_2f0_m4m5_noshield
X$788 \$90 topn cap_mim_2f0_m4m5_noshield c_length=2.714U c_width=2.714U
* device instance $789 r0 *1 241.001,104.055 cap_mim_2f0_m4m5_noshield
X$789 \$115 topn cap_mim_2f0_m4m5_noshield c_length=2.714U c_width=2.714U
* device instance $790 r0 *1 246.115,104.055 cap_mim_2f0_m4m5_noshield
X$790 \$90 topn cap_mim_2f0_m4m5_noshield c_length=2.714U c_width=2.714U
* device instance $791 r0 *1 251.229,104.055 cap_mim_2f0_m4m5_noshield
X$791 \$115 topn cap_mim_2f0_m4m5_noshield c_length=2.714U c_width=2.714U
* device instance $792 r0 *1 256.343,104.055 cap_mim_2f0_m4m5_noshield
X$792 \$90 topn cap_mim_2f0_m4m5_noshield c_length=2.714U c_width=2.714U
* device instance $793 r0 *1 261.457,104.055 cap_mim_2f0_m4m5_noshield
X$793 \$123 topn cap_mim_2f0_m4m5_noshield c_length=2.714U c_width=2.714U
* device instance $794 r0 *1 266.571,104.055 cap_mim_2f0_m4m5_noshield
X$794 \$90 topn cap_mim_2f0_m4m5_noshield c_length=2.714U c_width=2.714U
* device instance $795 r0 *1 271.685,104.055 cap_mim_2f0_m4m5_noshield
X$795 \$123 topn cap_mim_2f0_m4m5_noshield c_length=2.714U c_width=2.714U
* device instance $796 r0 *1 276.799,104.055 cap_mim_2f0_m4m5_noshield
X$796 \$90 topn cap_mim_2f0_m4m5_noshield c_length=2.714U c_width=2.714U
* device instance $797 r0 *1 281.913,104.055 cap_mim_2f0_m4m5_noshield
X$797 \$123 topn cap_mim_2f0_m4m5_noshield c_length=2.714U c_width=2.714U
* device instance $798 r0 *1 287.027,104.055 cap_mim_2f0_m4m5_noshield
X$798 \$90 topn cap_mim_2f0_m4m5_noshield c_length=2.714U c_width=2.714U
* device instance $799 r0 *1 292.141,104.055 cap_mim_2f0_m4m5_noshield
X$799 \$123 topn cap_mim_2f0_m4m5_noshield c_length=2.714U c_width=2.714U
* device instance $800 r0 *1 297.255,104.055 cap_mim_2f0_m4m5_noshield
X$800 \$90 topn cap_mim_2f0_m4m5_noshield c_length=2.714U c_width=2.714U
* device instance $801 r0 *1 302.369,104.055 cap_mim_2f0_m4m5_noshield
X$801 \$131 topn cap_mim_2f0_m4m5_noshield c_length=2.714U c_width=2.714U
* device instance $802 r0 *1 307.483,104.055 cap_mim_2f0_m4m5_noshield
X$802 \$90 topn cap_mim_2f0_m4m5_noshield c_length=2.714U c_width=2.714U
* device instance $803 r0 *1 312.597,104.055 cap_mim_2f0_m4m5_noshield
X$803 \$131 topn cap_mim_2f0_m4m5_noshield c_length=2.714U c_width=2.714U
* device instance $804 r0 *1 317.711,104.055 cap_mim_2f0_m4m5_noshield
X$804 \$90 topn cap_mim_2f0_m4m5_noshield c_length=2.714U c_width=2.714U
* device instance $805 r0 *1 322.825,104.055 cap_mim_2f0_m4m5_noshield
X$805 \$139 topn cap_mim_2f0_m4m5_noshield c_length=2.714U c_width=2.714U
* device instance $806 r0 *1 327.939,104.055 cap_mim_2f0_m4m5_noshield
X$806 \$90 topn cap_mim_2f0_m4m5_noshield c_length=2.714U c_width=2.714U
* device instance $807 r0 *1 333.053,104.055 cap_mim_2f0_m4m5_noshield
X$807 \$155 topn cap_mim_2f0_m4m5_noshield c_length=2.714U c_width=2.714U
* device instance $808 r0 *1 338.167,104.055 cap_mim_2f0_m4m5_noshield
X$808 \$90 topn cap_mim_2f0_m4m5_noshield c_length=2.714U c_width=2.714U
* device instance $809 r0 *1 1.957,109.169 cap_mim_2f0_m4m5_noshield
X$809 \$10 topp cap_mim_2f0_m4m5_noshield c_length=2.714U c_width=2.714U
* device instance $810 r0 *1 7.071,109.169 cap_mim_2f0_m4m5_noshield
X$810 vcm topp cap_mim_2f0_m4m5_noshield c_length=2.714U c_width=2.714U
* device instance $811 r0 *1 12.185,109.169 cap_mim_2f0_m4m5_noshield
X$811 \$10 topp cap_mim_2f0_m4m5_noshield c_length=2.714U c_width=2.714U
* device instance $812 r0 *1 17.299,109.169 cap_mim_2f0_m4m5_noshield
X$812 \$22 topp cap_mim_2f0_m4m5_noshield c_length=2.714U c_width=2.714U
* device instance $813 r0 *1 22.413,109.169 cap_mim_2f0_m4m5_noshield
X$813 \$10 topp cap_mim_2f0_m4m5_noshield c_length=2.714U c_width=2.714U
* device instance $814 r0 *1 27.527,109.169 cap_mim_2f0_m4m5_noshield
X$814 \$20 topp cap_mim_2f0_m4m5_noshield c_length=2.714U c_width=2.714U
* device instance $815 r0 *1 32.641,109.169 cap_mim_2f0_m4m5_noshield
X$815 \$10 topp cap_mim_2f0_m4m5_noshield c_length=2.714U c_width=2.714U
* device instance $816 r0 *1 37.755,109.169 cap_mim_2f0_m4m5_noshield
X$816 \$20 topp cap_mim_2f0_m4m5_noshield c_length=2.714U c_width=2.714U
* device instance $817 r0 *1 42.869,109.169 cap_mim_2f0_m4m5_noshield
X$817 \$10 topp cap_mim_2f0_m4m5_noshield c_length=2.714U c_width=2.714U
* device instance $818 r0 *1 47.983,109.169 cap_mim_2f0_m4m5_noshield
X$818 \$18 topp cap_mim_2f0_m4m5_noshield c_length=2.714U c_width=2.714U
* device instance $819 r0 *1 53.097,109.169 cap_mim_2f0_m4m5_noshield
X$819 \$10 topp cap_mim_2f0_m4m5_noshield c_length=2.714U c_width=2.714U
* device instance $820 r0 *1 58.211,109.169 cap_mim_2f0_m4m5_noshield
X$820 \$18 topp cap_mim_2f0_m4m5_noshield c_length=2.714U c_width=2.714U
* device instance $821 r0 *1 63.325,109.169 cap_mim_2f0_m4m5_noshield
X$821 \$10 topp cap_mim_2f0_m4m5_noshield c_length=2.714U c_width=2.714U
* device instance $822 r0 *1 68.439,109.169 cap_mim_2f0_m4m5_noshield
X$822 \$18 topp cap_mim_2f0_m4m5_noshield c_length=2.714U c_width=2.714U
* device instance $823 r0 *1 73.553,109.169 cap_mim_2f0_m4m5_noshield
X$823 \$10 topp cap_mim_2f0_m4m5_noshield c_length=2.714U c_width=2.714U
* device instance $824 r0 *1 78.667,109.169 cap_mim_2f0_m4m5_noshield
X$824 \$18 topp cap_mim_2f0_m4m5_noshield c_length=2.714U c_width=2.714U
* device instance $825 r0 *1 83.781,109.169 cap_mim_2f0_m4m5_noshield
X$825 \$10 topp cap_mim_2f0_m4m5_noshield c_length=2.714U c_width=2.714U
* device instance $826 r0 *1 88.895,109.169 cap_mim_2f0_m4m5_noshield
X$826 \$16 topp cap_mim_2f0_m4m5_noshield c_length=2.714U c_width=2.714U
* device instance $827 r0 *1 94.009,109.169 cap_mim_2f0_m4m5_noshield
X$827 \$10 topp cap_mim_2f0_m4m5_noshield c_length=2.714U c_width=2.714U
* device instance $828 r0 *1 99.123,109.169 cap_mim_2f0_m4m5_noshield
X$828 \$16 topp cap_mim_2f0_m4m5_noshield c_length=2.714U c_width=2.714U
* device instance $829 r0 *1 104.237,109.169 cap_mim_2f0_m4m5_noshield
X$829 \$10 topp cap_mim_2f0_m4m5_noshield c_length=2.714U c_width=2.714U
* device instance $830 r0 *1 109.351,109.169 cap_mim_2f0_m4m5_noshield
X$830 \$16 topp cap_mim_2f0_m4m5_noshield c_length=2.714U c_width=2.714U
* device instance $831 r0 *1 114.465,109.169 cap_mim_2f0_m4m5_noshield
X$831 \$10 topp cap_mim_2f0_m4m5_noshield c_length=2.714U c_width=2.714U
* device instance $832 r0 *1 119.579,109.169 cap_mim_2f0_m4m5_noshield
X$832 \$16 topp cap_mim_2f0_m4m5_noshield c_length=2.714U c_width=2.714U
* device instance $833 r0 *1 124.693,109.169 cap_mim_2f0_m4m5_noshield
X$833 \$10 topp cap_mim_2f0_m4m5_noshield c_length=2.714U c_width=2.714U
* device instance $834 r0 *1 129.807,109.169 cap_mim_2f0_m4m5_noshield
X$834 \$16 topp cap_mim_2f0_m4m5_noshield c_length=2.714U c_width=2.714U
* device instance $835 r0 *1 134.921,109.169 cap_mim_2f0_m4m5_noshield
X$835 \$10 topp cap_mim_2f0_m4m5_noshield c_length=2.714U c_width=2.714U
* device instance $836 r0 *1 140.035,109.169 cap_mim_2f0_m4m5_noshield
X$836 \$16 topp cap_mim_2f0_m4m5_noshield c_length=2.714U c_width=2.714U
* device instance $837 r0 *1 145.149,109.169 cap_mim_2f0_m4m5_noshield
X$837 \$10 topp cap_mim_2f0_m4m5_noshield c_length=2.714U c_width=2.714U
* device instance $838 r0 *1 150.263,109.169 cap_mim_2f0_m4m5_noshield
X$838 \$16 topp cap_mim_2f0_m4m5_noshield c_length=2.714U c_width=2.714U
* device instance $839 r0 *1 155.377,109.169 cap_mim_2f0_m4m5_noshield
X$839 \$10 topp cap_mim_2f0_m4m5_noshield c_length=2.714U c_width=2.714U
* device instance $840 r0 *1 160.491,109.169 cap_mim_2f0_m4m5_noshield
X$840 \$16 topp cap_mim_2f0_m4m5_noshield c_length=2.714U c_width=2.714U
* device instance $841 r0 *1 179.633,109.169 cap_mim_2f0_m4m5_noshield
X$841 \$90 topn cap_mim_2f0_m4m5_noshield c_length=2.714U c_width=2.714U
* device instance $842 r0 *1 184.747,109.169 cap_mim_2f0_m4m5_noshield
X$842 vcm topn cap_mim_2f0_m4m5_noshield c_length=2.714U c_width=2.714U
* device instance $843 r0 *1 189.861,109.169 cap_mim_2f0_m4m5_noshield
X$843 \$90 topn cap_mim_2f0_m4m5_noshield c_length=2.714U c_width=2.714U
* device instance $844 r0 *1 194.975,109.169 cap_mim_2f0_m4m5_noshield
X$844 \$139 topn cap_mim_2f0_m4m5_noshield c_length=2.714U c_width=2.714U
* device instance $845 r0 *1 200.089,109.169 cap_mim_2f0_m4m5_noshield
X$845 \$90 topn cap_mim_2f0_m4m5_noshield c_length=2.714U c_width=2.714U
* device instance $846 r0 *1 205.203,109.169 cap_mim_2f0_m4m5_noshield
X$846 \$131 topn cap_mim_2f0_m4m5_noshield c_length=2.714U c_width=2.714U
* device instance $847 r0 *1 210.317,109.169 cap_mim_2f0_m4m5_noshield
X$847 \$90 topn cap_mim_2f0_m4m5_noshield c_length=2.714U c_width=2.714U
* device instance $848 r0 *1 215.431,109.169 cap_mim_2f0_m4m5_noshield
X$848 \$131 topn cap_mim_2f0_m4m5_noshield c_length=2.714U c_width=2.714U
* device instance $849 r0 *1 220.545,109.169 cap_mim_2f0_m4m5_noshield
X$849 \$90 topn cap_mim_2f0_m4m5_noshield c_length=2.714U c_width=2.714U
* device instance $850 r0 *1 225.659,109.169 cap_mim_2f0_m4m5_noshield
X$850 \$123 topn cap_mim_2f0_m4m5_noshield c_length=2.714U c_width=2.714U
* device instance $851 r0 *1 230.773,109.169 cap_mim_2f0_m4m5_noshield
X$851 \$90 topn cap_mim_2f0_m4m5_noshield c_length=2.714U c_width=2.714U
* device instance $852 r0 *1 235.887,109.169 cap_mim_2f0_m4m5_noshield
X$852 \$123 topn cap_mim_2f0_m4m5_noshield c_length=2.714U c_width=2.714U
* device instance $853 r0 *1 241.001,109.169 cap_mim_2f0_m4m5_noshield
X$853 \$90 topn cap_mim_2f0_m4m5_noshield c_length=2.714U c_width=2.714U
* device instance $854 r0 *1 246.115,109.169 cap_mim_2f0_m4m5_noshield
X$854 \$123 topn cap_mim_2f0_m4m5_noshield c_length=2.714U c_width=2.714U
* device instance $855 r0 *1 251.229,109.169 cap_mim_2f0_m4m5_noshield
X$855 \$90 topn cap_mim_2f0_m4m5_noshield c_length=2.714U c_width=2.714U
* device instance $856 r0 *1 256.343,109.169 cap_mim_2f0_m4m5_noshield
X$856 \$123 topn cap_mim_2f0_m4m5_noshield c_length=2.714U c_width=2.714U
* device instance $857 r0 *1 261.457,109.169 cap_mim_2f0_m4m5_noshield
X$857 \$90 topn cap_mim_2f0_m4m5_noshield c_length=2.714U c_width=2.714U
* device instance $858 r0 *1 266.571,109.169 cap_mim_2f0_m4m5_noshield
X$858 \$115 topn cap_mim_2f0_m4m5_noshield c_length=2.714U c_width=2.714U
* device instance $859 r0 *1 271.685,109.169 cap_mim_2f0_m4m5_noshield
X$859 \$90 topn cap_mim_2f0_m4m5_noshield c_length=2.714U c_width=2.714U
* device instance $860 r0 *1 276.799,109.169 cap_mim_2f0_m4m5_noshield
X$860 \$115 topn cap_mim_2f0_m4m5_noshield c_length=2.714U c_width=2.714U
* device instance $861 r0 *1 281.913,109.169 cap_mim_2f0_m4m5_noshield
X$861 \$90 topn cap_mim_2f0_m4m5_noshield c_length=2.714U c_width=2.714U
* device instance $862 r0 *1 287.027,109.169 cap_mim_2f0_m4m5_noshield
X$862 \$115 topn cap_mim_2f0_m4m5_noshield c_length=2.714U c_width=2.714U
* device instance $863 r0 *1 292.141,109.169 cap_mim_2f0_m4m5_noshield
X$863 \$90 topn cap_mim_2f0_m4m5_noshield c_length=2.714U c_width=2.714U
* device instance $864 r0 *1 297.255,109.169 cap_mim_2f0_m4m5_noshield
X$864 \$115 topn cap_mim_2f0_m4m5_noshield c_length=2.714U c_width=2.714U
* device instance $865 r0 *1 302.369,109.169 cap_mim_2f0_m4m5_noshield
X$865 \$90 topn cap_mim_2f0_m4m5_noshield c_length=2.714U c_width=2.714U
* device instance $866 r0 *1 307.483,109.169 cap_mim_2f0_m4m5_noshield
X$866 \$115 topn cap_mim_2f0_m4m5_noshield c_length=2.714U c_width=2.714U
* device instance $867 r0 *1 312.597,109.169 cap_mim_2f0_m4m5_noshield
X$867 \$90 topn cap_mim_2f0_m4m5_noshield c_length=2.714U c_width=2.714U
* device instance $868 r0 *1 317.711,109.169 cap_mim_2f0_m4m5_noshield
X$868 \$115 topn cap_mim_2f0_m4m5_noshield c_length=2.714U c_width=2.714U
* device instance $869 r0 *1 322.825,109.169 cap_mim_2f0_m4m5_noshield
X$869 \$90 topn cap_mim_2f0_m4m5_noshield c_length=2.714U c_width=2.714U
* device instance $870 r0 *1 327.939,109.169 cap_mim_2f0_m4m5_noshield
X$870 \$115 topn cap_mim_2f0_m4m5_noshield c_length=2.714U c_width=2.714U
* device instance $871 r0 *1 333.053,109.169 cap_mim_2f0_m4m5_noshield
X$871 \$90 topn cap_mim_2f0_m4m5_noshield c_length=2.714U c_width=2.714U
* device instance $872 r0 *1 338.167,109.169 cap_mim_2f0_m4m5_noshield
X$872 \$115 topn cap_mim_2f0_m4m5_noshield c_length=2.714U c_width=2.714U
* device instance $873 r0 *1 1.957,114.283 cap_mim_2f0_m4m5_noshield
X$873 \$10 topp cap_mim_2f0_m4m5_noshield c_length=2.714U c_width=2.714U
* device instance $874 r0 *1 7.071,114.283 cap_mim_2f0_m4m5_noshield
X$874 \$14 topp cap_mim_2f0_m4m5_noshield c_length=2.714U c_width=2.714U
* device instance $875 r0 *1 12.185,114.283 cap_mim_2f0_m4m5_noshield
X$875 \$10 topp cap_mim_2f0_m4m5_noshield c_length=2.714U c_width=2.714U
* device instance $876 r0 *1 17.299,114.283 cap_mim_2f0_m4m5_noshield
X$876 \$14 topp cap_mim_2f0_m4m5_noshield c_length=2.714U c_width=2.714U
* device instance $877 r0 *1 22.413,114.283 cap_mim_2f0_m4m5_noshield
X$877 \$10 topp cap_mim_2f0_m4m5_noshield c_length=2.714U c_width=2.714U
* device instance $878 r0 *1 27.527,114.283 cap_mim_2f0_m4m5_noshield
X$878 \$14 topp cap_mim_2f0_m4m5_noshield c_length=2.714U c_width=2.714U
* device instance $879 r0 *1 32.641,114.283 cap_mim_2f0_m4m5_noshield
X$879 \$10 topp cap_mim_2f0_m4m5_noshield c_length=2.714U c_width=2.714U
* device instance $880 r0 *1 37.755,114.283 cap_mim_2f0_m4m5_noshield
X$880 \$14 topp cap_mim_2f0_m4m5_noshield c_length=2.714U c_width=2.714U
* device instance $881 r0 *1 42.869,114.283 cap_mim_2f0_m4m5_noshield
X$881 \$10 topp cap_mim_2f0_m4m5_noshield c_length=2.714U c_width=2.714U
* device instance $882 r0 *1 47.983,114.283 cap_mim_2f0_m4m5_noshield
X$882 \$14 topp cap_mim_2f0_m4m5_noshield c_length=2.714U c_width=2.714U
* device instance $883 r0 *1 53.097,114.283 cap_mim_2f0_m4m5_noshield
X$883 \$10 topp cap_mim_2f0_m4m5_noshield c_length=2.714U c_width=2.714U
* device instance $884 r0 *1 58.211,114.283 cap_mim_2f0_m4m5_noshield
X$884 \$14 topp cap_mim_2f0_m4m5_noshield c_length=2.714U c_width=2.714U
* device instance $885 r0 *1 63.325,114.283 cap_mim_2f0_m4m5_noshield
X$885 \$10 topp cap_mim_2f0_m4m5_noshield c_length=2.714U c_width=2.714U
* device instance $886 r0 *1 68.439,114.283 cap_mim_2f0_m4m5_noshield
X$886 \$14 topp cap_mim_2f0_m4m5_noshield c_length=2.714U c_width=2.714U
* device instance $887 r0 *1 73.553,114.283 cap_mim_2f0_m4m5_noshield
X$887 \$10 topp cap_mim_2f0_m4m5_noshield c_length=2.714U c_width=2.714U
* device instance $888 r0 *1 78.667,114.283 cap_mim_2f0_m4m5_noshield
X$888 \$14 topp cap_mim_2f0_m4m5_noshield c_length=2.714U c_width=2.714U
* device instance $889 r0 *1 83.781,114.283 cap_mim_2f0_m4m5_noshield
X$889 \$10 topp cap_mim_2f0_m4m5_noshield c_length=2.714U c_width=2.714U
* device instance $890 r0 *1 88.895,114.283 cap_mim_2f0_m4m5_noshield
X$890 \$14 topp cap_mim_2f0_m4m5_noshield c_length=2.714U c_width=2.714U
* device instance $891 r0 *1 94.009,114.283 cap_mim_2f0_m4m5_noshield
X$891 \$10 topp cap_mim_2f0_m4m5_noshield c_length=2.714U c_width=2.714U
* device instance $892 r0 *1 99.123,114.283 cap_mim_2f0_m4m5_noshield
X$892 \$14 topp cap_mim_2f0_m4m5_noshield c_length=2.714U c_width=2.714U
* device instance $893 r0 *1 104.237,114.283 cap_mim_2f0_m4m5_noshield
X$893 \$10 topp cap_mim_2f0_m4m5_noshield c_length=2.714U c_width=2.714U
* device instance $894 r0 *1 109.351,114.283 cap_mim_2f0_m4m5_noshield
X$894 \$14 topp cap_mim_2f0_m4m5_noshield c_length=2.714U c_width=2.714U
* device instance $895 r0 *1 114.465,114.283 cap_mim_2f0_m4m5_noshield
X$895 \$10 topp cap_mim_2f0_m4m5_noshield c_length=2.714U c_width=2.714U
* device instance $896 r0 *1 119.579,114.283 cap_mim_2f0_m4m5_noshield
X$896 \$14 topp cap_mim_2f0_m4m5_noshield c_length=2.714U c_width=2.714U
* device instance $897 r0 *1 124.693,114.283 cap_mim_2f0_m4m5_noshield
X$897 \$10 topp cap_mim_2f0_m4m5_noshield c_length=2.714U c_width=2.714U
* device instance $898 r0 *1 129.807,114.283 cap_mim_2f0_m4m5_noshield
X$898 \$14 topp cap_mim_2f0_m4m5_noshield c_length=2.714U c_width=2.714U
* device instance $899 r0 *1 134.921,114.283 cap_mim_2f0_m4m5_noshield
X$899 \$10 topp cap_mim_2f0_m4m5_noshield c_length=2.714U c_width=2.714U
* device instance $900 r0 *1 140.035,114.283 cap_mim_2f0_m4m5_noshield
X$900 \$14 topp cap_mim_2f0_m4m5_noshield c_length=2.714U c_width=2.714U
* device instance $901 r0 *1 145.149,114.283 cap_mim_2f0_m4m5_noshield
X$901 \$10 topp cap_mim_2f0_m4m5_noshield c_length=2.714U c_width=2.714U
* device instance $902 r0 *1 150.263,114.283 cap_mim_2f0_m4m5_noshield
X$902 \$14 topp cap_mim_2f0_m4m5_noshield c_length=2.714U c_width=2.714U
* device instance $903 r0 *1 155.377,114.283 cap_mim_2f0_m4m5_noshield
X$903 \$10 topp cap_mim_2f0_m4m5_noshield c_length=2.714U c_width=2.714U
* device instance $904 r0 *1 160.491,114.283 cap_mim_2f0_m4m5_noshield
X$904 \$14 topp cap_mim_2f0_m4m5_noshield c_length=2.714U c_width=2.714U
* device instance $905 r0 *1 179.633,114.283 cap_mim_2f0_m4m5_noshield
X$905 \$90 topn cap_mim_2f0_m4m5_noshield c_length=2.714U c_width=2.714U
* device instance $906 r0 *1 184.747,114.283 cap_mim_2f0_m4m5_noshield
X$906 \$107 topn cap_mim_2f0_m4m5_noshield c_length=2.714U c_width=2.714U
* device instance $907 r0 *1 189.861,114.283 cap_mim_2f0_m4m5_noshield
X$907 \$90 topn cap_mim_2f0_m4m5_noshield c_length=2.714U c_width=2.714U
* device instance $908 r0 *1 194.975,114.283 cap_mim_2f0_m4m5_noshield
X$908 \$107 topn cap_mim_2f0_m4m5_noshield c_length=2.714U c_width=2.714U
* device instance $909 r0 *1 200.089,114.283 cap_mim_2f0_m4m5_noshield
X$909 \$90 topn cap_mim_2f0_m4m5_noshield c_length=2.714U c_width=2.714U
* device instance $910 r0 *1 205.203,114.283 cap_mim_2f0_m4m5_noshield
X$910 \$107 topn cap_mim_2f0_m4m5_noshield c_length=2.714U c_width=2.714U
* device instance $911 r0 *1 210.317,114.283 cap_mim_2f0_m4m5_noshield
X$911 \$90 topn cap_mim_2f0_m4m5_noshield c_length=2.714U c_width=2.714U
* device instance $912 r0 *1 215.431,114.283 cap_mim_2f0_m4m5_noshield
X$912 \$107 topn cap_mim_2f0_m4m5_noshield c_length=2.714U c_width=2.714U
* device instance $913 r0 *1 220.545,114.283 cap_mim_2f0_m4m5_noshield
X$913 \$90 topn cap_mim_2f0_m4m5_noshield c_length=2.714U c_width=2.714U
* device instance $914 r0 *1 225.659,114.283 cap_mim_2f0_m4m5_noshield
X$914 \$107 topn cap_mim_2f0_m4m5_noshield c_length=2.714U c_width=2.714U
* device instance $915 r0 *1 230.773,114.283 cap_mim_2f0_m4m5_noshield
X$915 \$90 topn cap_mim_2f0_m4m5_noshield c_length=2.714U c_width=2.714U
* device instance $916 r0 *1 235.887,114.283 cap_mim_2f0_m4m5_noshield
X$916 \$107 topn cap_mim_2f0_m4m5_noshield c_length=2.714U c_width=2.714U
* device instance $917 r0 *1 241.001,114.283 cap_mim_2f0_m4m5_noshield
X$917 \$90 topn cap_mim_2f0_m4m5_noshield c_length=2.714U c_width=2.714U
* device instance $918 r0 *1 246.115,114.283 cap_mim_2f0_m4m5_noshield
X$918 \$107 topn cap_mim_2f0_m4m5_noshield c_length=2.714U c_width=2.714U
* device instance $919 r0 *1 251.229,114.283 cap_mim_2f0_m4m5_noshield
X$919 \$90 topn cap_mim_2f0_m4m5_noshield c_length=2.714U c_width=2.714U
* device instance $920 r0 *1 256.343,114.283 cap_mim_2f0_m4m5_noshield
X$920 \$107 topn cap_mim_2f0_m4m5_noshield c_length=2.714U c_width=2.714U
* device instance $921 r0 *1 261.457,114.283 cap_mim_2f0_m4m5_noshield
X$921 \$90 topn cap_mim_2f0_m4m5_noshield c_length=2.714U c_width=2.714U
* device instance $922 r0 *1 266.571,114.283 cap_mim_2f0_m4m5_noshield
X$922 \$107 topn cap_mim_2f0_m4m5_noshield c_length=2.714U c_width=2.714U
* device instance $923 r0 *1 271.685,114.283 cap_mim_2f0_m4m5_noshield
X$923 \$90 topn cap_mim_2f0_m4m5_noshield c_length=2.714U c_width=2.714U
* device instance $924 r0 *1 276.799,114.283 cap_mim_2f0_m4m5_noshield
X$924 \$107 topn cap_mim_2f0_m4m5_noshield c_length=2.714U c_width=2.714U
* device instance $925 r0 *1 281.913,114.283 cap_mim_2f0_m4m5_noshield
X$925 \$90 topn cap_mim_2f0_m4m5_noshield c_length=2.714U c_width=2.714U
* device instance $926 r0 *1 287.027,114.283 cap_mim_2f0_m4m5_noshield
X$926 \$107 topn cap_mim_2f0_m4m5_noshield c_length=2.714U c_width=2.714U
* device instance $927 r0 *1 292.141,114.283 cap_mim_2f0_m4m5_noshield
X$927 \$90 topn cap_mim_2f0_m4m5_noshield c_length=2.714U c_width=2.714U
* device instance $928 r0 *1 297.255,114.283 cap_mim_2f0_m4m5_noshield
X$928 \$107 topn cap_mim_2f0_m4m5_noshield c_length=2.714U c_width=2.714U
* device instance $929 r0 *1 302.369,114.283 cap_mim_2f0_m4m5_noshield
X$929 \$90 topn cap_mim_2f0_m4m5_noshield c_length=2.714U c_width=2.714U
* device instance $930 r0 *1 307.483,114.283 cap_mim_2f0_m4m5_noshield
X$930 \$107 topn cap_mim_2f0_m4m5_noshield c_length=2.714U c_width=2.714U
* device instance $931 r0 *1 312.597,114.283 cap_mim_2f0_m4m5_noshield
X$931 \$90 topn cap_mim_2f0_m4m5_noshield c_length=2.714U c_width=2.714U
* device instance $932 r0 *1 317.711,114.283 cap_mim_2f0_m4m5_noshield
X$932 \$107 topn cap_mim_2f0_m4m5_noshield c_length=2.714U c_width=2.714U
* device instance $933 r0 *1 322.825,114.283 cap_mim_2f0_m4m5_noshield
X$933 \$90 topn cap_mim_2f0_m4m5_noshield c_length=2.714U c_width=2.714U
* device instance $934 r0 *1 327.939,114.283 cap_mim_2f0_m4m5_noshield
X$934 \$107 topn cap_mim_2f0_m4m5_noshield c_length=2.714U c_width=2.714U
* device instance $935 r0 *1 333.053,114.283 cap_mim_2f0_m4m5_noshield
X$935 \$90 topn cap_mim_2f0_m4m5_noshield c_length=2.714U c_width=2.714U
* device instance $936 r0 *1 338.167,114.283 cap_mim_2f0_m4m5_noshield
X$936 \$107 topn cap_mim_2f0_m4m5_noshield c_length=2.714U c_width=2.714U
* device instance $937 r0 *1 1.957,119.397 cap_mim_2f0_m4m5_noshield
X$937 \$10 topp cap_mim_2f0_m4m5_noshield c_length=2.714U c_width=2.714U
* device instance $938 r0 *1 7.071,119.397 cap_mim_2f0_m4m5_noshield
X$938 \$12 topp cap_mim_2f0_m4m5_noshield c_length=2.714U c_width=2.714U
* device instance $939 r0 *1 12.185,119.397 cap_mim_2f0_m4m5_noshield
X$939 \$10 topp cap_mim_2f0_m4m5_noshield c_length=2.714U c_width=2.714U
* device instance $940 r0 *1 17.299,119.397 cap_mim_2f0_m4m5_noshield
X$940 \$12 topp cap_mim_2f0_m4m5_noshield c_length=2.714U c_width=2.714U
* device instance $941 r0 *1 22.413,119.397 cap_mim_2f0_m4m5_noshield
X$941 \$10 topp cap_mim_2f0_m4m5_noshield c_length=2.714U c_width=2.714U
* device instance $942 r0 *1 27.527,119.397 cap_mim_2f0_m4m5_noshield
X$942 \$12 topp cap_mim_2f0_m4m5_noshield c_length=2.714U c_width=2.714U
* device instance $943 r0 *1 32.641,119.397 cap_mim_2f0_m4m5_noshield
X$943 \$10 topp cap_mim_2f0_m4m5_noshield c_length=2.714U c_width=2.714U
* device instance $944 r0 *1 37.755,119.397 cap_mim_2f0_m4m5_noshield
X$944 \$12 topp cap_mim_2f0_m4m5_noshield c_length=2.714U c_width=2.714U
* device instance $945 r0 *1 42.869,119.397 cap_mim_2f0_m4m5_noshield
X$945 \$10 topp cap_mim_2f0_m4m5_noshield c_length=2.714U c_width=2.714U
* device instance $946 r0 *1 47.983,119.397 cap_mim_2f0_m4m5_noshield
X$946 \$12 topp cap_mim_2f0_m4m5_noshield c_length=2.714U c_width=2.714U
* device instance $947 r0 *1 53.097,119.397 cap_mim_2f0_m4m5_noshield
X$947 \$10 topp cap_mim_2f0_m4m5_noshield c_length=2.714U c_width=2.714U
* device instance $948 r0 *1 58.211,119.397 cap_mim_2f0_m4m5_noshield
X$948 \$12 topp cap_mim_2f0_m4m5_noshield c_length=2.714U c_width=2.714U
* device instance $949 r0 *1 63.325,119.397 cap_mim_2f0_m4m5_noshield
X$949 \$10 topp cap_mim_2f0_m4m5_noshield c_length=2.714U c_width=2.714U
* device instance $950 r0 *1 68.439,119.397 cap_mim_2f0_m4m5_noshield
X$950 \$12 topp cap_mim_2f0_m4m5_noshield c_length=2.714U c_width=2.714U
* device instance $951 r0 *1 73.553,119.397 cap_mim_2f0_m4m5_noshield
X$951 \$10 topp cap_mim_2f0_m4m5_noshield c_length=2.714U c_width=2.714U
* device instance $952 r0 *1 78.667,119.397 cap_mim_2f0_m4m5_noshield
X$952 \$12 topp cap_mim_2f0_m4m5_noshield c_length=2.714U c_width=2.714U
* device instance $953 r0 *1 83.781,119.397 cap_mim_2f0_m4m5_noshield
X$953 \$10 topp cap_mim_2f0_m4m5_noshield c_length=2.714U c_width=2.714U
* device instance $954 r0 *1 88.895,119.397 cap_mim_2f0_m4m5_noshield
X$954 \$12 topp cap_mim_2f0_m4m5_noshield c_length=2.714U c_width=2.714U
* device instance $955 r0 *1 94.009,119.397 cap_mim_2f0_m4m5_noshield
X$955 \$10 topp cap_mim_2f0_m4m5_noshield c_length=2.714U c_width=2.714U
* device instance $956 r0 *1 99.123,119.397 cap_mim_2f0_m4m5_noshield
X$956 \$12 topp cap_mim_2f0_m4m5_noshield c_length=2.714U c_width=2.714U
* device instance $957 r0 *1 104.237,119.397 cap_mim_2f0_m4m5_noshield
X$957 \$10 topp cap_mim_2f0_m4m5_noshield c_length=2.714U c_width=2.714U
* device instance $958 r0 *1 109.351,119.397 cap_mim_2f0_m4m5_noshield
X$958 \$12 topp cap_mim_2f0_m4m5_noshield c_length=2.714U c_width=2.714U
* device instance $959 r0 *1 114.465,119.397 cap_mim_2f0_m4m5_noshield
X$959 \$10 topp cap_mim_2f0_m4m5_noshield c_length=2.714U c_width=2.714U
* device instance $960 r0 *1 119.579,119.397 cap_mim_2f0_m4m5_noshield
X$960 \$12 topp cap_mim_2f0_m4m5_noshield c_length=2.714U c_width=2.714U
* device instance $961 r0 *1 124.693,119.397 cap_mim_2f0_m4m5_noshield
X$961 \$10 topp cap_mim_2f0_m4m5_noshield c_length=2.714U c_width=2.714U
* device instance $962 r0 *1 129.807,119.397 cap_mim_2f0_m4m5_noshield
X$962 \$12 topp cap_mim_2f0_m4m5_noshield c_length=2.714U c_width=2.714U
* device instance $963 r0 *1 134.921,119.397 cap_mim_2f0_m4m5_noshield
X$963 \$10 topp cap_mim_2f0_m4m5_noshield c_length=2.714U c_width=2.714U
* device instance $964 r0 *1 140.035,119.397 cap_mim_2f0_m4m5_noshield
X$964 \$12 topp cap_mim_2f0_m4m5_noshield c_length=2.714U c_width=2.714U
* device instance $965 r0 *1 145.149,119.397 cap_mim_2f0_m4m5_noshield
X$965 \$10 topp cap_mim_2f0_m4m5_noshield c_length=2.714U c_width=2.714U
* device instance $966 r0 *1 150.263,119.397 cap_mim_2f0_m4m5_noshield
X$966 \$12 topp cap_mim_2f0_m4m5_noshield c_length=2.714U c_width=2.714U
* device instance $967 r0 *1 155.377,119.397 cap_mim_2f0_m4m5_noshield
X$967 \$10 topp cap_mim_2f0_m4m5_noshield c_length=2.714U c_width=2.714U
* device instance $968 r0 *1 160.491,119.397 cap_mim_2f0_m4m5_noshield
X$968 \$12 topp cap_mim_2f0_m4m5_noshield c_length=2.714U c_width=2.714U
* device instance $969 r0 *1 179.633,119.397 cap_mim_2f0_m4m5_noshield
X$969 \$90 topn cap_mim_2f0_m4m5_noshield c_length=2.714U c_width=2.714U
* device instance $970 r0 *1 184.747,119.397 cap_mim_2f0_m4m5_noshield
X$970 \$99 topn cap_mim_2f0_m4m5_noshield c_length=2.714U c_width=2.714U
* device instance $971 r0 *1 189.861,119.397 cap_mim_2f0_m4m5_noshield
X$971 \$90 topn cap_mim_2f0_m4m5_noshield c_length=2.714U c_width=2.714U
* device instance $972 r0 *1 194.975,119.397 cap_mim_2f0_m4m5_noshield
X$972 \$99 topn cap_mim_2f0_m4m5_noshield c_length=2.714U c_width=2.714U
* device instance $973 r0 *1 200.089,119.397 cap_mim_2f0_m4m5_noshield
X$973 \$90 topn cap_mim_2f0_m4m5_noshield c_length=2.714U c_width=2.714U
* device instance $974 r0 *1 205.203,119.397 cap_mim_2f0_m4m5_noshield
X$974 \$99 topn cap_mim_2f0_m4m5_noshield c_length=2.714U c_width=2.714U
* device instance $975 r0 *1 210.317,119.397 cap_mim_2f0_m4m5_noshield
X$975 \$90 topn cap_mim_2f0_m4m5_noshield c_length=2.714U c_width=2.714U
* device instance $976 r0 *1 215.431,119.397 cap_mim_2f0_m4m5_noshield
X$976 \$99 topn cap_mim_2f0_m4m5_noshield c_length=2.714U c_width=2.714U
* device instance $977 r0 *1 220.545,119.397 cap_mim_2f0_m4m5_noshield
X$977 \$90 topn cap_mim_2f0_m4m5_noshield c_length=2.714U c_width=2.714U
* device instance $978 r0 *1 225.659,119.397 cap_mim_2f0_m4m5_noshield
X$978 \$99 topn cap_mim_2f0_m4m5_noshield c_length=2.714U c_width=2.714U
* device instance $979 r0 *1 230.773,119.397 cap_mim_2f0_m4m5_noshield
X$979 \$90 topn cap_mim_2f0_m4m5_noshield c_length=2.714U c_width=2.714U
* device instance $980 r0 *1 235.887,119.397 cap_mim_2f0_m4m5_noshield
X$980 \$99 topn cap_mim_2f0_m4m5_noshield c_length=2.714U c_width=2.714U
* device instance $981 r0 *1 241.001,119.397 cap_mim_2f0_m4m5_noshield
X$981 \$90 topn cap_mim_2f0_m4m5_noshield c_length=2.714U c_width=2.714U
* device instance $982 r0 *1 246.115,119.397 cap_mim_2f0_m4m5_noshield
X$982 \$99 topn cap_mim_2f0_m4m5_noshield c_length=2.714U c_width=2.714U
* device instance $983 r0 *1 251.229,119.397 cap_mim_2f0_m4m5_noshield
X$983 \$90 topn cap_mim_2f0_m4m5_noshield c_length=2.714U c_width=2.714U
* device instance $984 r0 *1 256.343,119.397 cap_mim_2f0_m4m5_noshield
X$984 \$99 topn cap_mim_2f0_m4m5_noshield c_length=2.714U c_width=2.714U
* device instance $985 r0 *1 261.457,119.397 cap_mim_2f0_m4m5_noshield
X$985 \$90 topn cap_mim_2f0_m4m5_noshield c_length=2.714U c_width=2.714U
* device instance $986 r0 *1 266.571,119.397 cap_mim_2f0_m4m5_noshield
X$986 \$99 topn cap_mim_2f0_m4m5_noshield c_length=2.714U c_width=2.714U
* device instance $987 r0 *1 271.685,119.397 cap_mim_2f0_m4m5_noshield
X$987 \$90 topn cap_mim_2f0_m4m5_noshield c_length=2.714U c_width=2.714U
* device instance $988 r0 *1 276.799,119.397 cap_mim_2f0_m4m5_noshield
X$988 \$99 topn cap_mim_2f0_m4m5_noshield c_length=2.714U c_width=2.714U
* device instance $989 r0 *1 281.913,119.397 cap_mim_2f0_m4m5_noshield
X$989 \$90 topn cap_mim_2f0_m4m5_noshield c_length=2.714U c_width=2.714U
* device instance $990 r0 *1 287.027,119.397 cap_mim_2f0_m4m5_noshield
X$990 \$99 topn cap_mim_2f0_m4m5_noshield c_length=2.714U c_width=2.714U
* device instance $991 r0 *1 292.141,119.397 cap_mim_2f0_m4m5_noshield
X$991 \$90 topn cap_mim_2f0_m4m5_noshield c_length=2.714U c_width=2.714U
* device instance $992 r0 *1 297.255,119.397 cap_mim_2f0_m4m5_noshield
X$992 \$99 topn cap_mim_2f0_m4m5_noshield c_length=2.714U c_width=2.714U
* device instance $993 r0 *1 302.369,119.397 cap_mim_2f0_m4m5_noshield
X$993 \$90 topn cap_mim_2f0_m4m5_noshield c_length=2.714U c_width=2.714U
* device instance $994 r0 *1 307.483,119.397 cap_mim_2f0_m4m5_noshield
X$994 \$99 topn cap_mim_2f0_m4m5_noshield c_length=2.714U c_width=2.714U
* device instance $995 r0 *1 312.597,119.397 cap_mim_2f0_m4m5_noshield
X$995 \$90 topn cap_mim_2f0_m4m5_noshield c_length=2.714U c_width=2.714U
* device instance $996 r0 *1 317.711,119.397 cap_mim_2f0_m4m5_noshield
X$996 \$99 topn cap_mim_2f0_m4m5_noshield c_length=2.714U c_width=2.714U
* device instance $997 r0 *1 322.825,119.397 cap_mim_2f0_m4m5_noshield
X$997 \$90 topn cap_mim_2f0_m4m5_noshield c_length=2.714U c_width=2.714U
* device instance $998 r0 *1 327.939,119.397 cap_mim_2f0_m4m5_noshield
X$998 \$99 topn cap_mim_2f0_m4m5_noshield c_length=2.714U c_width=2.714U
* device instance $999 r0 *1 333.053,119.397 cap_mim_2f0_m4m5_noshield
X$999 \$90 topn cap_mim_2f0_m4m5_noshield c_length=2.714U c_width=2.714U
* device instance $1000 r0 *1 338.167,119.397 cap_mim_2f0_m4m5_noshield
X$1000 \$99 topn cap_mim_2f0_m4m5_noshield c_length=2.714U c_width=2.714U
* device instance $1001 r0 *1 1.957,124.511 cap_mim_2f0_m4m5_noshield
X$1001 \$10 topp cap_mim_2f0_m4m5_noshield c_length=2.714U c_width=2.714U
* device instance $1002 r0 *1 7.071,124.511 cap_mim_2f0_m4m5_noshield
X$1002 \$12 topp cap_mim_2f0_m4m5_noshield c_length=2.714U c_width=2.714U
* device instance $1003 r0 *1 12.185,124.511 cap_mim_2f0_m4m5_noshield
X$1003 \$10 topp cap_mim_2f0_m4m5_noshield c_length=2.714U c_width=2.714U
* device instance $1004 r0 *1 17.299,124.511 cap_mim_2f0_m4m5_noshield
X$1004 \$12 topp cap_mim_2f0_m4m5_noshield c_length=2.714U c_width=2.714U
* device instance $1005 r0 *1 22.413,124.511 cap_mim_2f0_m4m5_noshield
X$1005 \$10 topp cap_mim_2f0_m4m5_noshield c_length=2.714U c_width=2.714U
* device instance $1006 r0 *1 27.527,124.511 cap_mim_2f0_m4m5_noshield
X$1006 \$12 topp cap_mim_2f0_m4m5_noshield c_length=2.714U c_width=2.714U
* device instance $1007 r0 *1 32.641,124.511 cap_mim_2f0_m4m5_noshield
X$1007 \$10 topp cap_mim_2f0_m4m5_noshield c_length=2.714U c_width=2.714U
* device instance $1008 r0 *1 37.755,124.511 cap_mim_2f0_m4m5_noshield
X$1008 \$12 topp cap_mim_2f0_m4m5_noshield c_length=2.714U c_width=2.714U
* device instance $1009 r0 *1 42.869,124.511 cap_mim_2f0_m4m5_noshield
X$1009 \$10 topp cap_mim_2f0_m4m5_noshield c_length=2.714U c_width=2.714U
* device instance $1010 r0 *1 47.983,124.511 cap_mim_2f0_m4m5_noshield
X$1010 \$12 topp cap_mim_2f0_m4m5_noshield c_length=2.714U c_width=2.714U
* device instance $1011 r0 *1 53.097,124.511 cap_mim_2f0_m4m5_noshield
X$1011 \$10 topp cap_mim_2f0_m4m5_noshield c_length=2.714U c_width=2.714U
* device instance $1012 r0 *1 58.211,124.511 cap_mim_2f0_m4m5_noshield
X$1012 \$12 topp cap_mim_2f0_m4m5_noshield c_length=2.714U c_width=2.714U
* device instance $1013 r0 *1 63.325,124.511 cap_mim_2f0_m4m5_noshield
X$1013 \$10 topp cap_mim_2f0_m4m5_noshield c_length=2.714U c_width=2.714U
* device instance $1014 r0 *1 68.439,124.511 cap_mim_2f0_m4m5_noshield
X$1014 \$12 topp cap_mim_2f0_m4m5_noshield c_length=2.714U c_width=2.714U
* device instance $1015 r0 *1 73.553,124.511 cap_mim_2f0_m4m5_noshield
X$1015 \$10 topp cap_mim_2f0_m4m5_noshield c_length=2.714U c_width=2.714U
* device instance $1016 r0 *1 78.667,124.511 cap_mim_2f0_m4m5_noshield
X$1016 \$12 topp cap_mim_2f0_m4m5_noshield c_length=2.714U c_width=2.714U
* device instance $1017 r0 *1 83.781,124.511 cap_mim_2f0_m4m5_noshield
X$1017 \$10 topp cap_mim_2f0_m4m5_noshield c_length=2.714U c_width=2.714U
* device instance $1018 r0 *1 88.895,124.511 cap_mim_2f0_m4m5_noshield
X$1018 \$12 topp cap_mim_2f0_m4m5_noshield c_length=2.714U c_width=2.714U
* device instance $1019 r0 *1 94.009,124.511 cap_mim_2f0_m4m5_noshield
X$1019 \$10 topp cap_mim_2f0_m4m5_noshield c_length=2.714U c_width=2.714U
* device instance $1020 r0 *1 99.123,124.511 cap_mim_2f0_m4m5_noshield
X$1020 \$12 topp cap_mim_2f0_m4m5_noshield c_length=2.714U c_width=2.714U
* device instance $1021 r0 *1 104.237,124.511 cap_mim_2f0_m4m5_noshield
X$1021 \$10 topp cap_mim_2f0_m4m5_noshield c_length=2.714U c_width=2.714U
* device instance $1022 r0 *1 109.351,124.511 cap_mim_2f0_m4m5_noshield
X$1022 \$12 topp cap_mim_2f0_m4m5_noshield c_length=2.714U c_width=2.714U
* device instance $1023 r0 *1 114.465,124.511 cap_mim_2f0_m4m5_noshield
X$1023 \$10 topp cap_mim_2f0_m4m5_noshield c_length=2.714U c_width=2.714U
* device instance $1024 r0 *1 119.579,124.511 cap_mim_2f0_m4m5_noshield
X$1024 \$12 topp cap_mim_2f0_m4m5_noshield c_length=2.714U c_width=2.714U
* device instance $1025 r0 *1 124.693,124.511 cap_mim_2f0_m4m5_noshield
X$1025 \$10 topp cap_mim_2f0_m4m5_noshield c_length=2.714U c_width=2.714U
* device instance $1026 r0 *1 129.807,124.511 cap_mim_2f0_m4m5_noshield
X$1026 \$12 topp cap_mim_2f0_m4m5_noshield c_length=2.714U c_width=2.714U
* device instance $1027 r0 *1 134.921,124.511 cap_mim_2f0_m4m5_noshield
X$1027 \$10 topp cap_mim_2f0_m4m5_noshield c_length=2.714U c_width=2.714U
* device instance $1028 r0 *1 140.035,124.511 cap_mim_2f0_m4m5_noshield
X$1028 \$12 topp cap_mim_2f0_m4m5_noshield c_length=2.714U c_width=2.714U
* device instance $1029 r0 *1 145.149,124.511 cap_mim_2f0_m4m5_noshield
X$1029 \$10 topp cap_mim_2f0_m4m5_noshield c_length=2.714U c_width=2.714U
* device instance $1030 r0 *1 150.263,124.511 cap_mim_2f0_m4m5_noshield
X$1030 \$12 topp cap_mim_2f0_m4m5_noshield c_length=2.714U c_width=2.714U
* device instance $1031 r0 *1 155.377,124.511 cap_mim_2f0_m4m5_noshield
X$1031 \$10 topp cap_mim_2f0_m4m5_noshield c_length=2.714U c_width=2.714U
* device instance $1032 r0 *1 160.491,124.511 cap_mim_2f0_m4m5_noshield
X$1032 \$12 topp cap_mim_2f0_m4m5_noshield c_length=2.714U c_width=2.714U
* device instance $1033 r0 *1 179.633,124.511 cap_mim_2f0_m4m5_noshield
X$1033 \$90 topn cap_mim_2f0_m4m5_noshield c_length=2.714U c_width=2.714U
* device instance $1034 r0 *1 184.747,124.511 cap_mim_2f0_m4m5_noshield
X$1034 \$99 topn cap_mim_2f0_m4m5_noshield c_length=2.714U c_width=2.714U
* device instance $1035 r0 *1 189.861,124.511 cap_mim_2f0_m4m5_noshield
X$1035 \$90 topn cap_mim_2f0_m4m5_noshield c_length=2.714U c_width=2.714U
* device instance $1036 r0 *1 194.975,124.511 cap_mim_2f0_m4m5_noshield
X$1036 \$99 topn cap_mim_2f0_m4m5_noshield c_length=2.714U c_width=2.714U
* device instance $1037 r0 *1 200.089,124.511 cap_mim_2f0_m4m5_noshield
X$1037 \$90 topn cap_mim_2f0_m4m5_noshield c_length=2.714U c_width=2.714U
* device instance $1038 r0 *1 205.203,124.511 cap_mim_2f0_m4m5_noshield
X$1038 \$99 topn cap_mim_2f0_m4m5_noshield c_length=2.714U c_width=2.714U
* device instance $1039 r0 *1 210.317,124.511 cap_mim_2f0_m4m5_noshield
X$1039 \$90 topn cap_mim_2f0_m4m5_noshield c_length=2.714U c_width=2.714U
* device instance $1040 r0 *1 215.431,124.511 cap_mim_2f0_m4m5_noshield
X$1040 \$99 topn cap_mim_2f0_m4m5_noshield c_length=2.714U c_width=2.714U
* device instance $1041 r0 *1 220.545,124.511 cap_mim_2f0_m4m5_noshield
X$1041 \$90 topn cap_mim_2f0_m4m5_noshield c_length=2.714U c_width=2.714U
* device instance $1042 r0 *1 225.659,124.511 cap_mim_2f0_m4m5_noshield
X$1042 \$99 topn cap_mim_2f0_m4m5_noshield c_length=2.714U c_width=2.714U
* device instance $1043 r0 *1 230.773,124.511 cap_mim_2f0_m4m5_noshield
X$1043 \$90 topn cap_mim_2f0_m4m5_noshield c_length=2.714U c_width=2.714U
* device instance $1044 r0 *1 235.887,124.511 cap_mim_2f0_m4m5_noshield
X$1044 \$99 topn cap_mim_2f0_m4m5_noshield c_length=2.714U c_width=2.714U
* device instance $1045 r0 *1 241.001,124.511 cap_mim_2f0_m4m5_noshield
X$1045 \$90 topn cap_mim_2f0_m4m5_noshield c_length=2.714U c_width=2.714U
* device instance $1046 r0 *1 246.115,124.511 cap_mim_2f0_m4m5_noshield
X$1046 \$99 topn cap_mim_2f0_m4m5_noshield c_length=2.714U c_width=2.714U
* device instance $1047 r0 *1 251.229,124.511 cap_mim_2f0_m4m5_noshield
X$1047 \$90 topn cap_mim_2f0_m4m5_noshield c_length=2.714U c_width=2.714U
* device instance $1048 r0 *1 256.343,124.511 cap_mim_2f0_m4m5_noshield
X$1048 \$99 topn cap_mim_2f0_m4m5_noshield c_length=2.714U c_width=2.714U
* device instance $1049 r0 *1 261.457,124.511 cap_mim_2f0_m4m5_noshield
X$1049 \$90 topn cap_mim_2f0_m4m5_noshield c_length=2.714U c_width=2.714U
* device instance $1050 r0 *1 266.571,124.511 cap_mim_2f0_m4m5_noshield
X$1050 \$99 topn cap_mim_2f0_m4m5_noshield c_length=2.714U c_width=2.714U
* device instance $1051 r0 *1 271.685,124.511 cap_mim_2f0_m4m5_noshield
X$1051 \$90 topn cap_mim_2f0_m4m5_noshield c_length=2.714U c_width=2.714U
* device instance $1052 r0 *1 276.799,124.511 cap_mim_2f0_m4m5_noshield
X$1052 \$99 topn cap_mim_2f0_m4m5_noshield c_length=2.714U c_width=2.714U
* device instance $1053 r0 *1 281.913,124.511 cap_mim_2f0_m4m5_noshield
X$1053 \$90 topn cap_mim_2f0_m4m5_noshield c_length=2.714U c_width=2.714U
* device instance $1054 r0 *1 287.027,124.511 cap_mim_2f0_m4m5_noshield
X$1054 \$99 topn cap_mim_2f0_m4m5_noshield c_length=2.714U c_width=2.714U
* device instance $1055 r0 *1 292.141,124.511 cap_mim_2f0_m4m5_noshield
X$1055 \$90 topn cap_mim_2f0_m4m5_noshield c_length=2.714U c_width=2.714U
* device instance $1056 r0 *1 297.255,124.511 cap_mim_2f0_m4m5_noshield
X$1056 \$99 topn cap_mim_2f0_m4m5_noshield c_length=2.714U c_width=2.714U
* device instance $1057 r0 *1 302.369,124.511 cap_mim_2f0_m4m5_noshield
X$1057 \$90 topn cap_mim_2f0_m4m5_noshield c_length=2.714U c_width=2.714U
* device instance $1058 r0 *1 307.483,124.511 cap_mim_2f0_m4m5_noshield
X$1058 \$99 topn cap_mim_2f0_m4m5_noshield c_length=2.714U c_width=2.714U
* device instance $1059 r0 *1 312.597,124.511 cap_mim_2f0_m4m5_noshield
X$1059 \$90 topn cap_mim_2f0_m4m5_noshield c_length=2.714U c_width=2.714U
* device instance $1060 r0 *1 317.711,124.511 cap_mim_2f0_m4m5_noshield
X$1060 \$99 topn cap_mim_2f0_m4m5_noshield c_length=2.714U c_width=2.714U
* device instance $1061 r0 *1 322.825,124.511 cap_mim_2f0_m4m5_noshield
X$1061 \$90 topn cap_mim_2f0_m4m5_noshield c_length=2.714U c_width=2.714U
* device instance $1062 r0 *1 327.939,124.511 cap_mim_2f0_m4m5_noshield
X$1062 \$99 topn cap_mim_2f0_m4m5_noshield c_length=2.714U c_width=2.714U
* device instance $1063 r0 *1 333.053,124.511 cap_mim_2f0_m4m5_noshield
X$1063 \$90 topn cap_mim_2f0_m4m5_noshield c_length=2.714U c_width=2.714U
* device instance $1064 r0 *1 338.167,124.511 cap_mim_2f0_m4m5_noshield
X$1064 \$99 topn cap_mim_2f0_m4m5_noshield c_length=2.714U c_width=2.714U
* device instance $1065 r0 *1 1.957,129.625 cap_mim_2f0_m4m5_noshield
X$1065 \$12 topp cap_mim_2f0_m4m5_noshield c_length=2.714U c_width=2.714U
* device instance $1066 r0 *1 7.071,129.625 cap_mim_2f0_m4m5_noshield
X$1066 \$10 topp cap_mim_2f0_m4m5_noshield c_length=2.714U c_width=2.714U
* device instance $1067 r0 *1 12.185,129.625 cap_mim_2f0_m4m5_noshield
X$1067 \$12 topp cap_mim_2f0_m4m5_noshield c_length=2.714U c_width=2.714U
* device instance $1068 r0 *1 17.299,129.625 cap_mim_2f0_m4m5_noshield
X$1068 \$10 topp cap_mim_2f0_m4m5_noshield c_length=2.714U c_width=2.714U
* device instance $1069 r0 *1 22.413,129.625 cap_mim_2f0_m4m5_noshield
X$1069 \$12 topp cap_mim_2f0_m4m5_noshield c_length=2.714U c_width=2.714U
* device instance $1070 r0 *1 27.527,129.625 cap_mim_2f0_m4m5_noshield
X$1070 \$10 topp cap_mim_2f0_m4m5_noshield c_length=2.714U c_width=2.714U
* device instance $1071 r0 *1 32.641,129.625 cap_mim_2f0_m4m5_noshield
X$1071 \$12 topp cap_mim_2f0_m4m5_noshield c_length=2.714U c_width=2.714U
* device instance $1072 r0 *1 37.755,129.625 cap_mim_2f0_m4m5_noshield
X$1072 \$10 topp cap_mim_2f0_m4m5_noshield c_length=2.714U c_width=2.714U
* device instance $1073 r0 *1 42.869,129.625 cap_mim_2f0_m4m5_noshield
X$1073 \$12 topp cap_mim_2f0_m4m5_noshield c_length=2.714U c_width=2.714U
* device instance $1074 r0 *1 47.983,129.625 cap_mim_2f0_m4m5_noshield
X$1074 \$10 topp cap_mim_2f0_m4m5_noshield c_length=2.714U c_width=2.714U
* device instance $1075 r0 *1 53.097,129.625 cap_mim_2f0_m4m5_noshield
X$1075 \$12 topp cap_mim_2f0_m4m5_noshield c_length=2.714U c_width=2.714U
* device instance $1076 r0 *1 58.211,129.625 cap_mim_2f0_m4m5_noshield
X$1076 \$10 topp cap_mim_2f0_m4m5_noshield c_length=2.714U c_width=2.714U
* device instance $1077 r0 *1 63.325,129.625 cap_mim_2f0_m4m5_noshield
X$1077 \$12 topp cap_mim_2f0_m4m5_noshield c_length=2.714U c_width=2.714U
* device instance $1078 r0 *1 68.439,129.625 cap_mim_2f0_m4m5_noshield
X$1078 \$10 topp cap_mim_2f0_m4m5_noshield c_length=2.714U c_width=2.714U
* device instance $1079 r0 *1 73.553,129.625 cap_mim_2f0_m4m5_noshield
X$1079 \$12 topp cap_mim_2f0_m4m5_noshield c_length=2.714U c_width=2.714U
* device instance $1080 r0 *1 78.667,129.625 cap_mim_2f0_m4m5_noshield
X$1080 \$10 topp cap_mim_2f0_m4m5_noshield c_length=2.714U c_width=2.714U
* device instance $1081 r0 *1 83.781,129.625 cap_mim_2f0_m4m5_noshield
X$1081 \$12 topp cap_mim_2f0_m4m5_noshield c_length=2.714U c_width=2.714U
* device instance $1082 r0 *1 88.895,129.625 cap_mim_2f0_m4m5_noshield
X$1082 \$10 topp cap_mim_2f0_m4m5_noshield c_length=2.714U c_width=2.714U
* device instance $1083 r0 *1 94.009,129.625 cap_mim_2f0_m4m5_noshield
X$1083 \$12 topp cap_mim_2f0_m4m5_noshield c_length=2.714U c_width=2.714U
* device instance $1084 r0 *1 99.123,129.625 cap_mim_2f0_m4m5_noshield
X$1084 \$10 topp cap_mim_2f0_m4m5_noshield c_length=2.714U c_width=2.714U
* device instance $1085 r0 *1 104.237,129.625 cap_mim_2f0_m4m5_noshield
X$1085 \$12 topp cap_mim_2f0_m4m5_noshield c_length=2.714U c_width=2.714U
* device instance $1086 r0 *1 109.351,129.625 cap_mim_2f0_m4m5_noshield
X$1086 \$10 topp cap_mim_2f0_m4m5_noshield c_length=2.714U c_width=2.714U
* device instance $1087 r0 *1 114.465,129.625 cap_mim_2f0_m4m5_noshield
X$1087 \$12 topp cap_mim_2f0_m4m5_noshield c_length=2.714U c_width=2.714U
* device instance $1088 r0 *1 119.579,129.625 cap_mim_2f0_m4m5_noshield
X$1088 \$10 topp cap_mim_2f0_m4m5_noshield c_length=2.714U c_width=2.714U
* device instance $1089 r0 *1 124.693,129.625 cap_mim_2f0_m4m5_noshield
X$1089 \$12 topp cap_mim_2f0_m4m5_noshield c_length=2.714U c_width=2.714U
* device instance $1090 r0 *1 129.807,129.625 cap_mim_2f0_m4m5_noshield
X$1090 \$10 topp cap_mim_2f0_m4m5_noshield c_length=2.714U c_width=2.714U
* device instance $1091 r0 *1 134.921,129.625 cap_mim_2f0_m4m5_noshield
X$1091 \$12 topp cap_mim_2f0_m4m5_noshield c_length=2.714U c_width=2.714U
* device instance $1092 r0 *1 140.035,129.625 cap_mim_2f0_m4m5_noshield
X$1092 \$10 topp cap_mim_2f0_m4m5_noshield c_length=2.714U c_width=2.714U
* device instance $1093 r0 *1 145.149,129.625 cap_mim_2f0_m4m5_noshield
X$1093 \$12 topp cap_mim_2f0_m4m5_noshield c_length=2.714U c_width=2.714U
* device instance $1094 r0 *1 150.263,129.625 cap_mim_2f0_m4m5_noshield
X$1094 \$10 topp cap_mim_2f0_m4m5_noshield c_length=2.714U c_width=2.714U
* device instance $1095 r0 *1 155.377,129.625 cap_mim_2f0_m4m5_noshield
X$1095 \$12 topp cap_mim_2f0_m4m5_noshield c_length=2.714U c_width=2.714U
* device instance $1096 r0 *1 160.491,129.625 cap_mim_2f0_m4m5_noshield
X$1096 \$10 topp cap_mim_2f0_m4m5_noshield c_length=2.714U c_width=2.714U
* device instance $1097 r0 *1 179.633,129.625 cap_mim_2f0_m4m5_noshield
X$1097 \$99 topn cap_mim_2f0_m4m5_noshield c_length=2.714U c_width=2.714U
* device instance $1098 r0 *1 184.747,129.625 cap_mim_2f0_m4m5_noshield
X$1098 \$90 topn cap_mim_2f0_m4m5_noshield c_length=2.714U c_width=2.714U
* device instance $1099 r0 *1 189.861,129.625 cap_mim_2f0_m4m5_noshield
X$1099 \$99 topn cap_mim_2f0_m4m5_noshield c_length=2.714U c_width=2.714U
* device instance $1100 r0 *1 194.975,129.625 cap_mim_2f0_m4m5_noshield
X$1100 \$90 topn cap_mim_2f0_m4m5_noshield c_length=2.714U c_width=2.714U
* device instance $1101 r0 *1 200.089,129.625 cap_mim_2f0_m4m5_noshield
X$1101 \$99 topn cap_mim_2f0_m4m5_noshield c_length=2.714U c_width=2.714U
* device instance $1102 r0 *1 205.203,129.625 cap_mim_2f0_m4m5_noshield
X$1102 \$90 topn cap_mim_2f0_m4m5_noshield c_length=2.714U c_width=2.714U
* device instance $1103 r0 *1 210.317,129.625 cap_mim_2f0_m4m5_noshield
X$1103 \$99 topn cap_mim_2f0_m4m5_noshield c_length=2.714U c_width=2.714U
* device instance $1104 r0 *1 215.431,129.625 cap_mim_2f0_m4m5_noshield
X$1104 \$90 topn cap_mim_2f0_m4m5_noshield c_length=2.714U c_width=2.714U
* device instance $1105 r0 *1 220.545,129.625 cap_mim_2f0_m4m5_noshield
X$1105 \$99 topn cap_mim_2f0_m4m5_noshield c_length=2.714U c_width=2.714U
* device instance $1106 r0 *1 225.659,129.625 cap_mim_2f0_m4m5_noshield
X$1106 \$90 topn cap_mim_2f0_m4m5_noshield c_length=2.714U c_width=2.714U
* device instance $1107 r0 *1 230.773,129.625 cap_mim_2f0_m4m5_noshield
X$1107 \$99 topn cap_mim_2f0_m4m5_noshield c_length=2.714U c_width=2.714U
* device instance $1108 r0 *1 235.887,129.625 cap_mim_2f0_m4m5_noshield
X$1108 \$90 topn cap_mim_2f0_m4m5_noshield c_length=2.714U c_width=2.714U
* device instance $1109 r0 *1 241.001,129.625 cap_mim_2f0_m4m5_noshield
X$1109 \$99 topn cap_mim_2f0_m4m5_noshield c_length=2.714U c_width=2.714U
* device instance $1110 r0 *1 246.115,129.625 cap_mim_2f0_m4m5_noshield
X$1110 \$90 topn cap_mim_2f0_m4m5_noshield c_length=2.714U c_width=2.714U
* device instance $1111 r0 *1 251.229,129.625 cap_mim_2f0_m4m5_noshield
X$1111 \$99 topn cap_mim_2f0_m4m5_noshield c_length=2.714U c_width=2.714U
* device instance $1112 r0 *1 256.343,129.625 cap_mim_2f0_m4m5_noshield
X$1112 \$90 topn cap_mim_2f0_m4m5_noshield c_length=2.714U c_width=2.714U
* device instance $1113 r0 *1 261.457,129.625 cap_mim_2f0_m4m5_noshield
X$1113 \$99 topn cap_mim_2f0_m4m5_noshield c_length=2.714U c_width=2.714U
* device instance $1114 r0 *1 266.571,129.625 cap_mim_2f0_m4m5_noshield
X$1114 \$90 topn cap_mim_2f0_m4m5_noshield c_length=2.714U c_width=2.714U
* device instance $1115 r0 *1 271.685,129.625 cap_mim_2f0_m4m5_noshield
X$1115 \$99 topn cap_mim_2f0_m4m5_noshield c_length=2.714U c_width=2.714U
* device instance $1116 r0 *1 276.799,129.625 cap_mim_2f0_m4m5_noshield
X$1116 \$90 topn cap_mim_2f0_m4m5_noshield c_length=2.714U c_width=2.714U
* device instance $1117 r0 *1 281.913,129.625 cap_mim_2f0_m4m5_noshield
X$1117 \$99 topn cap_mim_2f0_m4m5_noshield c_length=2.714U c_width=2.714U
* device instance $1118 r0 *1 287.027,129.625 cap_mim_2f0_m4m5_noshield
X$1118 \$90 topn cap_mim_2f0_m4m5_noshield c_length=2.714U c_width=2.714U
* device instance $1119 r0 *1 292.141,129.625 cap_mim_2f0_m4m5_noshield
X$1119 \$99 topn cap_mim_2f0_m4m5_noshield c_length=2.714U c_width=2.714U
* device instance $1120 r0 *1 297.255,129.625 cap_mim_2f0_m4m5_noshield
X$1120 \$90 topn cap_mim_2f0_m4m5_noshield c_length=2.714U c_width=2.714U
* device instance $1121 r0 *1 302.369,129.625 cap_mim_2f0_m4m5_noshield
X$1121 \$99 topn cap_mim_2f0_m4m5_noshield c_length=2.714U c_width=2.714U
* device instance $1122 r0 *1 307.483,129.625 cap_mim_2f0_m4m5_noshield
X$1122 \$90 topn cap_mim_2f0_m4m5_noshield c_length=2.714U c_width=2.714U
* device instance $1123 r0 *1 312.597,129.625 cap_mim_2f0_m4m5_noshield
X$1123 \$99 topn cap_mim_2f0_m4m5_noshield c_length=2.714U c_width=2.714U
* device instance $1124 r0 *1 317.711,129.625 cap_mim_2f0_m4m5_noshield
X$1124 \$90 topn cap_mim_2f0_m4m5_noshield c_length=2.714U c_width=2.714U
* device instance $1125 r0 *1 322.825,129.625 cap_mim_2f0_m4m5_noshield
X$1125 \$99 topn cap_mim_2f0_m4m5_noshield c_length=2.714U c_width=2.714U
* device instance $1126 r0 *1 327.939,129.625 cap_mim_2f0_m4m5_noshield
X$1126 \$90 topn cap_mim_2f0_m4m5_noshield c_length=2.714U c_width=2.714U
* device instance $1127 r0 *1 333.053,129.625 cap_mim_2f0_m4m5_noshield
X$1127 \$99 topn cap_mim_2f0_m4m5_noshield c_length=2.714U c_width=2.714U
* device instance $1128 r0 *1 338.167,129.625 cap_mim_2f0_m4m5_noshield
X$1128 \$90 topn cap_mim_2f0_m4m5_noshield c_length=2.714U c_width=2.714U
* device instance $1129 r0 *1 1.957,134.739 cap_mim_2f0_m4m5_noshield
X$1129 \$12 topp cap_mim_2f0_m4m5_noshield c_length=2.714U c_width=2.714U
* device instance $1130 r0 *1 7.071,134.739 cap_mim_2f0_m4m5_noshield
X$1130 \$10 topp cap_mim_2f0_m4m5_noshield c_length=2.714U c_width=2.714U
* device instance $1131 r0 *1 12.185,134.739 cap_mim_2f0_m4m5_noshield
X$1131 \$12 topp cap_mim_2f0_m4m5_noshield c_length=2.714U c_width=2.714U
* device instance $1132 r0 *1 17.299,134.739 cap_mim_2f0_m4m5_noshield
X$1132 \$10 topp cap_mim_2f0_m4m5_noshield c_length=2.714U c_width=2.714U
* device instance $1133 r0 *1 22.413,134.739 cap_mim_2f0_m4m5_noshield
X$1133 \$12 topp cap_mim_2f0_m4m5_noshield c_length=2.714U c_width=2.714U
* device instance $1134 r0 *1 27.527,134.739 cap_mim_2f0_m4m5_noshield
X$1134 \$10 topp cap_mim_2f0_m4m5_noshield c_length=2.714U c_width=2.714U
* device instance $1135 r0 *1 32.641,134.739 cap_mim_2f0_m4m5_noshield
X$1135 \$12 topp cap_mim_2f0_m4m5_noshield c_length=2.714U c_width=2.714U
* device instance $1136 r0 *1 37.755,134.739 cap_mim_2f0_m4m5_noshield
X$1136 \$10 topp cap_mim_2f0_m4m5_noshield c_length=2.714U c_width=2.714U
* device instance $1137 r0 *1 42.869,134.739 cap_mim_2f0_m4m5_noshield
X$1137 \$12 topp cap_mim_2f0_m4m5_noshield c_length=2.714U c_width=2.714U
* device instance $1138 r0 *1 47.983,134.739 cap_mim_2f0_m4m5_noshield
X$1138 \$10 topp cap_mim_2f0_m4m5_noshield c_length=2.714U c_width=2.714U
* device instance $1139 r0 *1 53.097,134.739 cap_mim_2f0_m4m5_noshield
X$1139 \$12 topp cap_mim_2f0_m4m5_noshield c_length=2.714U c_width=2.714U
* device instance $1140 r0 *1 58.211,134.739 cap_mim_2f0_m4m5_noshield
X$1140 \$10 topp cap_mim_2f0_m4m5_noshield c_length=2.714U c_width=2.714U
* device instance $1141 r0 *1 63.325,134.739 cap_mim_2f0_m4m5_noshield
X$1141 \$12 topp cap_mim_2f0_m4m5_noshield c_length=2.714U c_width=2.714U
* device instance $1142 r0 *1 68.439,134.739 cap_mim_2f0_m4m5_noshield
X$1142 \$10 topp cap_mim_2f0_m4m5_noshield c_length=2.714U c_width=2.714U
* device instance $1143 r0 *1 73.553,134.739 cap_mim_2f0_m4m5_noshield
X$1143 \$12 topp cap_mim_2f0_m4m5_noshield c_length=2.714U c_width=2.714U
* device instance $1144 r0 *1 78.667,134.739 cap_mim_2f0_m4m5_noshield
X$1144 \$10 topp cap_mim_2f0_m4m5_noshield c_length=2.714U c_width=2.714U
* device instance $1145 r0 *1 83.781,134.739 cap_mim_2f0_m4m5_noshield
X$1145 \$12 topp cap_mim_2f0_m4m5_noshield c_length=2.714U c_width=2.714U
* device instance $1146 r0 *1 88.895,134.739 cap_mim_2f0_m4m5_noshield
X$1146 \$10 topp cap_mim_2f0_m4m5_noshield c_length=2.714U c_width=2.714U
* device instance $1147 r0 *1 94.009,134.739 cap_mim_2f0_m4m5_noshield
X$1147 \$12 topp cap_mim_2f0_m4m5_noshield c_length=2.714U c_width=2.714U
* device instance $1148 r0 *1 99.123,134.739 cap_mim_2f0_m4m5_noshield
X$1148 \$10 topp cap_mim_2f0_m4m5_noshield c_length=2.714U c_width=2.714U
* device instance $1149 r0 *1 104.237,134.739 cap_mim_2f0_m4m5_noshield
X$1149 \$12 topp cap_mim_2f0_m4m5_noshield c_length=2.714U c_width=2.714U
* device instance $1150 r0 *1 109.351,134.739 cap_mim_2f0_m4m5_noshield
X$1150 \$10 topp cap_mim_2f0_m4m5_noshield c_length=2.714U c_width=2.714U
* device instance $1151 r0 *1 114.465,134.739 cap_mim_2f0_m4m5_noshield
X$1151 \$12 topp cap_mim_2f0_m4m5_noshield c_length=2.714U c_width=2.714U
* device instance $1152 r0 *1 119.579,134.739 cap_mim_2f0_m4m5_noshield
X$1152 \$10 topp cap_mim_2f0_m4m5_noshield c_length=2.714U c_width=2.714U
* device instance $1153 r0 *1 124.693,134.739 cap_mim_2f0_m4m5_noshield
X$1153 \$12 topp cap_mim_2f0_m4m5_noshield c_length=2.714U c_width=2.714U
* device instance $1154 r0 *1 129.807,134.739 cap_mim_2f0_m4m5_noshield
X$1154 \$10 topp cap_mim_2f0_m4m5_noshield c_length=2.714U c_width=2.714U
* device instance $1155 r0 *1 134.921,134.739 cap_mim_2f0_m4m5_noshield
X$1155 \$12 topp cap_mim_2f0_m4m5_noshield c_length=2.714U c_width=2.714U
* device instance $1156 r0 *1 140.035,134.739 cap_mim_2f0_m4m5_noshield
X$1156 \$10 topp cap_mim_2f0_m4m5_noshield c_length=2.714U c_width=2.714U
* device instance $1157 r0 *1 145.149,134.739 cap_mim_2f0_m4m5_noshield
X$1157 \$12 topp cap_mim_2f0_m4m5_noshield c_length=2.714U c_width=2.714U
* device instance $1158 r0 *1 150.263,134.739 cap_mim_2f0_m4m5_noshield
X$1158 \$10 topp cap_mim_2f0_m4m5_noshield c_length=2.714U c_width=2.714U
* device instance $1159 r0 *1 155.377,134.739 cap_mim_2f0_m4m5_noshield
X$1159 \$12 topp cap_mim_2f0_m4m5_noshield c_length=2.714U c_width=2.714U
* device instance $1160 r0 *1 160.491,134.739 cap_mim_2f0_m4m5_noshield
X$1160 \$10 topp cap_mim_2f0_m4m5_noshield c_length=2.714U c_width=2.714U
* device instance $1161 r0 *1 179.633,134.739 cap_mim_2f0_m4m5_noshield
X$1161 \$99 topn cap_mim_2f0_m4m5_noshield c_length=2.714U c_width=2.714U
* device instance $1162 r0 *1 184.747,134.739 cap_mim_2f0_m4m5_noshield
X$1162 \$90 topn cap_mim_2f0_m4m5_noshield c_length=2.714U c_width=2.714U
* device instance $1163 r0 *1 189.861,134.739 cap_mim_2f0_m4m5_noshield
X$1163 \$99 topn cap_mim_2f0_m4m5_noshield c_length=2.714U c_width=2.714U
* device instance $1164 r0 *1 194.975,134.739 cap_mim_2f0_m4m5_noshield
X$1164 \$90 topn cap_mim_2f0_m4m5_noshield c_length=2.714U c_width=2.714U
* device instance $1165 r0 *1 200.089,134.739 cap_mim_2f0_m4m5_noshield
X$1165 \$99 topn cap_mim_2f0_m4m5_noshield c_length=2.714U c_width=2.714U
* device instance $1166 r0 *1 205.203,134.739 cap_mim_2f0_m4m5_noshield
X$1166 \$90 topn cap_mim_2f0_m4m5_noshield c_length=2.714U c_width=2.714U
* device instance $1167 r0 *1 210.317,134.739 cap_mim_2f0_m4m5_noshield
X$1167 \$99 topn cap_mim_2f0_m4m5_noshield c_length=2.714U c_width=2.714U
* device instance $1168 r0 *1 215.431,134.739 cap_mim_2f0_m4m5_noshield
X$1168 \$90 topn cap_mim_2f0_m4m5_noshield c_length=2.714U c_width=2.714U
* device instance $1169 r0 *1 220.545,134.739 cap_mim_2f0_m4m5_noshield
X$1169 \$99 topn cap_mim_2f0_m4m5_noshield c_length=2.714U c_width=2.714U
* device instance $1170 r0 *1 225.659,134.739 cap_mim_2f0_m4m5_noshield
X$1170 \$90 topn cap_mim_2f0_m4m5_noshield c_length=2.714U c_width=2.714U
* device instance $1171 r0 *1 230.773,134.739 cap_mim_2f0_m4m5_noshield
X$1171 \$99 topn cap_mim_2f0_m4m5_noshield c_length=2.714U c_width=2.714U
* device instance $1172 r0 *1 235.887,134.739 cap_mim_2f0_m4m5_noshield
X$1172 \$90 topn cap_mim_2f0_m4m5_noshield c_length=2.714U c_width=2.714U
* device instance $1173 r0 *1 241.001,134.739 cap_mim_2f0_m4m5_noshield
X$1173 \$99 topn cap_mim_2f0_m4m5_noshield c_length=2.714U c_width=2.714U
* device instance $1174 r0 *1 246.115,134.739 cap_mim_2f0_m4m5_noshield
X$1174 \$90 topn cap_mim_2f0_m4m5_noshield c_length=2.714U c_width=2.714U
* device instance $1175 r0 *1 251.229,134.739 cap_mim_2f0_m4m5_noshield
X$1175 \$99 topn cap_mim_2f0_m4m5_noshield c_length=2.714U c_width=2.714U
* device instance $1176 r0 *1 256.343,134.739 cap_mim_2f0_m4m5_noshield
X$1176 \$90 topn cap_mim_2f0_m4m5_noshield c_length=2.714U c_width=2.714U
* device instance $1177 r0 *1 261.457,134.739 cap_mim_2f0_m4m5_noshield
X$1177 \$99 topn cap_mim_2f0_m4m5_noshield c_length=2.714U c_width=2.714U
* device instance $1178 r0 *1 266.571,134.739 cap_mim_2f0_m4m5_noshield
X$1178 \$90 topn cap_mim_2f0_m4m5_noshield c_length=2.714U c_width=2.714U
* device instance $1179 r0 *1 271.685,134.739 cap_mim_2f0_m4m5_noshield
X$1179 \$99 topn cap_mim_2f0_m4m5_noshield c_length=2.714U c_width=2.714U
* device instance $1180 r0 *1 276.799,134.739 cap_mim_2f0_m4m5_noshield
X$1180 \$90 topn cap_mim_2f0_m4m5_noshield c_length=2.714U c_width=2.714U
* device instance $1181 r0 *1 281.913,134.739 cap_mim_2f0_m4m5_noshield
X$1181 \$99 topn cap_mim_2f0_m4m5_noshield c_length=2.714U c_width=2.714U
* device instance $1182 r0 *1 287.027,134.739 cap_mim_2f0_m4m5_noshield
X$1182 \$90 topn cap_mim_2f0_m4m5_noshield c_length=2.714U c_width=2.714U
* device instance $1183 r0 *1 292.141,134.739 cap_mim_2f0_m4m5_noshield
X$1183 \$99 topn cap_mim_2f0_m4m5_noshield c_length=2.714U c_width=2.714U
* device instance $1184 r0 *1 297.255,134.739 cap_mim_2f0_m4m5_noshield
X$1184 \$90 topn cap_mim_2f0_m4m5_noshield c_length=2.714U c_width=2.714U
* device instance $1185 r0 *1 302.369,134.739 cap_mim_2f0_m4m5_noshield
X$1185 \$99 topn cap_mim_2f0_m4m5_noshield c_length=2.714U c_width=2.714U
* device instance $1186 r0 *1 307.483,134.739 cap_mim_2f0_m4m5_noshield
X$1186 \$90 topn cap_mim_2f0_m4m5_noshield c_length=2.714U c_width=2.714U
* device instance $1187 r0 *1 312.597,134.739 cap_mim_2f0_m4m5_noshield
X$1187 \$99 topn cap_mim_2f0_m4m5_noshield c_length=2.714U c_width=2.714U
* device instance $1188 r0 *1 317.711,134.739 cap_mim_2f0_m4m5_noshield
X$1188 \$90 topn cap_mim_2f0_m4m5_noshield c_length=2.714U c_width=2.714U
* device instance $1189 r0 *1 322.825,134.739 cap_mim_2f0_m4m5_noshield
X$1189 \$99 topn cap_mim_2f0_m4m5_noshield c_length=2.714U c_width=2.714U
* device instance $1190 r0 *1 327.939,134.739 cap_mim_2f0_m4m5_noshield
X$1190 \$90 topn cap_mim_2f0_m4m5_noshield c_length=2.714U c_width=2.714U
* device instance $1191 r0 *1 333.053,134.739 cap_mim_2f0_m4m5_noshield
X$1191 \$99 topn cap_mim_2f0_m4m5_noshield c_length=2.714U c_width=2.714U
* device instance $1192 r0 *1 338.167,134.739 cap_mim_2f0_m4m5_noshield
X$1192 \$90 topn cap_mim_2f0_m4m5_noshield c_length=2.714U c_width=2.714U
* device instance $1193 r0 *1 1.957,139.853 cap_mim_2f0_m4m5_noshield
X$1193 \$14 topp cap_mim_2f0_m4m5_noshield c_length=2.714U c_width=2.714U
* device instance $1194 r0 *1 7.071,139.853 cap_mim_2f0_m4m5_noshield
X$1194 \$10 topp cap_mim_2f0_m4m5_noshield c_length=2.714U c_width=2.714U
* device instance $1195 r0 *1 12.185,139.853 cap_mim_2f0_m4m5_noshield
X$1195 \$14 topp cap_mim_2f0_m4m5_noshield c_length=2.714U c_width=2.714U
* device instance $1196 r0 *1 17.299,139.853 cap_mim_2f0_m4m5_noshield
X$1196 \$10 topp cap_mim_2f0_m4m5_noshield c_length=2.714U c_width=2.714U
* device instance $1197 r0 *1 22.413,139.853 cap_mim_2f0_m4m5_noshield
X$1197 \$14 topp cap_mim_2f0_m4m5_noshield c_length=2.714U c_width=2.714U
* device instance $1198 r0 *1 27.527,139.853 cap_mim_2f0_m4m5_noshield
X$1198 \$10 topp cap_mim_2f0_m4m5_noshield c_length=2.714U c_width=2.714U
* device instance $1199 r0 *1 32.641,139.853 cap_mim_2f0_m4m5_noshield
X$1199 \$14 topp cap_mim_2f0_m4m5_noshield c_length=2.714U c_width=2.714U
* device instance $1200 r0 *1 37.755,139.853 cap_mim_2f0_m4m5_noshield
X$1200 \$10 topp cap_mim_2f0_m4m5_noshield c_length=2.714U c_width=2.714U
* device instance $1201 r0 *1 42.869,139.853 cap_mim_2f0_m4m5_noshield
X$1201 \$14 topp cap_mim_2f0_m4m5_noshield c_length=2.714U c_width=2.714U
* device instance $1202 r0 *1 47.983,139.853 cap_mim_2f0_m4m5_noshield
X$1202 \$10 topp cap_mim_2f0_m4m5_noshield c_length=2.714U c_width=2.714U
* device instance $1203 r0 *1 53.097,139.853 cap_mim_2f0_m4m5_noshield
X$1203 \$14 topp cap_mim_2f0_m4m5_noshield c_length=2.714U c_width=2.714U
* device instance $1204 r0 *1 58.211,139.853 cap_mim_2f0_m4m5_noshield
X$1204 \$10 topp cap_mim_2f0_m4m5_noshield c_length=2.714U c_width=2.714U
* device instance $1205 r0 *1 63.325,139.853 cap_mim_2f0_m4m5_noshield
X$1205 \$14 topp cap_mim_2f0_m4m5_noshield c_length=2.714U c_width=2.714U
* device instance $1206 r0 *1 68.439,139.853 cap_mim_2f0_m4m5_noshield
X$1206 \$10 topp cap_mim_2f0_m4m5_noshield c_length=2.714U c_width=2.714U
* device instance $1207 r0 *1 73.553,139.853 cap_mim_2f0_m4m5_noshield
X$1207 \$14 topp cap_mim_2f0_m4m5_noshield c_length=2.714U c_width=2.714U
* device instance $1208 r0 *1 78.667,139.853 cap_mim_2f0_m4m5_noshield
X$1208 \$10 topp cap_mim_2f0_m4m5_noshield c_length=2.714U c_width=2.714U
* device instance $1209 r0 *1 83.781,139.853 cap_mim_2f0_m4m5_noshield
X$1209 \$14 topp cap_mim_2f0_m4m5_noshield c_length=2.714U c_width=2.714U
* device instance $1210 r0 *1 88.895,139.853 cap_mim_2f0_m4m5_noshield
X$1210 \$10 topp cap_mim_2f0_m4m5_noshield c_length=2.714U c_width=2.714U
* device instance $1211 r0 *1 94.009,139.853 cap_mim_2f0_m4m5_noshield
X$1211 \$14 topp cap_mim_2f0_m4m5_noshield c_length=2.714U c_width=2.714U
* device instance $1212 r0 *1 99.123,139.853 cap_mim_2f0_m4m5_noshield
X$1212 \$10 topp cap_mim_2f0_m4m5_noshield c_length=2.714U c_width=2.714U
* device instance $1213 r0 *1 104.237,139.853 cap_mim_2f0_m4m5_noshield
X$1213 \$14 topp cap_mim_2f0_m4m5_noshield c_length=2.714U c_width=2.714U
* device instance $1214 r0 *1 109.351,139.853 cap_mim_2f0_m4m5_noshield
X$1214 \$10 topp cap_mim_2f0_m4m5_noshield c_length=2.714U c_width=2.714U
* device instance $1215 r0 *1 114.465,139.853 cap_mim_2f0_m4m5_noshield
X$1215 \$14 topp cap_mim_2f0_m4m5_noshield c_length=2.714U c_width=2.714U
* device instance $1216 r0 *1 119.579,139.853 cap_mim_2f0_m4m5_noshield
X$1216 \$10 topp cap_mim_2f0_m4m5_noshield c_length=2.714U c_width=2.714U
* device instance $1217 r0 *1 124.693,139.853 cap_mim_2f0_m4m5_noshield
X$1217 \$14 topp cap_mim_2f0_m4m5_noshield c_length=2.714U c_width=2.714U
* device instance $1218 r0 *1 129.807,139.853 cap_mim_2f0_m4m5_noshield
X$1218 \$10 topp cap_mim_2f0_m4m5_noshield c_length=2.714U c_width=2.714U
* device instance $1219 r0 *1 134.921,139.853 cap_mim_2f0_m4m5_noshield
X$1219 \$14 topp cap_mim_2f0_m4m5_noshield c_length=2.714U c_width=2.714U
* device instance $1220 r0 *1 140.035,139.853 cap_mim_2f0_m4m5_noshield
X$1220 \$10 topp cap_mim_2f0_m4m5_noshield c_length=2.714U c_width=2.714U
* device instance $1221 r0 *1 145.149,139.853 cap_mim_2f0_m4m5_noshield
X$1221 \$14 topp cap_mim_2f0_m4m5_noshield c_length=2.714U c_width=2.714U
* device instance $1222 r0 *1 150.263,139.853 cap_mim_2f0_m4m5_noshield
X$1222 \$10 topp cap_mim_2f0_m4m5_noshield c_length=2.714U c_width=2.714U
* device instance $1223 r0 *1 155.377,139.853 cap_mim_2f0_m4m5_noshield
X$1223 \$14 topp cap_mim_2f0_m4m5_noshield c_length=2.714U c_width=2.714U
* device instance $1224 r0 *1 160.491,139.853 cap_mim_2f0_m4m5_noshield
X$1224 \$10 topp cap_mim_2f0_m4m5_noshield c_length=2.714U c_width=2.714U
* device instance $1225 r0 *1 179.633,139.853 cap_mim_2f0_m4m5_noshield
X$1225 \$107 topn cap_mim_2f0_m4m5_noshield c_length=2.714U c_width=2.714U
* device instance $1226 r0 *1 184.747,139.853 cap_mim_2f0_m4m5_noshield
X$1226 \$90 topn cap_mim_2f0_m4m5_noshield c_length=2.714U c_width=2.714U
* device instance $1227 r0 *1 189.861,139.853 cap_mim_2f0_m4m5_noshield
X$1227 \$107 topn cap_mim_2f0_m4m5_noshield c_length=2.714U c_width=2.714U
* device instance $1228 r0 *1 194.975,139.853 cap_mim_2f0_m4m5_noshield
X$1228 \$90 topn cap_mim_2f0_m4m5_noshield c_length=2.714U c_width=2.714U
* device instance $1229 r0 *1 200.089,139.853 cap_mim_2f0_m4m5_noshield
X$1229 \$107 topn cap_mim_2f0_m4m5_noshield c_length=2.714U c_width=2.714U
* device instance $1230 r0 *1 205.203,139.853 cap_mim_2f0_m4m5_noshield
X$1230 \$90 topn cap_mim_2f0_m4m5_noshield c_length=2.714U c_width=2.714U
* device instance $1231 r0 *1 210.317,139.853 cap_mim_2f0_m4m5_noshield
X$1231 \$107 topn cap_mim_2f0_m4m5_noshield c_length=2.714U c_width=2.714U
* device instance $1232 r0 *1 215.431,139.853 cap_mim_2f0_m4m5_noshield
X$1232 \$90 topn cap_mim_2f0_m4m5_noshield c_length=2.714U c_width=2.714U
* device instance $1233 r0 *1 220.545,139.853 cap_mim_2f0_m4m5_noshield
X$1233 \$107 topn cap_mim_2f0_m4m5_noshield c_length=2.714U c_width=2.714U
* device instance $1234 r0 *1 225.659,139.853 cap_mim_2f0_m4m5_noshield
X$1234 \$90 topn cap_mim_2f0_m4m5_noshield c_length=2.714U c_width=2.714U
* device instance $1235 r0 *1 230.773,139.853 cap_mim_2f0_m4m5_noshield
X$1235 \$107 topn cap_mim_2f0_m4m5_noshield c_length=2.714U c_width=2.714U
* device instance $1236 r0 *1 235.887,139.853 cap_mim_2f0_m4m5_noshield
X$1236 \$90 topn cap_mim_2f0_m4m5_noshield c_length=2.714U c_width=2.714U
* device instance $1237 r0 *1 241.001,139.853 cap_mim_2f0_m4m5_noshield
X$1237 \$107 topn cap_mim_2f0_m4m5_noshield c_length=2.714U c_width=2.714U
* device instance $1238 r0 *1 246.115,139.853 cap_mim_2f0_m4m5_noshield
X$1238 \$90 topn cap_mim_2f0_m4m5_noshield c_length=2.714U c_width=2.714U
* device instance $1239 r0 *1 251.229,139.853 cap_mim_2f0_m4m5_noshield
X$1239 \$107 topn cap_mim_2f0_m4m5_noshield c_length=2.714U c_width=2.714U
* device instance $1240 r0 *1 256.343,139.853 cap_mim_2f0_m4m5_noshield
X$1240 \$90 topn cap_mim_2f0_m4m5_noshield c_length=2.714U c_width=2.714U
* device instance $1241 r0 *1 261.457,139.853 cap_mim_2f0_m4m5_noshield
X$1241 \$107 topn cap_mim_2f0_m4m5_noshield c_length=2.714U c_width=2.714U
* device instance $1242 r0 *1 266.571,139.853 cap_mim_2f0_m4m5_noshield
X$1242 \$90 topn cap_mim_2f0_m4m5_noshield c_length=2.714U c_width=2.714U
* device instance $1243 r0 *1 271.685,139.853 cap_mim_2f0_m4m5_noshield
X$1243 \$107 topn cap_mim_2f0_m4m5_noshield c_length=2.714U c_width=2.714U
* device instance $1244 r0 *1 276.799,139.853 cap_mim_2f0_m4m5_noshield
X$1244 \$90 topn cap_mim_2f0_m4m5_noshield c_length=2.714U c_width=2.714U
* device instance $1245 r0 *1 281.913,139.853 cap_mim_2f0_m4m5_noshield
X$1245 \$107 topn cap_mim_2f0_m4m5_noshield c_length=2.714U c_width=2.714U
* device instance $1246 r0 *1 287.027,139.853 cap_mim_2f0_m4m5_noshield
X$1246 \$90 topn cap_mim_2f0_m4m5_noshield c_length=2.714U c_width=2.714U
* device instance $1247 r0 *1 292.141,139.853 cap_mim_2f0_m4m5_noshield
X$1247 \$107 topn cap_mim_2f0_m4m5_noshield c_length=2.714U c_width=2.714U
* device instance $1248 r0 *1 297.255,139.853 cap_mim_2f0_m4m5_noshield
X$1248 \$90 topn cap_mim_2f0_m4m5_noshield c_length=2.714U c_width=2.714U
* device instance $1249 r0 *1 302.369,139.853 cap_mim_2f0_m4m5_noshield
X$1249 \$107 topn cap_mim_2f0_m4m5_noshield c_length=2.714U c_width=2.714U
* device instance $1250 r0 *1 307.483,139.853 cap_mim_2f0_m4m5_noshield
X$1250 \$90 topn cap_mim_2f0_m4m5_noshield c_length=2.714U c_width=2.714U
* device instance $1251 r0 *1 312.597,139.853 cap_mim_2f0_m4m5_noshield
X$1251 \$107 topn cap_mim_2f0_m4m5_noshield c_length=2.714U c_width=2.714U
* device instance $1252 r0 *1 317.711,139.853 cap_mim_2f0_m4m5_noshield
X$1252 \$90 topn cap_mim_2f0_m4m5_noshield c_length=2.714U c_width=2.714U
* device instance $1253 r0 *1 322.825,139.853 cap_mim_2f0_m4m5_noshield
X$1253 \$107 topn cap_mim_2f0_m4m5_noshield c_length=2.714U c_width=2.714U
* device instance $1254 r0 *1 327.939,139.853 cap_mim_2f0_m4m5_noshield
X$1254 \$90 topn cap_mim_2f0_m4m5_noshield c_length=2.714U c_width=2.714U
* device instance $1255 r0 *1 333.053,139.853 cap_mim_2f0_m4m5_noshield
X$1255 \$107 topn cap_mim_2f0_m4m5_noshield c_length=2.714U c_width=2.714U
* device instance $1256 r0 *1 338.167,139.853 cap_mim_2f0_m4m5_noshield
X$1256 \$90 topn cap_mim_2f0_m4m5_noshield c_length=2.714U c_width=2.714U
* device instance $1257 r0 *1 1.957,144.967 cap_mim_2f0_m4m5_noshield
X$1257 \$16 topp cap_mim_2f0_m4m5_noshield c_length=2.714U c_width=2.714U
* device instance $1258 r0 *1 7.071,144.967 cap_mim_2f0_m4m5_noshield
X$1258 \$10 topp cap_mim_2f0_m4m5_noshield c_length=2.714U c_width=2.714U
* device instance $1259 r0 *1 12.185,144.967 cap_mim_2f0_m4m5_noshield
X$1259 \$16 topp cap_mim_2f0_m4m5_noshield c_length=2.714U c_width=2.714U
* device instance $1260 r0 *1 17.299,144.967 cap_mim_2f0_m4m5_noshield
X$1260 \$10 topp cap_mim_2f0_m4m5_noshield c_length=2.714U c_width=2.714U
* device instance $1261 r0 *1 22.413,144.967 cap_mim_2f0_m4m5_noshield
X$1261 \$16 topp cap_mim_2f0_m4m5_noshield c_length=2.714U c_width=2.714U
* device instance $1262 r0 *1 27.527,144.967 cap_mim_2f0_m4m5_noshield
X$1262 \$10 topp cap_mim_2f0_m4m5_noshield c_length=2.714U c_width=2.714U
* device instance $1263 r0 *1 32.641,144.967 cap_mim_2f0_m4m5_noshield
X$1263 \$16 topp cap_mim_2f0_m4m5_noshield c_length=2.714U c_width=2.714U
* device instance $1264 r0 *1 37.755,144.967 cap_mim_2f0_m4m5_noshield
X$1264 \$10 topp cap_mim_2f0_m4m5_noshield c_length=2.714U c_width=2.714U
* device instance $1265 r0 *1 42.869,144.967 cap_mim_2f0_m4m5_noshield
X$1265 \$16 topp cap_mim_2f0_m4m5_noshield c_length=2.714U c_width=2.714U
* device instance $1266 r0 *1 47.983,144.967 cap_mim_2f0_m4m5_noshield
X$1266 \$10 topp cap_mim_2f0_m4m5_noshield c_length=2.714U c_width=2.714U
* device instance $1267 r0 *1 53.097,144.967 cap_mim_2f0_m4m5_noshield
X$1267 \$16 topp cap_mim_2f0_m4m5_noshield c_length=2.714U c_width=2.714U
* device instance $1268 r0 *1 58.211,144.967 cap_mim_2f0_m4m5_noshield
X$1268 \$10 topp cap_mim_2f0_m4m5_noshield c_length=2.714U c_width=2.714U
* device instance $1269 r0 *1 63.325,144.967 cap_mim_2f0_m4m5_noshield
X$1269 \$16 topp cap_mim_2f0_m4m5_noshield c_length=2.714U c_width=2.714U
* device instance $1270 r0 *1 68.439,144.967 cap_mim_2f0_m4m5_noshield
X$1270 \$10 topp cap_mim_2f0_m4m5_noshield c_length=2.714U c_width=2.714U
* device instance $1271 r0 *1 73.553,144.967 cap_mim_2f0_m4m5_noshield
X$1271 \$16 topp cap_mim_2f0_m4m5_noshield c_length=2.714U c_width=2.714U
* device instance $1272 r0 *1 78.667,144.967 cap_mim_2f0_m4m5_noshield
X$1272 \$10 topp cap_mim_2f0_m4m5_noshield c_length=2.714U c_width=2.714U
* device instance $1273 r0 *1 83.781,144.967 cap_mim_2f0_m4m5_noshield
X$1273 \$18 topp cap_mim_2f0_m4m5_noshield c_length=2.714U c_width=2.714U
* device instance $1274 r0 *1 88.895,144.967 cap_mim_2f0_m4m5_noshield
X$1274 \$10 topp cap_mim_2f0_m4m5_noshield c_length=2.714U c_width=2.714U
* device instance $1275 r0 *1 94.009,144.967 cap_mim_2f0_m4m5_noshield
X$1275 \$18 topp cap_mim_2f0_m4m5_noshield c_length=2.714U c_width=2.714U
* device instance $1276 r0 *1 99.123,144.967 cap_mim_2f0_m4m5_noshield
X$1276 \$10 topp cap_mim_2f0_m4m5_noshield c_length=2.714U c_width=2.714U
* device instance $1277 r0 *1 104.237,144.967 cap_mim_2f0_m4m5_noshield
X$1277 \$18 topp cap_mim_2f0_m4m5_noshield c_length=2.714U c_width=2.714U
* device instance $1278 r0 *1 109.351,144.967 cap_mim_2f0_m4m5_noshield
X$1278 \$10 topp cap_mim_2f0_m4m5_noshield c_length=2.714U c_width=2.714U
* device instance $1279 r0 *1 114.465,144.967 cap_mim_2f0_m4m5_noshield
X$1279 \$18 topp cap_mim_2f0_m4m5_noshield c_length=2.714U c_width=2.714U
* device instance $1280 r0 *1 119.579,144.967 cap_mim_2f0_m4m5_noshield
X$1280 \$10 topp cap_mim_2f0_m4m5_noshield c_length=2.714U c_width=2.714U
* device instance $1281 r0 *1 124.693,144.967 cap_mim_2f0_m4m5_noshield
X$1281 \$20 topp cap_mim_2f0_m4m5_noshield c_length=2.714U c_width=2.714U
* device instance $1282 r0 *1 129.807,144.967 cap_mim_2f0_m4m5_noshield
X$1282 \$10 topp cap_mim_2f0_m4m5_noshield c_length=2.714U c_width=2.714U
* device instance $1283 r0 *1 134.921,144.967 cap_mim_2f0_m4m5_noshield
X$1283 \$20 topp cap_mim_2f0_m4m5_noshield c_length=2.714U c_width=2.714U
* device instance $1284 r0 *1 140.035,144.967 cap_mim_2f0_m4m5_noshield
X$1284 \$10 topp cap_mim_2f0_m4m5_noshield c_length=2.714U c_width=2.714U
* device instance $1285 r0 *1 145.149,144.967 cap_mim_2f0_m4m5_noshield
X$1285 \$22 topp cap_mim_2f0_m4m5_noshield c_length=2.714U c_width=2.714U
* device instance $1286 r0 *1 150.263,144.967 cap_mim_2f0_m4m5_noshield
X$1286 \$10 topp cap_mim_2f0_m4m5_noshield c_length=2.714U c_width=2.714U
* device instance $1287 r0 *1 155.377,144.967 cap_mim_2f0_m4m5_noshield
X$1287 \$24 topp cap_mim_2f0_m4m5_noshield c_length=2.714U c_width=2.714U
* device instance $1288 r0 *1 160.491,144.967 cap_mim_2f0_m4m5_noshield
X$1288 \$10 topp cap_mim_2f0_m4m5_noshield c_length=2.714U c_width=2.714U
* device instance $1289 r0 *1 179.633,144.967 cap_mim_2f0_m4m5_noshield
X$1289 \$115 topn cap_mim_2f0_m4m5_noshield c_length=2.714U c_width=2.714U
* device instance $1290 r0 *1 184.747,144.967 cap_mim_2f0_m4m5_noshield
X$1290 \$90 topn cap_mim_2f0_m4m5_noshield c_length=2.714U c_width=2.714U
* device instance $1291 r0 *1 189.861,144.967 cap_mim_2f0_m4m5_noshield
X$1291 \$115 topn cap_mim_2f0_m4m5_noshield c_length=2.714U c_width=2.714U
* device instance $1292 r0 *1 194.975,144.967 cap_mim_2f0_m4m5_noshield
X$1292 \$90 topn cap_mim_2f0_m4m5_noshield c_length=2.714U c_width=2.714U
* device instance $1293 r0 *1 200.089,144.967 cap_mim_2f0_m4m5_noshield
X$1293 \$115 topn cap_mim_2f0_m4m5_noshield c_length=2.714U c_width=2.714U
* device instance $1294 r0 *1 205.203,144.967 cap_mim_2f0_m4m5_noshield
X$1294 \$90 topn cap_mim_2f0_m4m5_noshield c_length=2.714U c_width=2.714U
* device instance $1295 r0 *1 210.317,144.967 cap_mim_2f0_m4m5_noshield
X$1295 \$115 topn cap_mim_2f0_m4m5_noshield c_length=2.714U c_width=2.714U
* device instance $1296 r0 *1 215.431,144.967 cap_mim_2f0_m4m5_noshield
X$1296 \$90 topn cap_mim_2f0_m4m5_noshield c_length=2.714U c_width=2.714U
* device instance $1297 r0 *1 220.545,144.967 cap_mim_2f0_m4m5_noshield
X$1297 \$115 topn cap_mim_2f0_m4m5_noshield c_length=2.714U c_width=2.714U
* device instance $1298 r0 *1 225.659,144.967 cap_mim_2f0_m4m5_noshield
X$1298 \$90 topn cap_mim_2f0_m4m5_noshield c_length=2.714U c_width=2.714U
* device instance $1299 r0 *1 230.773,144.967 cap_mim_2f0_m4m5_noshield
X$1299 \$115 topn cap_mim_2f0_m4m5_noshield c_length=2.714U c_width=2.714U
* device instance $1300 r0 *1 235.887,144.967 cap_mim_2f0_m4m5_noshield
X$1300 \$90 topn cap_mim_2f0_m4m5_noshield c_length=2.714U c_width=2.714U
* device instance $1301 r0 *1 241.001,144.967 cap_mim_2f0_m4m5_noshield
X$1301 \$115 topn cap_mim_2f0_m4m5_noshield c_length=2.714U c_width=2.714U
* device instance $1302 r0 *1 246.115,144.967 cap_mim_2f0_m4m5_noshield
X$1302 \$90 topn cap_mim_2f0_m4m5_noshield c_length=2.714U c_width=2.714U
* device instance $1303 r0 *1 251.229,144.967 cap_mim_2f0_m4m5_noshield
X$1303 \$115 topn cap_mim_2f0_m4m5_noshield c_length=2.714U c_width=2.714U
* device instance $1304 r0 *1 256.343,144.967 cap_mim_2f0_m4m5_noshield
X$1304 \$90 topn cap_mim_2f0_m4m5_noshield c_length=2.714U c_width=2.714U
* device instance $1305 r0 *1 261.457,144.967 cap_mim_2f0_m4m5_noshield
X$1305 \$123 topn cap_mim_2f0_m4m5_noshield c_length=2.714U c_width=2.714U
* device instance $1306 r0 *1 266.571,144.967 cap_mim_2f0_m4m5_noshield
X$1306 \$90 topn cap_mim_2f0_m4m5_noshield c_length=2.714U c_width=2.714U
* device instance $1307 r0 *1 271.685,144.967 cap_mim_2f0_m4m5_noshield
X$1307 \$123 topn cap_mim_2f0_m4m5_noshield c_length=2.714U c_width=2.714U
* device instance $1308 r0 *1 276.799,144.967 cap_mim_2f0_m4m5_noshield
X$1308 \$90 topn cap_mim_2f0_m4m5_noshield c_length=2.714U c_width=2.714U
* device instance $1309 r0 *1 281.913,144.967 cap_mim_2f0_m4m5_noshield
X$1309 \$123 topn cap_mim_2f0_m4m5_noshield c_length=2.714U c_width=2.714U
* device instance $1310 r0 *1 287.027,144.967 cap_mim_2f0_m4m5_noshield
X$1310 \$90 topn cap_mim_2f0_m4m5_noshield c_length=2.714U c_width=2.714U
* device instance $1311 r0 *1 292.141,144.967 cap_mim_2f0_m4m5_noshield
X$1311 \$123 topn cap_mim_2f0_m4m5_noshield c_length=2.714U c_width=2.714U
* device instance $1312 r0 *1 297.255,144.967 cap_mim_2f0_m4m5_noshield
X$1312 \$90 topn cap_mim_2f0_m4m5_noshield c_length=2.714U c_width=2.714U
* device instance $1313 r0 *1 302.369,144.967 cap_mim_2f0_m4m5_noshield
X$1313 \$131 topn cap_mim_2f0_m4m5_noshield c_length=2.714U c_width=2.714U
* device instance $1314 r0 *1 307.483,144.967 cap_mim_2f0_m4m5_noshield
X$1314 \$90 topn cap_mim_2f0_m4m5_noshield c_length=2.714U c_width=2.714U
* device instance $1315 r0 *1 312.597,144.967 cap_mim_2f0_m4m5_noshield
X$1315 \$131 topn cap_mim_2f0_m4m5_noshield c_length=2.714U c_width=2.714U
* device instance $1316 r0 *1 317.711,144.967 cap_mim_2f0_m4m5_noshield
X$1316 \$90 topn cap_mim_2f0_m4m5_noshield c_length=2.714U c_width=2.714U
* device instance $1317 r0 *1 322.825,144.967 cap_mim_2f0_m4m5_noshield
X$1317 \$139 topn cap_mim_2f0_m4m5_noshield c_length=2.714U c_width=2.714U
* device instance $1318 r0 *1 327.939,144.967 cap_mim_2f0_m4m5_noshield
X$1318 \$90 topn cap_mim_2f0_m4m5_noshield c_length=2.714U c_width=2.714U
* device instance $1319 r0 *1 333.053,144.967 cap_mim_2f0_m4m5_noshield
X$1319 \$147 topn cap_mim_2f0_m4m5_noshield c_length=2.714U c_width=2.714U
* device instance $1320 r0 *1 338.167,144.967 cap_mim_2f0_m4m5_noshield
X$1320 \$90 topn cap_mim_2f0_m4m5_noshield c_length=2.714U c_width=2.714U
* device instance _10 r0 *1 0,0
R_10 \$10 \$10__par 1848.7597
* device instance _10 r0 *1 0,0
C_10 \$10__par vsubs 2.551103e-13
* device instance _100 r0 *1 0,0
R_100 \$100 \$100__par 203.5755
* device instance _100 r0 *1 0,0
C_100 \$100__par vsubs 5.967584e-15
* device instance _102 r0 *1 0,0
R_102 \$102 \$102__par 270.9967
* device instance _102 r0 *1 0,0
C_102 \$102__par vsubs 6.498027e-15
* device instance _104 r0 *1 0,0
R_104 \$104 \$104__par 338.6213
* device instance _104 r0 *1 0,0
C_104 \$104__par vsubs 7.028469e-15
* device instance _106 r0 *1 0,0
R_106 \$106 \$106__par 406.3369
* device instance _106 r0 *1 0,0
C_106 \$106__par vsubs 7.558912e-15
* device instance _107 r0 *1 0,0
R_107 \$107 \$107__par 1330.6193
* device instance _107 r0 *1 0,0
C_107 \$107__par vsubs 8.1173218e-14
* device instance _108 r0 *1 0,0
R_108 \$108 \$108__par 203.5755
* device instance _108 r0 *1 0,0
C_108 \$108__par vsubs 5.967584e-15
* device instance _11 r0 *1 0,0
R_11 \$11 \$11__par 406.3369
* device instance _11 r0 *1 0,0
C_11 \$11__par vsubs 7.558912e-15
* device instance _110 r0 *1 0,0
R_110 \$110 \$110__par 270.9967
* device instance _110 r0 *1 0,0
C_110 \$110__par vsubs 6.498027e-15
* device instance _112 r0 *1 0,0
R_112 \$112 \$112__par 338.6213
* device instance _112 r0 *1 0,0
C_112 \$112__par vsubs 7.028469e-15
* device instance _114 r0 *1 0,0
R_114 \$114 \$114__par 406.3369
* device instance _114 r0 *1 0,0
C_114 \$114__par vsubs 7.558912e-15
* device instance _115 r0 *1 0,0
R_115 \$115 \$115__par 1330.6193
* device instance _115 r0 *1 0,0
C_115 \$115__par vsubs 8.1173218e-14
* device instance _116 r0 *1 0,0
R_116 \$116 \$116__par 203.5755
* device instance _116 r0 *1 0,0
C_116 \$116__par vsubs 5.967584e-15
* device instance _118 r0 *1 0,0
R_118 \$118 \$118__par 270.9967
* device instance _118 r0 *1 0,0
C_118 \$118__par vsubs 6.498027e-15
* device instance _12 r0 *1 0,0
R_12 \$12 \$12__par 1503.323
* device instance _12 r0 *1 0,0
C_12 \$12__par vsubs 1.39152245e-13
* device instance _120 r0 *1 0,0
R_120 \$120 \$120__par 338.6213
* device instance _120 r0 *1 0,0
C_120 \$120__par vsubs 7.028469e-15
* device instance _122 r0 *1 0,0
R_122 \$122 \$122__par 406.3369
* device instance _122 r0 *1 0,0
C_122 \$122__par vsubs 7.558912e-15
* device instance _123 r0 *1 0,0
R_123 \$123 \$123__par 1330.6193
* device instance _123 r0 *1 0,0
C_123 \$123__par vsubs 8.1173218e-14
* device instance _124 r0 *1 0,0
R_124 \$124 \$124__par 203.5755
* device instance _124 r0 *1 0,0
C_124 \$124__par vsubs 5.967584e-15
* device instance _126 r0 *1 0,0
R_126 \$126 \$126__par 270.9967
* device instance _126 r0 *1 0,0
C_126 \$126__par vsubs 6.498027e-15
* device instance _128 r0 *1 0,0
R_128 \$128 \$128__par 338.6213
* device instance _128 r0 *1 0,0
C_128 \$128__par vsubs 7.028469e-15
* device instance _13 r0 *1 0,0
R_13 \$13 \$13__par 406.3369
* device instance _13 r0 *1 0,0
C_13 \$13__par vsubs 7.558912e-15
* device instance _130 r0 *1 0,0
R_130 \$130 \$130__par 406.3369
* device instance _130 r0 *1 0,0
C_130 \$130__par vsubs 7.558912e-15
* device instance _131 r0 *1 0,0
R_131 \$131 \$131__par 1330.6193
* device instance _131 r0 *1 0,0
C_131 \$131__par vsubs 8.1173218e-14
* device instance _132 r0 *1 0,0
R_132 \$132 \$132__par 203.5755
* device instance _132 r0 *1 0,0
C_132 \$132__par vsubs 5.967584e-15
* device instance _134 r0 *1 0,0
R_134 \$134 \$134__par 270.9967
* device instance _134 r0 *1 0,0
C_134 \$134__par vsubs 6.498027e-15
* device instance _136 r0 *1 0,0
R_136 \$136 \$136__par 338.6213
* device instance _136 r0 *1 0,0
C_136 \$136__par vsubs 7.028469e-15
* device instance _138 r0 *1 0,0
R_138 \$138 \$138__par 406.3369
* device instance _138 r0 *1 0,0
C_138 \$138__par vsubs 7.558912e-15
* device instance _139 r0 *1 0,0
R_139 \$139 \$139__par 1330.6193
* device instance _139 r0 *1 0,0
C_139 \$139__par vsubs 8.1173218e-14
* device instance _14 r0 *1 0,0
R_14 \$14 \$14__par 1330.6193
* device instance _14 r0 *1 0,0
C_14 \$14__par vsubs 8.1173218e-14
* device instance _140 r0 *1 0,0
R_140 \$140 \$140__par 203.5755
* device instance _140 r0 *1 0,0
C_140 \$140__par vsubs 5.967584e-15
* device instance _142 r0 *1 0,0
R_142 \$142 \$142__par 270.9967
* device instance _142 r0 *1 0,0
C_142 \$142__par vsubs 6.498027e-15
* device instance _144 r0 *1 0,0
R_144 \$144 \$144__par 338.6213
* device instance _144 r0 *1 0,0
C_144 \$144__par vsubs 7.028469e-15
* device instance _146 r0 *1 0,0
R_146 \$146 \$146__par 406.3369
* device instance _146 r0 *1 0,0
C_146 \$146__par vsubs 7.558912e-15
* device instance _147 r0 *1 0,0
R_147 \$147 \$147__par 1244.2875
* device instance _147 r0 *1 0,0
C_147 \$147__par vsubs 5.2183704e-14
* device instance _148 r0 *1 0,0
R_148 \$148 \$148__par 203.5755
* device instance _148 r0 *1 0,0
C_148 \$148__par vsubs 5.967584e-15
* device instance _15 r0 *1 0,0
R_15 \$15 \$15__par 406.3369
* device instance _15 r0 *1 0,0
C_15 \$15__par vsubs 7.558912e-15
* device instance _150 r0 *1 0,0
R_150 \$150 \$150__par 270.9967
* device instance _150 r0 *1 0,0
C_150 \$150__par vsubs 6.498027e-15
* device instance _152 r0 *1 0,0
R_152 \$152 \$152__par 338.6213
* device instance _152 r0 *1 0,0
C_152 \$152__par vsubs 7.028469e-15
* device instance _154 r0 *1 0,0
R_154 \$154 \$154__par 406.3369
* device instance _154 r0 *1 0,0
C_154 \$154__par vsubs 7.558912e-15
* device instance _155 r0 *1 0,0
R_155 \$155 \$155__par 1201.1436
* device instance _155 r0 *1 0,0
C_155 \$155__par vsubs 3.7688947e-14
* device instance _16 r0 *1 0,0
R_16 \$16 \$16__par 1330.6193
* device instance _16 r0 *1 0,0
C_16 \$16__par vsubs 8.1173218e-14
* device instance _166 r0 *1 0,0
R_166 \$166 \$166__par 196.6042
* device instance _166 r0 *1 0,0
C_166 \$166__par vsubs 3.621691e-15
* device instance _167 r0 *1 0,0
R_167 \$167 \$167__par 196.6042
* device instance _167 r0 *1 0,0
C_167 \$167__par vsubs 3.621691e-15
* device instance _17 r0 *1 0,0
R_17 \$17 \$17__par 406.3369
* device instance _17 r0 *1 0,0
C_17 \$17__par vsubs 7.558912e-15
* device instance _18 r0 *1 0,0
R_18 \$18 \$18__par 1330.6193
* device instance _18 r0 *1 0,0
C_18 \$18__par vsubs 8.1173218e-14
* device instance _19 r0 *1 0,0
R_19 \$19 \$19__par 406.3369
* device instance _19 r0 *1 0,0
C_19 \$19__par vsubs 7.558912e-15
* device instance _20 r0 *1 0,0
R_20 \$20 \$20__par 1330.6193
* device instance _20 r0 *1 0,0
C_20 \$20__par vsubs 8.1173218e-14
* device instance _21 r0 *1 0,0
R_21 \$21 \$21__par 406.3369
* device instance _21 r0 *1 0,0
C_21 \$21__par vsubs 7.558912e-15
* device instance _22 r0 *1 0,0
R_22 \$22 \$22__par 1330.6193
* device instance _22 r0 *1 0,0
C_22 \$22__par vsubs 8.1173218e-14
* device instance _23 r0 *1 0,0
R_23 \$23 \$23__par 406.3369
* device instance _23 r0 *1 0,0
C_23 \$23__par vsubs 7.558912e-15
* device instance _24 r0 *1 0,0
R_24 \$24 \$24__par 1244.2875
* device instance _24 r0 *1 0,0
C_24 \$24__par vsubs 5.2183704e-14
* device instance _25 r0 *1 0,0
R_25 \$25 \$25__par 406.3369
* device instance _25 r0 *1 0,0
C_25 \$25__par vsubs 7.558912e-15
* device instance _26 r0 *1 0,0
R_26 \$26 \$26__par 1201.1436
* device instance _26 r0 *1 0,0
C_26 \$26__par vsubs 3.7688947e-14
* device instance _27 r0 *1 0,0
R_27 \$27 \$27__par 270.9967
* device instance _27 r0 *1 0,0
C_27 \$27__par vsubs 6.498027e-15
* device instance _29 r0 *1 0,0
R_29 \$29 \$29__par 338.6213
* device instance _29 r0 *1 0,0
C_29 \$29__par vsubs 7.028469e-15
* device instance _31 r0 *1 0,0
R_31 \$31 \$31__par 270.9967
* device instance _31 r0 *1 0,0
C_31 \$31__par vsubs 6.498027e-15
* device instance _33 r0 *1 0,0
R_33 \$33 \$33__par 338.6213
* device instance _33 r0 *1 0,0
C_33 \$33__par vsubs 7.028469e-15
* device instance _35 r0 *1 0,0
R_35 \$35 \$35__par 270.9967
* device instance _35 r0 *1 0,0
C_35 \$35__par vsubs 6.498027e-15
* device instance _37 r0 *1 0,0
R_37 \$37 \$37__par 338.6213
* device instance _37 r0 *1 0,0
C_37 \$37__par vsubs 7.028469e-15
* device instance _39 r0 *1 0,0
R_39 \$39 \$39__par 270.9967
* device instance _39 r0 *1 0,0
C_39 \$39__par vsubs 6.498027e-15
* device instance _41 r0 *1 0,0
R_41 \$41 \$41__par 338.6213
* device instance _41 r0 *1 0,0
C_41 \$41__par vsubs 7.028469e-15
* device instance _43 r0 *1 0,0
R_43 \$43 \$43__par 270.9967
* device instance _43 r0 *1 0,0
C_43 \$43__par vsubs 6.498027e-15
* device instance _45 r0 *1 0,0
R_45 \$45 \$45__par 338.6213
* device instance _45 r0 *1 0,0
C_45 \$45__par vsubs 7.028469e-15
* device instance _47 r0 *1 0,0
R_47 \$47 \$47__par 270.9967
* device instance _47 r0 *1 0,0
C_47 \$47__par vsubs 6.498027e-15
* device instance _49 r0 *1 0,0
R_49 \$49 \$49__par 338.6213
* device instance _49 r0 *1 0,0
C_49 \$49__par vsubs 7.028469e-15
* device instance _51 r0 *1 0,0
R_51 \$51 \$51__par 270.9967
* device instance _51 r0 *1 0,0
C_51 \$51__par vsubs 6.498027e-15
* device instance _53 r0 *1 0,0
R_53 \$53 \$53__par 338.6213
* device instance _53 r0 *1 0,0
C_53 \$53__par vsubs 7.028469e-15
* device instance _55 r0 *1 0,0
R_55 \$55 \$55__par 270.9967
* device instance _55 r0 *1 0,0
C_55 \$55__par vsubs 6.498027e-15
* device instance _57 r0 *1 0,0
R_57 \$57 \$57__par 338.6213
* device instance _57 r0 *1 0,0
C_57 \$57__par vsubs 7.028469e-15
* device instance _59 r0 *1 0,0
R_59 \$59 \$59__par 270.9967
* device instance _59 r0 *1 0,0
C_59 \$59__par vsubs 6.498027e-15
* device instance _61 r0 *1 0,0
R_61 \$61 \$61__par 338.6213
* device instance _61 r0 *1 0,0
C_61 \$61__par vsubs 7.028469e-15
* device instance _65 r0 *1 0,0
R_65 \$65 \$65__par 203.5755
* device instance _65 r0 *1 0,0
C_65 \$65__par vsubs 5.967584e-15
* device instance _67 r0 *1 0,0
R_67 \$67 \$67__par 203.5755
* device instance _67 r0 *1 0,0
C_67 \$67__par vsubs 5.967584e-15
* device instance _69 r0 *1 0,0
R_69 \$69 \$69__par 203.5755
* device instance _69 r0 *1 0,0
C_69 \$69__par vsubs 5.967584e-15
* device instance _71 r0 *1 0,0
R_71 \$71 \$71__par 203.5755
* device instance _71 r0 *1 0,0
C_71 \$71__par vsubs 5.967584e-15
* device instance _73 r0 *1 0,0
R_73 \$73 \$73__par 203.5755
* device instance _73 r0 *1 0,0
C_73 \$73__par vsubs 5.967584e-15
* device instance _75 r0 *1 0,0
R_75 \$75 \$75__par 203.5755
* device instance _75 r0 *1 0,0
C_75 \$75__par vsubs 5.967584e-15
* device instance _77 r0 *1 0,0
R_77 \$77 \$77__par 203.5755
* device instance _77 r0 *1 0,0
C_77 \$77__par vsubs 5.967584e-15
* device instance _79 r0 *1 0,0
R_79 \$79 \$79__par 203.5755
* device instance _79 r0 *1 0,0
C_79 \$79__par vsubs 5.967584e-15
* device instance _81 r0 *1 0,0
R_81 \$81 \$81__par 203.5755
* device instance _81 r0 *1 0,0
C_81 \$81__par vsubs 5.967584e-15
* device instance _83 r0 *1 0,0
R_83 \$83 \$83__par 203.5755
* device instance _83 r0 *1 0,0
C_83 \$83__par vsubs 5.967584e-15
* device instance _85 r0 *1 0,0
R_85 \$85 \$85__par 270.9967
* device instance _85 r0 *1 0,0
C_85 \$85__par vsubs 6.498027e-15
* device instance _87 r0 *1 0,0
R_87 \$87 \$87__par 338.6213
* device instance _87 r0 *1 0,0
C_87 \$87__par vsubs 7.028469e-15
* device instance _89 r0 *1 0,0
R_89 \$89 \$89__par 406.3369
* device instance _89 r0 *1 0,0
C_89 \$89__par vsubs 7.558912e-15
* device instance _9 r0 *1 0,0
R_9 \$9 \$9__par 406.3369
* device instance _9 r0 *1 0,0
C_9 \$9__par vsubs 7.558912e-15
* device instance _90 r0 *1 0,0
R_90 \$90 \$90__par 1848.7597
* device instance _90 r0 *1 0,0
C_90 \$90__par vsubs 2.551103e-13
* device instance _92 r0 *1 0,0
R_92 \$92 \$92__par 203.5755
* device instance _92 r0 *1 0,0
C_92 \$92__par vsubs 5.967584e-15
* device instance _94 r0 *1 0,0
R_94 \$94 \$94__par 270.9967
* device instance _94 r0 *1 0,0
C_94 \$94__par vsubs 6.498027e-15
* device instance _96 r0 *1 0,0
R_96 \$96 \$96__par 338.6213
* device instance _96 r0 *1 0,0
C_96 \$96__par vsubs 7.028469e-15
* device instance _98 r0 *1 0,0
R_98 \$98 \$98__par 406.3369
* device instance _98 r0 *1 0,0
C_98 \$98__par vsubs 7.558912e-15
* device instance _99 r0 *1 0,0
R_99 \$99 \$99__par 1503.323
* device instance _99 r0 *1 0,0
C_99 \$99__par vsubs 1.39152245e-13
* device instance hi_128_n r0 *1 0,0
Rhi_128_n hi_128_n hi_128_n__par 334.3378
* device instance hi_128_n r0 *1 0,0
Chi_128_n hi_128_n__par vsubs 4.862937e-15
* device instance hi_128_p r0 *1 0,0
Rhi_128_p hi_128_p hi_128_p__par 334.3378
* device instance hi_128_p r0 *1 0,0
Chi_128_p hi_128_p__par vsubs 4.862937e-15
* device instance hi_16_n r0 *1 0,0
Rhi_16_n hi_16_n hi_16_n__par 334.3378
* device instance hi_16_n r0 *1 0,0
Chi_16_n hi_16_n__par vsubs 4.862937e-15
* device instance hi_16_p r0 *1 0,0
Rhi_16_p hi_16_p hi_16_p__par 334.3378
* device instance hi_16_p r0 *1 0,0
Chi_16_p hi_16_p__par vsubs 4.862937e-15
* device instance hi_1_n r0 *1 0,0
Rhi_1_n hi_1_n hi_1_n__par 334.3378
* device instance hi_1_n r0 *1 0,0
Chi_1_n hi_1_n__par vsubs 4.862937e-15
* device instance hi_1_p r0 *1 0,0
Rhi_1_p hi_1_p hi_1_p__par 334.3378
* device instance hi_1_p r0 *1 0,0
Chi_1_p hi_1_p__par vsubs 4.862937e-15
* device instance hi_256_n r0 *1 0,0
Rhi_256_n hi_256_n hi_256_n__par 334.3378
* device instance hi_256_n r0 *1 0,0
Chi_256_n hi_256_n__par vsubs 4.862937e-15
* device instance hi_256_p r0 *1 0,0
Rhi_256_p hi_256_p hi_256_p__par 334.3378
* device instance hi_256_p r0 *1 0,0
Chi_256_p hi_256_p__par vsubs 4.862937e-15
* device instance hi_2_n r0 *1 0,0
Rhi_2_n hi_2_n hi_2_n__par 334.3378
* device instance hi_2_n r0 *1 0,0
Chi_2_n hi_2_n__par vsubs 4.862937e-15
* device instance hi_2_p r0 *1 0,0
Rhi_2_p hi_2_p hi_2_p__par 334.3378
* device instance hi_2_p r0 *1 0,0
Chi_2_p hi_2_p__par vsubs 4.862937e-15
* device instance hi_32_n r0 *1 0,0
Rhi_32_n hi_32_n hi_32_n__par 334.3378
* device instance hi_32_n r0 *1 0,0
Chi_32_n hi_32_n__par vsubs 4.862937e-15
* device instance hi_32_p r0 *1 0,0
Rhi_32_p hi_32_p hi_32_p__par 334.3378
* device instance hi_32_p r0 *1 0,0
Chi_32_p hi_32_p__par vsubs 4.862937e-15
* device instance hi_4_n r0 *1 0,0
Rhi_4_n hi_4_n hi_4_n__par 334.3378
* device instance hi_4_n r0 *1 0,0
Chi_4_n hi_4_n__par vsubs 4.862937e-15
* device instance hi_4_p r0 *1 0,0
Rhi_4_p hi_4_p hi_4_p__par 334.3378
* device instance hi_4_p r0 *1 0,0
Chi_4_p hi_4_p__par vsubs 4.862937e-15
* device instance hi_64_n r0 *1 0,0
Rhi_64_n hi_64_n hi_64_n__par 334.3378
* device instance hi_64_n r0 *1 0,0
Chi_64_n hi_64_n__par vsubs 4.862937e-15
* device instance hi_64_p r0 *1 0,0
Rhi_64_p hi_64_p hi_64_p__par 334.3378
* device instance hi_64_p r0 *1 0,0
Chi_64_p hi_64_p__par vsubs 4.862937e-15
* device instance hi_8_n r0 *1 0,0
Rhi_8_n hi_8_n hi_8_n__par 334.3378
* device instance hi_8_n r0 *1 0,0
Chi_8_n hi_8_n__par vsubs 4.862937e-15
* device instance hi_8_p r0 *1 0,0
Rhi_8_p hi_8_p hi_8_p__par 334.3378
* device instance hi_8_p r0 *1 0,0
Chi_8_p hi_8_p__par vsubs 4.862937e-15
* device instance lo_128_n r0 *1 0,0
Rlo_128_n lo_128_n lo_128_n__par 402.2264
* device instance lo_128_n r0 *1 0,0
Clo_128_n lo_128_n__par vsubs 5.399614e-15
* device instance lo_128_p r0 *1 0,0
Rlo_128_p lo_128_p lo_128_p__par 402.2264
* device instance lo_128_p r0 *1 0,0
Clo_128_p lo_128_p__par vsubs 5.399614e-15
* device instance lo_16_n r0 *1 0,0
Rlo_16_n lo_16_n lo_16_n__par 402.2264
* device instance lo_16_n r0 *1 0,0
Clo_16_n lo_16_n__par vsubs 5.399614e-15
* device instance lo_16_p r0 *1 0,0
Rlo_16_p lo_16_p lo_16_p__par 402.2264
* device instance lo_16_p r0 *1 0,0
Clo_16_p lo_16_p__par vsubs 5.399614e-15
* device instance lo_1_n r0 *1 0,0
Rlo_1_n lo_1_n lo_1_n__par 402.2264
* device instance lo_1_n r0 *1 0,0
Clo_1_n lo_1_n__par vsubs 5.399614e-15
* device instance lo_1_p r0 *1 0,0
Rlo_1_p lo_1_p lo_1_p__par 402.2264
* device instance lo_1_p r0 *1 0,0
Clo_1_p lo_1_p__par vsubs 5.399614e-15
* device instance lo_256_n r0 *1 0,0
Rlo_256_n lo_256_n lo_256_n__par 402.2264
* device instance lo_256_n r0 *1 0,0
Clo_256_n lo_256_n__par vsubs 5.399614e-15
* device instance lo_256_p r0 *1 0,0
Rlo_256_p lo_256_p lo_256_p__par 402.2264
* device instance lo_256_p r0 *1 0,0
Clo_256_p lo_256_p__par vsubs 5.399614e-15
* device instance lo_2_n r0 *1 0,0
Rlo_2_n lo_2_n lo_2_n__par 402.2264
* device instance lo_2_n r0 *1 0,0
Clo_2_n lo_2_n__par vsubs 5.399614e-15
* device instance lo_2_p r0 *1 0,0
Rlo_2_p lo_2_p lo_2_p__par 402.2264
* device instance lo_2_p r0 *1 0,0
Clo_2_p lo_2_p__par vsubs 5.399614e-15
* device instance lo_32_n r0 *1 0,0
Rlo_32_n lo_32_n lo_32_n__par 402.2264
* device instance lo_32_n r0 *1 0,0
Clo_32_n lo_32_n__par vsubs 5.399614e-15
* device instance lo_32_p r0 *1 0,0
Rlo_32_p lo_32_p lo_32_p__par 402.2264
* device instance lo_32_p r0 *1 0,0
Clo_32_p lo_32_p__par vsubs 5.399614e-15
* device instance lo_4_n r0 *1 0,0
Rlo_4_n lo_4_n lo_4_n__par 402.2264
* device instance lo_4_n r0 *1 0,0
Clo_4_n lo_4_n__par vsubs 5.399614e-15
* device instance lo_4_p r0 *1 0,0
Rlo_4_p lo_4_p lo_4_p__par 402.2264
* device instance lo_4_p r0 *1 0,0
Clo_4_p lo_4_p__par vsubs 5.399614e-15
* device instance lo_64_n r0 *1 0,0
Rlo_64_n lo_64_n lo_64_n__par 402.2264
* device instance lo_64_n r0 *1 0,0
Clo_64_n lo_64_n__par vsubs 5.399614e-15
* device instance lo_64_p r0 *1 0,0
Rlo_64_p lo_64_p lo_64_p__par 402.2264
* device instance lo_64_p r0 *1 0,0
Clo_64_p lo_64_p__par vsubs 5.399614e-15
* device instance lo_8_n r0 *1 0,0
Rlo_8_n lo_8_n lo_8_n__par 402.2264
* device instance lo_8_n r0 *1 0,0
Clo_8_n lo_8_n__par vsubs 5.399614e-15
* device instance lo_8_p r0 *1 0,0
Rlo_8_p lo_8_p lo_8_p__par 402.2264
* device instance lo_8_p r0 *1 0,0
Clo_8_p lo_8_p__par vsubs 5.399614e-15
* device instance pinn r0 *1 0,0
Rpinn vinn pinn__par 2916.0662
* device instance pinn r0 *1 0,0
Cpinn pinn__par vsubs 8.3786688e-14
* device instance pinp r0 *1 0,0
Rpinp vinp pinp__par 2916.0662
* device instance pinp r0 *1 0,0
Cpinp pinp__par vsubs 8.3786688e-14
* device instance rel_128_n r0 *1 0,0
Rrel_128_n rel_128_n rel_128_n__par 266.4501
* device instance rel_128_n r0 *1 0,0
Crel_128_n rel_128_n__par vsubs 4.32626e-15
* device instance rel_128_p r0 *1 0,0
Rrel_128_p rel_128_p rel_128_p__par 266.4501
* device instance rel_128_p r0 *1 0,0
Crel_128_p rel_128_p__par vsubs 4.32626e-15
* device instance rel_16_n r0 *1 0,0
Rrel_16_n rel_16_n rel_16_n__par 266.4501
* device instance rel_16_n r0 *1 0,0
Crel_16_n rel_16_n__par vsubs 4.32626e-15
* device instance rel_16_p r0 *1 0,0
Rrel_16_p rel_16_p rel_16_p__par 266.4501
* device instance rel_16_p r0 *1 0,0
Crel_16_p rel_16_p__par vsubs 4.32626e-15
* device instance rel_1_n r0 *1 0,0
Rrel_1_n rel_1_n rel_1_n__par 266.4501
* device instance rel_1_n r0 *1 0,0
Crel_1_n rel_1_n__par vsubs 4.32626e-15
* device instance rel_1_p r0 *1 0,0
Rrel_1_p rel_1_p rel_1_p__par 266.4501
* device instance rel_1_p r0 *1 0,0
Crel_1_p rel_1_p__par vsubs 4.32626e-15
* device instance rel_256_n r0 *1 0,0
Rrel_256_n rel_256_n rel_256_n__par 266.4501
* device instance rel_256_n r0 *1 0,0
Crel_256_n rel_256_n__par vsubs 4.32626e-15
* device instance rel_256_p r0 *1 0,0
Rrel_256_p rel_256_p rel_256_p__par 266.4501
* device instance rel_256_p r0 *1 0,0
Crel_256_p rel_256_p__par vsubs 4.32626e-15
* device instance rel_2_n r0 *1 0,0
Rrel_2_n rel_2_n rel_2_n__par 266.4501
* device instance rel_2_n r0 *1 0,0
Crel_2_n rel_2_n__par vsubs 4.32626e-15
* device instance rel_2_p r0 *1 0,0
Rrel_2_p rel_2_p rel_2_p__par 266.4501
* device instance rel_2_p r0 *1 0,0
Crel_2_p rel_2_p__par vsubs 4.32626e-15
* device instance rel_32_n r0 *1 0,0
Rrel_32_n rel_32_n rel_32_n__par 266.4501
* device instance rel_32_n r0 *1 0,0
Crel_32_n rel_32_n__par vsubs 4.32626e-15
* device instance rel_32_p r0 *1 0,0
Rrel_32_p rel_32_p rel_32_p__par 266.4501
* device instance rel_32_p r0 *1 0,0
Crel_32_p rel_32_p__par vsubs 4.32626e-15
* device instance rel_4_n r0 *1 0,0
Rrel_4_n rel_4_n rel_4_n__par 266.4501
* device instance rel_4_n r0 *1 0,0
Crel_4_n rel_4_n__par vsubs 4.32626e-15
* device instance rel_4_p r0 *1 0,0
Rrel_4_p rel_4_p rel_4_p__par 266.4501
* device instance rel_4_p r0 *1 0,0
Crel_4_p rel_4_p__par vsubs 4.32626e-15
* device instance rel_64_n r0 *1 0,0
Rrel_64_n rel_64_n rel_64_n__par 266.4501
* device instance rel_64_n r0 *1 0,0
Crel_64_n rel_64_n__par vsubs 4.32626e-15
* device instance rel_64_p r0 *1 0,0
Rrel_64_p rel_64_p rel_64_p__par 266.4501
* device instance rel_64_p r0 *1 0,0
Crel_64_p rel_64_p__par vsubs 4.32626e-15
* device instance rel_8_n r0 *1 0,0
Rrel_8_n rel_8_n rel_8_n__par 266.4501
* device instance rel_8_n r0 *1 0,0
Crel_8_n rel_8_n__par vsubs 4.32626e-15
* device instance rel_8_p r0 *1 0,0
Rrel_8_p rel_8_p rel_8_p__par 266.4501
* device instance rel_8_p r0 *1 0,0
Crel_8_p rel_8_p__par vsubs 4.32626e-15
* device instance sel_in r0 *1 0,0
Rsel_in sel_in sel_in__par 4571.5028
* device instance sel_in r0 *1 0,0
Csel_in sel_in__par vsubs 1.1132343e-13
* device instance topn r0 *1 0,0
Rtopn topn topn__par 212.0673
* device instance topn r0 *1 0,0
Ctopn topn__par vsubs 5.735751e-15
* device instance topp r0 *1 0,0
Rtopp topp topp__par 148.2651
* device instance topp r0 *1 0,0
Ctopp topp__par vsubs 6.397849e-15
* device instance tp_gn r0 *1 0,0
Rtp_gn tp_gn tp_gn__par 404.5234
* device instance tp_gn r0 *1 0,0
Ctp_gn tp_gn__par vsubs 4.986478e-15
* device instance vcm r0 *1 0,0
Rvcm vcm vcm__par 8695.7618
* device instance vcm r0 *1 0,0
Cvcm vcm__par vsubs 2.35028694e-13
* device instance vdd r0 *1 0,0
Rvdd vdd vdd__par 16013.5381
* device instance vdd r0 *1 0,0
Cvdd vdd__par vsubs 2.63552797e-13
* device instance vref r0 *1 0,0
Rvref vref vref__par 7293.4243
* device instance vref r0 *1 0,0
Cvref vref__par vsubs 1.80552629e-13
* device instance vss r0 *1 0,0
Rvss vss vss__par 6848.2403
* device instance vss r0 *1 0,0
Cvss vss__par vsubs 2.18536232e-13
.ENDS ADC_TOP

* ================= extracted core se (single-ended) ==================
vsestart se_start 0 dc 0
vsemode se_mode 0 dc 0
xsectrl clk se_start se_mode se_cmp se_samp_tp_n se_sel_in_n se_drdy se_c9
+ se_c8 se_c7 se_c6 se_c5 se_c4 se_c3 se_c2 se_c1 se_c0 se_rel_n_256p
+ se_sel_hi_n_256p se_sel_lo_n_256p se_rel_n_128p se_sel_hi_n_128p
+ se_sel_lo_n_128p se_rel_n_64p se_sel_hi_n_64p se_sel_lo_n_64p
+ se_rel_n_32p se_sel_hi_n_32p se_sel_lo_n_32p se_rel_n_16p
+ se_sel_hi_n_16p se_sel_lo_n_16p se_rel_n_8p se_sel_hi_n_8p
+ se_sel_lo_n_8p se_rel_n_4p se_sel_hi_n_4p se_sel_lo_n_4p se_rel_n_2p
+ se_sel_hi_n_2p se_sel_lo_n_2p se_rel_n_1p se_sel_hi_n_1p se_sel_lo_n_1p
+ se_rel_n_256n se_sel_hi_n_256n se_sel_lo_n_256n se_rel_n_128n
+ se_sel_hi_n_128n se_sel_lo_n_128n se_rel_n_64n se_sel_hi_n_64n
+ se_sel_lo_n_64n se_rel_n_32n se_sel_hi_n_32n se_sel_lo_n_32n
+ se_rel_n_16n se_sel_hi_n_16n se_sel_lo_n_16n se_rel_n_8n se_sel_hi_n_8n
+ se_sel_lo_n_8n se_rel_n_4n se_sel_hi_n_4n se_sel_lo_n_4n se_rel_n_2n
+ se_sel_hi_n_2n se_sel_lo_n_2n se_rel_n_1n se_sel_hi_n_1n se_sel_lo_n_1n
+ sar_ctrl_a
* Input drive network (DR-0013), same R_s/C_pin gen_adc_top._core()
* uses for the schematic core -- the drive contract is unchanged by
* which core sits behind it.
Rsesp se_vinp se_pinp 25
Csexp se_pinp 0 1n
Rsesn se_vinn se_pinn 25
Csexn se_pinn 0 1n
* ADC_TOP: both CDAC array sides (four-leg bottom-plate switches, local
* drivers) and the per-side top-plate V_cm switch (DR-0014), all in ONE
* flat extracted instance, PMOS-body-remediated and MiM-mapped to the
* native PDK subckt (layout/adc-top/parasitics/remediate_extracted.py).
* Comparator and controller stay schematic-level (Scope item 0).
Xdut se_sel_hi_n_128n se_sel_hi_n_128p se_sel_hi_n_16n se_sel_hi_n_16p
+ se_sel_hi_n_1n se_sel_hi_n_1p se_sel_hi_n_256n se_sel_hi_n_256p
+ se_sel_hi_n_2n se_sel_hi_n_2p se_sel_hi_n_32n se_sel_hi_n_32p
+ se_sel_hi_n_4n se_sel_hi_n_4p se_sel_hi_n_64n se_sel_hi_n_64p
+ se_sel_hi_n_8n se_sel_hi_n_8p se_sel_lo_n_128n se_sel_lo_n_128p
+ se_sel_lo_n_16n se_sel_lo_n_16p se_sel_lo_n_1n se_sel_lo_n_1p
+ se_sel_lo_n_256n se_sel_lo_n_256p se_sel_lo_n_2n se_sel_lo_n_2p
+ se_sel_lo_n_32n se_sel_lo_n_32p se_sel_lo_n_4n se_sel_lo_n_4p
+ se_sel_lo_n_64n se_sel_lo_n_64p se_sel_lo_n_8n se_sel_lo_n_8p
+ se_rel_n_128n se_rel_n_128p se_rel_n_16n se_rel_n_16p se_rel_n_1n
+ se_rel_n_1p se_rel_n_256n se_rel_n_256p se_rel_n_2n se_rel_n_2p
+ se_rel_n_32n se_rel_n_32p se_rel_n_4n se_rel_n_4p se_rel_n_64n
+ se_rel_n_64p se_rel_n_8n se_rel_n_8p se_sel_in_n se_topn se_topp
+ se_samp_tp_n vcmn vddd vrefn 0 0 se_pinp se_pinn ADC_TOP
iseb vddc se_ibias dc 10u
Xsecmp se_topp se_topn cmpclk se_ibias se_cmp se_cmpb vddc 0 comparator
bsecode se_code 0 V =
+ (512)*(v(se_c9)>vth ? 1 : 0) + (256)*(v(se_c8)>vth ? 1 : 0) + (128)*(v(se_c7)>vth ? 1 : 0) + (64)*(v(se_c6)>vth ? 1 : 0) + (32)*(v(se_c5)>vth ? 1 : 0) + (16)*(v(se_c4)>vth ? 1 : 0) + (8)*(v(se_c3)>vth ? 1 : 0) + (4)*(v(se_c2)>vth ? 1 : 0) + (2)*(v(se_c1)>vth ? 1 : 0) + (1)*(v(se_c0)>vth ? 1 : 0)

* ---- ideal shadow DAC + error node (issue #89 Scope items 1/3/8) ----
* Verbatim formula from gen_adc_top._core() -- see that function for
* the charge-conservation derivation. Wired onto the SAME per-weight
* nets gen_extracted_core_tb._wire_pin() already drives.
bsedacp se_dacp 0 V = (1.0/512)*(
+ 256*((v(se_rel_n_256p)*vcm+v(se_sel_hi_n_256p)*vref+v(se_sel_in_n)*v(se_vinp))/vdd_val-vcm) + 128*((v(se_rel_n_128p)*vcm+v(se_sel_hi_n_128p)*vref+v(se_sel_in_n)*v(se_vinp))/vdd_val-vcm) + 64*((v(se_rel_n_64p)*vcm+v(se_sel_hi_n_64p)*vref+v(se_sel_in_n)*v(se_vinp))/vdd_val-vcm) + 32*((v(se_rel_n_32p)*vcm+v(se_sel_hi_n_32p)*vref+v(se_sel_in_n)*v(se_vinp))/vdd_val-vcm) + 16*((v(se_rel_n_16p)*vcm+v(se_sel_hi_n_16p)*vref+v(se_sel_in_n)*v(se_vinp))/vdd_val-vcm) + 8*((v(se_rel_n_8p)*vcm+v(se_sel_hi_n_8p)*vref+v(se_sel_in_n)*v(se_vinp))/vdd_val-vcm) + 4*((v(se_rel_n_4p)*vcm+v(se_sel_hi_n_4p)*vref+v(se_sel_in_n)*v(se_vinp))/vdd_val-vcm) + 2*((v(se_rel_n_2p)*vcm+v(se_sel_hi_n_2p)*vref+v(se_sel_in_n)*v(se_vinp))/vdd_val-vcm) + 1*((v(se_rel_n_1p)*vcm+v(se_sel_hi_n_1p)*vref+v(se_sel_in_n)*v(se_vinp))/vdd_val-vcm) )
bsedacn se_dacn 0 V = (1.0/512)*(
+ 256*((v(se_rel_n_256n)*vcm+v(se_sel_hi_n_256n)*vref+v(se_sel_in_n)*v(se_vinn))/vdd_val-vcm) + 128*((v(se_rel_n_128n)*vcm+v(se_sel_hi_n_128n)*vref+v(se_sel_in_n)*v(se_vinn))/vdd_val-vcm) + 64*((v(se_rel_n_64n)*vcm+v(se_sel_hi_n_64n)*vref+v(se_sel_in_n)*v(se_vinn))/vdd_val-vcm) + 32*((v(se_rel_n_32n)*vcm+v(se_sel_hi_n_32n)*vref+v(se_sel_in_n)*v(se_vinn))/vdd_val-vcm) + 16*((v(se_rel_n_16n)*vcm+v(se_sel_hi_n_16n)*vref+v(se_sel_in_n)*v(se_vinn))/vdd_val-vcm) + 8*((v(se_rel_n_8n)*vcm+v(se_sel_hi_n_8n)*vref+v(se_sel_in_n)*v(se_vinn))/vdd_val-vcm) + 4*((v(se_rel_n_4n)*vcm+v(se_sel_hi_n_4n)*vref+v(se_sel_in_n)*v(se_vinn))/vdd_val-vcm) + 2*((v(se_rel_n_2n)*vcm+v(se_sel_hi_n_2n)*vref+v(se_sel_in_n)*v(se_vinn))/vdd_val-vcm) + 1*((v(se_rel_n_1n)*vcm+v(se_sel_hi_n_1n)*vref+v(se_sel_in_n)*v(se_vinn))/vdd_val-vcm) )
bsedi se_di 0 V = v(se_vinn)-v(se_vinp)+v(se_dacp)-v(se_dacn)
bsee se_err 0 V = (v(se_di)-(v(se_topp)-v(se_topn)))/lsb
* |err| gated to the ten comparator-strobe windows -- verbatim from
* gen_adc_top._core(); MAX over a trial window is that conversion's
* WORST DECISION ERROR. Gating, not holding: see _core()'s own note
* on why a track-and-hold reported the settling transient instead.
bseea se_aerrh 0 V = abs(v(se_err))*(v(cmpclk)>vth ? 1 : 0)

* Sample-and-hold on the output code, opened at the end of each
* conversion's drdy phase -- identical to fft_netlist(), kept for
* parity even though tb.json's own `meas ... FIND` reads v(se_code)
* directly rather than this node.
bseph seph 0 V = v(se_drdy)
