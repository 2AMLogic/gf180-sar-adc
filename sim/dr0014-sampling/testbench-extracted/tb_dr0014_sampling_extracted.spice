* --- COMPARATOR-NETLIST-BEGIN (verbatim-copied into every testbench) ---
.subckt preamp vinp vinn ibias pop pon vdd vss
* 1:1 NMOS current mirror; ibias is forced into the diode branch.
Xmb  ibias ibias vss vss nfet_03v3 w=20u l=2u
Xmt  ptail ibias vss vss nfet_03v3 w=20u l=2u
* Input pair. The device whose gate is vinp drives the INVERTING node
* pon, so v(pop) - v(pon) = +A_v * (v(vinp) - v(vinn)).
Xmip pon vinp ptail vss nfet_03v3 w=40u l=1u
Xmin pop vinn ptail vss nfet_03v3 w=40u l=1u
* Unsalicided 1 kohm/sq p+ poly loads, 150 squares = 150 kohm nominal.
* Third terminal is the substrate/body contact. `ppolyf_u_1k`, not the
* 2 kohm/sq `ppolyf_u_2k` an earlier revision assumed: issue #118 drew
* SAB(49/0)+RES_MK(110/5)+Resistor(62/0) markers over the load-resistor
* bodies so `klt extract`'s gf180mcu deck recognises them as real devices
* instead of a Poly2 short, and at this repo's pinned klt commit that
* marker geometry can only select `ppolyf_u_1k` (1000 ohm/sq) -- the
* `_2k`/`_3k` flavours share the identical drawn geometry and are chosen by
* a build-time deck option this curated deck does not implement
* (`2AMLogic/klayout-tools#595`, open). `r_length` is doubled (75u -> 150u)
* at the same `r_width=1u` to preserve the 150 kohm target at the new
* sheet-rho -- see layout/adc-top/README.md "Resistors".
Xrlp vdd pop vss ppolyf_u_1k r_width=1u r_length=150u
Xrln vdd pon vss ppolyf_u_1k r_width=1u r_length=150u
.ends preamp

.subckt sarlatch inp inn clk outp outn vdd vss
* clk low  -> tail off; outp/outn/dip/din precharged to vdd
* clk high -> tail on; the input pair discharges dip/din at rates set by
*             v(inp)/v(inn), then the cross-coupled pairs regenerate.
Xmlt ltail clk   vss   vss nfet_03v3 w=16u l=0.35u
Xmlp dip   inp   ltail vss nfet_03v3 w=8u  l=0.5u
Xmln din   inn   ltail vss nfet_03v3 w=8u  l=0.5u
Xmnp outn  outp  dip   vss nfet_03v3 w=6u  l=0.35u
Xmnn outp  outn  din   vss nfet_03v3 w=6u  l=0.35u
Xmpp outn  outp  vdd   vdd pfet_03v3 w=8u  l=0.35u
Xmpn outp  outn  vdd   vdd pfet_03v3 w=8u  l=0.35u
Xmrp outn  clk   vdd   vdd pfet_03v3 w=4u  l=0.35u
Xmrn outp  clk   vdd   vdd pfet_03v3 w=4u  l=0.35u
Xmrd dip   clk   vdd   vdd pfet_03v3 w=2u  l=0.35u
Xmre din   clk   vdd   vdd pfet_03v3 w=2u  l=0.35u
.ends sarlatch

* Minimum-ish isolation inverter. Deliberately small: it is the only
* thing the regeneration nodes drive, so its gate capacitance is added
* directly to the latch's own output nodes and shows up as regeneration
* time.
.subckt inv a y vdd vss
Xp y a vdd vdd pfet_03v3 w=2u   l=0.35u
Xn y a vss vss nfet_03v3 w=1u   l=0.35u
.ends inv

.subckt nor2 a b y vdd vss
Xp1 ps a vdd vdd pfet_03v3 w=8u l=0.35u
Xp2 y  b ps  vdd pfet_03v3 w=8u l=0.35u
Xn1 y  a vss vss nfet_03v3 w=4u l=0.35u
Xn2 y  b vss vss nfet_03v3 w=4u l=0.35u
.ends nor2

.subckt comparator vinp vinn clk ibias dout doutb vdd vss
Xpre preamp_in1 preamp_in2 ibias pop pon vdd vss preamp
Xlat pop pon clk outp outn vdd vss sarlatch
* THE ISOLATION INVERTERS ARE NOT OPTIONAL -- they fix a measured
* hysteresis defect. Both StrongARM outputs precharge HIGH, so the
* decision arrives as an active-low pulse on exactly one of them, and
* the obvious way to hold it is a NAND SR latch wired straight to
* outp/outn. That circuit was built first and MEASURED: after deciding
* one way it would not flip back until the input reached ~10 mV of the
* opposite polarity -- about 3 LSB of hysteresis, which in a SAR (where
* the same comparator makes ten successive decisions on a shrinking
* residue) is a code-dependent error, not an offset.
*
* The cause is that a NAND SR latch's HELD STATE loads the two
* regeneration nodes asymmetrically. Wired directly, the node driving
* the NAND whose output is LOW sees that output swing when it falls
* (Miller-multiplied C_gd, ~26 fF against a regeneration node of a few
* tens of fF), while its twin drives a NAND whose output is already
* HIGH and stays there. The latch is therefore biased toward keeping
* the answer it already holds.
*
* Interposing one small inverter per side removes the coupling: the
* inverters are identical, both of their inputs precharge to V_DD, and
* neither loading depends on what the SR latch is holding. The SR latch
* becomes NOR-type because the inverters make the decision pulses
* active-HIGH. dout goes HIGH when outn falls, i.e. when
* v(vinp) > v(vinn), exactly as before.
Xis outn sset vdd vss inv
Xir outp srst vdd vss inv
Xno1 srst doutb dout  vdd vss nor2
Xno2 sset dout  doutb vdd vss nor2
* Input pass-through (zero-volt sources) so a testbench can probe the
* current the comparator draws from each CDAC top plate directly.
Vpp preamp_in1 vinp dc 0
Vpn preamp_in2 vinn dc 0
.ends comparator
* --- COMPARATOR-NETLIST-END ---

* REMEDIATED extracted core -- NOT raw `klt extract` output.
* Produced by layout/adc-top/parasitics/remediate_extracted.py:
*   - body-tie step NOT APPLIED: all 148 PMOS body terminals already
*     extract on `vdd` because DR-0035 draws an n+ tap in every Nwell and routes
*     it there, closing the klayout-tools#555 body gap in the LAYOUT. Asserted,
*     not assumed -- see _assert_no_unreachable_bodies() (issue #381).
*   - input rails pinp/pinn promoted to pins vinp/vinn (sampled-input port gap).
*   - 1024 MiM caps left as native PDK 'cap_mim_2f0_m4m5_noshield' subckt calls.
* See remediate_extracted.py's module docstring for provenance.
* parasitic model (--parasitics):
* - capacitance: net-to-ground for every net's own (non-coupled) area/perimeter, plus net-to-net for the vertical-overlap coupling `coupling` describes below -- a coupled net pair gets a direct capacitor between their two hub nodes, not just capacitors to the deck's ground/substrate net
* - coupling: vertical overlap (crossover) unconditionally -- where one net's conductor on an adjacent metal level sits directly over another *distinct* net's conductor, that overlap area is charged between the two nets instead of to ground (issue #760) -- plus lateral (same-layer, sidewall) coupling, but only for a net pair naming one of the caller's declared `--critical-net` nets (issue #976): facing-edge length within that layer's own minimum-spacing lookback is charged between the two nets, *additively* (not deducted from either net's substrate fringe term, unlike the vertical case -- a known simplification). Any same-layer pair with neither side named `--critical-net`, and fringe shielding in general, are still not modelled
* - resistance: single lumped series resistance per net, distributed as a star across that net's device terminals (issue #592) -- not a per-segment, distributed RC ladder, *unless* `--distributed-rc` names this net via `--critical-net` (issue #977, Epic #709 Phase 2b): then the net's terminals are ordered along their approximate physical spread and its total R/C is broken into a chain of per-segment resistors (segment length proportional to inter-terminal distance) with a ground capacitor at each terminal node (proportional to its adjacent segment length/2), instead of one star hub -- still an approximation (terminal position is a device-placement proxy, not true per-segment routing geometry), but a strictly finer-grained one than the single-hub star
* - frequency: quasi-static -- one frequency-independent R and C per net; no skin effect, no distributed transmission-line behavior
* cell ADC_TOP
* pin hi_128_n
* pin hi_128_p
* pin hi_16_n
* pin hi_16_p
* pin hi_1_n
* pin hi_1_p
* pin hi_256_n
* pin hi_256_p
* pin hi_2_n
* pin hi_2_p
* pin hi_32_n
* pin hi_32_p
* pin hi_4_n
* pin hi_4_p
* pin hi_64_n
* pin hi_64_p
* pin hi_8_n
* pin hi_8_p
* pin lo_128_n
* pin lo_128_p
* pin lo_16_n
* pin lo_16_p
* pin lo_1_n
* pin lo_1_p
* pin lo_256_n
* pin lo_256_p
* pin lo_2_n
* pin lo_2_p
* pin lo_32_n
* pin lo_32_p
* pin lo_4_n
* pin lo_4_p
* pin lo_64_n
* pin lo_64_p
* pin lo_8_n
* pin lo_8_p
* pin pinn
* pin pinp
* pin rel_128_n
* pin rel_128_p
* pin rel_16_n
* pin rel_16_p
* pin rel_1_n
* pin rel_1_p
* pin rel_256_n
* pin rel_256_p
* pin rel_2_n
* pin rel_2_p
* pin rel_32_n
* pin rel_32_p
* pin rel_4_n
* pin rel_4_p
* pin rel_64_n
* pin rel_64_p
* pin rel_8_n
* pin rel_8_p
* pin sel_in
* pin topn
* pin topp
* pin tp_gn
* pin vcm
* pin vdd
* pin vref
* pin vss
.SUBCKT ADC_TOP hi_128_n hi_128_p hi_16_n hi_16_p hi_1_n hi_1_p hi_256_n hi_256_p hi_2_n hi_2_p hi_32_n hi_32_p hi_4_n hi_4_p hi_64_n hi_64_p hi_8_n hi_8_p lo_128_n lo_128_p lo_16_n lo_16_p lo_1_n lo_1_p lo_256_n lo_256_p lo_2_n lo_2_p lo_32_n lo_32_p lo_4_n lo_4_p lo_64_n lo_64_p lo_8_n lo_8_p rel_128_n rel_128_p rel_16_n rel_16_p rel_1_n rel_1_p rel_256_n rel_256_p rel_2_n rel_2_p rel_32_n rel_32_p rel_4_n rel_4_p rel_64_n rel_64_p rel_8_n rel_8_p sel_in topn topp tp_gn vcm vdd vref vss vinp vinn
* device instance $1 r0 *1 1.275,2 nfet
X$1 \$3__t0 sel_in__t0 vss__t0 vss__t110 nfet_03v3 L=0.35U W=4U AS=4.4P AD=4.4P PS=10.2U PD=10.2U
* device instance $2 r0 *1 4.225,2 nfet
X$2 \$5__t2 rel_256_p__t2 vss__t46 vss__t111 nfet_03v3 L=0.35U W=4U AS=4.4P AD=4.4P PS=10.2U PD=10.2U
* device instance $3 r0 *1 7.175,2 nfet
X$3 \$7__t2 hi_256_p__t2 vss__t45 vss__t112 nfet_03v3 L=0.35U W=4U AS=4.4P AD=4.4P PS=10.2U PD=10.2U
* device instance $4 r0 *1 10.125,2 nfet
X$4 \$9__t2 lo_256_p__t2 vss__t44 vss__t113 nfet_03v3 L=0.35U W=4U AS=4.4P AD=4.4P PS=10.2U PD=10.2U
* device instance $5 r0 *1 13.04,5 nfet
X$5 vinp__t0 sel_in__t1 \$10__t0 vss__t184 nfet_03v3 L=0.28U W=10U AS=11P AD=11P PS=22.2U PD=22.2U
* device instance $6 r0 *1 15.92,5 nfet
X$6 vcm__t27 rel_256_p__t1 \$10__t262 vss__t185 nfet_03v3 L=0.28U W=10U AS=11P AD=11P PS=22.2U PD=22.2U
* device instance $7 r0 *1 18.8,5 nfet
X$7 vref__t21 hi_256_p__t1 \$10__t261 vss__t186 nfet_03v3 L=0.28U W=10U AS=11P AD=11P PS=22.2U PD=22.2U
* device instance $8 r0 *1 21.68,5 nfet
X$8 vss__t24 lo_256_p__t1 \$10__t263 vss__t187 nfet_03v3 L=0.28U W=10U AS=11P AD=11P PS=22.2U PD=22.2U
* device instance $9 r0 *1 49.715,2 nfet
X$9 \$15__t2 sel_in__t50 vss__t94 vss__t114 nfet_03v3 L=0.35U W=4U AS=4.4P AD=4.4P PS=10.2U PD=10.2U
* device instance $10 r0 *1 52.665,2 nfet
X$10 \$17__t2 rel_128_p__t2 vss__t109 vss__t115 nfet_03v3 L=0.35U W=4U AS=4.4P AD=4.4P PS=10.2U PD=10.2U
* device instance $11 r0 *1 55.615,2 nfet
X$11 \$19__t2 hi_128_p__t2 vss__t96 vss__t116 nfet_03v3 L=0.35U W=4U AS=4.4P AD=4.4P PS=10.2U PD=10.2U
* device instance $12 r0 *1 58.565,2 nfet
X$12 \$21__t2 lo_128_p__t2 vss__t99 vss__t117 nfet_03v3 L=0.35U W=4U AS=4.4P AD=4.4P PS=10.2U PD=10.2U
* device instance $13 r0 *1 61.48,5 nfet
X$13 vinp__t12 sel_in__t25 \$22__t132 vss__t188 nfet_03v3 L=0.28U W=10U AS=11P AD=11P PS=22.2U PD=22.2U
* device instance $14 r0 *1 64.36,5 nfet
X$14 vcm__t30 rel_128_p__t1 \$22__t133 vss__t189 nfet_03v3 L=0.28U W=10U AS=11P AD=11P PS=22.2U PD=22.2U
* device instance $15 r0 *1 67.24,5 nfet
X$15 vref__t23 hi_128_p__t1 \$22__t134 vss__t190 nfet_03v3 L=0.28U W=10U AS=11P AD=11P PS=22.2U PD=22.2U
* device instance $16 r0 *1 70.12,5 nfet
X$16 vss__t25 lo_128_p__t1 \$22__t135 vss__t191 nfet_03v3 L=0.28U W=10U AS=11P AD=11P PS=22.2U PD=22.2U
* device instance $17 r0 *1 98.155,2 nfet
X$17 \$23__t2 sel_in__t52 vss__t102 vss__t118 nfet_03v3 L=0.35U W=4U AS=4.4P AD=4.4P PS=10.2U PD=10.2U
* device instance $18 r0 *1 101.105,2 nfet
X$18 \$25__t2 rel_64_p__t2 vss__t103 vss__t119 nfet_03v3 L=0.35U W=4U AS=4.4P AD=4.4P PS=10.2U PD=10.2U
* device instance $19 r0 *1 104.055,2 nfet
X$19 \$27__t2 hi_64_p__t2 vss__t104 vss__t120 nfet_03v3 L=0.35U W=4U AS=4.4P AD=4.4P PS=10.2U PD=10.2U
* device instance $20 r0 *1 107.005,2 nfet
X$20 \$29__t2 lo_64_p__t2 vss__t105 vss__t121 nfet_03v3 L=0.35U W=4U AS=4.4P AD=4.4P PS=10.2U PD=10.2U
* device instance $21 r0 *1 109.92,5 nfet
X$21 vinp__t13 sel_in__t26 \$30__t68 vss__t192 nfet_03v3 L=0.28U W=10U AS=11P AD=11P PS=22.2U PD=22.2U
* device instance $22 r0 *1 112.8,5 nfet
X$22 vcm__t31 rel_64_p__t1 \$30__t69 vss__t193 nfet_03v3 L=0.28U W=10U AS=11P AD=11P PS=22.2U PD=22.2U
* device instance $23 r0 *1 115.68,5 nfet
X$23 vref__t32 hi_64_p__t1 \$30__t71 vss__t194 nfet_03v3 L=0.28U W=10U AS=11P AD=11P PS=22.2U PD=22.2U
* device instance $24 r0 *1 118.56,5 nfet
X$24 vss__t29 lo_64_p__t1 \$30__t70 vss__t195 nfet_03v3 L=0.28U W=10U AS=11P AD=11P PS=22.2U PD=22.2U
* device instance $25 r0 *1 146.595,2 nfet
X$25 \$31__t2 sel_in__t46 vss__t76 vss__t122 nfet_03v3 L=0.35U W=4U AS=4.4P AD=4.4P PS=10.2U PD=10.2U
* device instance $26 r0 *1 149.545,2 nfet
X$26 \$33__t2 rel_32_p__t2 vss__t75 vss__t123 nfet_03v3 L=0.35U W=4U AS=4.4P AD=4.4P PS=10.2U PD=10.2U
* device instance $27 r0 *1 152.495,2 nfet
X$27 \$35__t2 hi_32_p__t2 vss__t65 vss__t124 nfet_03v3 L=0.35U W=4U AS=4.4P AD=4.4P PS=10.2U PD=10.2U
* device instance $28 r0 *1 155.445,2 nfet
X$28 \$37__t2 lo_32_p__t2 vss__t70 vss__t125 nfet_03v3 L=0.35U W=4U AS=4.4P AD=4.4P PS=10.2U PD=10.2U
* device instance $29 r0 *1 158.36,5 nfet
X$29 vinp__t16 sel_in__t31 \$38__t37 vss__t196 nfet_03v3 L=0.28U W=10U AS=11P AD=11P PS=22.2U PD=22.2U
* device instance $30 r0 *1 161.24,5 nfet
X$30 vcm__t35 rel_32_p__t1 \$38__t38 vss__t197 nfet_03v3 L=0.28U W=10U AS=11P AD=11P PS=22.2U PD=22.2U
* device instance $31 r0 *1 164.12,5 nfet
X$31 vref__t30 hi_32_p__t1 \$38__t39 vss__t198 nfet_03v3 L=0.28U W=10U AS=11P AD=11P PS=22.2U PD=22.2U
* device instance $32 r0 *1 167,5 nfet
X$32 vss__t28 lo_32_p__t1 \$38__t36 vss__t199 nfet_03v3 L=0.28U W=10U AS=11P AD=11P PS=22.2U PD=22.2U
* device instance $33 r0 *1 195.035,2 nfet
X$33 \$39__t2 sel_in__t45 vss__t71 vss__t126 nfet_03v3 L=0.35U W=4U AS=4.4P AD=4.4P PS=10.2U PD=10.2U
* device instance $34 r0 *1 197.985,2 nfet
X$34 \$41__t2 rel_16_p__t2 vss__t72 vss__t127 nfet_03v3 L=0.35U W=4U AS=4.4P AD=4.4P PS=10.2U PD=10.2U
* device instance $35 r0 *1 200.935,2 nfet
X$35 \$43__t2 hi_16_p__t2 vss__t73 vss__t128 nfet_03v3 L=0.35U W=4U AS=4.4P AD=4.4P PS=10.2U PD=10.2U
* device instance $36 r0 *1 203.885,2 nfet
X$36 \$45__t2 lo_16_p__t2 vss__t74 vss__t129 nfet_03v3 L=0.35U W=4U AS=4.4P AD=4.4P PS=10.2U PD=10.2U
* device instance $37 r0 *1 206.8,5 nfet
X$37 vinp__t17 sel_in__t32 \$46__t23 vss__t200 nfet_03v3 L=0.28U W=10U AS=11P AD=11P PS=22.2U PD=22.2U
* device instance $38 r0 *1 209.68,5 nfet
X$38 vcm__t33 rel_16_p__t1 \$46__t20 vss__t201 nfet_03v3 L=0.28U W=10U AS=11P AD=11P PS=22.2U PD=22.2U
* device instance $39 r0 *1 212.56,5 nfet
X$39 vref__t29 hi_16_p__t1 \$46__t21 vss__t202 nfet_03v3 L=0.28U W=10U AS=11P AD=11P PS=22.2U PD=22.2U
* device instance $40 r0 *1 215.44,5 nfet
X$40 vss__t32 lo_16_p__t1 \$46__t22 vss__t203 nfet_03v3 L=0.28U W=10U AS=11P AD=11P PS=22.2U PD=22.2U
* device instance $41 r0 *1 243.475,2 nfet
X$41 \$47__t2 sel_in__t38 vss__t41 vss__t130 nfet_03v3 L=0.35U W=4U AS=4.4P AD=4.4P PS=10.2U PD=10.2U
* device instance $42 r0 *1 246.425,2 nfet
X$42 \$49__t2 rel_8_p__t2 vss__t67 vss__t131 nfet_03v3 L=0.35U W=4U AS=4.4P AD=4.4P PS=10.2U PD=10.2U
* device instance $43 r0 *1 249.375,2 nfet
X$43 \$51__t2 hi_8_p__t2 vss__t83 vss__t132 nfet_03v3 L=0.35U W=4U AS=4.4P AD=4.4P PS=10.2U PD=10.2U
* device instance $44 r0 *1 252.325,2 nfet
X$44 \$53__t2 lo_8_p__t2 vss__t38 vss__t133 nfet_03v3 L=0.35U W=4U AS=4.4P AD=4.4P PS=10.2U PD=10.2U
* device instance $45 r0 *1 255.24,5 nfet
X$45 vinp__t11 sel_in__t24 \$54__t12 vss__t204 nfet_03v3 L=0.28U W=10U AS=11P AD=11P PS=22.2U PD=22.2U
* device instance $46 r0 *1 258.12,5 nfet
X$46 vcm__t26 rel_8_p__t1 \$54__t13 vss__t205 nfet_03v3 L=0.28U W=10U AS=11P AD=11P PS=22.2U PD=22.2U
* device instance $47 r0 *1 261,5 nfet
X$47 vref__t20 hi_8_p__t1 \$54__t14 vss__t206 nfet_03v3 L=0.28U W=10U AS=11P AD=11P PS=22.2U PD=22.2U
* device instance $48 r0 *1 263.88,5 nfet
X$48 vss__t22 lo_8_p__t1 \$54__t15 vss__t207 nfet_03v3 L=0.28U W=10U AS=11P AD=11P PS=22.2U PD=22.2U
* device instance $49 r0 *1 291.915,2 nfet
X$49 \$55__t2 sel_in__t51 vss__t101 vss__t134 nfet_03v3 L=0.35U W=4U AS=4.4P AD=4.4P PS=10.2U PD=10.2U
* device instance $50 r0 *1 294.865,2 nfet
X$50 \$57__t2 rel_4_p__t2 vss__t100 vss__t135 nfet_03v3 L=0.35U W=4U AS=4.4P AD=4.4P PS=10.2U PD=10.2U
* device instance $51 r0 *1 297.815,2 nfet
X$51 \$59__t2 hi_4_p__t2 vss__t98 vss__t136 nfet_03v3 L=0.35U W=4U AS=4.4P AD=4.4P PS=10.2U PD=10.2U
* device instance $52 r0 *1 300.765,2 nfet
X$52 \$61__t2 lo_4_p__t2 vss__t97 vss__t137 nfet_03v3 L=0.35U W=4U AS=4.4P AD=4.4P PS=10.2U PD=10.2U
* device instance $53 r0 *1 303.68,5 nfet
X$53 vinp__t14 sel_in__t28 \$62__t11 vss__t208 nfet_03v3 L=0.28U W=10U AS=11P AD=11P PS=22.2U PD=22.2U
* device instance $54 r0 *1 306.56,5 nfet
X$54 vcm__t28 rel_4_p__t1 \$62__t10 vss__t209 nfet_03v3 L=0.28U W=10U AS=11P AD=11P PS=22.2U PD=22.2U
* device instance $55 r0 *1 309.44,5 nfet
X$55 vref__t22 hi_4_p__t1 \$62__t9 vss__t210 nfet_03v3 L=0.28U W=10U AS=11P AD=11P PS=22.2U PD=22.2U
* device instance $56 r0 *1 312.32,5 nfet
X$56 vss__t23 lo_4_p__t1 \$62__t8 vss__t211 nfet_03v3 L=0.28U W=10U AS=11P AD=11P PS=22.2U PD=22.2U
* device instance $57 r0 *1 340.355,2 nfet
X$57 \$63__t2 sel_in__t49 vss__t93 vss__t138 nfet_03v3 L=0.35U W=4U AS=4.4P AD=4.4P PS=10.2U PD=10.2U
* device instance $58 r0 *1 343.305,2 nfet
X$58 \$65__t2 rel_2_p__t2 vss__t92 vss__t139 nfet_03v3 L=0.35U W=4U AS=4.4P AD=4.4P PS=10.2U PD=10.2U
* device instance $59 r0 *1 346.255,2 nfet
X$59 \$67__t2 hi_2_p__t2 vss__t85 vss__t140 nfet_03v3 L=0.35U W=4U AS=4.4P AD=4.4P PS=10.2U PD=10.2U
* device instance $60 r0 *1 349.205,2 nfet
X$60 \$69__t2 lo_2_p__t2 vss__t84 vss__t141 nfet_03v3 L=0.35U W=4U AS=4.4P AD=4.4P PS=10.2U PD=10.2U
* device instance $61 r0 *1 352.12,5 nfet
X$61 vinp__t10 sel_in__t23 \$70__t6 vss__t212 nfet_03v3 L=0.28U W=10U AS=11P AD=11P PS=22.2U PD=22.2U
* device instance $62 r0 *1 355,5 nfet
X$62 vcm__t32 rel_2_p__t1 \$70__t7 vss__t213 nfet_03v3 L=0.28U W=10U AS=11P AD=11P PS=22.2U PD=22.2U
* device instance $63 r0 *1 357.88,5 nfet
X$63 vref__t27 hi_2_p__t1 \$70__t8 vss__t214 nfet_03v3 L=0.28U W=10U AS=11P AD=11P PS=22.2U PD=22.2U
* device instance $64 r0 *1 360.76,5 nfet
X$64 vss__t30 lo_2_p__t1 \$70__t9 vss__t215 nfet_03v3 L=0.28U W=10U AS=11P AD=11P PS=22.2U PD=22.2U
* device instance $65 r0 *1 388.795,2 nfet
X$65 \$71__t2 sel_in__t39 vss__t48 vss__t142 nfet_03v3 L=0.35U W=4U AS=4.4P AD=4.4P PS=10.2U PD=10.2U
* device instance $66 r0 *1 391.745,2 nfet
X$66 \$73__t2 rel_1_p__t2 vss__t47 vss__t143 nfet_03v3 L=0.35U W=4U AS=4.4P AD=4.4P PS=10.2U PD=10.2U
* device instance $67 r0 *1 394.695,2 nfet
X$67 \$75__t2 hi_1_p__t2 vss__t43 vss__t144 nfet_03v3 L=0.35U W=4U AS=4.4P AD=4.4P PS=10.2U PD=10.2U
* device instance $68 r0 *1 397.645,2 nfet
X$68 \$77__t2 lo_1_p__t2 vss__t42 vss__t145 nfet_03v3 L=0.35U W=4U AS=4.4P AD=4.4P PS=10.2U PD=10.2U
* device instance $69 r0 *1 400.56,5 nfet
X$69 vinp__t15 sel_in__t30 \$78__t8 vss__t216 nfet_03v3 L=0.28U W=10U AS=11P AD=11P PS=22.2U PD=22.2U
* device instance $70 r0 *1 403.44,5 nfet
X$70 vcm__t34 rel_1_p__t1 \$78__t7 vss__t217 nfet_03v3 L=0.28U W=10U AS=11P AD=11P PS=22.2U PD=22.2U
* device instance $71 r0 *1 406.32,5 nfet
X$71 vref__t28 hi_1_p__t1 \$78__t6 vss__t218 nfet_03v3 L=0.28U W=10U AS=11P AD=11P PS=22.2U PD=22.2U
* device instance $72 r0 *1 409.2,5 nfet
X$72 vss__t21 lo_1_p__t1 \$78__t5 vss__t219 nfet_03v3 L=0.28U W=10U AS=11P AD=11P PS=22.2U PD=22.2U
* device instance $73 r0 *1 1.275,36 nfet
X$73 \$125__t2 sel_in__t53 vss__t107 vss__t146 nfet_03v3 L=0.35U W=4U AS=4.4P AD=4.4P PS=10.2U PD=10.2U
* device instance $74 r0 *1 4.225,36 nfet
X$74 \$127__t2 rel_256_n__t2 vss__t108 vss__t147 nfet_03v3 L=0.35U W=4U AS=4.4P AD=4.4P PS=10.2U PD=10.2U
* device instance $75 r0 *1 7.175,36 nfet
X$75 \$90__t2 hi_256_n__t2 vss__t95 vss__t148 nfet_03v3 L=0.35U W=4U AS=4.4P AD=4.4P PS=10.2U PD=10.2U
* device instance $76 r0 *1 10.125,36 nfet
X$76 \$92__t2 lo_256_n__t2 vss__t55 vss__t149 nfet_03v3 L=0.35U W=4U AS=4.4P AD=4.4P PS=10.2U PD=10.2U
* device instance $77 r0 *1 13.04,39 nfet
X$77 vinn__t13 sel_in__t29 \$79__t261 vss__t220 nfet_03v3 L=0.28U W=10U AS=11P AD=11P PS=22.2U PD=22.2U
* device instance $78 r0 *1 15.92,39 nfet
X$78 vcm__t41 rel_256_n__t1 \$79__t263 vss__t221 nfet_03v3 L=0.28U W=10U AS=11P AD=11P PS=22.2U PD=22.2U
* device instance $79 r0 *1 18.8,39 nfet
X$79 vref__t26 hi_256_n__t1 \$79__t260 vss__t222 nfet_03v3 L=0.28U W=10U AS=11P AD=11P PS=22.2U PD=22.2U
* device instance $80 r0 *1 21.68,39 nfet
X$80 vss__t31 lo_256_n__t1 \$79__t262 vss__t223 nfet_03v3 L=0.28U W=10U AS=11P AD=11P PS=22.2U PD=22.2U
* device instance $81 r0 *1 49.715,36 nfet
X$81 \$128__t2 sel_in__t43 vss__t62 vss__t150 nfet_03v3 L=0.35U W=4U AS=4.4P AD=4.4P PS=10.2U PD=10.2U
* device instance $82 r0 *1 52.665,36 nfet
X$82 \$130__t2 rel_128_n__t2 vss__t63 vss__t151 nfet_03v3 L=0.35U W=4U AS=4.4P AD=4.4P PS=10.2U PD=10.2U
* device instance $83 r0 *1 55.615,36 nfet
X$83 \$94__t2 hi_128_n__t2 vss__t64 vss__t152 nfet_03v3 L=0.35U W=4U AS=4.4P AD=4.4P PS=10.2U PD=10.2U
* device instance $84 r0 *1 58.565,36 nfet
X$84 \$96__t2 lo_128_n__t2 vss__t106 vss__t153 nfet_03v3 L=0.35U W=4U AS=4.4P AD=4.4P PS=10.2U PD=10.2U
* device instance $85 r0 *1 61.48,39 nfet
X$85 vinn__t17 sel_in__t36 \$81__t135 vss__t224 nfet_03v3 L=0.28U W=10U AS=11P AD=11P PS=22.2U PD=22.2U
* device instance $86 r0 *1 64.36,39 nfet
X$86 vcm__t40 rel_128_n__t1 \$81__t134 vss__t225 nfet_03v3 L=0.28U W=10U AS=11P AD=11P PS=22.2U PD=22.2U
* device instance $87 r0 *1 67.24,39 nfet
X$87 vref__t31 hi_128_n__t1 \$81__t133 vss__t226 nfet_03v3 L=0.28U W=10U AS=11P AD=11P PS=22.2U PD=22.2U
* device instance $88 r0 *1 70.12,39 nfet
X$88 vss__t33 lo_128_n__t1 \$81__t132 vss__t227 nfet_03v3 L=0.28U W=10U AS=11P AD=11P PS=22.2U PD=22.2U
* device instance $89 r0 *1 98.155,36 nfet
X$89 \$131__t2 sel_in__t42 vss__t56 vss__t154 nfet_03v3 L=0.35U W=4U AS=4.4P AD=4.4P PS=10.2U PD=10.2U
* device instance $90 r0 *1 101.105,36 nfet
X$90 \$133__t2 rel_64_n__t2 vss__t59 vss__t155 nfet_03v3 L=0.35U W=4U AS=4.4P AD=4.4P PS=10.2U PD=10.2U
* device instance $91 r0 *1 104.055,36 nfet
X$91 \$98__t2 hi_64_n__t2 vss__t60 vss__t156 nfet_03v3 L=0.35U W=4U AS=4.4P AD=4.4P PS=10.2U PD=10.2U
* device instance $92 r0 *1 107.005,36 nfet
X$92 \$100__t2 lo_64_n__t2 vss__t61 vss__t157 nfet_03v3 L=0.35U W=4U AS=4.4P AD=4.4P PS=10.2U PD=10.2U
* device instance $93 r0 *1 109.92,39 nfet
X$93 vinn__t14 sel_in__t33 \$82__t71 vss__t228 nfet_03v3 L=0.28U W=10U AS=11P AD=11P PS=22.2U PD=22.2U
* device instance $94 r0 *1 112.8,39 nfet
X$94 vcm__t36 rel_64_n__t1 \$82__t70 vss__t229 nfet_03v3 L=0.28U W=10U AS=11P AD=11P PS=22.2U PD=22.2U
* device instance $95 r0 *1 115.68,39 nfet
X$95 vref__t25 hi_64_n__t1 \$82__t68 vss__t230 nfet_03v3 L=0.28U W=10U AS=11P AD=11P PS=22.2U PD=22.2U
* device instance $96 r0 *1 118.56,39 nfet
X$96 vss__t26 lo_64_n__t1 \$82__t69 vss__t231 nfet_03v3 L=0.28U W=10U AS=11P AD=11P PS=22.2U PD=22.2U
* device instance $97 r0 *1 146.595,36 nfet
X$97 \$134__t2 sel_in__t47 vss__t77 vss__t158 nfet_03v3 L=0.35U W=4U AS=4.4P AD=4.4P PS=10.2U PD=10.2U
* device instance $98 r0 *1 149.545,36 nfet
X$98 \$136__t2 rel_32_n__t2 vss__t78 vss__t159 nfet_03v3 L=0.35U W=4U AS=4.4P AD=4.4P PS=10.2U PD=10.2U
* device instance $99 r0 *1 152.495,36 nfet
X$99 \$102__t2 hi_32_n__t2 vss__t79 vss__t160 nfet_03v3 L=0.35U W=4U AS=4.4P AD=4.4P PS=10.2U PD=10.2U
* device instance $100 r0 *1 155.445,36 nfet
X$100 \$104__t2 lo_32_n__t2 vss__t80 vss__t161 nfet_03v3 L=0.35U W=4U AS=4.4P AD=4.4P PS=10.2U PD=10.2U
* device instance $101 r0 *1 158.36,39 nfet
X$101 vinn__t12 sel_in__t27 \$83__t39 vss__t232 nfet_03v3 L=0.28U W=10U AS=11P AD=11P PS=22.2U PD=22.2U
* device instance $102 r0 *1 161.24,39 nfet
X$102 vcm__t29 rel_32_n__t1 \$83__t37 vss__t233 nfet_03v3 L=0.28U W=10U AS=11P AD=11P PS=22.2U PD=22.2U
* device instance $103 r0 *1 164.12,39 nfet
X$103 vref__t24 hi_32_n__t1 \$83__t38 vss__t234 nfet_03v3 L=0.28U W=10U AS=11P AD=11P PS=22.2U PD=22.2U
* device instance $104 r0 *1 167,39 nfet
X$104 vss__t20 lo_32_n__t1 \$83__t36 vss__t235 nfet_03v3 L=0.28U W=10U AS=11P AD=11P PS=22.2U PD=22.2U
* device instance $105 r0 *1 195.035,36 nfet
X$105 \$137__t2 sel_in__t44 vss__t66 vss__t162 nfet_03v3 L=0.35U W=4U AS=4.4P AD=4.4P PS=10.2U PD=10.2U
* device instance $106 r0 *1 197.985,36 nfet
X$106 \$139__t2 rel_16_n__t2 vss__t81 vss__t163 nfet_03v3 L=0.35U W=4U AS=4.4P AD=4.4P PS=10.2U PD=10.2U
* device instance $107 r0 *1 200.935,36 nfet
X$107 \$106__t2 hi_16_n__t2 vss__t68 vss__t164 nfet_03v3 L=0.35U W=4U AS=4.4P AD=4.4P PS=10.2U PD=10.2U
* device instance $108 r0 *1 203.885,36 nfet
X$108 \$108__t2 lo_16_n__t2 vss__t69 vss__t165 nfet_03v3 L=0.35U W=4U AS=4.4P AD=4.4P PS=10.2U PD=10.2U
* device instance $109 r0 *1 206.8,39 nfet
X$109 vinn__t9 sel_in__t20 \$84__t22 vss__t236 nfet_03v3 L=0.28U W=10U AS=11P AD=11P PS=22.2U PD=22.2U
* device instance $110 r0 *1 209.68,39 nfet
X$110 vcm__t23 rel_16_n__t1 \$84__t20 vss__t237 nfet_03v3 L=0.28U W=10U AS=11P AD=11P PS=22.2U PD=22.2U
* device instance $111 r0 *1 212.56,39 nfet
X$111 vref__t18 hi_16_n__t1 \$84__t21 vss__t238 nfet_03v3 L=0.28U W=10U AS=11P AD=11P PS=22.2U PD=22.2U
* device instance $112 r0 *1 215.44,39 nfet
X$112 vss__t27 lo_16_n__t1 \$84__t23 vss__t239 nfet_03v3 L=0.28U W=10U AS=11P AD=11P PS=22.2U PD=22.2U
* device instance $113 r0 *1 243.475,36 nfet
X$113 \$140__t2 sel_in__t48 vss__t82 vss__t166 nfet_03v3 L=0.35U W=4U AS=4.4P AD=4.4P PS=10.2U PD=10.2U
* device instance $114 r0 *1 246.425,36 nfet
X$114 \$142__t2 rel_8_n__t2 vss__t91 vss__t167 nfet_03v3 L=0.35U W=4U AS=4.4P AD=4.4P PS=10.2U PD=10.2U
* device instance $115 r0 *1 249.375,36 nfet
X$115 \$110__t2 hi_8_n__t2 vss__t90 vss__t168 nfet_03v3 L=0.35U W=4U AS=4.4P AD=4.4P PS=10.2U PD=10.2U
* device instance $116 r0 *1 252.325,36 nfet
X$116 \$112__t2 lo_8_n__t2 vss__t89 vss__t169 nfet_03v3 L=0.35U W=4U AS=4.4P AD=4.4P PS=10.2U PD=10.2U
* device instance $117 r0 *1 255.24,39 nfet
X$117 vinn__t16 sel_in__t35 \$85__t15 vss__t240 nfet_03v3 L=0.28U W=10U AS=11P AD=11P PS=22.2U PD=22.2U
* device instance $118 r0 *1 258.12,39 nfet
X$118 vcm__t39 rel_8_n__t1 \$85__t14 vss__t241 nfet_03v3 L=0.28U W=10U AS=11P AD=11P PS=22.2U PD=22.2U
* device instance $119 r0 *1 261,39 nfet
X$119 vref__t35 hi_8_n__t1 \$85__t13 vss__t242 nfet_03v3 L=0.28U W=10U AS=11P AD=11P PS=22.2U PD=22.2U
* device instance $120 r0 *1 263.88,39 nfet
X$120 vss__t36 lo_8_n__t1 \$85__t12 vss__t243 nfet_03v3 L=0.28U W=10U AS=11P AD=11P PS=22.2U PD=22.2U
* device instance $121 r0 *1 291.915,36 nfet
X$121 \$143__t2 sel_in__t41 vss__t54 vss__t170 nfet_03v3 L=0.35U W=4U AS=4.4P AD=4.4P PS=10.2U PD=10.2U
* device instance $122 r0 *1 294.865,36 nfet
X$122 \$145__t2 rel_4_n__t2 vss__t88 vss__t171 nfet_03v3 L=0.35U W=4U AS=4.4P AD=4.4P PS=10.2U PD=10.2U
* device instance $123 r0 *1 297.815,36 nfet
X$123 \$114__t2 hi_4_n__t2 vss__t87 vss__t172 nfet_03v3 L=0.35U W=4U AS=4.4P AD=4.4P PS=10.2U PD=10.2U
* device instance $124 r0 *1 300.765,36 nfet
X$124 \$116__t2 lo_4_n__t2 vss__t86 vss__t173 nfet_03v3 L=0.35U W=4U AS=4.4P AD=4.4P PS=10.2U PD=10.2U
* device instance $125 r0 *1 303.68,39 nfet
X$125 vinn__t10 sel_in__t21 \$86__t11 vss__t244 nfet_03v3 L=0.28U W=10U AS=11P AD=11P PS=22.2U PD=22.2U
* device instance $126 r0 *1 306.56,39 nfet
X$126 vcm__t25 rel_4_n__t1 \$86__t10 vss__t245 nfet_03v3 L=0.28U W=10U AS=11P AD=11P PS=22.2U PD=22.2U
* device instance $127 r0 *1 309.44,39 nfet
X$127 vref__t19 hi_4_n__t1 \$86__t9 vss__t246 nfet_03v3 L=0.28U W=10U AS=11P AD=11P PS=22.2U PD=22.2U
* device instance $128 r0 *1 312.32,39 nfet
X$128 vss__t19 lo_4_n__t1 \$86__t8 vss__t247 nfet_03v3 L=0.28U W=10U AS=11P AD=11P PS=22.2U PD=22.2U
* device instance $129 r0 *1 340.355,36 nfet
X$129 \$146__t2 sel_in__t37 vss__t37 vss__t174 nfet_03v3 L=0.35U W=4U AS=4.4P AD=4.4P PS=10.2U PD=10.2U
* device instance $130 r0 *1 343.305,36 nfet
X$130 \$148__t2 rel_2_n__t2 vss__t53 vss__t175 nfet_03v3 L=0.35U W=4U AS=4.4P AD=4.4P PS=10.2U PD=10.2U
* device instance $131 r0 *1 346.255,36 nfet
X$131 \$118__t2 hi_2_n__t2 vss__t40 vss__t176 nfet_03v3 L=0.35U W=4U AS=4.4P AD=4.4P PS=10.2U PD=10.2U
* device instance $132 r0 *1 349.205,36 nfet
X$132 \$120__t2 lo_2_n__t2 vss__t39 vss__t177 nfet_03v3 L=0.35U W=4U AS=4.4P AD=4.4P PS=10.2U PD=10.2U
* device instance $133 r0 *1 352.12,39 nfet
X$133 vinn__t11 sel_in__t22 \$87__t6 vss__t248 nfet_03v3 L=0.28U W=10U AS=11P AD=11P PS=22.2U PD=22.2U
* device instance $134 r0 *1 355,39 nfet
X$134 vcm__t38 rel_2_n__t1 \$87__t9 vss__t249 nfet_03v3 L=0.28U W=10U AS=11P AD=11P PS=22.2U PD=22.2U
* device instance $135 r0 *1 357.88,39 nfet
X$135 vref__t34 hi_2_n__t1 \$87__t8 vss__t250 nfet_03v3 L=0.28U W=10U AS=11P AD=11P PS=22.2U PD=22.2U
* device instance $136 r0 *1 360.76,39 nfet
X$136 vss__t35 lo_2_n__t1 \$87__t7 vss__t251 nfet_03v3 L=0.28U W=10U AS=11P AD=11P PS=22.2U PD=22.2U
* device instance $137 r0 *1 388.795,36 nfet
X$137 \$149__t2 sel_in__t40 vss__t49 vss__t178 nfet_03v3 L=0.35U W=4U AS=4.4P AD=4.4P PS=10.2U PD=10.2U
* device instance $138 r0 *1 391.745,36 nfet
X$138 \$151__t2 rel_1_n__t2 vss__t50 vss__t179 nfet_03v3 L=0.35U W=4U AS=4.4P AD=4.4P PS=10.2U PD=10.2U
* device instance $139 r0 *1 394.695,36 nfet
X$139 \$122__t2 hi_1_n__t2 vss__t51 vss__t180 nfet_03v3 L=0.35U W=4U AS=4.4P AD=4.4P PS=10.2U PD=10.2U
* device instance $140 r0 *1 397.645,36 nfet
X$140 \$124__t2 lo_1_n__t2 vss__t52 vss__t181 nfet_03v3 L=0.35U W=4U AS=4.4P AD=4.4P PS=10.2U PD=10.2U
* device instance $141 r0 *1 400.56,39 nfet
X$141 vinn__t15 sel_in__t34 \$88__t8 vss__t252 nfet_03v3 L=0.28U W=10U AS=11P AD=11P PS=22.2U PD=22.2U
* device instance $142 r0 *1 403.44,39 nfet
X$142 vcm__t37 rel_1_n__t1 \$88__t7 vss__t253 nfet_03v3 L=0.28U W=10U AS=11P AD=11P PS=22.2U PD=22.2U
* device instance $143 r0 *1 406.32,39 nfet
X$143 vref__t33 hi_1_n__t1 \$88__t6 vss__t254 nfet_03v3 L=0.28U W=10U AS=11P AD=11P PS=22.2U PD=22.2U
* device instance $144 r0 *1 409.2,39 nfet
X$144 vss__t34 lo_1_n__t1 \$88__t5 vss__t255 nfet_03v3 L=0.28U W=10U AS=11P AD=11P PS=22.2U PD=22.2U
* device instance $145 r0 *1 444.075,70 nfet
X$145 \$155__t2 tp_gn__t4 vss__t57 vss__t182 nfet_03v3 L=0.35U W=4U AS=4.4P AD=4.4P PS=10.2U PD=10.2U
* device instance $146 r0 *1 446.99,73 nfet
X$146 vcm__t24 tp_gn__t3 topp__t513 vss__t256 nfet_03v3 L=0.28U W=10U AS=11P AD=11P PS=22.2U PD=22.2U
* device instance $147 r0 *1 457.535,70 nfet
X$147 \$156__t2 tp_gn__t5 vss__t58 vss__t183 nfet_03v3 L=0.35U W=4U AS=4.4P AD=4.4P PS=10.2U PD=10.2U
* device instance $148 r0 *1 460.45,73 nfet
X$148 vcm__t22 tp_gn__t2 topn__t513 vss__t257 nfet_03v3 L=0.28U W=10U AS=11P AD=11P PS=22.2U PD=22.2U
* device instance $149 r0 *1 25.495,4 pfet
X$149 \$3__t1 sel_in__t2 vdd__t0 vdd__t1 pfet_03v3 L=0.35U W=8U AS=8.8P AD=8.8P PS=18.2U PD=18.2U
* device instance $150 r0 *1 28.445,4 pfet
X$150 \$5__t1 rel_256_p__t0 vdd__t209 vdd__t136 pfet_03v3 L=0.35U W=8U AS=8.8P AD=8.8P PS=18.2U PD=18.2U
* device instance $151 r0 *1 31.395,4 pfet
X$151 \$7__t1 hi_256_p__t0 vdd__t208 vdd__t135 pfet_03v3 L=0.35U W=8U AS=8.8P AD=8.8P PS=18.2U PD=18.2U
* device instance $152 r0 *1 34.345,4 pfet
X$152 \$9__t1 lo_256_p__t0 vdd__t218 vdd__t145 pfet_03v3 L=0.35U W=8U AS=8.8P AD=8.8P PS=18.2U PD=18.2U
* device instance $153 r0 *1 37.26,10 pfet
X$153 vinp__t1 \$3__t2 \$10__t1 vdd__t2 pfet_03v3 L=0.28U W=20U AS=22P AD=22P PS=42.2U PD=42.2U
* device instance $154 r0 *1 40.14,10 pfet
X$154 vcm__t21 \$5__t0 \$10__t260 vdd__t74 pfet_03v3 L=0.28U W=20U AS=22P AD=22P PS=42.2U PD=42.2U
* device instance $155 r0 *1 43.02,10 pfet
X$155 vref__t3 \$7__t0 \$10__t258 vdd__t13 pfet_03v3 L=0.28U W=20U AS=22P AD=22P PS=42.2U PD=42.2U
* device instance $156 r0 *1 45.9,10 pfet
X$156 vss__t5 \$9__t0 \$10__t259 vdd__t22 pfet_03v3 L=0.28U W=20U AS=22P AD=22P PS=42.2U PD=42.2U
* device instance $157 r0 *1 73.935,4 pfet
X$157 \$15__t1 sel_in__t19 vdd__t220 vdd__t147 pfet_03v3 L=0.35U W=8U AS=8.8P AD=8.8P PS=18.2U PD=18.2U
* device instance $158 r0 *1 76.885,4 pfet
X$158 \$17__t1 rel_128_p__t0 vdd__t219 vdd__t146 pfet_03v3 L=0.35U W=8U AS=8.8P AD=8.8P PS=18.2U PD=18.2U
* device instance $159 r0 *1 79.835,4 pfet
X$159 \$19__t1 hi_128_p__t0 vdd__t206 vdd__t133 pfet_03v3 L=0.35U W=8U AS=8.8P AD=8.8P PS=18.2U PD=18.2U
* device instance $160 r0 *1 82.785,4 pfet
X$160 \$21__t1 lo_128_p__t0 vdd__t207 vdd__t134 pfet_03v3 L=0.35U W=8U AS=8.8P AD=8.8P PS=18.2U PD=18.2U
* device instance $161 r0 *1 85.7,10 pfet
X$161 vinp__t6 \$15__t0 \$22__t131 vdd__t43 pfet_03v3 L=0.28U W=20U AS=22P AD=22P PS=42.2U PD=42.2U
* device instance $162 r0 *1 88.58,10 pfet
X$162 vcm__t6 \$17__t0 \$22__t130 vdd__t17 pfet_03v3 L=0.28U W=20U AS=22P AD=22P PS=42.2U PD=42.2U
* device instance $163 r0 *1 91.46,10 pfet
X$163 vref__t4 \$19__t0 \$22__t129 vdd__t16 pfet_03v3 L=0.28U W=20U AS=22P AD=22P PS=42.2U PD=42.2U
* device instance $164 r0 *1 94.34,10 pfet
X$164 vss__t2 \$21__t0 \$22__t128 vdd__t15 pfet_03v3 L=0.28U W=20U AS=22P AD=22P PS=42.2U PD=42.2U
* device instance $165 r0 *1 122.375,4 pfet
X$165 \$23__t1 sel_in__t16 vdd__t210 vdd__t137 pfet_03v3 L=0.35U W=8U AS=8.8P AD=8.8P PS=18.2U PD=18.2U
* device instance $166 r0 *1 125.325,4 pfet
X$166 \$25__t1 rel_64_p__t0 vdd__t201 vdd__t128 pfet_03v3 L=0.35U W=8U AS=8.8P AD=8.8P PS=18.2U PD=18.2U
* device instance $167 r0 *1 128.275,4 pfet
X$167 \$27__t1 hi_64_p__t0 vdd__t217 vdd__t144 pfet_03v3 L=0.35U W=8U AS=8.8P AD=8.8P PS=18.2U PD=18.2U
* device instance $168 r0 *1 131.225,4 pfet
X$168 \$29__t1 lo_64_p__t0 vdd__t151 vdd__t78 pfet_03v3 L=0.35U W=8U AS=8.8P AD=8.8P PS=18.2U PD=18.2U
* device instance $169 r0 *1 134.14,10 pfet
X$169 vinp__t9 \$23__t0 \$30__t67 vdd__t75 pfet_03v3 L=0.28U W=20U AS=22P AD=22P PS=42.2U PD=42.2U
* device instance $170 r0 *1 137.02,10 pfet
X$170 vcm__t18 \$25__t0 \$30__t66 vdd__t66 pfet_03v3 L=0.28U W=20U AS=22P AD=22P PS=42.2U PD=42.2U
* device instance $171 r0 *1 139.9,10 pfet
X$171 vref__t15 \$27__t0 \$30__t65 vdd__t64 pfet_03v3 L=0.28U W=20U AS=22P AD=22P PS=42.2U PD=42.2U
* device instance $172 r0 *1 142.78,10 pfet
X$172 vss__t4 \$29__t0 \$30__t64 vdd__t19 pfet_03v3 L=0.28U W=20U AS=22P AD=22P PS=42.2U PD=42.2U
* device instance $173 r0 *1 170.815,4 pfet
X$173 \$31__t1 sel_in__t4 vdd__t156 vdd__t83 pfet_03v3 L=0.35U W=8U AS=8.8P AD=8.8P PS=18.2U PD=18.2U
* device instance $174 r0 *1 173.765,4 pfet
X$174 \$33__t1 rel_32_p__t0 vdd__t158 vdd__t85 pfet_03v3 L=0.35U W=8U AS=8.8P AD=8.8P PS=18.2U PD=18.2U
* device instance $175 r0 *1 176.715,4 pfet
X$175 \$35__t1 hi_32_p__t0 vdd__t160 vdd__t87 pfet_03v3 L=0.35U W=8U AS=8.8P AD=8.8P PS=18.2U PD=18.2U
* device instance $176 r0 *1 179.665,4 pfet
X$176 \$37__t1 lo_32_p__t0 vdd__t161 vdd__t88 pfet_03v3 L=0.35U W=8U AS=8.8P AD=8.8P PS=18.2U PD=18.2U
* device instance $177 r0 *1 182.58,10 pfet
X$177 vinp__t3 \$31__t0 \$38__t32 vdd__t11 pfet_03v3 L=0.28U W=20U AS=22P AD=22P PS=42.2U PD=42.2U
* device instance $178 r0 *1 185.46,10 pfet
X$178 vcm__t13 \$33__t0 \$38__t33 vdd__t44 pfet_03v3 L=0.28U W=20U AS=22P AD=22P PS=42.2U PD=42.2U
* device instance $179 r0 *1 188.34,10 pfet
X$179 vref__t10 \$35__t0 \$38__t34 vdd__t45 pfet_03v3 L=0.28U W=20U AS=22P AD=22P PS=42.2U PD=42.2U
* device instance $180 r0 *1 191.22,10 pfet
X$180 vss__t12 \$37__t0 \$38__t35 vdd__t46 pfet_03v3 L=0.28U W=20U AS=22P AD=22P PS=42.2U PD=42.2U
* device instance $181 r0 *1 219.255,4 pfet
X$181 \$39__t1 sel_in__t18 vdd__t215 vdd__t142 pfet_03v3 L=0.35U W=8U AS=8.8P AD=8.8P PS=18.2U PD=18.2U
* device instance $182 r0 *1 222.205,4 pfet
X$182 \$41__t1 rel_16_p__t0 vdd__t216 vdd__t143 pfet_03v3 L=0.35U W=8U AS=8.8P AD=8.8P PS=18.2U PD=18.2U
* device instance $183 r0 *1 225.155,4 pfet
X$183 \$43__t1 hi_16_p__t0 vdd__t154 vdd__t81 pfet_03v3 L=0.35U W=8U AS=8.8P AD=8.8P PS=18.2U PD=18.2U
* device instance $184 r0 *1 228.105,4 pfet
X$184 \$45__t1 lo_16_p__t0 vdd__t155 vdd__t82 pfet_03v3 L=0.35U W=8U AS=8.8P AD=8.8P PS=18.2U PD=18.2U
* device instance $185 r0 *1 231.02,10 pfet
X$185 vinp__t7 \$39__t0 \$46__t19 vdd__t47 pfet_03v3 L=0.28U W=20U AS=22P AD=22P PS=42.2U PD=42.2U
* device instance $186 r0 *1 233.9,10 pfet
X$186 vcm__t4 \$41__t0 \$46__t16 vdd__t5 pfet_03v3 L=0.28U W=20U AS=22P AD=22P PS=42.2U PD=42.2U
* device instance $187 r0 *1 236.78,10 pfet
X$187 vref__t2 \$43__t0 \$46__t17 vdd__t12 pfet_03v3 L=0.28U W=20U AS=22P AD=22P PS=42.2U PD=42.2U
* device instance $188 r0 *1 239.66,10 pfet
X$188 vss__t6 \$45__t0 \$46__t18 vdd__t23 pfet_03v3 L=0.28U W=20U AS=22P AD=22P PS=42.2U PD=42.2U
* device instance $189 r0 *1 267.695,4 pfet
X$189 \$47__t1 sel_in__t14 vdd__t198 vdd__t125 pfet_03v3 L=0.35U W=8U AS=8.8P AD=8.8P PS=18.2U PD=18.2U
* device instance $190 r0 *1 270.645,4 pfet
X$190 \$49__t1 rel_8_p__t0 vdd__t199 vdd__t126 pfet_03v3 L=0.35U W=8U AS=8.8P AD=8.8P PS=18.2U PD=18.2U
* device instance $191 r0 *1 273.595,4 pfet
X$191 \$51__t1 hi_8_p__t0 vdd__t191 vdd__t118 pfet_03v3 L=0.35U W=8U AS=8.8P AD=8.8P PS=18.2U PD=18.2U
* device instance $192 r0 *1 276.545,4 pfet
X$192 \$53__t1 lo_8_p__t0 vdd__t167 vdd__t94 pfet_03v3 L=0.35U W=8U AS=8.8P AD=8.8P PS=18.2U PD=18.2U
* device instance $193 r0 *1 279.46,10 pfet
X$193 vinp__t4 \$47__t0 \$54__t8 vdd__t14 pfet_03v3 L=0.28U W=20U AS=22P AD=22P PS=42.2U PD=42.2U
* device instance $194 r0 *1 282.34,10 pfet
X$194 vcm__t12 \$49__t0 \$54__t9 vdd__t38 pfet_03v3 L=0.28U W=20U AS=22P AD=22P PS=42.2U PD=42.2U
* device instance $195 r0 *1 285.22,10 pfet
X$195 vref__t9 \$51__t0 \$54__t10 vdd__t39 pfet_03v3 L=0.28U W=20U AS=22P AD=22P PS=42.2U PD=42.2U
* device instance $196 r0 *1 288.1,10 pfet
X$196 vss__t11 \$53__t0 \$54__t11 vdd__t40 pfet_03v3 L=0.28U W=20U AS=22P AD=22P PS=42.2U PD=42.2U
* device instance $197 r0 *1 316.135,4 pfet
X$197 \$55__t1 sel_in__t11 vdd__t186 vdd__t113 pfet_03v3 L=0.35U W=8U AS=8.8P AD=8.8P PS=18.2U PD=18.2U
* device instance $198 r0 *1 319.085,4 pfet
X$198 \$57__t1 rel_4_p__t0 vdd__t187 vdd__t114 pfet_03v3 L=0.35U W=8U AS=8.8P AD=8.8P PS=18.2U PD=18.2U
* device instance $199 r0 *1 322.035,4 pfet
X$199 \$59__t1 hi_4_p__t0 vdd__t188 vdd__t115 pfet_03v3 L=0.35U W=8U AS=8.8P AD=8.8P PS=18.2U PD=18.2U
* device instance $200 r0 *1 324.985,4 pfet
X$200 \$61__t1 lo_4_p__t0 vdd__t189 vdd__t116 pfet_03v3 L=0.35U W=8U AS=8.8P AD=8.8P PS=18.2U PD=18.2U
* device instance $201 r0 *1 327.9,10 pfet
X$201 vinp__t2 \$55__t0 \$62__t4 vdd__t7 pfet_03v3 L=0.28U W=20U AS=22P AD=22P PS=42.2U PD=42.2U
* device instance $202 r0 *1 330.78,10 pfet
X$202 vcm__t5 \$57__t0 \$62__t5 vdd__t8 pfet_03v3 L=0.28U W=20U AS=22P AD=22P PS=42.2U PD=42.2U
* device instance $203 r0 *1 333.66,10 pfet
X$203 vref__t1 \$59__t0 \$62__t6 vdd__t9 pfet_03v3 L=0.28U W=20U AS=22P AD=22P PS=42.2U PD=42.2U
* device instance $204 r0 *1 336.54,10 pfet
X$204 vss__t1 \$61__t0 \$62__t7 vdd__t10 pfet_03v3 L=0.28U W=20U AS=22P AD=22P PS=42.2U PD=42.2U
* device instance $205 r0 *1 364.575,4 pfet
X$205 \$63__t1 sel_in__t10 vdd__t183 vdd__t110 pfet_03v3 L=0.35U W=8U AS=8.8P AD=8.8P PS=18.2U PD=18.2U
* device instance $206 r0 *1 367.525,4 pfet
X$206 \$65__t1 rel_2_p__t0 vdd__t179 vdd__t106 pfet_03v3 L=0.35U W=8U AS=8.8P AD=8.8P PS=18.2U PD=18.2U
* device instance $207 r0 *1 370.475,4 pfet
X$207 \$67__t1 hi_2_p__t0 vdd__t180 vdd__t107 pfet_03v3 L=0.35U W=8U AS=8.8P AD=8.8P PS=18.2U PD=18.2U
* device instance $208 r0 *1 373.425,4 pfet
X$208 \$69__t1 lo_2_p__t0 vdd__t181 vdd__t108 pfet_03v3 L=0.35U W=8U AS=8.8P AD=8.8P PS=18.2U PD=18.2U
* device instance $209 r0 *1 376.34,10 pfet
X$209 vinp__t8 \$63__t0 \$70__t2 vdd__t48 pfet_03v3 L=0.28U W=20U AS=22P AD=22P PS=42.2U PD=42.2U
* device instance $210 r0 *1 379.22,10 pfet
X$210 vcm__t14 \$65__t0 \$70__t3 vdd__t49 pfet_03v3 L=0.28U W=20U AS=22P AD=22P PS=42.2U PD=42.2U
* device instance $211 r0 *1 382.1,10 pfet
X$211 vref__t11 \$67__t0 \$70__t4 vdd__t50 pfet_03v3 L=0.28U W=20U AS=22P AD=22P PS=42.2U PD=42.2U
* device instance $212 r0 *1 384.98,10 pfet
X$212 vss__t13 \$69__t0 \$70__t5 vdd__t51 pfet_03v3 L=0.28U W=20U AS=22P AD=22P PS=42.2U PD=42.2U
* device instance $213 r0 *1 413.015,4 pfet
X$213 \$71__t1 sel_in__t9 vdd__t182 vdd__t109 pfet_03v3 L=0.35U W=8U AS=8.8P AD=8.8P PS=18.2U PD=18.2U
* device instance $214 r0 *1 415.965,4 pfet
X$214 \$73__t1 rel_1_p__t0 vdd__t202 vdd__t129 pfet_03v3 L=0.35U W=8U AS=8.8P AD=8.8P PS=18.2U PD=18.2U
* device instance $215 r0 *1 418.915,4 pfet
X$215 \$75__t1 hi_1_p__t0 vdd__t168 vdd__t95 pfet_03v3 L=0.35U W=8U AS=8.8P AD=8.8P PS=18.2U PD=18.2U
* device instance $216 r0 *1 421.865,4 pfet
X$216 \$77__t1 lo_1_p__t0 vdd__t169 vdd__t96 pfet_03v3 L=0.35U W=8U AS=8.8P AD=8.8P PS=18.2U PD=18.2U
* device instance $217 r0 *1 424.78,10 pfet
X$217 vinp__t5 \$71__t0 \$78__t1 vdd__t20 pfet_03v3 L=0.28U W=20U AS=22P AD=22P PS=42.2U PD=42.2U
* device instance $218 r0 *1 427.66,10 pfet
X$218 vcm__t7 \$73__t0 \$78__t2 vdd__t21 pfet_03v3 L=0.28U W=20U AS=22P AD=22P PS=42.2U PD=42.2U
* device instance $219 r0 *1 430.54,10 pfet
X$219 vref__t12 \$75__t0 \$78__t3 vdd__t52 pfet_03v3 L=0.28U W=20U AS=22P AD=22P PS=42.2U PD=42.2U
* device instance $220 r0 *1 433.42,10 pfet
X$220 vss__t16 \$77__t0 \$78__t4 vdd__t63 pfet_03v3 L=0.28U W=20U AS=22P AD=22P PS=42.2U PD=42.2U
* device instance $221 r0 *1 25.495,38 pfet
X$221 \$125__t1 sel_in__t17 vdd__t214 vdd__t141 pfet_03v3 L=0.35U W=8U AS=8.8P AD=8.8P PS=18.2U PD=18.2U
* device instance $222 r0 *1 28.445,38 pfet
X$222 \$127__t1 rel_256_n__t0 vdd__t213 vdd__t140 pfet_03v3 L=0.35U W=8U AS=8.8P AD=8.8P PS=18.2U PD=18.2U
* device instance $223 r0 *1 31.395,38 pfet
X$223 \$90__t1 hi_256_n__t0 vdd__t212 vdd__t139 pfet_03v3 L=0.35U W=8U AS=8.8P AD=8.8P PS=18.2U PD=18.2U
* device instance $224 r0 *1 34.345,38 pfet
X$224 \$92__t1 lo_256_n__t0 vdd__t211 vdd__t138 pfet_03v3 L=0.35U W=8U AS=8.8P AD=8.8P PS=18.2U PD=18.2U
* device instance $225 r0 *1 37.26,44 pfet
X$225 vinn__t7 \$125__t0 \$79__t256 vdd__t65 pfet_03v3 L=0.28U W=20U AS=22P AD=22P PS=42.2U PD=42.2U
* device instance $226 r0 *1 40.14,44 pfet
X$226 vcm__t19 \$127__t0 \$79__t257 vdd__t67 pfet_03v3 L=0.28U W=20U AS=22P AD=22P PS=42.2U PD=42.2U
* device instance $227 r0 *1 43.02,44 pfet
X$227 vref__t16 \$90__t0 \$79__t258 vdd__t68 pfet_03v3 L=0.28U W=20U AS=22P AD=22P PS=42.2U PD=42.2U
* device instance $228 r0 *1 45.9,44 pfet
X$228 vss__t17 \$92__t0 \$79__t259 vdd__t69 pfet_03v3 L=0.28U W=20U AS=22P AD=22P PS=42.2U PD=42.2U
* device instance $229 r0 *1 73.935,38 pfet
X$229 \$128__t1 sel_in__t15 vdd__t205 vdd__t132 pfet_03v3 L=0.35U W=8U AS=8.8P AD=8.8P PS=18.2U PD=18.2U
* device instance $230 r0 *1 76.885,38 pfet
X$230 \$130__t1 rel_128_n__t0 vdd__t204 vdd__t131 pfet_03v3 L=0.35U W=8U AS=8.8P AD=8.8P PS=18.2U PD=18.2U
* device instance $231 r0 *1 79.835,38 pfet
X$231 \$94__t1 hi_128_n__t0 vdd__t203 vdd__t130 pfet_03v3 L=0.35U W=8U AS=8.8P AD=8.8P PS=18.2U PD=18.2U
* device instance $232 r0 *1 82.785,38 pfet
X$232 \$96__t1 lo_128_n__t0 vdd__t221 vdd__t148 pfet_03v3 L=0.35U W=8U AS=8.8P AD=8.8P PS=18.2U PD=18.2U
* device instance $233 r0 *1 85.7,44 pfet
X$233 vinn__t8 \$128__t0 \$81__t128 vdd__t70 pfet_03v3 L=0.28U W=20U AS=22P AD=22P PS=42.2U PD=42.2U
* device instance $234 r0 *1 88.58,44 pfet
X$234 vcm__t20 \$130__t0 \$81__t129 vdd__t71 pfet_03v3 L=0.28U W=20U AS=22P AD=22P PS=42.2U PD=42.2U
* device instance $235 r0 *1 91.46,44 pfet
X$235 vref__t17 \$94__t0 \$81__t130 vdd__t72 pfet_03v3 L=0.28U W=20U AS=22P AD=22P PS=42.2U PD=42.2U
* device instance $236 r0 *1 94.34,44 pfet
X$236 vss__t18 \$96__t0 \$81__t131 vdd__t73 pfet_03v3 L=0.28U W=20U AS=22P AD=22P PS=42.2U PD=42.2U
* device instance $237 r0 *1 122.375,38 pfet
X$237 \$131__t1 sel_in__t7 vdd__t174 vdd__t101 pfet_03v3 L=0.35U W=8U AS=8.8P AD=8.8P PS=18.2U PD=18.2U
* device instance $238 r0 *1 125.325,38 pfet
X$238 \$133__t1 rel_64_n__t0 vdd__t153 vdd__t80 pfet_03v3 L=0.35U W=8U AS=8.8P AD=8.8P PS=18.2U PD=18.2U
* device instance $239 r0 *1 128.275,38 pfet
X$239 \$98__t1 hi_64_n__t0 vdd__t159 vdd__t86 pfet_03v3 L=0.35U W=8U AS=8.8P AD=8.8P PS=18.2U PD=18.2U
* device instance $240 r0 *1 131.225,38 pfet
X$240 \$100__t1 lo_64_n__t0 vdd__t162 vdd__t89 pfet_03v3 L=0.35U W=8U AS=8.8P AD=8.8P PS=18.2U PD=18.2U
* device instance $241 r0 *1 134.14,44 pfet
X$241 vinn__t6 \$131__t0 \$82__t67 vdd__t61 pfet_03v3 L=0.28U W=20U AS=22P AD=22P PS=42.2U PD=42.2U
* device instance $242 r0 *1 137.02,44 pfet
X$242 vcm__t16 \$133__t0 \$82__t66 vdd__t60 pfet_03v3 L=0.28U W=20U AS=22P AD=22P PS=42.2U PD=42.2U
* device instance $243 r0 *1 139.9,44 pfet
X$243 vref__t14 \$98__t0 \$82__t65 vdd__t59 pfet_03v3 L=0.28U W=20U AS=22P AD=22P PS=42.2U PD=42.2U
* device instance $244 r0 *1 142.78,44 pfet
X$244 vss__t15 \$100__t0 \$82__t64 vdd__t58 pfet_03v3 L=0.28U W=20U AS=22P AD=22P PS=42.2U PD=42.2U
* device instance $245 r0 *1 170.815,38 pfet
X$245 \$134__t1 sel_in__t3 vdd__t149 vdd__t76 pfet_03v3 L=0.35U W=8U AS=8.8P AD=8.8P PS=18.2U PD=18.2U
* device instance $246 r0 *1 173.765,38 pfet
X$246 \$136__t1 rel_32_n__t0 vdd__t152 vdd__t79 pfet_03v3 L=0.35U W=8U AS=8.8P AD=8.8P PS=18.2U PD=18.2U
* device instance $247 r0 *1 176.715,38 pfet
X$247 \$102__t1 hi_32_n__t0 vdd__t150 vdd__t77 pfet_03v3 L=0.35U W=8U AS=8.8P AD=8.8P PS=18.2U PD=18.2U
* device instance $248 r0 *1 179.665,38 pfet
X$248 \$104__t1 lo_32_n__t0 vdd__t166 vdd__t93 pfet_03v3 L=0.35U W=8U AS=8.8P AD=8.8P PS=18.2U PD=18.2U
* device instance $249 r0 *1 182.58,44 pfet
X$249 vinn__t5 \$134__t0 \$83__t35 vdd__t57 pfet_03v3 L=0.28U W=20U AS=22P AD=22P PS=42.2U PD=42.2U
* device instance $250 r0 *1 185.46,44 pfet
X$250 vcm__t15 \$136__t0 \$83__t34 vdd__t56 pfet_03v3 L=0.28U W=20U AS=22P AD=22P PS=42.2U PD=42.2U
* device instance $251 r0 *1 188.34,44 pfet
X$251 vref__t13 \$102__t0 \$83__t33 vdd__t55 pfet_03v3 L=0.28U W=20U AS=22P AD=22P PS=42.2U PD=42.2U
* device instance $252 r0 *1 191.22,44 pfet
X$252 vss__t14 \$104__t0 \$83__t32 vdd__t54 pfet_03v3 L=0.28U W=20U AS=22P AD=22P PS=42.2U PD=42.2U
* device instance $253 r0 *1 219.255,38 pfet
X$253 \$137__t1 sel_in__t5 vdd__t165 vdd__t92 pfet_03v3 L=0.35U W=8U AS=8.8P AD=8.8P PS=18.2U PD=18.2U
* device instance $254 r0 *1 222.205,38 pfet
X$254 \$139__t1 rel_16_n__t0 vdd__t164 vdd__t91 pfet_03v3 L=0.35U W=8U AS=8.8P AD=8.8P PS=18.2U PD=18.2U
* device instance $255 r0 *1 225.155,38 pfet
X$255 \$106__t1 hi_16_n__t0 vdd__t163 vdd__t90 pfet_03v3 L=0.35U W=8U AS=8.8P AD=8.8P PS=18.2U PD=18.2U
* device instance $256 r0 *1 228.105,38 pfet
X$256 \$108__t1 lo_16_n__t0 vdd__t157 vdd__t84 pfet_03v3 L=0.35U W=8U AS=8.8P AD=8.8P PS=18.2U PD=18.2U
* device instance $257 r0 *1 231.02,44 pfet
X$257 vinn__t4 \$137__t0 \$84__t18 vdd__t53 pfet_03v3 L=0.28U W=20U AS=22P AD=22P PS=42.2U PD=42.2U
* device instance $258 r0 *1 233.9,44 pfet
X$258 vcm__t17 \$139__t0 \$84__t19 vdd__t62 pfet_03v3 L=0.28U W=20U AS=22P AD=22P PS=42.2U PD=42.2U
* device instance $259 r0 *1 236.78,44 pfet
X$259 vref__t0 \$106__t0 \$84__t16 vdd__t6 pfet_03v3 L=0.28U W=20U AS=22P AD=22P PS=42.2U PD=42.2U
* device instance $260 r0 *1 239.66,44 pfet
X$260 vss__t9 \$108__t0 \$84__t17 vdd__t32 pfet_03v3 L=0.28U W=20U AS=22P AD=22P PS=42.2U PD=42.2U
* device instance $261 r0 *1 267.695,38 pfet
X$261 \$140__t1 sel_in__t12 vdd__t190 vdd__t117 pfet_03v3 L=0.35U W=8U AS=8.8P AD=8.8P PS=18.2U PD=18.2U
* device instance $262 r0 *1 270.645,38 pfet
X$262 \$142__t1 rel_8_n__t0 vdd__t200 vdd__t127 pfet_03v3 L=0.35U W=8U AS=8.8P AD=8.8P PS=18.2U PD=18.2U
* device instance $263 r0 *1 273.595,38 pfet
X$263 \$110__t1 hi_8_n__t0 vdd__t192 vdd__t119 pfet_03v3 L=0.35U W=8U AS=8.8P AD=8.8P PS=18.2U PD=18.2U
* device instance $264 r0 *1 276.545,38 pfet
X$264 \$112__t1 lo_8_n__t0 vdd__t193 vdd__t120 pfet_03v3 L=0.35U W=8U AS=8.8P AD=8.8P PS=18.2U PD=18.2U
* device instance $265 r0 *1 279.46,44 pfet
X$265 vinn__t2 \$140__t0 \$85__t11 vdd__t41 pfet_03v3 L=0.28U W=20U AS=22P AD=22P PS=42.2U PD=42.2U
* device instance $266 r0 *1 282.34,44 pfet
X$266 vcm__t11 \$142__t0 \$85__t10 vdd__t37 pfet_03v3 L=0.28U W=20U AS=22P AD=22P PS=42.2U PD=42.2U
* device instance $267 r0 *1 285.22,44 pfet
X$267 vref__t8 \$110__t0 \$85__t9 vdd__t36 pfet_03v3 L=0.28U W=20U AS=22P AD=22P PS=42.2U PD=42.2U
* device instance $268 r0 *1 288.1,44 pfet
X$268 vss__t3 \$112__t0 \$85__t8 vdd__t18 pfet_03v3 L=0.28U W=20U AS=22P AD=22P PS=42.2U PD=42.2U
* device instance $269 r0 *1 316.135,38 pfet
X$269 \$143__t1 sel_in__t13 vdd__t194 vdd__t121 pfet_03v3 L=0.35U W=8U AS=8.8P AD=8.8P PS=18.2U PD=18.2U
* device instance $270 r0 *1 319.085,38 pfet
X$270 \$145__t1 rel_4_n__t0 vdd__t195 vdd__t122 pfet_03v3 L=0.35U W=8U AS=8.8P AD=8.8P PS=18.2U PD=18.2U
* device instance $271 r0 *1 322.035,38 pfet
X$271 \$114__t1 hi_4_n__t0 vdd__t196 vdd__t123 pfet_03v3 L=0.35U W=8U AS=8.8P AD=8.8P PS=18.2U PD=18.2U
* device instance $272 r0 *1 324.985,38 pfet
X$272 \$116__t1 lo_4_n__t0 vdd__t197 vdd__t124 pfet_03v3 L=0.35U W=8U AS=8.8P AD=8.8P PS=18.2U PD=18.2U
* device instance $273 r0 *1 327.9,44 pfet
X$273 vinn__t0 \$143__t0 \$86__t4 vdd__t24 pfet_03v3 L=0.28U W=20U AS=22P AD=22P PS=42.2U PD=42.2U
* device instance $274 r0 *1 330.78,44 pfet
X$274 vcm__t8 \$145__t0 \$86__t5 vdd__t25 pfet_03v3 L=0.28U W=20U AS=22P AD=22P PS=42.2U PD=42.2U
* device instance $275 r0 *1 333.66,44 pfet
X$275 vref__t5 \$114__t0 \$86__t6 vdd__t26 pfet_03v3 L=0.28U W=20U AS=22P AD=22P PS=42.2U PD=42.2U
* device instance $276 r0 *1 336.54,44 pfet
X$276 vss__t7 \$116__t0 \$86__t7 vdd__t27 pfet_03v3 L=0.28U W=20U AS=22P AD=22P PS=42.2U PD=42.2U
* device instance $277 r0 *1 364.575,38 pfet
X$277 \$146__t1 sel_in__t6 vdd__t170 vdd__t97 pfet_03v3 L=0.35U W=8U AS=8.8P AD=8.8P PS=18.2U PD=18.2U
* device instance $278 r0 *1 367.525,38 pfet
X$278 \$148__t1 rel_2_n__t0 vdd__t171 vdd__t98 pfet_03v3 L=0.35U W=8U AS=8.8P AD=8.8P PS=18.2U PD=18.2U
* device instance $279 r0 *1 370.475,38 pfet
X$279 \$118__t1 hi_2_n__t0 vdd__t172 vdd__t99 pfet_03v3 L=0.35U W=8U AS=8.8P AD=8.8P PS=18.2U PD=18.2U
* device instance $280 r0 *1 373.425,38 pfet
X$280 \$120__t1 lo_2_n__t0 vdd__t173 vdd__t100 pfet_03v3 L=0.35U W=8U AS=8.8P AD=8.8P PS=18.2U PD=18.2U
* device instance $281 r0 *1 376.34,44 pfet
X$281 vinn__t1 \$146__t0 \$87__t2 vdd__t28 pfet_03v3 L=0.28U W=20U AS=22P AD=22P PS=42.2U PD=42.2U
* device instance $282 r0 *1 379.22,44 pfet
X$282 vcm__t9 \$148__t0 \$87__t3 vdd__t29 pfet_03v3 L=0.28U W=20U AS=22P AD=22P PS=42.2U PD=42.2U
* device instance $283 r0 *1 382.1,44 pfet
X$283 vref__t6 \$118__t0 \$87__t4 vdd__t30 pfet_03v3 L=0.28U W=20U AS=22P AD=22P PS=42.2U PD=42.2U
* device instance $284 r0 *1 384.98,44 pfet
X$284 vss__t8 \$120__t0 \$87__t5 vdd__t31 pfet_03v3 L=0.28U W=20U AS=22P AD=22P PS=42.2U PD=42.2U
* device instance $285 r0 *1 413.015,38 pfet
X$285 \$149__t1 sel_in__t8 vdd__t175 vdd__t102 pfet_03v3 L=0.35U W=8U AS=8.8P AD=8.8P PS=18.2U PD=18.2U
* device instance $286 r0 *1 415.965,38 pfet
X$286 \$151__t1 rel_1_n__t0 vdd__t176 vdd__t103 pfet_03v3 L=0.35U W=8U AS=8.8P AD=8.8P PS=18.2U PD=18.2U
* device instance $287 r0 *1 418.915,38 pfet
X$287 \$122__t1 hi_1_n__t0 vdd__t177 vdd__t104 pfet_03v3 L=0.35U W=8U AS=8.8P AD=8.8P PS=18.2U PD=18.2U
* device instance $288 r0 *1 421.865,38 pfet
X$288 \$124__t1 lo_1_n__t0 vdd__t178 vdd__t105 pfet_03v3 L=0.35U W=8U AS=8.8P AD=8.8P PS=18.2U PD=18.2U
* device instance $289 r0 *1 424.78,44 pfet
X$289 vinn__t3 \$149__t0 \$88__t4 vdd__t42 pfet_03v3 L=0.28U W=20U AS=22P AD=22P PS=42.2U PD=42.2U
* device instance $290 r0 *1 427.66,44 pfet
X$290 vcm__t10 \$151__t0 \$88__t1 vdd__t33 pfet_03v3 L=0.28U W=20U AS=22P AD=22P PS=42.2U PD=42.2U
* device instance $291 r0 *1 430.54,44 pfet
X$291 vref__t7 \$122__t0 \$88__t2 vdd__t34 pfet_03v3 L=0.28U W=20U AS=22P AD=22P PS=42.2U PD=42.2U
* device instance $292 r0 *1 433.42,44 pfet
X$292 vss__t10 \$124__t0 \$88__t3 vdd__t35 pfet_03v3 L=0.28U W=20U AS=22P AD=22P PS=42.2U PD=42.2U
* device instance $293 r0 *1 450.805,72 pfet
X$293 \$155__t1 tp_gn__t0 vdd__t184 vdd__t111 pfet_03v3 L=0.35U W=8U AS=8.8P AD=8.8P PS=18.2U PD=18.2U
* device instance $294 r0 *1 453.72,78 pfet
X$294 vcm__t3 \$155__t0 topp__t512 vdd__t4 pfet_03v3 L=0.28U W=20U AS=22P AD=22P PS=42.2U PD=42.2U
* device instance $295 r0 *1 464.265,72 pfet
X$295 \$156__t1 tp_gn__t1 vdd__t185 vdd__t112 pfet_03v3 L=0.35U W=8U AS=8.8P AD=8.8P PS=18.2U PD=18.2U
* device instance $296 r0 *1 467.18,78 pfet
X$296 vcm__t2 \$156__t0 topn__t512 vdd__t3 pfet_03v3 L=0.28U W=20U AS=22P AD=22P PS=42.2U PD=42.2U
* device instance $297 r0 *1 2.6,70.6 cap_mim_2f0_m4m5_noshield
X$297 \$10__t248 topp__t0 cap_mim_2f0_m4m5_noshield c_length=4U c_width=4U
* device instance $298 r0 *1 9,70.6 cap_mim_2f0_m4m5_noshield
X$298 \$70__t1 topp__t494 cap_mim_2f0_m4m5_noshield c_length=4U c_width=4U
* device instance $299 r0 *1 15.4,70.6 cap_mim_2f0_m4m5_noshield
X$299 \$10__t247 topp__t493 cap_mim_2f0_m4m5_noshield c_length=4U c_width=4U
* device instance $300 r0 *1 21.8,70.6 cap_mim_2f0_m4m5_noshield
X$300 \$62__t3 topp__t492 cap_mim_2f0_m4m5_noshield c_length=4U c_width=4U
* device instance $301 r0 *1 28.2,70.6 cap_mim_2f0_m4m5_noshield
X$301 \$10__t246 topp__t491 cap_mim_2f0_m4m5_noshield c_length=4U c_width=4U
* device instance $302 r0 *1 34.6,70.6 cap_mim_2f0_m4m5_noshield
X$302 \$54__t7 topp__t490 cap_mim_2f0_m4m5_noshield c_length=4U c_width=4U
* device instance $303 r0 *1 41,70.6 cap_mim_2f0_m4m5_noshield
X$303 \$10__t245 topp__t489 cap_mim_2f0_m4m5_noshield c_length=4U c_width=4U
* device instance $304 r0 *1 47.4,70.6 cap_mim_2f0_m4m5_noshield
X$304 \$54__t6 topp__t488 cap_mim_2f0_m4m5_noshield c_length=4U c_width=4U
* device instance $305 r0 *1 53.8,70.6 cap_mim_2f0_m4m5_noshield
X$305 \$10__t244 topp__t487 cap_mim_2f0_m4m5_noshield c_length=4U c_width=4U
* device instance $306 r0 *1 60.2,70.6 cap_mim_2f0_m4m5_noshield
X$306 \$46__t15 topp__t486 cap_mim_2f0_m4m5_noshield c_length=4U c_width=4U
* device instance $307 r0 *1 66.6,70.6 cap_mim_2f0_m4m5_noshield
X$307 \$10__t243 topp__t485 cap_mim_2f0_m4m5_noshield c_length=4U c_width=4U
* device instance $308 r0 *1 73,70.6 cap_mim_2f0_m4m5_noshield
X$308 \$46__t14 topp__t484 cap_mim_2f0_m4m5_noshield c_length=4U c_width=4U
* device instance $309 r0 *1 79.4,70.6 cap_mim_2f0_m4m5_noshield
X$309 \$10__t242 topp__t483 cap_mim_2f0_m4m5_noshield c_length=4U c_width=4U
* device instance $310 r0 *1 85.8,70.6 cap_mim_2f0_m4m5_noshield
X$310 \$46__t13 topp__t482 cap_mim_2f0_m4m5_noshield c_length=4U c_width=4U
* device instance $311 r0 *1 92.2,70.6 cap_mim_2f0_m4m5_noshield
X$311 \$10__t249 topp__t496 cap_mim_2f0_m4m5_noshield c_length=4U c_width=4U
* device instance $312 r0 *1 98.6,70.6 cap_mim_2f0_m4m5_noshield
X$312 \$46__t12 topp__t450 cap_mim_2f0_m4m5_noshield c_length=4U c_width=4U
* device instance $313 r0 *1 105,70.6 cap_mim_2f0_m4m5_noshield
X$313 \$10__t257 topp__t511 cap_mim_2f0_m4m5_noshield c_length=4U c_width=4U
* device instance $314 r0 *1 111.4,70.6 cap_mim_2f0_m4m5_noshield
X$314 \$38__t30 topp__t495 cap_mim_2f0_m4m5_noshield c_length=4U c_width=4U
* device instance $315 r0 *1 117.8,70.6 cap_mim_2f0_m4m5_noshield
X$315 \$10__t198 topp__t392 cap_mim_2f0_m4m5_noshield c_length=4U c_width=4U
* device instance $316 r0 *1 124.2,70.6 cap_mim_2f0_m4m5_noshield
X$316 \$38__t27 topp__t476 cap_mim_2f0_m4m5_noshield c_length=4U c_width=4U
* device instance $317 r0 *1 130.6,70.6 cap_mim_2f0_m4m5_noshield
X$317 \$10__t233 topp__t462 cap_mim_2f0_m4m5_noshield c_length=4U c_width=4U
* device instance $318 r0 *1 137,70.6 cap_mim_2f0_m4m5_noshield
X$318 \$38__t25 topp__t461 cap_mim_2f0_m4m5_noshield c_length=4U c_width=4U
* device instance $319 r0 *1 143.4,70.6 cap_mim_2f0_m4m5_noshield
X$319 \$10__t232 topp__t460 cap_mim_2f0_m4m5_noshield c_length=4U c_width=4U
* device instance $320 r0 *1 149.8,70.6 cap_mim_2f0_m4m5_noshield
X$320 \$38__t24 topp__t459 cap_mim_2f0_m4m5_noshield c_length=4U c_width=4U
* device instance $321 r0 *1 156.2,70.6 cap_mim_2f0_m4m5_noshield
X$321 \$10__t231 topp__t458 cap_mim_2f0_m4m5_noshield c_length=4U c_width=4U
* device instance $322 r0 *1 162.6,70.6 cap_mim_2f0_m4m5_noshield
X$322 \$38__t26 topp__t471 cap_mim_2f0_m4m5_noshield c_length=4U c_width=4U
* device instance $323 r0 *1 169,70.6 cap_mim_2f0_m4m5_noshield
X$323 \$10__t256 topp__t510 cap_mim_2f0_m4m5_noshield c_length=4U c_width=4U
* device instance $324 r0 *1 175.4,70.6 cap_mim_2f0_m4m5_noshield
X$324 \$38__t31 topp__t497 cap_mim_2f0_m4m5_noshield c_length=4U c_width=4U
* device instance $325 r0 *1 181.8,70.6 cap_mim_2f0_m4m5_noshield
X$325 \$10__t241 topp__t480 cap_mim_2f0_m4m5_noshield c_length=4U c_width=4U
* device instance $326 r0 *1 188.2,70.6 cap_mim_2f0_m4m5_noshield
X$326 \$38__t29 topp__t479 cap_mim_2f0_m4m5_noshield c_length=4U c_width=4U
* device instance $327 r0 *1 194.6,70.6 cap_mim_2f0_m4m5_noshield
X$327 \$10__t240 topp__t478 cap_mim_2f0_m4m5_noshield c_length=4U c_width=4U
* device instance $328 r0 *1 201,70.6 cap_mim_2f0_m4m5_noshield
X$328 \$38__t28 topp__t477 cap_mim_2f0_m4m5_noshield c_length=4U c_width=4U
* device instance $329 r0 *1 224,70.6 cap_mim_2f0_m4m5_noshield
X$329 \$79__t252 topn__t506 cap_mim_2f0_m4m5_noshield c_length=4U c_width=4U
* device instance $330 r0 *1 230.4,70.6 cap_mim_2f0_m4m5_noshield
X$330 \$87__t1 topn__t505 cap_mim_2f0_m4m5_noshield c_length=4U c_width=4U
* device instance $331 r0 *1 236.8,70.6 cap_mim_2f0_m4m5_noshield
X$331 \$79__t173 topn__t346 cap_mim_2f0_m4m5_noshield c_length=4U c_width=4U
* device instance $332 r0 *1 243.2,70.6 cap_mim_2f0_m4m5_noshield
X$332 \$86__t3 topn__t345 cap_mim_2f0_m4m5_noshield c_length=4U c_width=4U
* device instance $333 r0 *1 249.6,70.6 cap_mim_2f0_m4m5_noshield
X$333 \$79__t172 topn__t344 cap_mim_2f0_m4m5_noshield c_length=4U c_width=4U
* device instance $334 r0 *1 256,70.6 cap_mim_2f0_m4m5_noshield
X$334 \$85__t7 topn__t343 cap_mim_2f0_m4m5_noshield c_length=4U c_width=4U
* device instance $335 r0 *1 262.4,70.6 cap_mim_2f0_m4m5_noshield
X$335 \$79__t171 topn__t342 cap_mim_2f0_m4m5_noshield c_length=4U c_width=4U
* device instance $336 r0 *1 268.8,70.6 cap_mim_2f0_m4m5_noshield
X$336 \$85__t6 topn__t341 cap_mim_2f0_m4m5_noshield c_length=4U c_width=4U
* device instance $337 r0 *1 275.2,70.6 cap_mim_2f0_m4m5_noshield
X$337 \$79__t170 topn__t340 cap_mim_2f0_m4m5_noshield c_length=4U c_width=4U
* device instance $338 r0 *1 281.6,70.6 cap_mim_2f0_m4m5_noshield
X$338 \$84__t9 topn__t339 cap_mim_2f0_m4m5_noshield c_length=4U c_width=4U
* device instance $339 r0 *1 288,70.6 cap_mim_2f0_m4m5_noshield
X$339 \$79__t169 topn__t338 cap_mim_2f0_m4m5_noshield c_length=4U c_width=4U
* device instance $340 r0 *1 294.4,70.6 cap_mim_2f0_m4m5_noshield
X$340 \$84__t12 topn__t385 cap_mim_2f0_m4m5_noshield c_length=4U c_width=4U
* device instance $341 r0 *1 300.8,70.6 cap_mim_2f0_m4m5_noshield
X$341 \$79__t199 topn__t400 cap_mim_2f0_m4m5_noshield c_length=4U c_width=4U
* device instance $342 r0 *1 307.2,70.6 cap_mim_2f0_m4m5_noshield
X$342 \$84__t7 topn__t211 cap_mim_2f0_m4m5_noshield c_length=4U c_width=4U
* device instance $343 r0 *1 313.6,70.6 cap_mim_2f0_m4m5_noshield
X$343 \$79__t176 topn__t352 cap_mim_2f0_m4m5_noshield c_length=4U c_width=4U
* device instance $344 r0 *1 320,70.6 cap_mim_2f0_m4m5_noshield
X$344 \$84__t10 topn__t351 cap_mim_2f0_m4m5_noshield c_length=4U c_width=4U
* device instance $345 r0 *1 326.4,70.6 cap_mim_2f0_m4m5_noshield
X$345 \$79__t175 topn__t350 cap_mim_2f0_m4m5_noshield c_length=4U c_width=4U
* device instance $346 r0 *1 332.8,70.6 cap_mim_2f0_m4m5_noshield
X$346 \$83__t22 topn__t349 cap_mim_2f0_m4m5_noshield c_length=4U c_width=4U
* device instance $347 r0 *1 339.2,70.6 cap_mim_2f0_m4m5_noshield
X$347 \$79__t174 topn__t348 cap_mim_2f0_m4m5_noshield c_length=4U c_width=4U
* device instance $348 r0 *1 345.6,70.6 cap_mim_2f0_m4m5_noshield
X$348 \$83__t21 topn__t347 cap_mim_2f0_m4m5_noshield c_length=4U c_width=4U
* device instance $349 r0 *1 352,70.6 cap_mim_2f0_m4m5_noshield
X$349 \$79__t137 topn__t277 cap_mim_2f0_m4m5_noshield c_length=4U c_width=4U
* device instance $350 r0 *1 358.4,70.6 cap_mim_2f0_m4m5_noshield
X$350 \$83__t15 topn__t214 cap_mim_2f0_m4m5_noshield c_length=4U c_width=4U
* device instance $351 r0 *1 364.8,70.6 cap_mim_2f0_m4m5_noshield
X$351 \$79__t113 topn__t230 cap_mim_2f0_m4m5_noshield c_length=4U c_width=4U
* device instance $352 r0 *1 371.2,70.6 cap_mim_2f0_m4m5_noshield
X$352 \$83__t19 topn__t229 cap_mim_2f0_m4m5_noshield c_length=4U c_width=4U
* device instance $353 r0 *1 377.6,70.6 cap_mim_2f0_m4m5_noshield
X$353 \$79__t112 topn__t228 cap_mim_2f0_m4m5_noshield c_length=4U c_width=4U
* device instance $354 r0 *1 384,70.6 cap_mim_2f0_m4m5_noshield
X$354 \$83__t18 topn__t227 cap_mim_2f0_m4m5_noshield c_length=4U c_width=4U
* device instance $355 r0 *1 390.4,70.6 cap_mim_2f0_m4m5_noshield
X$355 \$79__t111 topn__t226 cap_mim_2f0_m4m5_noshield c_length=4U c_width=4U
* device instance $356 r0 *1 396.8,70.6 cap_mim_2f0_m4m5_noshield
X$356 \$83__t20 topn__t241 cap_mim_2f0_m4m5_noshield c_length=4U c_width=4U
* device instance $357 r0 *1 403.2,70.6 cap_mim_2f0_m4m5_noshield
X$357 \$79__t109 topn__t224 cap_mim_2f0_m4m5_noshield c_length=4U c_width=4U
* device instance $358 r0 *1 409.6,70.6 cap_mim_2f0_m4m5_noshield
X$358 \$83__t17 topn__t218 cap_mim_2f0_m4m5_noshield c_length=4U c_width=4U
* device instance $359 r0 *1 416,70.6 cap_mim_2f0_m4m5_noshield
X$359 \$79__t105 topn__t216 cap_mim_2f0_m4m5_noshield c_length=4U c_width=4U
* device instance $360 r0 *1 422.4,70.6 cap_mim_2f0_m4m5_noshield
X$360 \$83__t16 topn__t215 cap_mim_2f0_m4m5_noshield c_length=4U c_width=4U
* device instance $361 r0 *1 2.6,77 cap_mim_2f0_m4m5_noshield
X$361 \$10__t229 topp__t456 cap_mim_2f0_m4m5_noshield c_length=4U c_width=4U
* device instance $362 r0 *1 9,77 cap_mim_2f0_m4m5_noshield
X$362 \$30__t50 topp__t455 cap_mim_2f0_m4m5_noshield c_length=4U c_width=4U
* device instance $363 r0 *1 15.4,77 cap_mim_2f0_m4m5_noshield
X$363 \$10__t228 topp__t454 cap_mim_2f0_m4m5_noshield c_length=4U c_width=4U
* device instance $364 r0 *1 21.8,77 cap_mim_2f0_m4m5_noshield
X$364 \$30__t49 topp__t453 cap_mim_2f0_m4m5_noshield c_length=4U c_width=4U
* device instance $365 r0 *1 28.2,77 cap_mim_2f0_m4m5_noshield
X$365 \$10__t227 topp__t452 cap_mim_2f0_m4m5_noshield c_length=4U c_width=4U
* device instance $366 r0 *1 34.6,77 cap_mim_2f0_m4m5_noshield
X$366 \$30__t48 topp__t451 cap_mim_2f0_m4m5_noshield c_length=4U c_width=4U
* device instance $367 r0 *1 41,77 cap_mim_2f0_m4m5_noshield
X$367 \$10__t250 topp__t498 cap_mim_2f0_m4m5_noshield c_length=4U c_width=4U
* device instance $368 r0 *1 47.4,77 cap_mim_2f0_m4m5_noshield
X$368 \$30__t58 topp__t499 cap_mim_2f0_m4m5_noshield c_length=4U c_width=4U
* device instance $369 r0 *1 53.8,77 cap_mim_2f0_m4m5_noshield
X$369 \$10__t251 topp__t500 cap_mim_2f0_m4m5_noshield c_length=4U c_width=4U
* device instance $370 r0 *1 60.2,77 cap_mim_2f0_m4m5_noshield
X$370 \$30__t59 topp__t501 cap_mim_2f0_m4m5_noshield c_length=4U c_width=4U
* device instance $371 r0 *1 66.6,77 cap_mim_2f0_m4m5_noshield
X$371 \$10__t252 topp__t502 cap_mim_2f0_m4m5_noshield c_length=4U c_width=4U
* device instance $372 r0 *1 73,77 cap_mim_2f0_m4m5_noshield
X$372 \$30__t60 topp__t503 cap_mim_2f0_m4m5_noshield c_length=4U c_width=4U
* device instance $373 r0 *1 79.4,77 cap_mim_2f0_m4m5_noshield
X$373 \$10__t253 topp__t504 cap_mim_2f0_m4m5_noshield c_length=4U c_width=4U
* device instance $374 r0 *1 85.8,77 cap_mim_2f0_m4m5_noshield
X$374 \$30__t61 topp__t505 cap_mim_2f0_m4m5_noshield c_length=4U c_width=4U
* device instance $375 r0 *1 92.2,77 cap_mim_2f0_m4m5_noshield
X$375 \$10__t254 topp__t506 cap_mim_2f0_m4m5_noshield c_length=4U c_width=4U
* device instance $376 r0 *1 98.6,77 cap_mim_2f0_m4m5_noshield
X$376 \$30__t62 topp__t507 cap_mim_2f0_m4m5_noshield c_length=4U c_width=4U
* device instance $377 r0 *1 105,77 cap_mim_2f0_m4m5_noshield
X$377 \$10__t255 topp__t508 cap_mim_2f0_m4m5_noshield c_length=4U c_width=4U
* device instance $378 r0 *1 111.4,77 cap_mim_2f0_m4m5_noshield
X$378 \$30__t63 topp__t509 cap_mim_2f0_m4m5_noshield c_length=4U c_width=4U
* device instance $379 r0 *1 117.8,77 cap_mim_2f0_m4m5_noshield
X$379 \$10__t197 topp__t391 cap_mim_2f0_m4m5_noshield c_length=4U c_width=4U
* device instance $380 r0 *1 124.2,77 cap_mim_2f0_m4m5_noshield
X$380 \$30__t56 topp__t475 cap_mim_2f0_m4m5_noshield c_length=4U c_width=4U
* device instance $381 r0 *1 130.6,77 cap_mim_2f0_m4m5_noshield
X$381 \$10__t239 topp__t474 cap_mim_2f0_m4m5_noshield c_length=4U c_width=4U
* device instance $382 r0 *1 137,77 cap_mim_2f0_m4m5_noshield
X$382 \$30__t55 topp__t473 cap_mim_2f0_m4m5_noshield c_length=4U c_width=4U
* device instance $383 r0 *1 143.4,77 cap_mim_2f0_m4m5_noshield
X$383 \$10__t238 topp__t472 cap_mim_2f0_m4m5_noshield c_length=4U c_width=4U
* device instance $384 r0 *1 149.8,77 cap_mim_2f0_m4m5_noshield
X$384 \$30__t57 topp__t481 cap_mim_2f0_m4m5_noshield c_length=4U c_width=4U
* device instance $385 r0 *1 156.2,77 cap_mim_2f0_m4m5_noshield
X$385 \$10__t237 topp__t470 cap_mim_2f0_m4m5_noshield c_length=4U c_width=4U
* device instance $386 r0 *1 162.6,77 cap_mim_2f0_m4m5_noshield
X$386 \$30__t54 topp__t469 cap_mim_2f0_m4m5_noshield c_length=4U c_width=4U
* device instance $387 r0 *1 169,77 cap_mim_2f0_m4m5_noshield
X$387 \$10__t236 topp__t468 cap_mim_2f0_m4m5_noshield c_length=4U c_width=4U
* device instance $388 r0 *1 175.4,77 cap_mim_2f0_m4m5_noshield
X$388 \$30__t53 topp__t467 cap_mim_2f0_m4m5_noshield c_length=4U c_width=4U
* device instance $389 r0 *1 181.8,77 cap_mim_2f0_m4m5_noshield
X$389 \$10__t235 topp__t466 cap_mim_2f0_m4m5_noshield c_length=4U c_width=4U
* device instance $390 r0 *1 188.2,77 cap_mim_2f0_m4m5_noshield
X$390 \$30__t52 topp__t465 cap_mim_2f0_m4m5_noshield c_length=4U c_width=4U
* device instance $391 r0 *1 194.6,77 cap_mim_2f0_m4m5_noshield
X$391 \$10__t234 topp__t464 cap_mim_2f0_m4m5_noshield c_length=4U c_width=4U
* device instance $392 r0 *1 201,77 cap_mim_2f0_m4m5_noshield
X$392 \$30__t51 topp__t463 cap_mim_2f0_m4m5_noshield c_length=4U c_width=4U
* device instance $393 r0 *1 224,77 cap_mim_2f0_m4m5_noshield
X$393 \$79__t251 topn__t504 cap_mim_2f0_m4m5_noshield c_length=4U c_width=4U
* device instance $394 r0 *1 230.4,77 cap_mim_2f0_m4m5_noshield
X$394 \$82__t63 topn__t503 cap_mim_2f0_m4m5_noshield c_length=4U c_width=4U
* device instance $395 r0 *1 236.8,77 cap_mim_2f0_m4m5_noshield
X$395 \$79__t103 topn__t210 cap_mim_2f0_m4m5_noshield c_length=4U c_width=4U
* device instance $396 r0 *1 243.2,77 cap_mim_2f0_m4m5_noshield
X$396 \$82__t31 topn__t321 cap_mim_2f0_m4m5_noshield c_length=4U c_width=4U
* device instance $397 r0 *1 249.6,77 cap_mim_2f0_m4m5_noshield
X$397 \$79__t184 topn__t368 cap_mim_2f0_m4m5_noshield c_length=4U c_width=4U
* device instance $398 r0 *1 256,77 cap_mim_2f0_m4m5_noshield
X$398 \$82__t38 topn__t367 cap_mim_2f0_m4m5_noshield c_length=4U c_width=4U
* device instance $399 r0 *1 262.4,77 cap_mim_2f0_m4m5_noshield
X$399 \$79__t183 topn__t366 cap_mim_2f0_m4m5_noshield c_length=4U c_width=4U
* device instance $400 r0 *1 268.8,77 cap_mim_2f0_m4m5_noshield
X$400 \$82__t37 topn__t365 cap_mim_2f0_m4m5_noshield c_length=4U c_width=4U
* device instance $401 r0 *1 275.2,77 cap_mim_2f0_m4m5_noshield
X$401 \$79__t182 topn__t364 cap_mim_2f0_m4m5_noshield c_length=4U c_width=4U
* device instance $402 r0 *1 281.6,77 cap_mim_2f0_m4m5_noshield
X$402 \$82__t36 topn__t363 cap_mim_2f0_m4m5_noshield c_length=4U c_width=4U
* device instance $403 r0 *1 288,77 cap_mim_2f0_m4m5_noshield
X$403 \$79__t181 topn__t362 cap_mim_2f0_m4m5_noshield c_length=4U c_width=4U
* device instance $404 r0 *1 294.4,77 cap_mim_2f0_m4m5_noshield
X$404 \$82__t35 topn__t361 cap_mim_2f0_m4m5_noshield c_length=4U c_width=4U
* device instance $405 r0 *1 300.8,77 cap_mim_2f0_m4m5_noshield
X$405 \$79__t180 topn__t360 cap_mim_2f0_m4m5_noshield c_length=4U c_width=4U
* device instance $406 r0 *1 307.2,77 cap_mim_2f0_m4m5_noshield
X$406 \$82__t34 topn__t359 cap_mim_2f0_m4m5_noshield c_length=4U c_width=4U
* device instance $407 r0 *1 313.6,77 cap_mim_2f0_m4m5_noshield
X$407 \$79__t179 topn__t358 cap_mim_2f0_m4m5_noshield c_length=4U c_width=4U
* device instance $408 r0 *1 320,77 cap_mim_2f0_m4m5_noshield
X$408 \$82__t33 topn__t357 cap_mim_2f0_m4m5_noshield c_length=4U c_width=4U
* device instance $409 r0 *1 326.4,77 cap_mim_2f0_m4m5_noshield
X$409 \$79__t178 topn__t356 cap_mim_2f0_m4m5_noshield c_length=4U c_width=4U
* device instance $410 r0 *1 332.8,77 cap_mim_2f0_m4m5_noshield
X$410 \$82__t32 topn__t355 cap_mim_2f0_m4m5_noshield c_length=4U c_width=4U
* device instance $411 r0 *1 339.2,77 cap_mim_2f0_m4m5_noshield
X$411 \$79__t177 topn__t354 cap_mim_2f0_m4m5_noshield c_length=4U c_width=4U
* device instance $412 r0 *1 345.6,77 cap_mim_2f0_m4m5_noshield
X$412 \$82__t39 topn__t369 cap_mim_2f0_m4m5_noshield c_length=4U c_width=4U
* device instance $413 r0 *1 352,77 cap_mim_2f0_m4m5_noshield
X$413 \$79__t136 topn__t276 cap_mim_2f0_m4m5_noshield c_length=4U c_width=4U
* device instance $414 r0 *1 358.4,77 cap_mim_2f0_m4m5_noshield
X$414 \$82__t17 topn__t213 cap_mim_2f0_m4m5_noshield c_length=4U c_width=4U
* device instance $415 r0 *1 364.8,77 cap_mim_2f0_m4m5_noshield
X$415 \$79__t104 topn__t212 cap_mim_2f0_m4m5_noshield c_length=4U c_width=4U
* device instance $416 r0 *1 371.2,77 cap_mim_2f0_m4m5_noshield
X$416 \$82__t25 topn__t239 cap_mim_2f0_m4m5_noshield c_length=4U c_width=4U
* device instance $417 r0 *1 377.6,77 cap_mim_2f0_m4m5_noshield
X$417 \$79__t117 topn__t238 cap_mim_2f0_m4m5_noshield c_length=4U c_width=4U
* device instance $418 r0 *1 384,77 cap_mim_2f0_m4m5_noshield
X$418 \$82__t24 topn__t237 cap_mim_2f0_m4m5_noshield c_length=4U c_width=4U
* device instance $419 r0 *1 390.4,77 cap_mim_2f0_m4m5_noshield
X$419 \$79__t116 topn__t236 cap_mim_2f0_m4m5_noshield c_length=4U c_width=4U
* device instance $420 r0 *1 396.8,77 cap_mim_2f0_m4m5_noshield
X$420 \$82__t23 topn__t235 cap_mim_2f0_m4m5_noshield c_length=4U c_width=4U
* device instance $421 r0 *1 403.2,77 cap_mim_2f0_m4m5_noshield
X$421 \$79__t115 topn__t234 cap_mim_2f0_m4m5_noshield c_length=4U c_width=4U
* device instance $422 r0 *1 409.6,77 cap_mim_2f0_m4m5_noshield
X$422 \$82__t22 topn__t233 cap_mim_2f0_m4m5_noshield c_length=4U c_width=4U
* device instance $423 r0 *1 416,77 cap_mim_2f0_m4m5_noshield
X$423 \$79__t114 topn__t232 cap_mim_2f0_m4m5_noshield c_length=4U c_width=4U
* device instance $424 r0 *1 422.4,77 cap_mim_2f0_m4m5_noshield
X$424 \$82__t21 topn__t231 cap_mim_2f0_m4m5_noshield c_length=4U c_width=4U
* device instance $425 r0 *1 2.6,83.4 cap_mim_2f0_m4m5_noshield
X$425 \$10__t168 topp__t335 cap_mim_2f0_m4m5_noshield c_length=4U c_width=4U
* device instance $426 r0 *1 9,83.4 cap_mim_2f0_m4m5_noshield
X$426 \$22__t91 topp__t336 cap_mim_2f0_m4m5_noshield c_length=4U c_width=4U
* device instance $427 r0 *1 15.4,83.4 cap_mim_2f0_m4m5_noshield
X$427 \$10__t169 topp__t337 cap_mim_2f0_m4m5_noshield c_length=4U c_width=4U
* device instance $428 r0 *1 21.8,83.4 cap_mim_2f0_m4m5_noshield
X$428 \$22__t92 topp__t338 cap_mim_2f0_m4m5_noshield c_length=4U c_width=4U
* device instance $429 r0 *1 28.2,83.4 cap_mim_2f0_m4m5_noshield
X$429 \$10__t170 topp__t339 cap_mim_2f0_m4m5_noshield c_length=4U c_width=4U
* device instance $430 r0 *1 34.6,83.4 cap_mim_2f0_m4m5_noshield
X$430 \$22__t93 topp__t340 cap_mim_2f0_m4m5_noshield c_length=4U c_width=4U
* device instance $431 r0 *1 41,83.4 cap_mim_2f0_m4m5_noshield
X$431 \$10__t171 topp__t341 cap_mim_2f0_m4m5_noshield c_length=4U c_width=4U
* device instance $432 r0 *1 47.4,83.4 cap_mim_2f0_m4m5_noshield
X$432 \$22__t94 topp__t342 cap_mim_2f0_m4m5_noshield c_length=4U c_width=4U
* device instance $433 r0 *1 53.8,83.4 cap_mim_2f0_m4m5_noshield
X$433 \$10__t172 topp__t343 cap_mim_2f0_m4m5_noshield c_length=4U c_width=4U
* device instance $434 r0 *1 60.2,83.4 cap_mim_2f0_m4m5_noshield
X$434 \$22__t95 topp__t344 cap_mim_2f0_m4m5_noshield c_length=4U c_width=4U
* device instance $435 r0 *1 66.6,83.4 cap_mim_2f0_m4m5_noshield
X$435 \$10__t173 topp__t345 cap_mim_2f0_m4m5_noshield c_length=4U c_width=4U
* device instance $436 r0 *1 73,83.4 cap_mim_2f0_m4m5_noshield
X$436 \$22__t96 topp__t346 cap_mim_2f0_m4m5_noshield c_length=4U c_width=4U
* device instance $437 r0 *1 79.4,83.4 cap_mim_2f0_m4m5_noshield
X$437 \$10__t174 topp__t347 cap_mim_2f0_m4m5_noshield c_length=4U c_width=4U
* device instance $438 r0 *1 85.8,83.4 cap_mim_2f0_m4m5_noshield
X$438 \$22__t97 topp__t348 cap_mim_2f0_m4m5_noshield c_length=4U c_width=4U
* device instance $439 r0 *1 92.2,83.4 cap_mim_2f0_m4m5_noshield
X$439 \$10__t175 topp__t349 cap_mim_2f0_m4m5_noshield c_length=4U c_width=4U
* device instance $440 r0 *1 98.6,83.4 cap_mim_2f0_m4m5_noshield
X$440 \$22__t106 topp__t366 cap_mim_2f0_m4m5_noshield c_length=4U c_width=4U
* device instance $441 r0 *1 105,83.4 cap_mim_2f0_m4m5_noshield
X$441 \$10__t176 topp__t351 cap_mim_2f0_m4m5_noshield c_length=4U c_width=4U
* device instance $442 r0 *1 111.4,83.4 cap_mim_2f0_m4m5_noshield
X$442 \$22__t99 topp__t352 cap_mim_2f0_m4m5_noshield c_length=4U c_width=4U
* device instance $443 r0 *1 117.8,83.4 cap_mim_2f0_m4m5_noshield
X$443 \$10__t177 topp__t353 cap_mim_2f0_m4m5_noshield c_length=4U c_width=4U
* device instance $444 r0 *1 124.2,83.4 cap_mim_2f0_m4m5_noshield
X$444 \$22__t100 topp__t354 cap_mim_2f0_m4m5_noshield c_length=4U c_width=4U
* device instance $445 r0 *1 130.6,83.4 cap_mim_2f0_m4m5_noshield
X$445 \$10__t178 topp__t355 cap_mim_2f0_m4m5_noshield c_length=4U c_width=4U
* device instance $446 r0 *1 137,83.4 cap_mim_2f0_m4m5_noshield
X$446 \$22__t101 topp__t356 cap_mim_2f0_m4m5_noshield c_length=4U c_width=4U
* device instance $447 r0 *1 143.4,83.4 cap_mim_2f0_m4m5_noshield
X$447 \$10__t179 topp__t357 cap_mim_2f0_m4m5_noshield c_length=4U c_width=4U
* device instance $448 r0 *1 149.8,83.4 cap_mim_2f0_m4m5_noshield
X$448 \$22__t102 topp__t358 cap_mim_2f0_m4m5_noshield c_length=4U c_width=4U
* device instance $449 r0 *1 156.2,83.4 cap_mim_2f0_m4m5_noshield
X$449 \$10__t180 topp__t359 cap_mim_2f0_m4m5_noshield c_length=4U c_width=4U
* device instance $450 r0 *1 162.6,83.4 cap_mim_2f0_m4m5_noshield
X$450 \$22__t103 topp__t360 cap_mim_2f0_m4m5_noshield c_length=4U c_width=4U
* device instance $451 r0 *1 169,83.4 cap_mim_2f0_m4m5_noshield
X$451 \$10__t181 topp__t361 cap_mim_2f0_m4m5_noshield c_length=4U c_width=4U
* device instance $452 r0 *1 175.4,83.4 cap_mim_2f0_m4m5_noshield
X$452 \$22__t104 topp__t362 cap_mim_2f0_m4m5_noshield c_length=4U c_width=4U
* device instance $453 r0 *1 181.8,83.4 cap_mim_2f0_m4m5_noshield
X$453 \$10__t182 topp__t363 cap_mim_2f0_m4m5_noshield c_length=4U c_width=4U
* device instance $454 r0 *1 188.2,83.4 cap_mim_2f0_m4m5_noshield
X$454 \$22__t105 topp__t364 cap_mim_2f0_m4m5_noshield c_length=4U c_width=4U
* device instance $455 r0 *1 194.6,83.4 cap_mim_2f0_m4m5_noshield
X$455 \$10__t183 topp__t365 cap_mim_2f0_m4m5_noshield c_length=4U c_width=4U
* device instance $456 r0 *1 201,83.4 cap_mim_2f0_m4m5_noshield
X$456 \$22__t98 topp__t350 cap_mim_2f0_m4m5_noshield c_length=4U c_width=4U
* device instance $457 r0 *1 224,83.4 cap_mim_2f0_m4m5_noshield
X$457 \$79__t153 topn__t306 cap_mim_2f0_m4m5_noshield c_length=4U c_width=4U
* device instance $458 r0 *1 230.4,83.4 cap_mim_2f0_m4m5_noshield
X$458 \$81__t81 topn__t307 cap_mim_2f0_m4m5_noshield c_length=4U c_width=4U
* device instance $459 r0 *1 236.8,83.4 cap_mim_2f0_m4m5_noshield
X$459 \$79__t154 topn__t308 cap_mim_2f0_m4m5_noshield c_length=4U c_width=4U
* device instance $460 r0 *1 243.2,83.4 cap_mim_2f0_m4m5_noshield
X$460 \$81__t82 topn__t309 cap_mim_2f0_m4m5_noshield c_length=4U c_width=4U
* device instance $461 r0 *1 249.6,83.4 cap_mim_2f0_m4m5_noshield
X$461 \$79__t155 topn__t310 cap_mim_2f0_m4m5_noshield c_length=4U c_width=4U
* device instance $462 r0 *1 256,83.4 cap_mim_2f0_m4m5_noshield
X$462 \$81__t83 topn__t311 cap_mim_2f0_m4m5_noshield c_length=4U c_width=4U
* device instance $463 r0 *1 262.4,83.4 cap_mim_2f0_m4m5_noshield
X$463 \$79__t156 topn__t312 cap_mim_2f0_m4m5_noshield c_length=4U c_width=4U
* device instance $464 r0 *1 268.8,83.4 cap_mim_2f0_m4m5_noshield
X$464 \$81__t84 topn__t313 cap_mim_2f0_m4m5_noshield c_length=4U c_width=4U
* device instance $465 r0 *1 275.2,83.4 cap_mim_2f0_m4m5_noshield
X$465 \$79__t157 topn__t314 cap_mim_2f0_m4m5_noshield c_length=4U c_width=4U
* device instance $466 r0 *1 281.6,83.4 cap_mim_2f0_m4m5_noshield
X$466 \$81__t85 topn__t315 cap_mim_2f0_m4m5_noshield c_length=4U c_width=4U
* device instance $467 r0 *1 288,83.4 cap_mim_2f0_m4m5_noshield
X$467 \$79__t158 topn__t316 cap_mim_2f0_m4m5_noshield c_length=4U c_width=4U
* device instance $468 r0 *1 294.4,83.4 cap_mim_2f0_m4m5_noshield
X$468 \$81__t86 topn__t317 cap_mim_2f0_m4m5_noshield c_length=4U c_width=4U
* device instance $469 r0 *1 300.8,83.4 cap_mim_2f0_m4m5_noshield
X$469 \$79__t159 topn__t318 cap_mim_2f0_m4m5_noshield c_length=4U c_width=4U
* device instance $470 r0 *1 307.2,83.4 cap_mim_2f0_m4m5_noshield
X$470 \$81__t87 topn__t319 cap_mim_2f0_m4m5_noshield c_length=4U c_width=4U
* device instance $471 r0 *1 313.6,83.4 cap_mim_2f0_m4m5_noshield
X$471 \$79__t160 topn__t320 cap_mim_2f0_m4m5_noshield c_length=4U c_width=4U
* device instance $472 r0 *1 320,83.4 cap_mim_2f0_m4m5_noshield
X$472 \$81__t95 topn__t337 cap_mim_2f0_m4m5_noshield c_length=4U c_width=4U
* device instance $473 r0 *1 326.4,83.4 cap_mim_2f0_m4m5_noshield
X$473 \$79__t161 topn__t322 cap_mim_2f0_m4m5_noshield c_length=4U c_width=4U
* device instance $474 r0 *1 332.8,83.4 cap_mim_2f0_m4m5_noshield
X$474 \$81__t88 topn__t323 cap_mim_2f0_m4m5_noshield c_length=4U c_width=4U
* device instance $475 r0 *1 339.2,83.4 cap_mim_2f0_m4m5_noshield
X$475 \$79__t162 topn__t324 cap_mim_2f0_m4m5_noshield c_length=4U c_width=4U
* device instance $476 r0 *1 345.6,83.4 cap_mim_2f0_m4m5_noshield
X$476 \$81__t89 topn__t325 cap_mim_2f0_m4m5_noshield c_length=4U c_width=4U
* device instance $477 r0 *1 352,83.4 cap_mim_2f0_m4m5_noshield
X$477 \$79__t163 topn__t326 cap_mim_2f0_m4m5_noshield c_length=4U c_width=4U
* device instance $478 r0 *1 358.4,83.4 cap_mim_2f0_m4m5_noshield
X$478 \$81__t90 topn__t327 cap_mim_2f0_m4m5_noshield c_length=4U c_width=4U
* device instance $479 r0 *1 364.8,83.4 cap_mim_2f0_m4m5_noshield
X$479 \$79__t164 topn__t328 cap_mim_2f0_m4m5_noshield c_length=4U c_width=4U
* device instance $480 r0 *1 371.2,83.4 cap_mim_2f0_m4m5_noshield
X$480 \$81__t91 topn__t329 cap_mim_2f0_m4m5_noshield c_length=4U c_width=4U
* device instance $481 r0 *1 377.6,83.4 cap_mim_2f0_m4m5_noshield
X$481 \$79__t165 topn__t330 cap_mim_2f0_m4m5_noshield c_length=4U c_width=4U
* device instance $482 r0 *1 384,83.4 cap_mim_2f0_m4m5_noshield
X$482 \$81__t92 topn__t331 cap_mim_2f0_m4m5_noshield c_length=4U c_width=4U
* device instance $483 r0 *1 390.4,83.4 cap_mim_2f0_m4m5_noshield
X$483 \$79__t166 topn__t332 cap_mim_2f0_m4m5_noshield c_length=4U c_width=4U
* device instance $484 r0 *1 396.8,83.4 cap_mim_2f0_m4m5_noshield
X$484 \$81__t93 topn__t333 cap_mim_2f0_m4m5_noshield c_length=4U c_width=4U
* device instance $485 r0 *1 403.2,83.4 cap_mim_2f0_m4m5_noshield
X$485 \$79__t167 topn__t334 cap_mim_2f0_m4m5_noshield c_length=4U c_width=4U
* device instance $486 r0 *1 409.6,83.4 cap_mim_2f0_m4m5_noshield
X$486 \$81__t94 topn__t335 cap_mim_2f0_m4m5_noshield c_length=4U c_width=4U
* device instance $487 r0 *1 416,83.4 cap_mim_2f0_m4m5_noshield
X$487 \$79__t168 topn__t336 cap_mim_2f0_m4m5_noshield c_length=4U c_width=4U
* device instance $488 r0 *1 422.4,83.4 cap_mim_2f0_m4m5_noshield
X$488 \$81__t96 topn__t353 cap_mim_2f0_m4m5_noshield c_length=4U c_width=4U
* device instance $489 r0 *1 2.6,89.8 cap_mim_2f0_m4m5_noshield
X$489 \$10__t66 topp__t129 cap_mim_2f0_m4m5_noshield c_length=4U c_width=4U
* device instance $490 r0 *1 9,89.8 cap_mim_2f0_m4m5_noshield
X$490 \$22__t34 topp__t128 cap_mim_2f0_m4m5_noshield c_length=4U c_width=4U
* device instance $491 r0 *1 15.4,89.8 cap_mim_2f0_m4m5_noshield
X$491 \$10__t67 topp__t131 cap_mim_2f0_m4m5_noshield c_length=4U c_width=4U
* device instance $492 r0 *1 21.8,89.8 cap_mim_2f0_m4m5_noshield
X$492 \$22__t35 topp__t130 cap_mim_2f0_m4m5_noshield c_length=4U c_width=4U
* device instance $493 r0 *1 28.2,89.8 cap_mim_2f0_m4m5_noshield
X$493 \$10__t65 topp__t127 cap_mim_2f0_m4m5_noshield c_length=4U c_width=4U
* device instance $494 r0 *1 34.6,89.8 cap_mim_2f0_m4m5_noshield
X$494 \$22__t33 topp__t126 cap_mim_2f0_m4m5_noshield c_length=4U c_width=4U
* device instance $495 r0 *1 41,89.8 cap_mim_2f0_m4m5_noshield
X$495 \$10__t92 topp__t182 cap_mim_2f0_m4m5_noshield c_length=4U c_width=4U
* device instance $496 r0 *1 47.4,89.8 cap_mim_2f0_m4m5_noshield
X$496 \$22__t36 topp__t133 cap_mim_2f0_m4m5_noshield c_length=4U c_width=4U
* device instance $497 r0 *1 53.8,89.8 cap_mim_2f0_m4m5_noshield
X$497 \$10__t68 topp__t132 cap_mim_2f0_m4m5_noshield c_length=4U c_width=4U
* device instance $498 r0 *1 60.2,89.8 cap_mim_2f0_m4m5_noshield
X$498 \$22__t53 topp__t190 cap_mim_2f0_m4m5_noshield c_length=4U c_width=4U
* device instance $499 r0 *1 66.6,89.8 cap_mim_2f0_m4m5_noshield
X$499 \$10__t87 topp__t170 cap_mim_2f0_m4m5_noshield c_length=4U c_width=4U
* device instance $500 r0 *1 73,89.8 cap_mim_2f0_m4m5_noshield
X$500 \$22__t42 topp__t164 cap_mim_2f0_m4m5_noshield c_length=4U c_width=4U
* device instance $501 r0 *1 79.4,89.8 cap_mim_2f0_m4m5_noshield
X$501 \$10__t81 topp__t158 cap_mim_2f0_m4m5_noshield c_length=4U c_width=4U
* device instance $502 r0 *1 85.8,89.8 cap_mim_2f0_m4m5_noshield
X$502 \$22__t46 topp__t171 cap_mim_2f0_m4m5_noshield c_length=4U c_width=4U
* device instance $503 r0 *1 92.2,89.8 cap_mim_2f0_m4m5_noshield
X$503 \$10__t84 topp__t163 cap_mim_2f0_m4m5_noshield c_length=4U c_width=4U
* device instance $504 r0 *1 98.6,89.8 cap_mim_2f0_m4m5_noshield
X$504 \$22__t41 topp__t162 cap_mim_2f0_m4m5_noshield c_length=4U c_width=4U
* device instance $505 r0 *1 105,89.8 cap_mim_2f0_m4m5_noshield
X$505 \$10__t83 topp__t161 cap_mim_2f0_m4m5_noshield c_length=4U c_width=4U
* device instance $506 r0 *1 111.4,89.8 cap_mim_2f0_m4m5_noshield
X$506 \$22__t40 topp__t160 cap_mim_2f0_m4m5_noshield c_length=4U c_width=4U
* device instance $507 r0 *1 117.8,89.8 cap_mim_2f0_m4m5_noshield
X$507 \$10__t136 topp__t273 cap_mim_2f0_m4m5_noshield c_length=4U c_width=4U
* device instance $508 r0 *1 124.2,89.8 cap_mim_2f0_m4m5_noshield
X$508 \$22__t117 topp__t414 cap_mim_2f0_m4m5_noshield c_length=4U c_width=4U
* device instance $509 r0 *1 130.6,89.8 cap_mim_2f0_m4m5_noshield
X$509 \$10__t199 topp__t394 cap_mim_2f0_m4m5_noshield c_length=4U c_width=4U
* device instance $510 r0 *1 137,89.8 cap_mim_2f0_m4m5_noshield
X$510 \$22__t112 topp__t393 cap_mim_2f0_m4m5_noshield c_length=4U c_width=4U
* device instance $511 r0 *1 143.4,89.8 cap_mim_2f0_m4m5_noshield
X$511 \$10__t218 topp__t433 cap_mim_2f0_m4m5_noshield c_length=4U c_width=4U
* device instance $512 r0 *1 149.8,89.8 cap_mim_2f0_m4m5_noshield
X$512 \$22__t126 topp__t445 cap_mim_2f0_m4m5_noshield c_length=4U c_width=4U
* device instance $513 r0 *1 156.2,89.8 cap_mim_2f0_m4m5_noshield
X$513 \$10__t223 topp__t444 cap_mim_2f0_m4m5_noshield c_length=4U c_width=4U
* device instance $514 r0 *1 162.6,89.8 cap_mim_2f0_m4m5_noshield
X$514 \$22__t125 topp__t443 cap_mim_2f0_m4m5_noshield c_length=4U c_width=4U
* device instance $515 r0 *1 169,89.8 cap_mim_2f0_m4m5_noshield
X$515 \$10__t194 topp__t386 cap_mim_2f0_m4m5_noshield c_length=4U c_width=4U
* device instance $516 r0 *1 175.4,89.8 cap_mim_2f0_m4m5_noshield
X$516 \$22__t109 topp__t385 cap_mim_2f0_m4m5_noshield c_length=4U c_width=4U
* device instance $517 r0 *1 181.8,89.8 cap_mim_2f0_m4m5_noshield
X$517 \$10__t193 topp__t384 cap_mim_2f0_m4m5_noshield c_length=4U c_width=4U
* device instance $518 r0 *1 188.2,89.8 cap_mim_2f0_m4m5_noshield
X$518 \$22__t108 topp__t383 cap_mim_2f0_m4m5_noshield c_length=4U c_width=4U
* device instance $519 r0 *1 194.6,89.8 cap_mim_2f0_m4m5_noshield
X$519 \$10__t192 topp__t382 cap_mim_2f0_m4m5_noshield c_length=4U c_width=4U
* device instance $520 r0 *1 201,89.8 cap_mim_2f0_m4m5_noshield
X$520 \$22__t107 topp__t381 cap_mim_2f0_m4m5_noshield c_length=4U c_width=4U
* device instance $521 r0 *1 224,89.8 cap_mim_2f0_m4m5_noshield
X$521 \$79__t202 topn__t406 cap_mim_2f0_m4m5_noshield c_length=4U c_width=4U
* device instance $522 r0 *1 230.4,89.8 cap_mim_2f0_m4m5_noshield
X$522 \$81__t99 topn__t405 cap_mim_2f0_m4m5_noshield c_length=4U c_width=4U
* device instance $523 r0 *1 236.8,89.8 cap_mim_2f0_m4m5_noshield
X$523 \$79__t56 topn__t115 cap_mim_2f0_m4m5_noshield c_length=4U c_width=4U
* device instance $524 r0 *1 243.2,89.8 cap_mim_2f0_m4m5_noshield
X$524 \$81__t29 topn__t87 cap_mim_2f0_m4m5_noshield c_length=4U c_width=4U
* device instance $525 r0 *1 249.6,89.8 cap_mim_2f0_m4m5_noshield
X$525 \$79__t58 topn__t118 cap_mim_2f0_m4m5_noshield c_length=4U c_width=4U
* device instance $526 r0 *1 256,89.8 cap_mim_2f0_m4m5_noshield
X$526 \$81__t14 topn__t34 cap_mim_2f0_m4m5_noshield c_length=4U c_width=4U
* device instance $527 r0 *1 262.4,89.8 cap_mim_2f0_m4m5_noshield
X$527 \$79__t51 topn__t106 cap_mim_2f0_m4m5_noshield c_length=4U c_width=4U
* device instance $528 r0 *1 268.8,89.8 cap_mim_2f0_m4m5_noshield
X$528 \$81__t35 topn__t116 cap_mim_2f0_m4m5_noshield c_length=4U c_width=4U
* device instance $529 r0 *1 275.2,89.8 cap_mim_2f0_m4m5_noshield
X$529 \$79__t50 topn__t104 cap_mim_2f0_m4m5_noshield c_length=4U c_width=4U
* device instance $530 r0 *1 281.6,89.8 cap_mim_2f0_m4m5_noshield
X$530 \$81__t36 topn__t135 cap_mim_2f0_m4m5_noshield c_length=4U c_width=4U
* device instance $531 r0 *1 288,89.8 cap_mim_2f0_m4m5_noshield
X$531 \$79__t57 topn__t117 cap_mim_2f0_m4m5_noshield c_length=4U c_width=4U
* device instance $532 r0 *1 294.4,89.8 cap_mim_2f0_m4m5_noshield
X$532 \$81__t112 topn__t433 cap_mim_2f0_m4m5_noshield c_length=4U c_width=4U
* device instance $533 r0 *1 300.8,89.8 cap_mim_2f0_m4m5_noshield
X$533 \$79__t11 topn__t23 cap_mim_2f0_m4m5_noshield c_length=4U c_width=4U
* device instance $534 r0 *1 307.2,89.8 cap_mim_2f0_m4m5_noshield
X$534 \$81__t8 topn__t22 cap_mim_2f0_m4m5_noshield c_length=4U c_width=4U
* device instance $535 r0 *1 313.6,89.8 cap_mim_2f0_m4m5_noshield
X$535 \$79__t10 topn__t21 cap_mim_2f0_m4m5_noshield c_length=4U c_width=4U
* device instance $536 r0 *1 320,89.8 cap_mim_2f0_m4m5_noshield
X$536 \$81__t10 topn__t27 cap_mim_2f0_m4m5_noshield c_length=4U c_width=4U
* device instance $537 r0 *1 326.4,89.8 cap_mim_2f0_m4m5_noshield
X$537 \$79__t13 topn__t26 cap_mim_2f0_m4m5_noshield c_length=4U c_width=4U
* device instance $538 r0 *1 332.8,89.8 cap_mim_2f0_m4m5_noshield
X$538 \$81__t9 topn__t25 cap_mim_2f0_m4m5_noshield c_length=4U c_width=4U
* device instance $539 r0 *1 339.2,89.8 cap_mim_2f0_m4m5_noshield
X$539 \$79__t12 topn__t24 cap_mim_2f0_m4m5_noshield c_length=4U c_width=4U
* device instance $540 r0 *1 345.6,89.8 cap_mim_2f0_m4m5_noshield
X$540 \$81__t17 topn__t39 cap_mim_2f0_m4m5_noshield c_length=4U c_width=4U
* device instance $541 r0 *1 352,89.8 cap_mim_2f0_m4m5_noshield
X$541 \$79__t185 topn__t370 cap_mim_2f0_m4m5_noshield c_length=4U c_width=4U
* device instance $542 r0 *1 358.4,89.8 cap_mim_2f0_m4m5_noshield
X$542 \$81__t19 topn__t43 cap_mim_2f0_m4m5_noshield c_length=4U c_width=4U
* device instance $543 r0 *1 364.8,89.8 cap_mim_2f0_m4m5_noshield
X$543 \$79__t20 topn__t42 cap_mim_2f0_m4m5_noshield c_length=4U c_width=4U
* device instance $544 r0 *1 371.2,89.8 cap_mim_2f0_m4m5_noshield
X$544 \$81__t18 topn__t41 cap_mim_2f0_m4m5_noshield c_length=4U c_width=4U
* device instance $545 r0 *1 377.6,89.8 cap_mim_2f0_m4m5_noshield
X$545 \$79__t19 topn__t40 cap_mim_2f0_m4m5_noshield c_length=4U c_width=4U
* device instance $546 r0 *1 384,89.8 cap_mim_2f0_m4m5_noshield
X$546 \$81__t37 topn__t136 cap_mim_2f0_m4m5_noshield c_length=4U c_width=4U
* device instance $547 r0 *1 390.4,89.8 cap_mim_2f0_m4m5_noshield
X$547 \$79__t84 topn__t170 cap_mim_2f0_m4m5_noshield c_length=4U c_width=4U
* device instance $548 r0 *1 396.8,89.8 cap_mim_2f0_m4m5_noshield
X$548 \$81__t43 topn__t169 cap_mim_2f0_m4m5_noshield c_length=4U c_width=4U
* device instance $549 r0 *1 403.2,89.8 cap_mim_2f0_m4m5_noshield
X$549 \$79__t83 topn__t168 cap_mim_2f0_m4m5_noshield c_length=4U c_width=4U
* device instance $550 r0 *1 409.6,89.8 cap_mim_2f0_m4m5_noshield
X$550 \$81__t22 topn__t57 cap_mim_2f0_m4m5_noshield c_length=4U c_width=4U
* device instance $551 r0 *1 416,89.8 cap_mim_2f0_m4m5_noshield
X$551 \$79__t26 topn__t56 cap_mim_2f0_m4m5_noshield c_length=4U c_width=4U
* device instance $552 r0 *1 422.4,89.8 cap_mim_2f0_m4m5_noshield
X$552 \$81__t20 topn__t44 cap_mim_2f0_m4m5_noshield c_length=4U c_width=4U
* device instance $553 r0 *1 2.6,96.2 cap_mim_2f0_m4m5_noshield
X$553 \$22__t0 topp__t181 cap_mim_2f0_m4m5_noshield c_length=4U c_width=4U
* device instance $554 r0 *1 9,96.2 cap_mim_2f0_m4m5_noshield
X$554 \$10__t91 topp__t180 cap_mim_2f0_m4m5_noshield c_length=4U c_width=4U
* device instance $555 r0 *1 15.4,96.2 cap_mim_2f0_m4m5_noshield
X$555 \$22__t51 topp__t179 cap_mim_2f0_m4m5_noshield c_length=4U c_width=4U
* device instance $556 r0 *1 21.8,96.2 cap_mim_2f0_m4m5_noshield
X$556 \$10__t90 topp__t178 cap_mim_2f0_m4m5_noshield c_length=4U c_width=4U
* device instance $557 r0 *1 28.2,96.2 cap_mim_2f0_m4m5_noshield
X$557 \$22__t50 topp__t177 cap_mim_2f0_m4m5_noshield c_length=4U c_width=4U
* device instance $558 r0 *1 34.6,96.2 cap_mim_2f0_m4m5_noshield
X$558 \$10__t89 topp__t176 cap_mim_2f0_m4m5_noshield c_length=4U c_width=4U
* device instance $559 r0 *1 41,96.2 cap_mim_2f0_m4m5_noshield
X$559 \$22__t49 topp__t175 cap_mim_2f0_m4m5_noshield c_length=4U c_width=4U
* device instance $560 r0 *1 47.4,96.2 cap_mim_2f0_m4m5_noshield
X$560 \$10__t88 topp__t174 cap_mim_2f0_m4m5_noshield c_length=4U c_width=4U
* device instance $561 r0 *1 53.8,96.2 cap_mim_2f0_m4m5_noshield
X$561 \$22__t48 topp__t173 cap_mim_2f0_m4m5_noshield c_length=4U c_width=4U
* device instance $562 r0 *1 60.2,96.2 cap_mim_2f0_m4m5_noshield
X$562 \$10__t94 topp__t186 cap_mim_2f0_m4m5_noshield c_length=4U c_width=4U
* device instance $563 r0 *1 66.6,96.2 cap_mim_2f0_m4m5_noshield
X$563 \$22__t39 topp__t157 cap_mim_2f0_m4m5_noshield c_length=4U c_width=4U
* device instance $564 r0 *1 73,96.2 cap_mim_2f0_m4m5_noshield
X$564 \$10__t80 topp__t156 cap_mim_2f0_m4m5_noshield c_length=4U c_width=4U
* device instance $565 r0 *1 79.4,96.2 cap_mim_2f0_m4m5_noshield
X$565 \$22__t38 topp__t155 cap_mim_2f0_m4m5_noshield c_length=4U c_width=4U
* device instance $566 r0 *1 85.8,96.2 cap_mim_2f0_m4m5_noshield
X$566 \$10__t79 topp__t154 cap_mim_2f0_m4m5_noshield c_length=4U c_width=4U
* device instance $567 r0 *1 92.2,96.2 cap_mim_2f0_m4m5_noshield
X$567 \$22__t43 topp__t165 cap_mim_2f0_m4m5_noshield c_length=4U c_width=4U
* device instance $568 r0 *1 98.6,96.2 cap_mim_2f0_m4m5_noshield
X$568 \$10__t82 topp__t159 cap_mim_2f0_m4m5_noshield c_length=4U c_width=4U
* device instance $569 r0 *1 105,96.2 cap_mim_2f0_m4m5_noshield
X$569 \$22__t52 topp__t183 cap_mim_2f0_m4m5_noshield c_length=4U c_width=4U
* device instance $570 r0 *1 111.4,96.2 cap_mim_2f0_m4m5_noshield
X$570 \$10__t85 topp__t166 cap_mim_2f0_m4m5_noshield c_length=4U c_width=4U
* device instance $571 r0 *1 117.8,96.2 cap_mim_2f0_m4m5_noshield
X$571 \$22__t90 topp__t308 cap_mim_2f0_m4m5_noshield c_length=4U c_width=4U
* device instance $572 r0 *1 124.2,96.2 cap_mim_2f0_m4m5_noshield
X$572 \$10__t208 topp__t415 cap_mim_2f0_m4m5_noshield c_length=4U c_width=4U
* device instance $573 r0 *1 130.6,96.2 cap_mim_2f0_m4m5_noshield
X$573 \$22__t124 topp__t442 cap_mim_2f0_m4m5_noshield c_length=4U c_width=4U
* device instance $574 r0 *1 137,96.2 cap_mim_2f0_m4m5_noshield
X$574 \$10__t222 topp__t441 cap_mim_2f0_m4m5_noshield c_length=4U c_width=4U
* device instance $575 r0 *1 143.4,96.2 cap_mim_2f0_m4m5_noshield
X$575 \$22__t123 topp__t440 cap_mim_2f0_m4m5_noshield c_length=4U c_width=4U
* device instance $576 r0 *1 149.8,96.2 cap_mim_2f0_m4m5_noshield
X$576 \$10__t191 topp__t380 cap_mim_2f0_m4m5_noshield c_length=4U c_width=4U
* device instance $577 r0 *1 156.2,96.2 cap_mim_2f0_m4m5_noshield
X$577 \$22__t111 topp__t390 cap_mim_2f0_m4m5_noshield c_length=4U c_width=4U
* device instance $578 r0 *1 162.6,96.2 cap_mim_2f0_m4m5_noshield
X$578 \$10__t190 topp__t379 cap_mim_2f0_m4m5_noshield c_length=4U c_width=4U
* device instance $579 r0 *1 169,96.2 cap_mim_2f0_m4m5_noshield
X$579 \$22__t122 topp__t426 cap_mim_2f0_m4m5_noshield c_length=4U c_width=4U
* device instance $580 r0 *1 175.4,96.2 cap_mim_2f0_m4m5_noshield
X$580 \$10__t214 topp__t425 cap_mim_2f0_m4m5_noshield c_length=4U c_width=4U
* device instance $581 r0 *1 181.8,96.2 cap_mim_2f0_m4m5_noshield
X$581 \$22__t121 topp__t424 cap_mim_2f0_m4m5_noshield c_length=4U c_width=4U
* device instance $582 r0 *1 188.2,96.2 cap_mim_2f0_m4m5_noshield
X$582 \$10__t213 topp__t423 cap_mim_2f0_m4m5_noshield c_length=4U c_width=4U
* device instance $583 r0 *1 194.6,96.2 cap_mim_2f0_m4m5_noshield
X$583 \$22__t120 topp__t422 cap_mim_2f0_m4m5_noshield c_length=4U c_width=4U
* device instance $584 r0 *1 201,96.2 cap_mim_2f0_m4m5_noshield
X$584 \$10__t212 topp__t421 cap_mim_2f0_m4m5_noshield c_length=4U c_width=4U
* device instance $585 r0 *1 224,96.2 cap_mim_2f0_m4m5_noshield
X$585 \$81__t113 topn__t444 cap_mim_2f0_m4m5_noshield c_length=4U c_width=4U
* device instance $586 r0 *1 230.4,96.2 cap_mim_2f0_m4m5_noshield
X$586 \$79__t203 topn__t407 cap_mim_2f0_m4m5_noshield c_length=4U c_width=4U
* device instance $587 r0 *1 236.8,96.2 cap_mim_2f0_m4m5_noshield
X$587 \$81__t34 topn__t114 cap_mim_2f0_m4m5_noshield c_length=4U c_width=4U
* device instance $588 r0 *1 243.2,96.2 cap_mim_2f0_m4m5_noshield
X$588 \$79__t55 topn__t113 cap_mim_2f0_m4m5_noshield c_length=4U c_width=4U
* device instance $589 r0 *1 249.6,96.2 cap_mim_2f0_m4m5_noshield
X$589 \$81__t33 topn__t112 cap_mim_2f0_m4m5_noshield c_length=4U c_width=4U
* device instance $590 r0 *1 256,96.2 cap_mim_2f0_m4m5_noshield
X$590 \$79__t54 topn__t111 cap_mim_2f0_m4m5_noshield c_length=4U c_width=4U
* device instance $591 r0 *1 262.4,96.2 cap_mim_2f0_m4m5_noshield
X$591 \$81__t32 topn__t110 cap_mim_2f0_m4m5_noshield c_length=4U c_width=4U
* device instance $592 r0 *1 268.8,96.2 cap_mim_2f0_m4m5_noshield
X$592 \$79__t53 topn__t109 cap_mim_2f0_m4m5_noshield c_length=4U c_width=4U
* device instance $593 r0 *1 275.2,96.2 cap_mim_2f0_m4m5_noshield
X$593 \$81__t31 topn__t108 cap_mim_2f0_m4m5_noshield c_length=4U c_width=4U
* device instance $594 r0 *1 281.6,96.2 cap_mim_2f0_m4m5_noshield
X$594 \$79__t52 topn__t107 cap_mim_2f0_m4m5_noshield c_length=4U c_width=4U
* device instance $595 r0 *1 288,96.2 cap_mim_2f0_m4m5_noshield
X$595 \$81__t30 topn__t105 cap_mim_2f0_m4m5_noshield c_length=4U c_width=4U
* device instance $596 r0 *1 294.4,96.2 cap_mim_2f0_m4m5_noshield
X$596 \$79__t217 topn__t434 cap_mim_2f0_m4m5_noshield c_length=4U c_width=4U
* device instance $597 r0 *1 300.8,96.2 cap_mim_2f0_m4m5_noshield
X$597 \$81__t7 topn__t20 cap_mim_2f0_m4m5_noshield c_length=4U c_width=4U
* device instance $598 r0 *1 307.2,96.2 cap_mim_2f0_m4m5_noshield
X$598 \$79__t9 topn__t19 cap_mim_2f0_m4m5_noshield c_length=4U c_width=4U
* device instance $599 r0 *1 313.6,96.2 cap_mim_2f0_m4m5_noshield
X$599 \$81__t6 topn__t18 cap_mim_2f0_m4m5_noshield c_length=4U c_width=4U
* device instance $600 r0 *1 320,96.2 cap_mim_2f0_m4m5_noshield
X$600 \$79__t4 topn__t9 cap_mim_2f0_m4m5_noshield c_length=4U c_width=4U
* device instance $601 r0 *1 326.4,96.2 cap_mim_2f0_m4m5_noshield
X$601 \$81__t21 topn__t55 cap_mim_2f0_m4m5_noshield c_length=4U c_width=4U
* device instance $602 r0 *1 332.8,96.2 cap_mim_2f0_m4m5_noshield
X$602 \$79__t33 topn__t70 cap_mim_2f0_m4m5_noshield c_length=4U c_width=4U
* device instance $603 r0 *1 339.2,96.2 cap_mim_2f0_m4m5_noshield
X$603 \$81__t28 topn__t69 cap_mim_2f0_m4m5_noshield c_length=4U c_width=4U
* device instance $604 r0 *1 345.6,96.2 cap_mim_2f0_m4m5_noshield
X$604 \$79__t14 topn__t28 cap_mim_2f0_m4m5_noshield c_length=4U c_width=4U
* device instance $605 r0 *1 352,96.2 cap_mim_2f0_m4m5_noshield
X$605 \$81__t97 topn__t371 cap_mim_2f0_m4m5_noshield c_length=4U c_width=4U
* device instance $606 r0 *1 358.4,96.2 cap_mim_2f0_m4m5_noshield
X$606 \$79__t82 topn__t167 cap_mim_2f0_m4m5_noshield c_length=4U c_width=4U
* device instance $607 r0 *1 364.8,96.2 cap_mim_2f0_m4m5_noshield
X$607 \$81__t42 topn__t166 cap_mim_2f0_m4m5_noshield c_length=4U c_width=4U
* device instance $608 r0 *1 371.2,96.2 cap_mim_2f0_m4m5_noshield
X$608 \$79__t81 topn__t165 cap_mim_2f0_m4m5_noshield c_length=4U c_width=4U
* device instance $609 r0 *1 377.6,96.2 cap_mim_2f0_m4m5_noshield
X$609 \$81__t41 topn__t164 cap_mim_2f0_m4m5_noshield c_length=4U c_width=4U
* device instance $610 r0 *1 384,96.2 cap_mim_2f0_m4m5_noshield
X$610 \$79__t80 topn__t163 cap_mim_2f0_m4m5_noshield c_length=4U c_width=4U
* device instance $611 r0 *1 390.4,96.2 cap_mim_2f0_m4m5_noshield
X$611 \$81__t40 topn__t141 cap_mim_2f0_m4m5_noshield c_length=4U c_width=4U
* device instance $612 r0 *1 396.8,96.2 cap_mim_2f0_m4m5_noshield
X$612 \$79__t86 topn__t174 cap_mim_2f0_m4m5_noshield c_length=4U c_width=4U
* device instance $613 r0 *1 403.2,96.2 cap_mim_2f0_m4m5_noshield
X$613 \$81__t44 topn__t175 cap_mim_2f0_m4m5_noshield c_length=4U c_width=4U
* device instance $614 r0 *1 409.6,96.2 cap_mim_2f0_m4m5_noshield
X$614 \$79__t28 topn__t60 cap_mim_2f0_m4m5_noshield c_length=4U c_width=4U
* device instance $615 r0 *1 416,96.2 cap_mim_2f0_m4m5_noshield
X$615 \$81__t23 topn__t59 cap_mim_2f0_m4m5_noshield c_length=4U c_width=4U
* device instance $616 r0 *1 422.4,96.2 cap_mim_2f0_m4m5_noshield
X$616 \$79__t27 topn__t58 cap_mim_2f0_m4m5_noshield c_length=4U c_width=4U
* device instance $617 r0 *1 2.6,102.6 cap_mim_2f0_m4m5_noshield
X$617 \$22__t47 topp__t172 cap_mim_2f0_m4m5_noshield c_length=4U c_width=4U
* device instance $618 r0 *1 9,102.6 cap_mim_2f0_m4m5_noshield
X$618 \$10__t69 topp__t134 cap_mim_2f0_m4m5_noshield c_length=4U c_width=4U
* device instance $619 r0 *1 15.4,102.6 cap_mim_2f0_m4m5_noshield
X$619 \$22__t32 topp__t125 cap_mim_2f0_m4m5_noshield c_length=4U c_width=4U
* device instance $620 r0 *1 21.8,102.6 cap_mim_2f0_m4m5_noshield
X$620 \$10__t64 topp__t124 cap_mim_2f0_m4m5_noshield c_length=4U c_width=4U
* device instance $621 r0 *1 28.2,102.6 cap_mim_2f0_m4m5_noshield
X$621 \$22__t31 topp__t123 cap_mim_2f0_m4m5_noshield c_length=4U c_width=4U
* device instance $622 r0 *1 34.6,102.6 cap_mim_2f0_m4m5_noshield
X$622 \$10__t63 topp__t122 cap_mim_2f0_m4m5_noshield c_length=4U c_width=4U
* device instance $623 r0 *1 41,102.6 cap_mim_2f0_m4m5_noshield
X$623 \$22__t30 topp__t121 cap_mim_2f0_m4m5_noshield c_length=4U c_width=4U
* device instance $624 r0 *1 47.4,102.6 cap_mim_2f0_m4m5_noshield
X$624 \$10__t62 topp__t120 cap_mim_2f0_m4m5_noshield c_length=4U c_width=4U
* device instance $625 r0 *1 53.8,102.6 cap_mim_2f0_m4m5_noshield
X$625 \$22__t44 topp__t167 cap_mim_2f0_m4m5_noshield c_length=4U c_width=4U
* device instance $626 r0 *1 60.2,102.6 cap_mim_2f0_m4m5_noshield
X$626 \$10__t95 topp__t187 cap_mim_2f0_m4m5_noshield c_length=4U c_width=4U
* device instance $627 r0 *1 66.6,102.6 cap_mim_2f0_m4m5_noshield
X$627 \$22__t45 topp__t169 cap_mim_2f0_m4m5_noshield c_length=4U c_width=4U
* device instance $628 r0 *1 73,102.6 cap_mim_2f0_m4m5_noshield
X$628 \$10__t86 topp__t168 cap_mim_2f0_m4m5_noshield c_length=4U c_width=4U
* device instance $629 r0 *1 79.4,102.6 cap_mim_2f0_m4m5_noshield
X$629 \$22__t37 topp__t153 cap_mim_2f0_m4m5_noshield c_length=4U c_width=4U
* device instance $630 r0 *1 85.8,102.6 cap_mim_2f0_m4m5_noshield
X$630 \$10__t78 topp__t152 cap_mim_2f0_m4m5_noshield c_length=4U c_width=4U
* device instance $631 r0 *1 92.2,102.6 cap_mim_2f0_m4m5_noshield
X$631 \$22__t119 topp__t419 cap_mim_2f0_m4m5_noshield c_length=4U c_width=4U
* device instance $632 r0 *1 98.6,102.6 cap_mim_2f0_m4m5_noshield
X$632 \$10__t230 topp__t457 cap_mim_2f0_m4m5_noshield c_length=4U c_width=4U
* device instance $633 r0 *1 105,102.6 cap_mim_2f0_m4m5_noshield
X$633 \$22__t118 topp__t418 cap_mim_2f0_m4m5_noshield c_length=4U c_width=4U
* device instance $634 r0 *1 111.4,102.6 cap_mim_2f0_m4m5_noshield
X$634 \$10__t210 topp__t417 cap_mim_2f0_m4m5_noshield c_length=4U c_width=4U
* device instance $635 r0 *1 117.8,102.6 cap_mim_2f0_m4m5_noshield
X$635 \$22__t74 topp__t271 cap_mim_2f0_m4m5_noshield c_length=4U c_width=4U
* device instance $636 r0 *1 124.2,102.6 cap_mim_2f0_m4m5_noshield
X$636 \$10__t225 topp__t448 cap_mim_2f0_m4m5_noshield c_length=4U c_width=4U
* device instance $637 r0 *1 130.6,102.6 cap_mim_2f0_m4m5_noshield
X$637 \$22__t127 topp__t447 cap_mim_2f0_m4m5_noshield c_length=4U c_width=4U
* device instance $638 r0 *1 137,102.6 cap_mim_2f0_m4m5_noshield
X$638 \$10__t224 topp__t446 cap_mim_2f0_m4m5_noshield c_length=4U c_width=4U
* device instance $639 r0 *1 143.4,102.6 cap_mim_2f0_m4m5_noshield
X$639 \$22__t115 topp__t400 cap_mim_2f0_m4m5_noshield c_length=4U c_width=4U
* device instance $640 r0 *1 149.8,102.6 cap_mim_2f0_m4m5_noshield
X$640 \$10__t202 topp__t399 cap_mim_2f0_m4m5_noshield c_length=4U c_width=4U
* device instance $641 r0 *1 156.2,102.6 cap_mim_2f0_m4m5_noshield
X$641 \$22__t114 topp__t398 cap_mim_2f0_m4m5_noshield c_length=4U c_width=4U
* device instance $642 r0 *1 162.6,102.6 cap_mim_2f0_m4m5_noshield
X$642 \$10__t201 topp__t397 cap_mim_2f0_m4m5_noshield c_length=4U c_width=4U
* device instance $643 r0 *1 169,102.6 cap_mim_2f0_m4m5_noshield
X$643 \$22__t113 topp__t396 cap_mim_2f0_m4m5_noshield c_length=4U c_width=4U
* device instance $644 r0 *1 175.4,102.6 cap_mim_2f0_m4m5_noshield
X$644 \$10__t200 topp__t395 cap_mim_2f0_m4m5_noshield c_length=4U c_width=4U
* device instance $645 r0 *1 181.8,102.6 cap_mim_2f0_m4m5_noshield
X$645 \$22__t116 topp__t406 cap_mim_2f0_m4m5_noshield c_length=4U c_width=4U
* device instance $646 r0 *1 188.2,102.6 cap_mim_2f0_m4m5_noshield
X$646 \$10__t196 topp__t389 cap_mim_2f0_m4m5_noshield c_length=4U c_width=4U
* device instance $647 r0 *1 194.6,102.6 cap_mim_2f0_m4m5_noshield
X$647 \$22__t110 topp__t388 cap_mim_2f0_m4m5_noshield c_length=4U c_width=4U
* device instance $648 r0 *1 201,102.6 cap_mim_2f0_m4m5_noshield
X$648 \$10__t195 topp__t387 cap_mim_2f0_m4m5_noshield c_length=4U c_width=4U
* device instance $649 r0 *1 224,102.6 cap_mim_2f0_m4m5_noshield
X$649 \$81__t100 topn__t409 cap_mim_2f0_m4m5_noshield c_length=4U c_width=4U
* device instance $650 r0 *1 230.4,102.6 cap_mim_2f0_m4m5_noshield
X$650 \$79__t204 topn__t408 cap_mim_2f0_m4m5_noshield c_length=4U c_width=4U
* device instance $651 r0 *1 236.8,102.6 cap_mim_2f0_m4m5_noshield
X$651 \$81__t16 topn__t38 cap_mim_2f0_m4m5_noshield c_length=4U c_width=4U
* device instance $652 r0 *1 243.2,102.6 cap_mim_2f0_m4m5_noshield
X$652 \$79__t18 topn__t37 cap_mim_2f0_m4m5_noshield c_length=4U c_width=4U
* device instance $653 r0 *1 249.6,102.6 cap_mim_2f0_m4m5_noshield
X$653 \$81__t15 topn__t36 cap_mim_2f0_m4m5_noshield c_length=4U c_width=4U
* device instance $654 r0 *1 256,102.6 cap_mim_2f0_m4m5_noshield
X$654 \$79__t17 topn__t35 cap_mim_2f0_m4m5_noshield c_length=4U c_width=4U
* device instance $655 r0 *1 262.4,102.6 cap_mim_2f0_m4m5_noshield
X$655 \$81__t13 topn__t33 cap_mim_2f0_m4m5_noshield c_length=4U c_width=4U
* device instance $656 r0 *1 268.8,102.6 cap_mim_2f0_m4m5_noshield
X$656 \$79__t16 topn__t32 cap_mim_2f0_m4m5_noshield c_length=4U c_width=4U
* device instance $657 r0 *1 275.2,102.6 cap_mim_2f0_m4m5_noshield
X$657 \$81__t12 topn__t31 cap_mim_2f0_m4m5_noshield c_length=4U c_width=4U
* device instance $658 r0 *1 281.6,102.6 cap_mim_2f0_m4m5_noshield
X$658 \$79__t15 topn__t30 cap_mim_2f0_m4m5_noshield c_length=4U c_width=4U
* device instance $659 r0 *1 288,102.6 cap_mim_2f0_m4m5_noshield
X$659 \$81__t11 topn__t29 cap_mim_2f0_m4m5_noshield c_length=4U c_width=4U
* device instance $660 r0 *1 294.4,102.6 cap_mim_2f0_m4m5_noshield
X$660 \$79__t218 topn__t435 cap_mim_2f0_m4m5_noshield c_length=4U c_width=4U
* device instance $661 r0 *1 300.8,102.6 cap_mim_2f0_m4m5_noshield
X$661 \$81__t5 topn__t17 cap_mim_2f0_m4m5_noshield c_length=4U c_width=4U
* device instance $662 r0 *1 307.2,102.6 cap_mim_2f0_m4m5_noshield
X$662 \$79__t8 topn__t16 cap_mim_2f0_m4m5_noshield c_length=4U c_width=4U
* device instance $663 r0 *1 313.6,102.6 cap_mim_2f0_m4m5_noshield
X$663 \$81__t4 topn__t15 cap_mim_2f0_m4m5_noshield c_length=4U c_width=4U
* device instance $664 r0 *1 320,102.6 cap_mim_2f0_m4m5_noshield
X$664 \$79__t7 topn__t14 cap_mim_2f0_m4m5_noshield c_length=4U c_width=4U
* device instance $665 r0 *1 326.4,102.6 cap_mim_2f0_m4m5_noshield
X$665 \$81__t3 topn__t13 cap_mim_2f0_m4m5_noshield c_length=4U c_width=4U
* device instance $666 r0 *1 332.8,102.6 cap_mim_2f0_m4m5_noshield
X$666 \$79__t6 topn__t12 cap_mim_2f0_m4m5_noshield c_length=4U c_width=4U
* device instance $667 r0 *1 339.2,102.6 cap_mim_2f0_m4m5_noshield
X$667 \$81__t2 topn__t11 cap_mim_2f0_m4m5_noshield c_length=4U c_width=4U
* device instance $668 r0 *1 345.6,102.6 cap_mim_2f0_m4m5_noshield
X$668 \$79__t5 topn__t10 cap_mim_2f0_m4m5_noshield c_length=4U c_width=4U
* device instance $669 r0 *1 352,102.6 cap_mim_2f0_m4m5_noshield
X$669 \$81__t98 topn__t372 cap_mim_2f0_m4m5_noshield c_length=4U c_width=4U
* device instance $670 r0 *1 358.4,102.6 cap_mim_2f0_m4m5_noshield
X$670 \$79__t87 topn__t176 cap_mim_2f0_m4m5_noshield c_length=4U c_width=4U
* device instance $671 r0 *1 364.8,102.6 cap_mim_2f0_m4m5_noshield
X$671 \$81__t45 topn__t177 cap_mim_2f0_m4m5_noshield c_length=4U c_width=4U
* device instance $672 r0 *1 371.2,102.6 cap_mim_2f0_m4m5_noshield
X$672 \$79__t88 topn__t178 cap_mim_2f0_m4m5_noshield c_length=4U c_width=4U
* device instance $673 r0 *1 377.6,102.6 cap_mim_2f0_m4m5_noshield
X$673 \$81__t27 topn__t68 cap_mim_2f0_m4m5_noshield c_length=4U c_width=4U
* device instance $674 r0 *1 384,102.6 cap_mim_2f0_m4m5_noshield
X$674 \$79__t32 topn__t67 cap_mim_2f0_m4m5_noshield c_length=4U c_width=4U
* device instance $675 r0 *1 390.4,102.6 cap_mim_2f0_m4m5_noshield
X$675 \$81__t26 topn__t66 cap_mim_2f0_m4m5_noshield c_length=4U c_width=4U
* device instance $676 r0 *1 396.8,102.6 cap_mim_2f0_m4m5_noshield
X$676 \$79__t31 topn__t65 cap_mim_2f0_m4m5_noshield c_length=4U c_width=4U
* device instance $677 r0 *1 403.2,102.6 cap_mim_2f0_m4m5_noshield
X$677 \$81__t25 topn__t64 cap_mim_2f0_m4m5_noshield c_length=4U c_width=4U
* device instance $678 r0 *1 409.6,102.6 cap_mim_2f0_m4m5_noshield
X$678 \$79__t30 topn__t63 cap_mim_2f0_m4m5_noshield c_length=4U c_width=4U
* device instance $679 r0 *1 416,102.6 cap_mim_2f0_m4m5_noshield
X$679 \$81__t24 topn__t62 cap_mim_2f0_m4m5_noshield c_length=4U c_width=4U
* device instance $680 r0 *1 422.4,102.6 cap_mim_2f0_m4m5_noshield
X$680 \$79__t29 topn__t61 cap_mim_2f0_m4m5_noshield c_length=4U c_width=4U
* device instance $681 r0 *1 2.6,109 cap_mim_2f0_m4m5_noshield
X$681 \$30__t19 topp__t147 cap_mim_2f0_m4m5_noshield c_length=4U c_width=4U
* device instance $682 r0 *1 9,109 cap_mim_2f0_m4m5_noshield
X$682 \$10__t75 topp__t146 cap_mim_2f0_m4m5_noshield c_length=4U c_width=4U
* device instance $683 r0 *1 15.4,109 cap_mim_2f0_m4m5_noshield
X$683 \$30__t18 topp__t145 cap_mim_2f0_m4m5_noshield c_length=4U c_width=4U
* device instance $684 r0 *1 21.8,109 cap_mim_2f0_m4m5_noshield
X$684 \$10__t74 topp__t144 cap_mim_2f0_m4m5_noshield c_length=4U c_width=4U
* device instance $685 r0 *1 28.2,109 cap_mim_2f0_m4m5_noshield
X$685 \$30__t17 topp__t143 cap_mim_2f0_m4m5_noshield c_length=4U c_width=4U
* device instance $686 r0 *1 34.6,109 cap_mim_2f0_m4m5_noshield
X$686 \$10__t73 topp__t142 cap_mim_2f0_m4m5_noshield c_length=4U c_width=4U
* device instance $687 r0 *1 41,109 cap_mim_2f0_m4m5_noshield
X$687 \$30__t16 topp__t141 cap_mim_2f0_m4m5_noshield c_length=4U c_width=4U
* device instance $688 r0 *1 47.4,109 cap_mim_2f0_m4m5_noshield
X$688 \$10__t72 topp__t140 cap_mim_2f0_m4m5_noshield c_length=4U c_width=4U
* device instance $689 r0 *1 53.8,109 cap_mim_2f0_m4m5_noshield
X$689 \$30__t15 topp__t139 cap_mim_2f0_m4m5_noshield c_length=4U c_width=4U
* device instance $690 r0 *1 60.2,109 cap_mim_2f0_m4m5_noshield
X$690 \$10__t96 topp__t188 cap_mim_2f0_m4m5_noshield c_length=4U c_width=4U
* device instance $691 r0 *1 66.6,109 cap_mim_2f0_m4m5_noshield
X$691 \$30__t22 topp__t228 cap_mim_2f0_m4m5_noshield c_length=4U c_width=4U
* device instance $692 r0 *1 73,109 cap_mim_2f0_m4m5_noshield
X$692 \$10__t118 topp__t231 cap_mim_2f0_m4m5_noshield c_length=4U c_width=4U
* device instance $693 r0 *1 79.4,109 cap_mim_2f0_m4m5_noshield
X$693 \$30__t23 topp__t234 cap_mim_2f0_m4m5_noshield c_length=4U c_width=4U
* device instance $694 r0 *1 85.8,109 cap_mim_2f0_m4m5_noshield
X$694 \$10__t116 topp__t229 cap_mim_2f0_m4m5_noshield c_length=4U c_width=4U
* device instance $695 r0 *1 92.2,109 cap_mim_2f0_m4m5_noshield
X$695 \$30__t21 topp__t227 cap_mim_2f0_m4m5_noshield c_length=4U c_width=4U
* device instance $696 r0 *1 98.6,109 cap_mim_2f0_m4m5_noshield
X$696 \$10__t115 topp__t226 cap_mim_2f0_m4m5_noshield c_length=4U c_width=4U
* device instance $697 r0 *1 105,109 cap_mim_2f0_m4m5_noshield
X$697 \$30__t20 topp__t185 cap_mim_2f0_m4m5_noshield c_length=4U c_width=4U
* device instance $698 r0 *1 111.4,109 cap_mim_2f0_m4m5_noshield
X$698 \$10__t93 topp__t184 cap_mim_2f0_m4m5_noshield c_length=4U c_width=4U
* device instance $699 r0 *1 117.8,109 cap_mim_2f0_m4m5_noshield
X$699 \$30__t28 topp__t277 cap_mim_2f0_m4m5_noshield c_length=4U c_width=4U
* device instance $700 r0 *1 124.2,109 cap_mim_2f0_m4m5_noshield
X$700 \$10__t221 topp__t439 cap_mim_2f0_m4m5_noshield c_length=4U c_width=4U
* device instance $701 r0 *1 130.6,109 cap_mim_2f0_m4m5_noshield
X$701 \$30__t47 topp__t438 cap_mim_2f0_m4m5_noshield c_length=4U c_width=4U
* device instance $702 r0 *1 137,109 cap_mim_2f0_m4m5_noshield
X$702 \$10__t220 topp__t437 cap_mim_2f0_m4m5_noshield c_length=4U c_width=4U
* device instance $703 r0 *1 143.4,109 cap_mim_2f0_m4m5_noshield
X$703 \$30__t46 topp__t436 cap_mim_2f0_m4m5_noshield c_length=4U c_width=4U
* device instance $704 r0 *1 149.8,109 cap_mim_2f0_m4m5_noshield
X$704 \$10__t219 topp__t435 cap_mim_2f0_m4m5_noshield c_length=4U c_width=4U
* device instance $705 r0 *1 156.2,109 cap_mim_2f0_m4m5_noshield
X$705 \$30__t45 topp__t434 cap_mim_2f0_m4m5_noshield c_length=4U c_width=4U
* device instance $706 r0 *1 162.6,109 cap_mim_2f0_m4m5_noshield
X$706 \$10__t226 topp__t449 cap_mim_2f0_m4m5_noshield c_length=4U c_width=4U
* device instance $707 r0 *1 169,109 cap_mim_2f0_m4m5_noshield
X$707 \$30__t44 topp__t432 cap_mim_2f0_m4m5_noshield c_length=4U c_width=4U
* device instance $708 r0 *1 175.4,109 cap_mim_2f0_m4m5_noshield
X$708 \$10__t217 topp__t431 cap_mim_2f0_m4m5_noshield c_length=4U c_width=4U
* device instance $709 r0 *1 181.8,109 cap_mim_2f0_m4m5_noshield
X$709 \$30__t43 topp__t430 cap_mim_2f0_m4m5_noshield c_length=4U c_width=4U
* device instance $710 r0 *1 188.2,109 cap_mim_2f0_m4m5_noshield
X$710 \$10__t216 topp__t429 cap_mim_2f0_m4m5_noshield c_length=4U c_width=4U
* device instance $711 r0 *1 194.6,109 cap_mim_2f0_m4m5_noshield
X$711 \$30__t42 topp__t428 cap_mim_2f0_m4m5_noshield c_length=4U c_width=4U
* device instance $712 r0 *1 201,109 cap_mim_2f0_m4m5_noshield
X$712 \$10__t215 topp__t427 cap_mim_2f0_m4m5_noshield c_length=4U c_width=4U
* device instance $713 r0 *1 224,109 cap_mim_2f0_m4m5_noshield
X$713 \$82__t53 topn__t446 cap_mim_2f0_m4m5_noshield c_length=4U c_width=4U
* device instance $714 r0 *1 230.4,109 cap_mim_2f0_m4m5_noshield
X$714 \$79__t224 topn__t445 cap_mim_2f0_m4m5_noshield c_length=4U c_width=4U
* device instance $715 r0 *1 236.8,109 cap_mim_2f0_m4m5_noshield
X$715 \$82__t4 topn__t77 cap_mim_2f0_m4m5_noshield c_length=4U c_width=4U
* device instance $716 r0 *1 243.2,109 cap_mim_2f0_m4m5_noshield
X$716 \$79__t37 topn__t76 cap_mim_2f0_m4m5_noshield c_length=4U c_width=4U
* device instance $717 r0 *1 249.6,109 cap_mim_2f0_m4m5_noshield
X$717 \$82__t3 topn__t75 cap_mim_2f0_m4m5_noshield c_length=4U c_width=4U
* device instance $718 r0 *1 256,109 cap_mim_2f0_m4m5_noshield
X$718 \$79__t36 topn__t74 cap_mim_2f0_m4m5_noshield c_length=4U c_width=4U
* device instance $719 r0 *1 262.4,109 cap_mim_2f0_m4m5_noshield
X$719 \$82__t2 topn__t73 cap_mim_2f0_m4m5_noshield c_length=4U c_width=4U
* device instance $720 r0 *1 268.8,109 cap_mim_2f0_m4m5_noshield
X$720 \$79__t35 topn__t72 cap_mim_2f0_m4m5_noshield c_length=4U c_width=4U
* device instance $721 r0 *1 275.2,109 cap_mim_2f0_m4m5_noshield
X$721 \$82__t8 topn__t119 cap_mim_2f0_m4m5_noshield c_length=4U c_width=4U
* device instance $722 r0 *1 281.6,109 cap_mim_2f0_m4m5_noshield
X$722 \$79__t66 topn__t134 cap_mim_2f0_m4m5_noshield c_length=4U c_width=4U
* device instance $723 r0 *1 288,109 cap_mim_2f0_m4m5_noshield
X$723 \$82__t9 topn__t133 cap_mim_2f0_m4m5_noshield c_length=4U c_width=4U
* device instance $724 r0 *1 294.4,109 cap_mim_2f0_m4m5_noshield
X$724 \$79__t219 topn__t436 cap_mim_2f0_m4m5_noshield c_length=4U c_width=4U
* device instance $725 r0 *1 300.8,109 cap_mim_2f0_m4m5_noshield
X$725 \$82__t0 topn__t0 cap_mim_2f0_m4m5_noshield c_length=4U c_width=4U
* device instance $726 r0 *1 307.2,109 cap_mim_2f0_m4m5_noshield
X$726 \$79__t48 topn__t102 cap_mim_2f0_m4m5_noshield c_length=4U c_width=4U
* device instance $727 r0 *1 313.6,109 cap_mim_2f0_m4m5_noshield
X$727 \$82__t7 topn__t101 cap_mim_2f0_m4m5_noshield c_length=4U c_width=4U
* device instance $728 r0 *1 320,109 cap_mim_2f0_m4m5_noshield
X$728 \$79__t47 topn__t100 cap_mim_2f0_m4m5_noshield c_length=4U c_width=4U
* device instance $729 r0 *1 326.4,109 cap_mim_2f0_m4m5_noshield
X$729 \$82__t6 topn__t99 cap_mim_2f0_m4m5_noshield c_length=4U c_width=4U
* device instance $730 r0 *1 332.8,109 cap_mim_2f0_m4m5_noshield
X$730 \$79__t46 topn__t98 cap_mim_2f0_m4m5_noshield c_length=4U c_width=4U
* device instance $731 r0 *1 339.2,109 cap_mim_2f0_m4m5_noshield
X$731 \$82__t5 topn__t97 cap_mim_2f0_m4m5_noshield c_length=4U c_width=4U
* device instance $732 r0 *1 345.6,109 cap_mim_2f0_m4m5_noshield
X$732 \$79__t45 topn__t96 cap_mim_2f0_m4m5_noshield c_length=4U c_width=4U
* device instance $733 r0 *1 352,109 cap_mim_2f0_m4m5_noshield
X$733 \$82__t40 topn__t373 cap_mim_2f0_m4m5_noshield c_length=4U c_width=4U
* device instance $734 r0 *1 358.4,109 cap_mim_2f0_m4m5_noshield
X$734 \$79__t79 topn__t162 cap_mim_2f0_m4m5_noshield c_length=4U c_width=4U
* device instance $735 r0 *1 364.8,109 cap_mim_2f0_m4m5_noshield
X$735 \$82__t14 topn__t161 cap_mim_2f0_m4m5_noshield c_length=4U c_width=4U
* device instance $736 r0 *1 371.2,109 cap_mim_2f0_m4m5_noshield
X$736 \$79__t78 topn__t160 cap_mim_2f0_m4m5_noshield c_length=4U c_width=4U
* device instance $737 r0 *1 377.6,109 cap_mim_2f0_m4m5_noshield
X$737 \$82__t13 topn__t159 cap_mim_2f0_m4m5_noshield c_length=4U c_width=4U
* device instance $738 r0 *1 384,109 cap_mim_2f0_m4m5_noshield
X$738 \$79__t77 topn__t158 cap_mim_2f0_m4m5_noshield c_length=4U c_width=4U
* device instance $739 r0 *1 390.4,109 cap_mim_2f0_m4m5_noshield
X$739 \$82__t12 topn__t147 cap_mim_2f0_m4m5_noshield c_length=4U c_width=4U
* device instance $740 r0 *1 396.8,109 cap_mim_2f0_m4m5_noshield
X$740 \$79__t71 topn__t146 cap_mim_2f0_m4m5_noshield c_length=4U c_width=4U
* device instance $741 r0 *1 403.2,109 cap_mim_2f0_m4m5_noshield
X$741 \$82__t11 topn__t145 cap_mim_2f0_m4m5_noshield c_length=4U c_width=4U
* device instance $742 r0 *1 409.6,109 cap_mim_2f0_m4m5_noshield
X$742 \$79__t70 topn__t144 cap_mim_2f0_m4m5_noshield c_length=4U c_width=4U
* device instance $743 r0 *1 416,109 cap_mim_2f0_m4m5_noshield
X$743 \$82__t10 topn__t143 cap_mim_2f0_m4m5_noshield c_length=4U c_width=4U
* device instance $744 r0 *1 422.4,109 cap_mim_2f0_m4m5_noshield
X$744 \$79__t69 topn__t142 cap_mim_2f0_m4m5_noshield c_length=4U c_width=4U
* device instance $745 r0 *1 2.6,115.4 cap_mim_2f0_m4m5_noshield
X$745 \$38__t10 topp__t199 cap_mim_2f0_m4m5_noshield c_length=4U c_width=4U
* device instance $746 r0 *1 9,115.4 cap_mim_2f0_m4m5_noshield
X$746 \$10__t77 topp__t150 cap_mim_2f0_m4m5_noshield c_length=4U c_width=4U
* device instance $747 r0 *1 15.4,115.4 cap_mim_2f0_m4m5_noshield
X$747 \$38__t9 topp__t149 cap_mim_2f0_m4m5_noshield c_length=4U c_width=4U
* device instance $748 r0 *1 21.8,115.4 cap_mim_2f0_m4m5_noshield
X$748 \$10__t76 topp__t148 cap_mim_2f0_m4m5_noshield c_length=4U c_width=4U
* device instance $749 r0 *1 28.2,115.4 cap_mim_2f0_m4m5_noshield
X$749 \$38__t8 topp__t138 cap_mim_2f0_m4m5_noshield c_length=4U c_width=4U
* device instance $750 r0 *1 34.6,115.4 cap_mim_2f0_m4m5_noshield
X$750 \$10__t111 topp__t220 cap_mim_2f0_m4m5_noshield c_length=4U c_width=4U
* device instance $751 r0 *1 41,115.4 cap_mim_2f0_m4m5_noshield
X$751 \$38__t12 topp__t219 cap_mim_2f0_m4m5_noshield c_length=4U c_width=4U
* device instance $752 r0 *1 47.4,115.4 cap_mim_2f0_m4m5_noshield
X$752 \$10__t110 topp__t218 cap_mim_2f0_m4m5_noshield c_length=4U c_width=4U
* device instance $753 r0 *1 53.8,115.4 cap_mim_2f0_m4m5_noshield
X$753 \$38__t11 topp__t217 cap_mim_2f0_m4m5_noshield c_length=4U c_width=4U
* device instance $754 r0 *1 60.2,115.4 cap_mim_2f0_m4m5_noshield
X$754 \$10__t97 topp__t189 cap_mim_2f0_m4m5_noshield c_length=4U c_width=4U
* device instance $755 r0 *1 66.6,115.4 cap_mim_2f0_m4m5_noshield
X$755 \$38__t13 topp__t233 cap_mim_2f0_m4m5_noshield c_length=4U c_width=4U
* device instance $756 r0 *1 73,115.4 cap_mim_2f0_m4m5_noshield
X$756 \$10__t119 topp__t232 cap_mim_2f0_m4m5_noshield c_length=4U c_width=4U
* device instance $757 r0 *1 79.4,115.4 cap_mim_2f0_m4m5_noshield
X$757 \$38__t16 topp__t247 cap_mim_2f0_m4m5_noshield c_length=4U c_width=4U
* device instance $758 r0 *1 85.8,115.4 cap_mim_2f0_m4m5_noshield
X$758 \$10__t117 topp__t230 cap_mim_2f0_m4m5_noshield c_length=4U c_width=4U
* device instance $759 r0 *1 92.2,115.4 cap_mim_2f0_m4m5_noshield
X$759 \$38__t15 topp__t246 cap_mim_2f0_m4m5_noshield c_length=4U c_width=4U
* device instance $760 r0 *1 98.6,115.4 cap_mim_2f0_m4m5_noshield
X$760 \$10__t125 topp__t245 cap_mim_2f0_m4m5_noshield c_length=4U c_width=4U
* device instance $761 r0 *1 105,115.4 cap_mim_2f0_m4m5_noshield
X$761 \$46__t7 topp__t244 cap_mim_2f0_m4m5_noshield c_length=4U c_width=4U
* device instance $762 r0 *1 111.4,115.4 cap_mim_2f0_m4m5_noshield
X$762 \$10__t124 topp__t243 cap_mim_2f0_m4m5_noshield c_length=4U c_width=4U
* device instance $763 r0 *1 117.8,115.4 cap_mim_2f0_m4m5_noshield
X$763 \$46__t9 topp__t274 cap_mim_2f0_m4m5_noshield c_length=4U c_width=4U
* device instance $764 r0 *1 124.2,115.4 cap_mim_2f0_m4m5_noshield
X$764 \$10__t189 topp__t378 cap_mim_2f0_m4m5_noshield c_length=4U c_width=4U
* device instance $765 r0 *1 130.6,115.4 cap_mim_2f0_m4m5_noshield
X$765 \$46__t11 topp__t377 cap_mim_2f0_m4m5_noshield c_length=4U c_width=4U
* device instance $766 r0 *1 137,115.4 cap_mim_2f0_m4m5_noshield
X$766 \$10__t188 topp__t376 cap_mim_2f0_m4m5_noshield c_length=4U c_width=4U
* device instance $767 r0 *1 143.4,115.4 cap_mim_2f0_m4m5_noshield
X$767 \$46__t10 topp__t375 cap_mim_2f0_m4m5_noshield c_length=4U c_width=4U
* device instance $768 r0 *1 149.8,115.4 cap_mim_2f0_m4m5_noshield
X$768 \$10__t187 topp__t374 cap_mim_2f0_m4m5_noshield c_length=4U c_width=4U
* device instance $769 r0 *1 156.2,115.4 cap_mim_2f0_m4m5_noshield
X$769 \$54__t5 topp__t373 cap_mim_2f0_m4m5_noshield c_length=4U c_width=4U
* device instance $770 r0 *1 162.6,115.4 cap_mim_2f0_m4m5_noshield
X$770 \$10__t186 topp__t372 cap_mim_2f0_m4m5_noshield c_length=4U c_width=4U
* device instance $771 r0 *1 169,115.4 cap_mim_2f0_m4m5_noshield
X$771 \$54__t4 topp__t371 cap_mim_2f0_m4m5_noshield c_length=4U c_width=4U
* device instance $772 r0 *1 175.4,115.4 cap_mim_2f0_m4m5_noshield
X$772 \$10__t185 topp__t370 cap_mim_2f0_m4m5_noshield c_length=4U c_width=4U
* device instance $773 r0 *1 181.8,115.4 cap_mim_2f0_m4m5_noshield
X$773 \$62__t2 topp__t369 cap_mim_2f0_m4m5_noshield c_length=4U c_width=4U
* device instance $774 r0 *1 188.2,115.4 cap_mim_2f0_m4m5_noshield
X$774 \$10__t184 topp__t368 cap_mim_2f0_m4m5_noshield c_length=4U c_width=4U
* device instance $775 r0 *1 194.6,115.4 cap_mim_2f0_m4m5_noshield
X$775 \$78__t0 topp__t367 cap_mim_2f0_m4m5_noshield c_length=4U c_width=4U
* device instance $776 r0 *1 201,115.4 cap_mim_2f0_m4m5_noshield
X$776 \$10__t209 topp__t416 cap_mim_2f0_m4m5_noshield c_length=4U c_width=4U
* device instance $777 r0 *1 224,115.4 cap_mim_2f0_m4m5_noshield
X$777 \$83__t24 topn__t443 cap_mim_2f0_m4m5_noshield c_length=4U c_width=4U
* device instance $778 r0 *1 230.4,115.4 cap_mim_2f0_m4m5_noshield
X$778 \$79__t223 topn__t442 cap_mim_2f0_m4m5_noshield c_length=4U c_width=4U
* device instance $779 r0 *1 236.8,115.4 cap_mim_2f0_m4m5_noshield
X$779 \$83__t8 topn__t123 cap_mim_2f0_m4m5_noshield c_length=4U c_width=4U
* device instance $780 r0 *1 243.2,115.4 cap_mim_2f0_m4m5_noshield
X$780 \$79__t60 topn__t122 cap_mim_2f0_m4m5_noshield c_length=4U c_width=4U
* device instance $781 r0 *1 249.6,115.4 cap_mim_2f0_m4m5_noshield
X$781 \$83__t7 topn__t121 cap_mim_2f0_m4m5_noshield c_length=4U c_width=4U
* device instance $782 r0 *1 256,115.4 cap_mim_2f0_m4m5_noshield
X$782 \$79__t59 topn__t120 cap_mim_2f0_m4m5_noshield c_length=4U c_width=4U
* device instance $783 r0 *1 262.4,115.4 cap_mim_2f0_m4m5_noshield
X$783 \$83__t3 topn__t82 cap_mim_2f0_m4m5_noshield c_length=4U c_width=4U
* device instance $784 r0 *1 268.8,115.4 cap_mim_2f0_m4m5_noshield
X$784 \$79__t39 topn__t81 cap_mim_2f0_m4m5_noshield c_length=4U c_width=4U
* device instance $785 r0 *1 275.2,115.4 cap_mim_2f0_m4m5_noshield
X$785 \$83__t2 topn__t80 cap_mim_2f0_m4m5_noshield c_length=4U c_width=4U
* device instance $786 r0 *1 281.6,115.4 cap_mim_2f0_m4m5_noshield
X$786 \$79__t38 topn__t79 cap_mim_2f0_m4m5_noshield c_length=4U c_width=4U
* device instance $787 r0 *1 288,115.4 cap_mim_2f0_m4m5_noshield
X$787 \$83__t1 topn__t78 cap_mim_2f0_m4m5_noshield c_length=4U c_width=4U
* device instance $788 r0 *1 294.4,115.4 cap_mim_2f0_m4m5_noshield
X$788 \$79__t220 topn__t437 cap_mim_2f0_m4m5_noshield c_length=4U c_width=4U
* device instance $789 r0 *1 300.8,115.4 cap_mim_2f0_m4m5_noshield
X$789 \$83__t5 topn__t94 cap_mim_2f0_m4m5_noshield c_length=4U c_width=4U
* device instance $790 r0 *1 307.2,115.4 cap_mim_2f0_m4m5_noshield
X$790 \$79__t44 topn__t93 cap_mim_2f0_m4m5_noshield c_length=4U c_width=4U
* device instance $791 r0 *1 313.6,115.4 cap_mim_2f0_m4m5_noshield
X$791 \$83__t4 topn__t92 cap_mim_2f0_m4m5_noshield c_length=4U c_width=4U
* device instance $792 r0 *1 320,115.4 cap_mim_2f0_m4m5_noshield
X$792 \$79__t43 topn__t91 cap_mim_2f0_m4m5_noshield c_length=4U c_width=4U
* device instance $793 r0 *1 326.4,115.4 cap_mim_2f0_m4m5_noshield
X$793 \$84__t4 topn__t90 cap_mim_2f0_m4m5_noshield c_length=4U c_width=4U
* device instance $794 r0 *1 332.8,115.4 cap_mim_2f0_m4m5_noshield
X$794 \$79__t42 topn__t89 cap_mim_2f0_m4m5_noshield c_length=4U c_width=4U
* device instance $795 r0 *1 339.2,115.4 cap_mim_2f0_m4m5_noshield
X$795 \$84__t3 topn__t88 cap_mim_2f0_m4m5_noshield c_length=4U c_width=4U
* device instance $796 r0 *1 345.6,115.4 cap_mim_2f0_m4m5_noshield
X$796 \$79__t49 topn__t103 cap_mim_2f0_m4m5_noshield c_length=4U c_width=4U
* device instance $797 r0 *1 352,115.4 cap_mim_2f0_m4m5_noshield
X$797 \$84__t11 topn__t374 cap_mim_2f0_m4m5_noshield c_length=4U c_width=4U
* device instance $798 r0 *1 358.4,115.4 cap_mim_2f0_m4m5_noshield
X$798 \$79__t34 topn__t71 cap_mim_2f0_m4m5_noshield c_length=4U c_width=4U
* device instance $799 r0 *1 364.8,115.4 cap_mim_2f0_m4m5_noshield
X$799 \$84__t0 topn__t54 cap_mim_2f0_m4m5_noshield c_length=4U c_width=4U
* device instance $800 r0 *1 371.2,115.4 cap_mim_2f0_m4m5_noshield
X$800 \$79__t25 topn__t53 cap_mim_2f0_m4m5_noshield c_length=4U c_width=4U
* device instance $801 r0 *1 377.6,115.4 cap_mim_2f0_m4m5_noshield
X$801 \$85__t1 topn__t52 cap_mim_2f0_m4m5_noshield c_length=4U c_width=4U
* device instance $802 r0 *1 384,115.4 cap_mim_2f0_m4m5_noshield
X$802 \$79__t24 topn__t51 cap_mim_2f0_m4m5_noshield c_length=4U c_width=4U
* device instance $803 r0 *1 390.4,115.4 cap_mim_2f0_m4m5_noshield
X$803 \$85__t0 topn__t50 cap_mim_2f0_m4m5_noshield c_length=4U c_width=4U
* device instance $804 r0 *1 396.8,115.4 cap_mim_2f0_m4m5_noshield
X$804 \$79__t23 topn__t49 cap_mim_2f0_m4m5_noshield c_length=4U c_width=4U
* device instance $805 r0 *1 403.2,115.4 cap_mim_2f0_m4m5_noshield
X$805 \$86__t0 topn__t48 cap_mim_2f0_m4m5_noshield c_length=4U c_width=4U
* device instance $806 r0 *1 409.6,115.4 cap_mim_2f0_m4m5_noshield
X$806 \$79__t22 topn__t47 cap_mim_2f0_m4m5_noshield c_length=4U c_width=4U
* device instance $807 r0 *1 416,115.4 cap_mim_2f0_m4m5_noshield
X$807 \$88__t0 topn__t46 cap_mim_2f0_m4m5_noshield c_length=4U c_width=4U
* device instance $808 r0 *1 422.4,115.4 cap_mim_2f0_m4m5_noshield
X$808 \$79__t21 topn__t45 cap_mim_2f0_m4m5_noshield c_length=4U c_width=4U
* device instance $809 r0 *1 2.6,121.8 cap_mim_2f0_m4m5_noshield
X$809 \$10__t112 topp__t222 cap_mim_2f0_m4m5_noshield c_length=4U c_width=4U
* device instance $810 r0 *1 9,121.8 cap_mim_2f0_m4m5_noshield
X$810 vcm__t0 topp__t221 cap_mim_2f0_m4m5_noshield c_length=4U c_width=4U
* device instance $811 r0 *1 15.4,121.8 cap_mim_2f0_m4m5_noshield
X$811 \$10__t109 topp__t216 cap_mim_2f0_m4m5_noshield c_length=4U c_width=4U
* device instance $812 r0 *1 21.8,121.8 cap_mim_2f0_m4m5_noshield
X$812 \$62__t1 topp__t137 cap_mim_2f0_m4m5_noshield c_length=4U c_width=4U
* device instance $813 r0 *1 28.2,121.8 cap_mim_2f0_m4m5_noshield
X$813 \$10__t71 topp__t136 cap_mim_2f0_m4m5_noshield c_length=4U c_width=4U
* device instance $814 r0 *1 34.6,121.8 cap_mim_2f0_m4m5_noshield
X$814 \$54__t2 topp__t151 cap_mim_2f0_m4m5_noshield c_length=4U c_width=4U
* device instance $815 r0 *1 41,121.8 cap_mim_2f0_m4m5_noshield
X$815 \$10__t114 topp__t225 cap_mim_2f0_m4m5_noshield c_length=4U c_width=4U
* device instance $816 r0 *1 47.4,121.8 cap_mim_2f0_m4m5_noshield
X$816 \$54__t3 topp__t224 cap_mim_2f0_m4m5_noshield c_length=4U c_width=4U
* device instance $817 r0 *1 53.8,121.8 cap_mim_2f0_m4m5_noshield
X$817 \$10__t113 topp__t223 cap_mim_2f0_m4m5_noshield c_length=4U c_width=4U
* device instance $818 r0 *1 60.2,121.8 cap_mim_2f0_m4m5_noshield
X$818 \$46__t3 topp__t191 cap_mim_2f0_m4m5_noshield c_length=4U c_width=4U
* device instance $819 r0 *1 66.6,121.8 cap_mim_2f0_m4m5_noshield
X$819 \$10__t123 topp__t242 cap_mim_2f0_m4m5_noshield c_length=4U c_width=4U
* device instance $820 r0 *1 73,121.8 cap_mim_2f0_m4m5_noshield
X$820 \$46__t6 topp__t241 cap_mim_2f0_m4m5_noshield c_length=4U c_width=4U
* device instance $821 r0 *1 79.4,121.8 cap_mim_2f0_m4m5_noshield
X$821 \$10__t122 topp__t240 cap_mim_2f0_m4m5_noshield c_length=4U c_width=4U
* device instance $822 r0 *1 85.8,121.8 cap_mim_2f0_m4m5_noshield
X$822 \$46__t5 topp__t239 cap_mim_2f0_m4m5_noshield c_length=4U c_width=4U
* device instance $823 r0 *1 92.2,121.8 cap_mim_2f0_m4m5_noshield
X$823 \$10__t121 topp__t238 cap_mim_2f0_m4m5_noshield c_length=4U c_width=4U
* device instance $824 r0 *1 98.6,121.8 cap_mim_2f0_m4m5_noshield
X$824 \$46__t4 topp__t237 cap_mim_2f0_m4m5_noshield c_length=4U c_width=4U
* device instance $825 r0 *1 105,121.8 cap_mim_2f0_m4m5_noshield
X$825 \$10__t120 topp__t236 cap_mim_2f0_m4m5_noshield c_length=4U c_width=4U
* device instance $826 r0 *1 111.4,121.8 cap_mim_2f0_m4m5_noshield
X$826 \$38__t14 topp__t235 cap_mim_2f0_m4m5_noshield c_length=4U c_width=4U
* device instance $827 r0 *1 117.8,121.8 cap_mim_2f0_m4m5_noshield
X$827 \$10__t135 topp__t269 cap_mim_2f0_m4m5_noshield c_length=4U c_width=4U
* device instance $828 r0 *1 124.2,121.8 cap_mim_2f0_m4m5_noshield
X$828 \$38__t23 topp__t413 cap_mim_2f0_m4m5_noshield c_length=4U c_width=4U
* device instance $829 r0 *1 130.6,121.8 cap_mim_2f0_m4m5_noshield
X$829 \$10__t207 topp__t412 cap_mim_2f0_m4m5_noshield c_length=4U c_width=4U
* device instance $830 r0 *1 137,121.8 cap_mim_2f0_m4m5_noshield
X$830 \$38__t22 topp__t411 cap_mim_2f0_m4m5_noshield c_length=4U c_width=4U
* device instance $831 r0 *1 143.4,121.8 cap_mim_2f0_m4m5_noshield
X$831 \$10__t206 topp__t410 cap_mim_2f0_m4m5_noshield c_length=4U c_width=4U
* device instance $832 r0 *1 149.8,121.8 cap_mim_2f0_m4m5_noshield
X$832 \$38__t21 topp__t409 cap_mim_2f0_m4m5_noshield c_length=4U c_width=4U
* device instance $833 r0 *1 156.2,121.8 cap_mim_2f0_m4m5_noshield
X$833 \$10__t205 topp__t408 cap_mim_2f0_m4m5_noshield c_length=4U c_width=4U
* device instance $834 r0 *1 162.6,121.8 cap_mim_2f0_m4m5_noshield
X$834 \$38__t20 topp__t407 cap_mim_2f0_m4m5_noshield c_length=4U c_width=4U
* device instance $835 r0 *1 169,121.8 cap_mim_2f0_m4m5_noshield
X$835 \$10__t211 topp__t420 cap_mim_2f0_m4m5_noshield c_length=4U c_width=4U
* device instance $836 r0 *1 175.4,121.8 cap_mim_2f0_m4m5_noshield
X$836 \$38__t19 topp__t405 cap_mim_2f0_m4m5_noshield c_length=4U c_width=4U
* device instance $837 r0 *1 181.8,121.8 cap_mim_2f0_m4m5_noshield
X$837 \$10__t204 topp__t404 cap_mim_2f0_m4m5_noshield c_length=4U c_width=4U
* device instance $838 r0 *1 188.2,121.8 cap_mim_2f0_m4m5_noshield
X$838 \$38__t18 topp__t403 cap_mim_2f0_m4m5_noshield c_length=4U c_width=4U
* device instance $839 r0 *1 194.6,121.8 cap_mim_2f0_m4m5_noshield
X$839 \$10__t203 topp__t402 cap_mim_2f0_m4m5_noshield c_length=4U c_width=4U
* device instance $840 r0 *1 201,121.8 cap_mim_2f0_m4m5_noshield
X$840 \$38__t17 topp__t401 cap_mim_2f0_m4m5_noshield c_length=4U c_width=4U
* device instance $841 r0 *1 224,121.8 cap_mim_2f0_m4m5_noshield
X$841 \$79__t222 topn__t441 cap_mim_2f0_m4m5_noshield c_length=4U c_width=4U
* device instance $842 r0 *1 230.4,121.8 cap_mim_2f0_m4m5_noshield
X$842 vcm__t1 topn__t440 cap_mim_2f0_m4m5_noshield c_length=4U c_width=4U
* device instance $843 r0 *1 236.8,121.8 cap_mim_2f0_m4m5_noshield
X$843 \$79__t65 topn__t132 cap_mim_2f0_m4m5_noshield c_length=4U c_width=4U
* device instance $844 r0 *1 243.2,121.8 cap_mim_2f0_m4m5_noshield
X$844 \$86__t1 topn__t131 cap_mim_2f0_m4m5_noshield c_length=4U c_width=4U
* device instance $845 r0 *1 249.6,121.8 cap_mim_2f0_m4m5_noshield
X$845 \$79__t64 topn__t130 cap_mim_2f0_m4m5_noshield c_length=4U c_width=4U
* device instance $846 r0 *1 256,121.8 cap_mim_2f0_m4m5_noshield
X$846 \$85__t3 topn__t129 cap_mim_2f0_m4m5_noshield c_length=4U c_width=4U
* device instance $847 r0 *1 262.4,121.8 cap_mim_2f0_m4m5_noshield
X$847 \$79__t63 topn__t128 cap_mim_2f0_m4m5_noshield c_length=4U c_width=4U
* device instance $848 r0 *1 268.8,121.8 cap_mim_2f0_m4m5_noshield
X$848 \$85__t2 topn__t127 cap_mim_2f0_m4m5_noshield c_length=4U c_width=4U
* device instance $849 r0 *1 275.2,121.8 cap_mim_2f0_m4m5_noshield
X$849 \$79__t62 topn__t126 cap_mim_2f0_m4m5_noshield c_length=4U c_width=4U
* device instance $850 r0 *1 281.6,121.8 cap_mim_2f0_m4m5_noshield
X$850 \$84__t5 topn__t125 cap_mim_2f0_m4m5_noshield c_length=4U c_width=4U
* device instance $851 r0 *1 288,121.8 cap_mim_2f0_m4m5_noshield
X$851 \$79__t61 topn__t124 cap_mim_2f0_m4m5_noshield c_length=4U c_width=4U
* device instance $852 r0 *1 294.4,121.8 cap_mim_2f0_m4m5_noshield
X$852 \$84__t13 topn__t438 cap_mim_2f0_m4m5_noshield c_length=4U c_width=4U
* device instance $853 r0 *1 300.8,121.8 cap_mim_2f0_m4m5_noshield
X$853 \$79__t41 topn__t85 cap_mim_2f0_m4m5_noshield c_length=4U c_width=4U
* device instance $854 r0 *1 307.2,121.8 cap_mim_2f0_m4m5_noshield
X$854 \$84__t1 topn__t84 cap_mim_2f0_m4m5_noshield c_length=4U c_width=4U
* device instance $855 r0 *1 313.6,121.8 cap_mim_2f0_m4m5_noshield
X$855 \$79__t40 topn__t83 cap_mim_2f0_m4m5_noshield c_length=4U c_width=4U
* device instance $856 r0 *1 320,121.8 cap_mim_2f0_m4m5_noshield
X$856 \$84__t2 topn__t86 cap_mim_2f0_m4m5_noshield c_length=4U c_width=4U
* device instance $857 r0 *1 326.4,121.8 cap_mim_2f0_m4m5_noshield
X$857 \$79__t212 topn__t423 cap_mim_2f0_m4m5_noshield c_length=4U c_width=4U
* device instance $858 r0 *1 332.8,121.8 cap_mim_2f0_m4m5_noshield
X$858 \$83__t23 topn__t402 cap_mim_2f0_m4m5_noshield c_length=4U c_width=4U
* device instance $859 r0 *1 339.2,121.8 cap_mim_2f0_m4m5_noshield
X$859 \$79__t200 topn__t403 cap_mim_2f0_m4m5_noshield c_length=4U c_width=4U
* device instance $860 r0 *1 345.6,121.8 cap_mim_2f0_m4m5_noshield
X$860 \$83__t6 topn__t95 cap_mim_2f0_m4m5_noshield c_length=4U c_width=4U
* device instance $861 r0 *1 352,121.8 cap_mim_2f0_m4m5_noshield
X$861 \$79__t186 topn__t375 cap_mim_2f0_m4m5_noshield c_length=4U c_width=4U
* device instance $862 r0 *1 358.4,121.8 cap_mim_2f0_m4m5_noshield
X$862 \$83__t13 topn__t157 cap_mim_2f0_m4m5_noshield c_length=4U c_width=4U
* device instance $863 r0 *1 364.8,121.8 cap_mim_2f0_m4m5_noshield
X$863 \$79__t76 topn__t156 cap_mim_2f0_m4m5_noshield c_length=4U c_width=4U
* device instance $864 r0 *1 371.2,121.8 cap_mim_2f0_m4m5_noshield
X$864 \$83__t14 topn__t171 cap_mim_2f0_m4m5_noshield c_length=4U c_width=4U
* device instance $865 r0 *1 377.6,121.8 cap_mim_2f0_m4m5_noshield
X$865 \$79__t75 topn__t155 cap_mim_2f0_m4m5_noshield c_length=4U c_width=4U
* device instance $866 r0 *1 384,121.8 cap_mim_2f0_m4m5_noshield
X$866 \$83__t12 topn__t154 cap_mim_2f0_m4m5_noshield c_length=4U c_width=4U
* device instance $867 r0 *1 390.4,121.8 cap_mim_2f0_m4m5_noshield
X$867 \$79__t74 topn__t153 cap_mim_2f0_m4m5_noshield c_length=4U c_width=4U
* device instance $868 r0 *1 396.8,121.8 cap_mim_2f0_m4m5_noshield
X$868 \$83__t11 topn__t152 cap_mim_2f0_m4m5_noshield c_length=4U c_width=4U
* device instance $869 r0 *1 403.2,121.8 cap_mim_2f0_m4m5_noshield
X$869 \$79__t73 topn__t151 cap_mim_2f0_m4m5_noshield c_length=4U c_width=4U
* device instance $870 r0 *1 409.6,121.8 cap_mim_2f0_m4m5_noshield
X$870 \$83__t10 topn__t150 cap_mim_2f0_m4m5_noshield c_length=4U c_width=4U
* device instance $871 r0 *1 416,121.8 cap_mim_2f0_m4m5_noshield
X$871 \$79__t72 topn__t149 cap_mim_2f0_m4m5_noshield c_length=4U c_width=4U
* device instance $872 r0 *1 422.4,121.8 cap_mim_2f0_m4m5_noshield
X$872 \$83__t9 topn__t148 cap_mim_2f0_m4m5_noshield c_length=4U c_width=4U
* device instance $873 r0 *1 2.6,128.2 cap_mim_2f0_m4m5_noshield
X$873 \$10__t134 topp__t267 cap_mim_2f0_m4m5_noshield c_length=4U c_width=4U
* device instance $874 r0 *1 9,128.2 cap_mim_2f0_m4m5_noshield
X$874 \$30__t26 topp__t266 cap_mim_2f0_m4m5_noshield c_length=4U c_width=4U
* device instance $875 r0 *1 15.4,128.2 cap_mim_2f0_m4m5_noshield
X$875 \$10__t133 topp__t265 cap_mim_2f0_m4m5_noshield c_length=4U c_width=4U
* device instance $876 r0 *1 21.8,128.2 cap_mim_2f0_m4m5_noshield
X$876 \$30__t25 topp__t264 cap_mim_2f0_m4m5_noshield c_length=4U c_width=4U
* device instance $877 r0 *1 28.2,128.2 cap_mim_2f0_m4m5_noshield
X$877 \$10__t139 topp__t279 cap_mim_2f0_m4m5_noshield c_length=4U c_width=4U
* device instance $878 r0 *1 34.6,128.2 cap_mim_2f0_m4m5_noshield
X$878 \$30__t24 topp__t263 cap_mim_2f0_m4m5_noshield c_length=4U c_width=4U
* device instance $879 r0 *1 41,128.2 cap_mim_2f0_m4m5_noshield
X$879 \$10__t161 topp__t322 cap_mim_2f0_m4m5_noshield c_length=4U c_width=4U
* device instance $880 r0 *1 47.4,128.2 cap_mim_2f0_m4m5_noshield
X$880 \$30__t36 topp__t323 cap_mim_2f0_m4m5_noshield c_length=4U c_width=4U
* device instance $881 r0 *1 53.8,128.2 cap_mim_2f0_m4m5_noshield
X$881 \$10__t162 topp__t324 cap_mim_2f0_m4m5_noshield c_length=4U c_width=4U
* device instance $882 r0 *1 60.2,128.2 cap_mim_2f0_m4m5_noshield
X$882 \$30__t41 topp__t334 cap_mim_2f0_m4m5_noshield c_length=4U c_width=4U
* device instance $883 r0 *1 66.6,128.2 cap_mim_2f0_m4m5_noshield
X$883 \$10__t164 topp__t326 cap_mim_2f0_m4m5_noshield c_length=4U c_width=4U
* device instance $884 r0 *1 73,128.2 cap_mim_2f0_m4m5_noshield
X$884 \$30__t37 topp__t327 cap_mim_2f0_m4m5_noshield c_length=4U c_width=4U
* device instance $885 r0 *1 79.4,128.2 cap_mim_2f0_m4m5_noshield
X$885 \$10__t165 topp__t328 cap_mim_2f0_m4m5_noshield c_length=4U c_width=4U
* device instance $886 r0 *1 85.8,128.2 cap_mim_2f0_m4m5_noshield
X$886 \$30__t38 topp__t329 cap_mim_2f0_m4m5_noshield c_length=4U c_width=4U
* device instance $887 r0 *1 92.2,128.2 cap_mim_2f0_m4m5_noshield
X$887 \$10__t166 topp__t330 cap_mim_2f0_m4m5_noshield c_length=4U c_width=4U
* device instance $888 r0 *1 98.6,128.2 cap_mim_2f0_m4m5_noshield
X$888 \$30__t39 topp__t331 cap_mim_2f0_m4m5_noshield c_length=4U c_width=4U
* device instance $889 r0 *1 105,128.2 cap_mim_2f0_m4m5_noshield
X$889 \$10__t167 topp__t332 cap_mim_2f0_m4m5_noshield c_length=4U c_width=4U
* device instance $890 r0 *1 111.4,128.2 cap_mim_2f0_m4m5_noshield
X$890 \$30__t40 topp__t333 cap_mim_2f0_m4m5_noshield c_length=4U c_width=4U
* device instance $891 r0 *1 117.8,128.2 cap_mim_2f0_m4m5_noshield
X$891 \$10__t163 topp__t325 cap_mim_2f0_m4m5_noshield c_length=4U c_width=4U
* device instance $892 r0 *1 124.2,128.2 cap_mim_2f0_m4m5_noshield
X$892 \$30__t35 topp__t321 cap_mim_2f0_m4m5_noshield c_length=4U c_width=4U
* device instance $893 r0 *1 130.6,128.2 cap_mim_2f0_m4m5_noshield
X$893 \$10__t160 topp__t320 cap_mim_2f0_m4m5_noshield c_length=4U c_width=4U
* device instance $894 r0 *1 137,128.2 cap_mim_2f0_m4m5_noshield
X$894 \$30__t34 topp__t319 cap_mim_2f0_m4m5_noshield c_length=4U c_width=4U
* device instance $895 r0 *1 143.4,128.2 cap_mim_2f0_m4m5_noshield
X$895 \$10__t159 topp__t318 cap_mim_2f0_m4m5_noshield c_length=4U c_width=4U
* device instance $896 r0 *1 149.8,128.2 cap_mim_2f0_m4m5_noshield
X$896 \$30__t33 topp__t317 cap_mim_2f0_m4m5_noshield c_length=4U c_width=4U
* device instance $897 r0 *1 156.2,128.2 cap_mim_2f0_m4m5_noshield
X$897 \$10__t158 topp__t316 cap_mim_2f0_m4m5_noshield c_length=4U c_width=4U
* device instance $898 r0 *1 162.6,128.2 cap_mim_2f0_m4m5_noshield
X$898 \$30__t32 topp__t315 cap_mim_2f0_m4m5_noshield c_length=4U c_width=4U
* device instance $899 r0 *1 169,128.2 cap_mim_2f0_m4m5_noshield
X$899 \$10__t157 topp__t314 cap_mim_2f0_m4m5_noshield c_length=4U c_width=4U
* device instance $900 r0 *1 175.4,128.2 cap_mim_2f0_m4m5_noshield
X$900 \$30__t31 topp__t313 cap_mim_2f0_m4m5_noshield c_length=4U c_width=4U
* device instance $901 r0 *1 181.8,128.2 cap_mim_2f0_m4m5_noshield
X$901 \$10__t156 topp__t312 cap_mim_2f0_m4m5_noshield c_length=4U c_width=4U
* device instance $902 r0 *1 188.2,128.2 cap_mim_2f0_m4m5_noshield
X$902 \$30__t30 topp__t311 cap_mim_2f0_m4m5_noshield c_length=4U c_width=4U
* device instance $903 r0 *1 194.6,128.2 cap_mim_2f0_m4m5_noshield
X$903 \$10__t155 topp__t310 cap_mim_2f0_m4m5_noshield c_length=4U c_width=4U
* device instance $904 r0 *1 201,128.2 cap_mim_2f0_m4m5_noshield
X$904 \$30__t29 topp__t309 cap_mim_2f0_m4m5_noshield c_length=4U c_width=4U
* device instance $905 r0 *1 224,128.2 cap_mim_2f0_m4m5_noshield
X$905 \$79__t85 topn__t173 cap_mim_2f0_m4m5_noshield c_length=4U c_width=4U
* device instance $906 r0 *1 230.4,128.2 cap_mim_2f0_m4m5_noshield
X$906 \$82__t15 topn__t172 cap_mim_2f0_m4m5_noshield c_length=4U c_width=4U
* device instance $907 r0 *1 236.8,128.2 cap_mim_2f0_m4m5_noshield
X$907 \$79__t187 topn__t376 cap_mim_2f0_m4m5_noshield c_length=4U c_width=4U
* device instance $908 r0 *1 243.2,128.2 cap_mim_2f0_m4m5_noshield
X$908 \$82__t41 topn__t377 cap_mim_2f0_m4m5_noshield c_length=4U c_width=4U
* device instance $909 r0 *1 249.6,128.2 cap_mim_2f0_m4m5_noshield
X$909 \$79__t188 topn__t378 cap_mim_2f0_m4m5_noshield c_length=4U c_width=4U
* device instance $910 r0 *1 256,128.2 cap_mim_2f0_m4m5_noshield
X$910 \$82__t42 topn__t379 cap_mim_2f0_m4m5_noshield c_length=4U c_width=4U
* device instance $911 r0 *1 262.4,128.2 cap_mim_2f0_m4m5_noshield
X$911 \$79__t189 topn__t380 cap_mim_2f0_m4m5_noshield c_length=4U c_width=4U
* device instance $912 r0 *1 268.8,128.2 cap_mim_2f0_m4m5_noshield
X$912 \$82__t43 topn__t381 cap_mim_2f0_m4m5_noshield c_length=4U c_width=4U
* device instance $913 r0 *1 275.2,128.2 cap_mim_2f0_m4m5_noshield
X$913 \$79__t190 topn__t382 cap_mim_2f0_m4m5_noshield c_length=4U c_width=4U
* device instance $914 r0 *1 281.6,128.2 cap_mim_2f0_m4m5_noshield
X$914 \$82__t44 topn__t383 cap_mim_2f0_m4m5_noshield c_length=4U c_width=4U
* device instance $915 r0 *1 288,128.2 cap_mim_2f0_m4m5_noshield
X$915 \$79__t191 topn__t384 cap_mim_2f0_m4m5_noshield c_length=4U c_width=4U
* device instance $916 r0 *1 294.4,128.2 cap_mim_2f0_m4m5_noshield
X$916 \$82__t52 topn__t401 cap_mim_2f0_m4m5_noshield c_length=4U c_width=4U
* device instance $917 r0 *1 300.8,128.2 cap_mim_2f0_m4m5_noshield
X$917 \$79__t192 topn__t386 cap_mim_2f0_m4m5_noshield c_length=4U c_width=4U
* device instance $918 r0 *1 307.2,128.2 cap_mim_2f0_m4m5_noshield
X$918 \$82__t45 topn__t387 cap_mim_2f0_m4m5_noshield c_length=4U c_width=4U
* device instance $919 r0 *1 313.6,128.2 cap_mim_2f0_m4m5_noshield
X$919 \$79__t193 topn__t388 cap_mim_2f0_m4m5_noshield c_length=4U c_width=4U
* device instance $920 r0 *1 320,128.2 cap_mim_2f0_m4m5_noshield
X$920 \$82__t46 topn__t389 cap_mim_2f0_m4m5_noshield c_length=4U c_width=4U
* device instance $921 r0 *1 326.4,128.2 cap_mim_2f0_m4m5_noshield
X$921 \$79__t194 topn__t390 cap_mim_2f0_m4m5_noshield c_length=4U c_width=4U
* device instance $922 r0 *1 332.8,128.2 cap_mim_2f0_m4m5_noshield
X$922 \$82__t47 topn__t391 cap_mim_2f0_m4m5_noshield c_length=4U c_width=4U
* device instance $923 r0 *1 339.2,128.2 cap_mim_2f0_m4m5_noshield
X$923 \$79__t195 topn__t392 cap_mim_2f0_m4m5_noshield c_length=4U c_width=4U
* device instance $924 r0 *1 345.6,128.2 cap_mim_2f0_m4m5_noshield
X$924 \$82__t48 topn__t393 cap_mim_2f0_m4m5_noshield c_length=4U c_width=4U
* device instance $925 r0 *1 352,128.2 cap_mim_2f0_m4m5_noshield
X$925 \$79__t196 topn__t394 cap_mim_2f0_m4m5_noshield c_length=4U c_width=4U
* device instance $926 r0 *1 358.4,128.2 cap_mim_2f0_m4m5_noshield
X$926 \$82__t49 topn__t395 cap_mim_2f0_m4m5_noshield c_length=4U c_width=4U
* device instance $927 r0 *1 364.8,128.2 cap_mim_2f0_m4m5_noshield
X$927 \$79__t197 topn__t396 cap_mim_2f0_m4m5_noshield c_length=4U c_width=4U
* device instance $928 r0 *1 371.2,128.2 cap_mim_2f0_m4m5_noshield
X$928 \$82__t50 topn__t397 cap_mim_2f0_m4m5_noshield c_length=4U c_width=4U
* device instance $929 r0 *1 377.6,128.2 cap_mim_2f0_m4m5_noshield
X$929 \$79__t198 topn__t398 cap_mim_2f0_m4m5_noshield c_length=4U c_width=4U
* device instance $930 r0 *1 384,128.2 cap_mim_2f0_m4m5_noshield
X$930 \$82__t51 topn__t399 cap_mim_2f0_m4m5_noshield c_length=4U c_width=4U
* device instance $931 r0 *1 390.4,128.2 cap_mim_2f0_m4m5_noshield
X$931 \$79__t106 topn__t217 cap_mim_2f0_m4m5_noshield c_length=4U c_width=4U
* device instance $932 r0 *1 396.8,128.2 cap_mim_2f0_m4m5_noshield
X$932 \$82__t18 topn__t219 cap_mim_2f0_m4m5_noshield c_length=4U c_width=4U
* device instance $933 r0 *1 403.2,128.2 cap_mim_2f0_m4m5_noshield
X$933 \$79__t107 topn__t220 cap_mim_2f0_m4m5_noshield c_length=4U c_width=4U
* device instance $934 r0 *1 409.6,128.2 cap_mim_2f0_m4m5_noshield
X$934 \$82__t19 topn__t221 cap_mim_2f0_m4m5_noshield c_length=4U c_width=4U
* device instance $935 r0 *1 416,128.2 cap_mim_2f0_m4m5_noshield
X$935 \$79__t108 topn__t222 cap_mim_2f0_m4m5_noshield c_length=4U c_width=4U
* device instance $936 r0 *1 422.4,128.2 cap_mim_2f0_m4m5_noshield
X$936 \$82__t20 topn__t223 cap_mim_2f0_m4m5_noshield c_length=4U c_width=4U
* device instance $937 r0 *1 2.6,134.6 cap_mim_2f0_m4m5_noshield
X$937 \$10__t19 topp__t36 cap_mim_2f0_m4m5_noshield c_length=4U c_width=4U
* device instance $938 r0 *1 9,134.6 cap_mim_2f0_m4m5_noshield
X$938 \$22__t63 topp__t210 cap_mim_2f0_m4m5_noshield c_length=4U c_width=4U
* device instance $939 r0 *1 15.4,134.6 cap_mim_2f0_m4m5_noshield
X$939 \$10__t105 topp__t209 cap_mim_2f0_m4m5_noshield c_length=4U c_width=4U
* device instance $940 r0 *1 21.8,134.6 cap_mim_2f0_m4m5_noshield
X$940 \$22__t62 topp__t208 cap_mim_2f0_m4m5_noshield c_length=4U c_width=4U
* device instance $941 r0 *1 28.2,134.6 cap_mim_2f0_m4m5_noshield
X$941 \$10__t22 topp__t41 cap_mim_2f0_m4m5_noshield c_length=4U c_width=4U
* device instance $942 r0 *1 34.6,134.6 cap_mim_2f0_m4m5_noshield
X$942 \$22__t10 topp__t40 cap_mim_2f0_m4m5_noshield c_length=4U c_width=4U
* device instance $943 r0 *1 41,134.6 cap_mim_2f0_m4m5_noshield
X$943 \$10__t21 topp__t39 cap_mim_2f0_m4m5_noshield c_length=4U c_width=4U
* device instance $944 r0 *1 47.4,134.6 cap_mim_2f0_m4m5_noshield
X$944 \$22__t9 topp__t38 cap_mim_2f0_m4m5_noshield c_length=4U c_width=4U
* device instance $945 r0 *1 53.8,134.6 cap_mim_2f0_m4m5_noshield
X$945 \$10__t20 topp__t37 cap_mim_2f0_m4m5_noshield c_length=4U c_width=4U
* device instance $946 r0 *1 60.2,134.6 cap_mim_2f0_m4m5_noshield
X$946 \$22__t26 topp__t110 cap_mim_2f0_m4m5_noshield c_length=4U c_width=4U
* device instance $947 r0 *1 66.6,134.6 cap_mim_2f0_m4m5_noshield
X$947 \$10__t104 topp__t207 cap_mim_2f0_m4m5_noshield c_length=4U c_width=4U
* device instance $948 r0 *1 73,134.6 cap_mim_2f0_m4m5_noshield
X$948 \$22__t61 topp__t205 cap_mim_2f0_m4m5_noshield c_length=4U c_width=4U
* device instance $949 r0 *1 79.4,134.6 cap_mim_2f0_m4m5_noshield
X$949 \$10__t102 topp__t204 cap_mim_2f0_m4m5_noshield c_length=4U c_width=4U
* device instance $950 r0 *1 85.8,134.6 cap_mim_2f0_m4m5_noshield
X$950 \$22__t60 topp__t203 cap_mim_2f0_m4m5_noshield c_length=4U c_width=4U
* device instance $951 r0 *1 92.2,134.6 cap_mim_2f0_m4m5_noshield
X$951 \$10__t103 topp__t206 cap_mim_2f0_m4m5_noshield c_length=4U c_width=4U
* device instance $952 r0 *1 98.6,134.6 cap_mim_2f0_m4m5_noshield
X$952 \$22__t58 topp__t201 cap_mim_2f0_m4m5_noshield c_length=4U c_width=4U
* device instance $953 r0 *1 105,134.6 cap_mim_2f0_m4m5_noshield
X$953 \$10__t101 topp__t200 cap_mim_2f0_m4m5_noshield c_length=4U c_width=4U
* device instance $954 r0 *1 111.4,134.6 cap_mim_2f0_m4m5_noshield
X$954 \$22__t54 topp__t193 cap_mim_2f0_m4m5_noshield c_length=4U c_width=4U
* device instance $955 r0 *1 117.8,134.6 cap_mim_2f0_m4m5_noshield
X$955 \$10__t138 topp__t278 cap_mim_2f0_m4m5_noshield c_length=4U c_width=4U
* device instance $956 r0 *1 124.2,134.6 cap_mim_2f0_m4m5_noshield
X$956 \$22__t27 topp__t112 cap_mim_2f0_m4m5_noshield c_length=4U c_width=4U
* device instance $957 r0 *1 130.6,134.6 cap_mim_2f0_m4m5_noshield
X$957 \$10__t132 topp__t262 cap_mim_2f0_m4m5_noshield c_length=4U c_width=4U
* device instance $958 r0 *1 137,134.6 cap_mim_2f0_m4m5_noshield
X$958 \$22__t89 topp__t307 cap_mim_2f0_m4m5_noshield c_length=4U c_width=4U
* device instance $959 r0 *1 143.4,134.6 cap_mim_2f0_m4m5_noshield
X$959 \$10__t147 topp__t293 cap_mim_2f0_m4m5_noshield c_length=4U c_width=4U
* device instance $960 r0 *1 149.8,134.6 cap_mim_2f0_m4m5_noshield
X$960 \$22__t82 topp__t292 cap_mim_2f0_m4m5_noshield c_length=4U c_width=4U
* device instance $961 r0 *1 156.2,134.6 cap_mim_2f0_m4m5_noshield
X$961 \$10__t146 topp__t291 cap_mim_2f0_m4m5_noshield c_length=4U c_width=4U
* device instance $962 r0 *1 162.6,134.6 cap_mim_2f0_m4m5_noshield
X$962 \$22__t17 topp__t89 cap_mim_2f0_m4m5_noshield c_length=4U c_width=4U
* device instance $963 r0 *1 169,134.6 cap_mim_2f0_m4m5_noshield
X$963 \$10__t45 topp__t88 cap_mim_2f0_m4m5_noshield c_length=4U c_width=4U
* device instance $964 r0 *1 175.4,134.6 cap_mim_2f0_m4m5_noshield
X$964 \$22__t15 topp__t74 cap_mim_2f0_m4m5_noshield c_length=4U c_width=4U
* device instance $965 r0 *1 181.8,134.6 cap_mim_2f0_m4m5_noshield
X$965 \$10__t38 topp__t73 cap_mim_2f0_m4m5_noshield c_length=4U c_width=4U
* device instance $966 r0 *1 188.2,134.6 cap_mim_2f0_m4m5_noshield
X$966 \$22__t29 topp__t115 cap_mim_2f0_m4m5_noshield c_length=4U c_width=4U
* device instance $967 r0 *1 194.6,134.6 cap_mim_2f0_m4m5_noshield
X$967 \$10__t58 topp__t114 cap_mim_2f0_m4m5_noshield c_length=4U c_width=4U
* device instance $968 r0 *1 201,134.6 cap_mim_2f0_m4m5_noshield
X$968 \$22__t28 topp__t113 cap_mim_2f0_m4m5_noshield c_length=4U c_width=4U
* device instance $969 r0 *1 224,134.6 cap_mim_2f0_m4m5_noshield
X$969 \$79__t2 topn__t6 cap_mim_2f0_m4m5_noshield c_length=4U c_width=4U
* device instance $970 r0 *1 230.4,134.6 cap_mim_2f0_m4m5_noshield
X$970 \$81__t1 topn__t5 cap_mim_2f0_m4m5_noshield c_length=4U c_width=4U
* device instance $971 r0 *1 236.8,134.6 cap_mim_2f0_m4m5_noshield
X$971 \$79__t233 topn__t465 cap_mim_2f0_m4m5_noshield c_length=4U c_width=4U
* device instance $972 r0 *1 243.2,134.6 cap_mim_2f0_m4m5_noshield
X$972 \$81__t118 topn__t466 cap_mim_2f0_m4m5_noshield c_length=4U c_width=4U
* device instance $973 r0 *1 249.6,134.6 cap_mim_2f0_m4m5_noshield
X$973 \$79__t234 topn__t467 cap_mim_2f0_m4m5_noshield c_length=4U c_width=4U
* device instance $974 r0 *1 256,134.6 cap_mim_2f0_m4m5_noshield
X$974 \$81__t119 topn__t468 cap_mim_2f0_m4m5_noshield c_length=4U c_width=4U
* device instance $975 r0 *1 262.4,134.6 cap_mim_2f0_m4m5_noshield
X$975 \$79__t235 topn__t469 cap_mim_2f0_m4m5_noshield c_length=4U c_width=4U
* device instance $976 r0 *1 268.8,134.6 cap_mim_2f0_m4m5_noshield
X$976 \$81__t120 topn__t470 cap_mim_2f0_m4m5_noshield c_length=4U c_width=4U
* device instance $977 r0 *1 275.2,134.6 cap_mim_2f0_m4m5_noshield
X$977 \$79__t206 topn__t412 cap_mim_2f0_m4m5_noshield c_length=4U c_width=4U
* device instance $978 r0 *1 281.6,134.6 cap_mim_2f0_m4m5_noshield
X$978 \$81__t101 topn__t410 cap_mim_2f0_m4m5_noshield c_length=4U c_width=4U
* device instance $979 r0 *1 288,134.6 cap_mim_2f0_m4m5_noshield
X$979 \$79__t205 topn__t411 cap_mim_2f0_m4m5_noshield c_length=4U c_width=4U
* device instance $980 r0 *1 294.4,134.6 cap_mim_2f0_m4m5_noshield
X$980 \$81__t72 topn__t273 cap_mim_2f0_m4m5_noshield c_length=4U c_width=4U
* device instance $981 r0 *1 300.8,134.6 cap_mim_2f0_m4m5_noshield
X$981 \$79__t216 topn__t431 cap_mim_2f0_m4m5_noshield c_length=4U c_width=4U
* device instance $982 r0 *1 307.2,134.6 cap_mim_2f0_m4m5_noshield
X$982 \$81__t111 topn__t432 cap_mim_2f0_m4m5_noshield c_length=4U c_width=4U
* device instance $983 r0 *1 313.6,134.6 cap_mim_2f0_m4m5_noshield
X$983 \$79__t221 topn__t439 cap_mim_2f0_m4m5_noshield c_length=4U c_width=4U
* device instance $984 r0 *1 320,134.6 cap_mim_2f0_m4m5_noshield
X$984 \$81__t107 topn__t424 cap_mim_2f0_m4m5_noshield c_length=4U c_width=4U
* device instance $985 r0 *1 326.4,134.6 cap_mim_2f0_m4m5_noshield
X$985 \$79__t213 topn__t425 cap_mim_2f0_m4m5_noshield c_length=4U c_width=4U
* device instance $986 r0 *1 332.8,134.6 cap_mim_2f0_m4m5_noshield
X$986 \$81__t108 topn__t426 cap_mim_2f0_m4m5_noshield c_length=4U c_width=4U
* device instance $987 r0 *1 339.2,134.6 cap_mim_2f0_m4m5_noshield
X$987 \$79__t214 topn__t427 cap_mim_2f0_m4m5_noshield c_length=4U c_width=4U
* device instance $988 r0 *1 345.6,134.6 cap_mim_2f0_m4m5_noshield
X$988 \$81__t109 topn__t428 cap_mim_2f0_m4m5_noshield c_length=4U c_width=4U
* device instance $989 r0 *1 352,134.6 cap_mim_2f0_m4m5_noshield
X$989 \$79__t118 topn__t240 cap_mim_2f0_m4m5_noshield c_length=4U c_width=4U
* device instance $990 r0 *1 358.4,134.6 cap_mim_2f0_m4m5_noshield
X$990 \$81__t51 topn__t189 cap_mim_2f0_m4m5_noshield c_length=4U c_width=4U
* device instance $991 r0 *1 364.8,134.6 cap_mim_2f0_m4m5_noshield
X$991 \$79__t97 topn__t201 cap_mim_2f0_m4m5_noshield c_length=4U c_width=4U
* device instance $992 r0 *1 371.2,134.6 cap_mim_2f0_m4m5_noshield
X$992 \$81__t74 topn__t279 cap_mim_2f0_m4m5_noshield c_length=4U c_width=4U
* device instance $993 r0 *1 377.6,134.6 cap_mim_2f0_m4m5_noshield
X$993 \$79__t145 topn__t291 cap_mim_2f0_m4m5_noshield c_length=4U c_width=4U
* device instance $994 r0 *1 384,134.6 cap_mim_2f0_m4m5_noshield
X$994 \$81__t79 topn__t303 cap_mim_2f0_m4m5_noshield c_length=4U c_width=4U
* device instance $995 r0 *1 390.4,134.6 cap_mim_2f0_m4m5_noshield
X$995 \$79__t89 topn__t183 cap_mim_2f0_m4m5_noshield c_length=4U c_width=4U
* device instance $996 r0 *1 396.8,134.6 cap_mim_2f0_m4m5_noshield
X$996 \$81__t48 topn__t184 cap_mim_2f0_m4m5_noshield c_length=4U c_width=4U
* device instance $997 r0 *1 403.2,134.6 cap_mim_2f0_m4m5_noshield
X$997 \$79__t90 topn__t185 cap_mim_2f0_m4m5_noshield c_length=4U c_width=4U
* device instance $998 r0 *1 409.6,134.6 cap_mim_2f0_m4m5_noshield
X$998 \$81__t49 topn__t186 cap_mim_2f0_m4m5_noshield c_length=4U c_width=4U
* device instance $999 r0 *1 416,134.6 cap_mim_2f0_m4m5_noshield
X$999 \$79__t91 topn__t187 cap_mim_2f0_m4m5_noshield c_length=4U c_width=4U
* device instance $1000 r0 *1 422.4,134.6 cap_mim_2f0_m4m5_noshield
X$1000 \$81__t50 topn__t188 cap_mim_2f0_m4m5_noshield c_length=4U c_width=4U
* device instance $1001 r0 *1 2.6,141 cap_mim_2f0_m4m5_noshield
X$1001 \$10__t18 topp__t35 cap_mim_2f0_m4m5_noshield c_length=4U c_width=4U
* device instance $1002 r0 *1 9,141 cap_mim_2f0_m4m5_noshield
X$1002 \$22__t8 topp__t34 cap_mim_2f0_m4m5_noshield c_length=4U c_width=4U
* device instance $1003 r0 *1 15.4,141 cap_mim_2f0_m4m5_noshield
X$1003 \$10__t17 topp__t33 cap_mim_2f0_m4m5_noshield c_length=4U c_width=4U
* device instance $1004 r0 *1 21.8,141 cap_mim_2f0_m4m5_noshield
X$1004 \$22__t7 topp__t32 cap_mim_2f0_m4m5_noshield c_length=4U c_width=4U
* device instance $1005 r0 *1 28.2,141 cap_mim_2f0_m4m5_noshield
X$1005 \$10__t70 topp__t135 cap_mim_2f0_m4m5_noshield c_length=4U c_width=4U
* device instance $1006 r0 *1 34.6,141 cap_mim_2f0_m4m5_noshield
X$1006 \$22__t65 topp__t214 cap_mim_2f0_m4m5_noshield c_length=4U c_width=4U
* device instance $1007 r0 *1 41,141 cap_mim_2f0_m4m5_noshield
X$1007 \$10__t107 topp__t213 cap_mim_2f0_m4m5_noshield c_length=4U c_width=4U
* device instance $1008 r0 *1 47.4,141 cap_mim_2f0_m4m5_noshield
X$1008 \$22__t64 topp__t212 cap_mim_2f0_m4m5_noshield c_length=4U c_width=4U
* device instance $1009 r0 *1 53.8,141 cap_mim_2f0_m4m5_noshield
X$1009 \$10__t106 topp__t211 cap_mim_2f0_m4m5_noshield c_length=4U c_width=4U
* device instance $1010 r0 *1 60.2,141 cap_mim_2f0_m4m5_noshield
X$1010 \$22__t6 topp__t29 cap_mim_2f0_m4m5_noshield c_length=4U c_width=4U
* device instance $1011 r0 *1 66.6,141 cap_mim_2f0_m4m5_noshield
X$1011 \$10__t108 topp__t215 cap_mim_2f0_m4m5_noshield c_length=4U c_width=4U
* device instance $1012 r0 *1 73,141 cap_mim_2f0_m4m5_noshield
X$1012 \$22__t57 topp__t198 cap_mim_2f0_m4m5_noshield c_length=4U c_width=4U
* device instance $1013 r0 *1 79.4,141 cap_mim_2f0_m4m5_noshield
X$1013 \$10__t100 topp__t197 cap_mim_2f0_m4m5_noshield c_length=4U c_width=4U
* device instance $1014 r0 *1 85.8,141 cap_mim_2f0_m4m5_noshield
X$1014 \$22__t56 topp__t196 cap_mim_2f0_m4m5_noshield c_length=4U c_width=4U
* device instance $1015 r0 *1 92.2,141 cap_mim_2f0_m4m5_noshield
X$1015 \$10__t99 topp__t195 cap_mim_2f0_m4m5_noshield c_length=4U c_width=4U
* device instance $1016 r0 *1 98.6,141 cap_mim_2f0_m4m5_noshield
X$1016 \$22__t55 topp__t194 cap_mim_2f0_m4m5_noshield c_length=4U c_width=4U
* device instance $1017 r0 *1 105,141 cap_mim_2f0_m4m5_noshield
X$1017 \$10__t98 topp__t192 cap_mim_2f0_m4m5_noshield c_length=4U c_width=4U
* device instance $1018 r0 *1 111.4,141 cap_mim_2f0_m4m5_noshield
X$1018 \$22__t59 topp__t202 cap_mim_2f0_m4m5_noshield c_length=4U c_width=4U
* device instance $1019 r0 *1 117.8,141 cap_mim_2f0_m4m5_noshield
X$1019 \$10__t137 topp__t276 cap_mim_2f0_m4m5_noshield c_length=4U c_width=4U
* device instance $1020 r0 *1 124.2,141 cap_mim_2f0_m4m5_noshield
X$1020 \$22__t73 topp__t261 cap_mim_2f0_m4m5_noshield c_length=4U c_width=4U
* device instance $1021 r0 *1 130.6,141 cap_mim_2f0_m4m5_noshield
X$1021 \$10__t131 topp__t260 cap_mim_2f0_m4m5_noshield c_length=4U c_width=4U
* device instance $1022 r0 *1 137,141 cap_mim_2f0_m4m5_noshield
X$1022 \$22__t72 topp__t259 cap_mim_2f0_m4m5_noshield c_length=4U c_width=4U
* device instance $1023 r0 *1 143.4,141 cap_mim_2f0_m4m5_noshield
X$1023 \$10__t130 topp__t258 cap_mim_2f0_m4m5_noshield c_length=4U c_width=4U
* device instance $1024 r0 *1 149.8,141 cap_mim_2f0_m4m5_noshield
X$1024 \$22__t71 topp__t257 cap_mim_2f0_m4m5_noshield c_length=4U c_width=4U
* device instance $1025 r0 *1 156.2,141 cap_mim_2f0_m4m5_noshield
X$1025 \$10__t129 topp__t256 cap_mim_2f0_m4m5_noshield c_length=4U c_width=4U
* device instance $1026 r0 *1 162.6,141 cap_mim_2f0_m4m5_noshield
X$1026 \$22__t70 topp__t255 cap_mim_2f0_m4m5_noshield c_length=4U c_width=4U
* device instance $1027 r0 *1 169,141 cap_mim_2f0_m4m5_noshield
X$1027 \$10__t128 topp__t254 cap_mim_2f0_m4m5_noshield c_length=4U c_width=4U
* device instance $1028 r0 *1 175.4,141 cap_mim_2f0_m4m5_noshield
X$1028 \$22__t69 topp__t253 cap_mim_2f0_m4m5_noshield c_length=4U c_width=4U
* device instance $1029 r0 *1 181.8,141 cap_mim_2f0_m4m5_noshield
X$1029 \$10__t127 topp__t252 cap_mim_2f0_m4m5_noshield c_length=4U c_width=4U
* device instance $1030 r0 *1 188.2,141 cap_mim_2f0_m4m5_noshield
X$1030 \$22__t68 topp__t251 cap_mim_2f0_m4m5_noshield c_length=4U c_width=4U
* device instance $1031 r0 *1 194.6,141 cap_mim_2f0_m4m5_noshield
X$1031 \$10__t126 topp__t250 cap_mim_2f0_m4m5_noshield c_length=4U c_width=4U
* device instance $1032 r0 *1 201,141 cap_mim_2f0_m4m5_noshield
X$1032 \$22__t67 topp__t249 cap_mim_2f0_m4m5_noshield c_length=4U c_width=4U
* device instance $1033 r0 *1 224,141 cap_mim_2f0_m4m5_noshield
X$1033 \$79__t68 topn__t138 cap_mim_2f0_m4m5_noshield c_length=4U c_width=4U
* device instance $1034 r0 *1 230.4,141 cap_mim_2f0_m4m5_noshield
X$1034 \$81__t38 topn__t139 cap_mim_2f0_m4m5_noshield c_length=4U c_width=4U
* device instance $1035 r0 *1 236.8,141 cap_mim_2f0_m4m5_noshield
X$1035 \$79__t207 topn__t413 cap_mim_2f0_m4m5_noshield c_length=4U c_width=4U
* device instance $1036 r0 *1 243.2,141 cap_mim_2f0_m4m5_noshield
X$1036 \$81__t102 topn__t414 cap_mim_2f0_m4m5_noshield c_length=4U c_width=4U
* device instance $1037 r0 *1 249.6,141 cap_mim_2f0_m4m5_noshield
X$1037 \$79__t208 topn__t415 cap_mim_2f0_m4m5_noshield c_length=4U c_width=4U
* device instance $1038 r0 *1 256,141 cap_mim_2f0_m4m5_noshield
X$1038 \$81__t103 topn__t416 cap_mim_2f0_m4m5_noshield c_length=4U c_width=4U
* device instance $1039 r0 *1 262.4,141 cap_mim_2f0_m4m5_noshield
X$1039 \$79__t253 topn__t507 cap_mim_2f0_m4m5_noshield c_length=4U c_width=4U
* device instance $1040 r0 *1 268.8,141 cap_mim_2f0_m4m5_noshield
X$1040 \$81__t126 topn__t508 cap_mim_2f0_m4m5_noshield c_length=4U c_width=4U
* device instance $1041 r0 *1 275.2,141 cap_mim_2f0_m4m5_noshield
X$1041 \$79__t254 topn__t509 cap_mim_2f0_m4m5_noshield c_length=4U c_width=4U
* device instance $1042 r0 *1 281.6,141 cap_mim_2f0_m4m5_noshield
X$1042 \$81__t127 topn__t511 cap_mim_2f0_m4m5_noshield c_length=4U c_width=4U
* device instance $1043 r0 *1 288,141 cap_mim_2f0_m4m5_noshield
X$1043 \$79__t201 topn__t404 cap_mim_2f0_m4m5_noshield c_length=4U c_width=4U
* device instance $1044 r0 *1 294.4,141 cap_mim_2f0_m4m5_noshield
X$1044 \$81__t65 topn__t259 cap_mim_2f0_m4m5_noshield c_length=4U c_width=4U
* device instance $1045 r0 *1 300.8,141 cap_mim_2f0_m4m5_noshield
X$1045 \$79__t209 topn__t417 cap_mim_2f0_m4m5_noshield c_length=4U c_width=4U
* device instance $1046 r0 *1 307.2,141 cap_mim_2f0_m4m5_noshield
X$1046 \$81__t104 topn__t418 cap_mim_2f0_m4m5_noshield c_length=4U c_width=4U
* device instance $1047 r0 *1 313.6,141 cap_mim_2f0_m4m5_noshield
X$1047 \$79__t210 topn__t419 cap_mim_2f0_m4m5_noshield c_length=4U c_width=4U
* device instance $1048 r0 *1 320,141 cap_mim_2f0_m4m5_noshield
X$1048 \$81__t105 topn__t420 cap_mim_2f0_m4m5_noshield c_length=4U c_width=4U
* device instance $1049 r0 *1 326.4,141 cap_mim_2f0_m4m5_noshield
X$1049 \$79__t211 topn__t421 cap_mim_2f0_m4m5_noshield c_length=4U c_width=4U
* device instance $1050 r0 *1 332.8,141 cap_mim_2f0_m4m5_noshield
X$1050 \$81__t106 topn__t422 cap_mim_2f0_m4m5_noshield c_length=4U c_width=4U
* device instance $1051 r0 *1 339.2,141 cap_mim_2f0_m4m5_noshield
X$1051 \$79__t215 topn__t429 cap_mim_2f0_m4m5_noshield c_length=4U c_width=4U
* device instance $1052 r0 *1 345.6,141 cap_mim_2f0_m4m5_noshield
X$1052 \$81__t110 topn__t430 cap_mim_2f0_m4m5_noshield c_length=4U c_width=4U
* device instance $1053 r0 *1 352,141 cap_mim_2f0_m4m5_noshield
X$1053 \$79__t110 topn__t225 cap_mim_2f0_m4m5_noshield c_length=4U c_width=4U
* device instance $1054 r0 *1 358.4,141 cap_mim_2f0_m4m5_noshield
X$1054 \$81__t52 topn__t190 cap_mim_2f0_m4m5_noshield c_length=4U c_width=4U
* device instance $1055 r0 *1 364.8,141 cap_mim_2f0_m4m5_noshield
X$1055 \$79__t92 topn__t191 cap_mim_2f0_m4m5_noshield c_length=4U c_width=4U
* device instance $1056 r0 *1 371.2,141 cap_mim_2f0_m4m5_noshield
X$1056 \$81__t53 topn__t192 cap_mim_2f0_m4m5_noshield c_length=4U c_width=4U
* device instance $1057 r0 *1 377.6,141 cap_mim_2f0_m4m5_noshield
X$1057 \$79__t102 topn__t209 cap_mim_2f0_m4m5_noshield c_length=4U c_width=4U
* device instance $1058 r0 *1 384,141 cap_mim_2f0_m4m5_noshield
X$1058 \$81__t54 topn__t194 cap_mim_2f0_m4m5_noshield c_length=4U c_width=4U
* device instance $1059 r0 *1 390.4,141 cap_mim_2f0_m4m5_noshield
X$1059 \$79__t94 topn__t195 cap_mim_2f0_m4m5_noshield c_length=4U c_width=4U
* device instance $1060 r0 *1 396.8,141 cap_mim_2f0_m4m5_noshield
X$1060 \$81__t55 topn__t196 cap_mim_2f0_m4m5_noshield c_length=4U c_width=4U
* device instance $1061 r0 *1 403.2,141 cap_mim_2f0_m4m5_noshield
X$1061 \$79__t95 topn__t197 cap_mim_2f0_m4m5_noshield c_length=4U c_width=4U
* device instance $1062 r0 *1 409.6,141 cap_mim_2f0_m4m5_noshield
X$1062 \$81__t56 topn__t198 cap_mim_2f0_m4m5_noshield c_length=4U c_width=4U
* device instance $1063 r0 *1 416,141 cap_mim_2f0_m4m5_noshield
X$1063 \$79__t96 topn__t199 cap_mim_2f0_m4m5_noshield c_length=4U c_width=4U
* device instance $1064 r0 *1 422.4,141 cap_mim_2f0_m4m5_noshield
X$1064 \$81__t57 topn__t200 cap_mim_2f0_m4m5_noshield c_length=4U c_width=4U
* device instance $1065 r0 *1 2.6,147.4 cap_mim_2f0_m4m5_noshield
X$1065 \$22__t25 topp__t108 cap_mim_2f0_m4m5_noshield c_length=4U c_width=4U
* device instance $1066 r0 *1 9,147.4 cap_mim_2f0_m4m5_noshield
X$1066 \$10__t61 topp__t119 cap_mim_2f0_m4m5_noshield c_length=4U c_width=4U
* device instance $1067 r0 *1 15.4,147.4 cap_mim_2f0_m4m5_noshield
X$1067 \$22__t24 topp__t106 cap_mim_2f0_m4m5_noshield c_length=4U c_width=4U
* device instance $1068 r0 *1 21.8,147.4 cap_mim_2f0_m4m5_noshield
X$1068 \$10__t55 topp__t105 cap_mim_2f0_m4m5_noshield c_length=4U c_width=4U
* device instance $1069 r0 *1 28.2,147.4 cap_mim_2f0_m4m5_noshield
X$1069 \$22__t23 topp__t104 cap_mim_2f0_m4m5_noshield c_length=4U c_width=4U
* device instance $1070 r0 *1 34.6,147.4 cap_mim_2f0_m4m5_noshield
X$1070 \$10__t54 topp__t103 cap_mim_2f0_m4m5_noshield c_length=4U c_width=4U
* device instance $1071 r0 *1 41,147.4 cap_mim_2f0_m4m5_noshield
X$1071 \$22__t22 topp__t102 cap_mim_2f0_m4m5_noshield c_length=4U c_width=4U
* device instance $1072 r0 *1 47.4,147.4 cap_mim_2f0_m4m5_noshield
X$1072 \$10__t53 topp__t101 cap_mim_2f0_m4m5_noshield c_length=4U c_width=4U
* device instance $1073 r0 *1 53.8,147.4 cap_mim_2f0_m4m5_noshield
X$1073 \$22__t21 topp__t100 cap_mim_2f0_m4m5_noshield c_length=4U c_width=4U
* device instance $1074 r0 *1 60.2,147.4 cap_mim_2f0_m4m5_noshield
X$1074 \$10__t52 topp__t99 cap_mim_2f0_m4m5_noshield c_length=4U c_width=4U
* device instance $1075 r0 *1 66.6,147.4 cap_mim_2f0_m4m5_noshield
X$1075 \$22__t20 topp__t98 cap_mim_2f0_m4m5_noshield c_length=4U c_width=4U
* device instance $1076 r0 *1 73,147.4 cap_mim_2f0_m4m5_noshield
X$1076 \$10__t51 topp__t97 cap_mim_2f0_m4m5_noshield c_length=4U c_width=4U
* device instance $1077 r0 *1 79.4,147.4 cap_mim_2f0_m4m5_noshield
X$1077 \$22__t19 topp__t96 cap_mim_2f0_m4m5_noshield c_length=4U c_width=4U
* device instance $1078 r0 *1 85.8,147.4 cap_mim_2f0_m4m5_noshield
X$1078 \$10__t50 topp__t95 cap_mim_2f0_m4m5_noshield c_length=4U c_width=4U
* device instance $1079 r0 *1 92.2,147.4 cap_mim_2f0_m4m5_noshield
X$1079 \$22__t18 topp__t94 cap_mim_2f0_m4m5_noshield c_length=4U c_width=4U
* device instance $1080 r0 *1 98.6,147.4 cap_mim_2f0_m4m5_noshield
X$1080 \$10__t49 topp__t93 cap_mim_2f0_m4m5_noshield c_length=4U c_width=4U
* device instance $1081 r0 *1 105,147.4 cap_mim_2f0_m4m5_noshield
X$1081 \$22__t16 topp__t77 cap_mim_2f0_m4m5_noshield c_length=4U c_width=4U
* device instance $1082 r0 *1 111.4,147.4 cap_mim_2f0_m4m5_noshield
X$1082 \$10__t16 topp__t30 cap_mim_2f0_m4m5_noshield c_length=4U c_width=4U
* device instance $1083 r0 *1 117.8,147.4 cap_mim_2f0_m4m5_noshield
X$1083 \$22__t76 topp__t275 cap_mim_2f0_m4m5_noshield c_length=4U c_width=4U
* device instance $1084 r0 *1 124.2,147.4 cap_mim_2f0_m4m5_noshield
X$1084 \$10__t154 topp__t306 cap_mim_2f0_m4m5_noshield c_length=4U c_width=4U
* device instance $1085 r0 *1 130.6,147.4 cap_mim_2f0_m4m5_noshield
X$1085 \$22__t88 topp__t305 cap_mim_2f0_m4m5_noshield c_length=4U c_width=4U
* device instance $1086 r0 *1 137,147.4 cap_mim_2f0_m4m5_noshield
X$1086 \$10__t153 topp__t304 cap_mim_2f0_m4m5_noshield c_length=4U c_width=4U
* device instance $1087 r0 *1 143.4,147.4 cap_mim_2f0_m4m5_noshield
X$1087 \$22__t87 topp__t303 cap_mim_2f0_m4m5_noshield c_length=4U c_width=4U
* device instance $1088 r0 *1 149.8,147.4 cap_mim_2f0_m4m5_noshield
X$1088 \$10__t152 topp__t302 cap_mim_2f0_m4m5_noshield c_length=4U c_width=4U
* device instance $1089 r0 *1 156.2,147.4 cap_mim_2f0_m4m5_noshield
X$1089 \$22__t86 topp__t301 cap_mim_2f0_m4m5_noshield c_length=4U c_width=4U
* device instance $1090 r0 *1 162.6,147.4 cap_mim_2f0_m4m5_noshield
X$1090 \$10__t151 topp__t300 cap_mim_2f0_m4m5_noshield c_length=4U c_width=4U
* device instance $1091 r0 *1 169,147.4 cap_mim_2f0_m4m5_noshield
X$1091 \$22__t85 topp__t299 cap_mim_2f0_m4m5_noshield c_length=4U c_width=4U
* device instance $1092 r0 *1 175.4,147.4 cap_mim_2f0_m4m5_noshield
X$1092 \$10__t150 topp__t298 cap_mim_2f0_m4m5_noshield c_length=4U c_width=4U
* device instance $1093 r0 *1 181.8,147.4 cap_mim_2f0_m4m5_noshield
X$1093 \$22__t84 topp__t297 cap_mim_2f0_m4m5_noshield c_length=4U c_width=4U
* device instance $1094 r0 *1 188.2,147.4 cap_mim_2f0_m4m5_noshield
X$1094 \$10__t149 topp__t296 cap_mim_2f0_m4m5_noshield c_length=4U c_width=4U
* device instance $1095 r0 *1 194.6,147.4 cap_mim_2f0_m4m5_noshield
X$1095 \$22__t83 topp__t295 cap_mim_2f0_m4m5_noshield c_length=4U c_width=4U
* device instance $1096 r0 *1 201,147.4 cap_mim_2f0_m4m5_noshield
X$1096 \$10__t148 topp__t294 cap_mim_2f0_m4m5_noshield c_length=4U c_width=4U
* device instance $1097 r0 *1 224,147.4 cap_mim_2f0_m4m5_noshield
X$1097 \$81__t39 topn__t140 cap_mim_2f0_m4m5_noshield c_length=4U c_width=4U
* device instance $1098 r0 *1 230.4,147.4 cap_mim_2f0_m4m5_noshield
X$1098 \$79__t67 topn__t137 cap_mim_2f0_m4m5_noshield c_length=4U c_width=4U
* device instance $1099 r0 *1 236.8,147.4 cap_mim_2f0_m4m5_noshield
X$1099 \$81__t66 topn__t262 cap_mim_2f0_m4m5_noshield c_length=4U c_width=4U
* device instance $1100 r0 *1 243.2,147.4 cap_mim_2f0_m4m5_noshield
X$1100 \$79__t130 topn__t263 cap_mim_2f0_m4m5_noshield c_length=4U c_width=4U
* device instance $1101 r0 *1 249.6,147.4 cap_mim_2f0_m4m5_noshield
X$1101 \$81__t67 topn__t264 cap_mim_2f0_m4m5_noshield c_length=4U c_width=4U
* device instance $1102 r0 *1 256,147.4 cap_mim_2f0_m4m5_noshield
X$1102 \$79__t131 topn__t265 cap_mim_2f0_m4m5_noshield c_length=4U c_width=4U
* device instance $1103 r0 *1 262.4,147.4 cap_mim_2f0_m4m5_noshield
X$1103 \$81__t68 topn__t266 cap_mim_2f0_m4m5_noshield c_length=4U c_width=4U
* device instance $1104 r0 *1 268.8,147.4 cap_mim_2f0_m4m5_noshield
X$1104 \$79__t132 topn__t267 cap_mim_2f0_m4m5_noshield c_length=4U c_width=4U
* device instance $1105 r0 *1 275.2,147.4 cap_mim_2f0_m4m5_noshield
X$1105 \$81__t69 topn__t268 cap_mim_2f0_m4m5_noshield c_length=4U c_width=4U
* device instance $1106 r0 *1 281.6,147.4 cap_mim_2f0_m4m5_noshield
X$1106 \$79__t133 topn__t269 cap_mim_2f0_m4m5_noshield c_length=4U c_width=4U
* device instance $1107 r0 *1 288,147.4 cap_mim_2f0_m4m5_noshield
X$1107 \$81__t70 topn__t270 cap_mim_2f0_m4m5_noshield c_length=4U c_width=4U
* device instance $1108 r0 *1 294.4,147.4 cap_mim_2f0_m4m5_noshield
X$1108 \$79__t134 topn__t271 cap_mim_2f0_m4m5_noshield c_length=4U c_width=4U
* device instance $1109 r0 *1 300.8,147.4 cap_mim_2f0_m4m5_noshield
X$1109 \$81__t71 topn__t272 cap_mim_2f0_m4m5_noshield c_length=4U c_width=4U
* device instance $1110 r0 *1 307.2,147.4 cap_mim_2f0_m4m5_noshield
X$1110 \$79__t93 topn__t193 cap_mim_2f0_m4m5_noshield c_length=4U c_width=4U
* device instance $1111 r0 *1 313.6,147.4 cap_mim_2f0_m4m5_noshield
X$1111 \$81__t61 topn__t251 cap_mim_2f0_m4m5_noshield c_length=4U c_width=4U
* device instance $1112 r0 *1 320,147.4 cap_mim_2f0_m4m5_noshield
X$1112 \$79__t124 topn__t252 cap_mim_2f0_m4m5_noshield c_length=4U c_width=4U
* device instance $1113 r0 *1 326.4,147.4 cap_mim_2f0_m4m5_noshield
X$1113 \$81__t62 topn__t253 cap_mim_2f0_m4m5_noshield c_length=4U c_width=4U
* device instance $1114 r0 *1 332.8,147.4 cap_mim_2f0_m4m5_noshield
X$1114 \$79__t125 topn__t254 cap_mim_2f0_m4m5_noshield c_length=4U c_width=4U
* device instance $1115 r0 *1 339.2,147.4 cap_mim_2f0_m4m5_noshield
X$1115 \$81__t63 topn__t255 cap_mim_2f0_m4m5_noshield c_length=4U c_width=4U
* device instance $1116 r0 *1 345.6,147.4 cap_mim_2f0_m4m5_noshield
X$1116 \$79__t126 topn__t256 cap_mim_2f0_m4m5_noshield c_length=4U c_width=4U
* device instance $1117 r0 *1 352,147.4 cap_mim_2f0_m4m5_noshield
X$1117 \$81__t46 topn__t179 cap_mim_2f0_m4m5_noshield c_length=4U c_width=4U
* device instance $1118 r0 *1 358.4,147.4 cap_mim_2f0_m4m5_noshield
X$1118 \$79__t98 topn__t202 cap_mim_2f0_m4m5_noshield c_length=4U c_width=4U
* device instance $1119 r0 *1 364.8,147.4 cap_mim_2f0_m4m5_noshield
X$1119 \$81__t58 topn__t203 cap_mim_2f0_m4m5_noshield c_length=4U c_width=4U
* device instance $1120 r0 *1 371.2,147.4 cap_mim_2f0_m4m5_noshield
X$1120 \$79__t99 topn__t204 cap_mim_2f0_m4m5_noshield c_length=4U c_width=4U
* device instance $1121 r0 *1 377.6,147.4 cap_mim_2f0_m4m5_noshield
X$1121 \$81__t59 topn__t205 cap_mim_2f0_m4m5_noshield c_length=4U c_width=4U
* device instance $1122 r0 *1 384,147.4 cap_mim_2f0_m4m5_noshield
X$1122 \$79__t100 topn__t206 cap_mim_2f0_m4m5_noshield c_length=4U c_width=4U
* device instance $1123 r0 *1 390.4,147.4 cap_mim_2f0_m4m5_noshield
X$1123 \$81__t60 topn__t207 cap_mim_2f0_m4m5_noshield c_length=4U c_width=4U
* device instance $1124 r0 *1 396.8,147.4 cap_mim_2f0_m4m5_noshield
X$1124 \$79__t101 topn__t208 cap_mim_2f0_m4m5_noshield c_length=4U c_width=4U
* device instance $1125 r0 *1 403.2,147.4 cap_mim_2f0_m4m5_noshield
X$1125 \$81__t64 topn__t257 cap_mim_2f0_m4m5_noshield c_length=4U c_width=4U
* device instance $1126 r0 *1 409.6,147.4 cap_mim_2f0_m4m5_noshield
X$1126 \$79__t135 topn__t274 cap_mim_2f0_m4m5_noshield c_length=4U c_width=4U
* device instance $1127 r0 *1 416,147.4 cap_mim_2f0_m4m5_noshield
X$1127 \$81__t73 topn__t275 cap_mim_2f0_m4m5_noshield c_length=4U c_width=4U
* device instance $1128 r0 *1 422.4,147.4 cap_mim_2f0_m4m5_noshield
X$1128 \$79__t138 topn__t278 cap_mim_2f0_m4m5_noshield c_length=4U c_width=4U
* device instance $1129 r0 *1 2.6,153.8 cap_mim_2f0_m4m5_noshield
X$1129 \$22__t11 topp__t43 cap_mim_2f0_m4m5_noshield c_length=4U c_width=4U
* device instance $1130 r0 *1 9,153.8 cap_mim_2f0_m4m5_noshield
X$1130 \$10__t23 topp__t42 cap_mim_2f0_m4m5_noshield c_length=4U c_width=4U
* device instance $1131 r0 *1 15.4,153.8 cap_mim_2f0_m4m5_noshield
X$1131 \$22__t12 topp__t44 cap_mim_2f0_m4m5_noshield c_length=4U c_width=4U
* device instance $1132 r0 *1 21.8,153.8 cap_mim_2f0_m4m5_noshield
X$1132 \$10__t3 topp__t5 cap_mim_2f0_m4m5_noshield c_length=4U c_width=4U
* device instance $1133 r0 *1 28.2,153.8 cap_mim_2f0_m4m5_noshield
X$1133 \$22__t1 topp__t4 cap_mim_2f0_m4m5_noshield c_length=4U c_width=4U
* device instance $1134 r0 *1 34.6,153.8 cap_mim_2f0_m4m5_noshield
X$1134 \$10__t26 topp__t48 cap_mim_2f0_m4m5_noshield c_length=4U c_width=4U
* device instance $1135 r0 *1 41,153.8 cap_mim_2f0_m4m5_noshield
X$1135 \$22__t14 topp__t63 cap_mim_2f0_m4m5_noshield c_length=4U c_width=4U
* device instance $1136 r0 *1 47.4,153.8 cap_mim_2f0_m4m5_noshield
X$1136 \$10__t24 topp__t46 cap_mim_2f0_m4m5_noshield c_length=4U c_width=4U
* device instance $1137 r0 *1 53.8,153.8 cap_mim_2f0_m4m5_noshield
X$1137 \$22__t13 topp__t45 cap_mim_2f0_m4m5_noshield c_length=4U c_width=4U
* device instance $1138 r0 *1 60.2,153.8 cap_mim_2f0_m4m5_noshield
X$1138 \$10__t57 topp__t111 cap_mim_2f0_m4m5_noshield c_length=4U c_width=4U
* device instance $1139 r0 *1 66.6,153.8 cap_mim_2f0_m4m5_noshield
X$1139 \$22__t4 topp__t26 cap_mim_2f0_m4m5_noshield c_length=4U c_width=4U
* device instance $1140 r0 *1 73,153.8 cap_mim_2f0_m4m5_noshield
X$1140 \$10__t14 topp__t25 cap_mim_2f0_m4m5_noshield c_length=4U c_width=4U
* device instance $1141 r0 *1 79.4,153.8 cap_mim_2f0_m4m5_noshield
X$1141 \$22__t3 topp__t16 cap_mim_2f0_m4m5_noshield c_length=4U c_width=4U
* device instance $1142 r0 *1 85.8,153.8 cap_mim_2f0_m4m5_noshield
X$1142 \$10__t5 topp__t8 cap_mim_2f0_m4m5_noshield c_length=4U c_width=4U
* device instance $1143 r0 *1 92.2,153.8 cap_mim_2f0_m4m5_noshield
X$1143 \$22__t2 topp__t7 cap_mim_2f0_m4m5_noshield c_length=4U c_width=4U
* device instance $1144 r0 *1 98.6,153.8 cap_mim_2f0_m4m5_noshield
X$1144 \$10__t4 topp__t6 cap_mim_2f0_m4m5_noshield c_length=4U c_width=4U
* device instance $1145 r0 *1 105,153.8 cap_mim_2f0_m4m5_noshield
X$1145 \$22__t5 topp__t28 cap_mim_2f0_m4m5_noshield c_length=4U c_width=4U
* device instance $1146 r0 *1 111.4,153.8 cap_mim_2f0_m4m5_noshield
X$1146 \$10__t15 topp__t27 cap_mim_2f0_m4m5_noshield c_length=4U c_width=4U
* device instance $1147 r0 *1 117.8,153.8 cap_mim_2f0_m4m5_noshield
X$1147 \$22__t75 topp__t272 cap_mim_2f0_m4m5_noshield c_length=4U c_width=4U
* device instance $1148 r0 *1 124.2,153.8 cap_mim_2f0_m4m5_noshield
X$1148 \$10__t145 topp__t290 cap_mim_2f0_m4m5_noshield c_length=4U c_width=4U
* device instance $1149 r0 *1 130.6,153.8 cap_mim_2f0_m4m5_noshield
X$1149 \$22__t81 topp__t289 cap_mim_2f0_m4m5_noshield c_length=4U c_width=4U
* device instance $1150 r0 *1 137,153.8 cap_mim_2f0_m4m5_noshield
X$1150 \$10__t144 topp__t288 cap_mim_2f0_m4m5_noshield c_length=4U c_width=4U
* device instance $1151 r0 *1 143.4,153.8 cap_mim_2f0_m4m5_noshield
X$1151 \$22__t80 topp__t287 cap_mim_2f0_m4m5_noshield c_length=4U c_width=4U
* device instance $1152 r0 *1 149.8,153.8 cap_mim_2f0_m4m5_noshield
X$1152 \$10__t143 topp__t286 cap_mim_2f0_m4m5_noshield c_length=4U c_width=4U
* device instance $1153 r0 *1 156.2,153.8 cap_mim_2f0_m4m5_noshield
X$1153 \$22__t79 topp__t285 cap_mim_2f0_m4m5_noshield c_length=4U c_width=4U
* device instance $1154 r0 *1 162.6,153.8 cap_mim_2f0_m4m5_noshield
X$1154 \$10__t142 topp__t284 cap_mim_2f0_m4m5_noshield c_length=4U c_width=4U
* device instance $1155 r0 *1 169,153.8 cap_mim_2f0_m4m5_noshield
X$1155 \$22__t78 topp__t283 cap_mim_2f0_m4m5_noshield c_length=4U c_width=4U
* device instance $1156 r0 *1 175.4,153.8 cap_mim_2f0_m4m5_noshield
X$1156 \$10__t141 topp__t282 cap_mim_2f0_m4m5_noshield c_length=4U c_width=4U
* device instance $1157 r0 *1 181.8,153.8 cap_mim_2f0_m4m5_noshield
X$1157 \$22__t77 topp__t281 cap_mim_2f0_m4m5_noshield c_length=4U c_width=4U
* device instance $1158 r0 *1 188.2,153.8 cap_mim_2f0_m4m5_noshield
X$1158 \$10__t140 topp__t280 cap_mim_2f0_m4m5_noshield c_length=4U c_width=4U
* device instance $1159 r0 *1 194.6,153.8 cap_mim_2f0_m4m5_noshield
X$1159 \$22__t66 topp__t248 cap_mim_2f0_m4m5_noshield c_length=4U c_width=4U
* device instance $1160 r0 *1 201,153.8 cap_mim_2f0_m4m5_noshield
X$1160 \$10__t46 topp__t90 cap_mim_2f0_m4m5_noshield c_length=4U c_width=4U
* device instance $1161 r0 *1 224,153.8 cap_mim_2f0_m4m5_noshield
X$1161 \$81__t0 topn__t4 cap_mim_2f0_m4m5_noshield c_length=4U c_width=4U
* device instance $1162 r0 *1 230.4,153.8 cap_mim_2f0_m4m5_noshield
X$1162 \$79__t1 topn__t3 cap_mim_2f0_m4m5_noshield c_length=4U c_width=4U
* device instance $1163 r0 *1 236.8,153.8 cap_mim_2f0_m4m5_noshield
X$1163 \$81__t121 topn__t471 cap_mim_2f0_m4m5_noshield c_length=4U c_width=4U
* device instance $1164 r0 *1 243.2,153.8 cap_mim_2f0_m4m5_noshield
X$1164 \$79__t228 topn__t454 cap_mim_2f0_m4m5_noshield c_length=4U c_width=4U
* device instance $1165 r0 *1 249.6,153.8 cap_mim_2f0_m4m5_noshield
X$1165 \$81__t114 topn__t455 cap_mim_2f0_m4m5_noshield c_length=4U c_width=4U
* device instance $1166 r0 *1 256,153.8 cap_mim_2f0_m4m5_noshield
X$1166 \$79__t229 topn__t456 cap_mim_2f0_m4m5_noshield c_length=4U c_width=4U
* device instance $1167 r0 *1 262.4,153.8 cap_mim_2f0_m4m5_noshield
X$1167 \$81__t115 topn__t457 cap_mim_2f0_m4m5_noshield c_length=4U c_width=4U
* device instance $1168 r0 *1 268.8,153.8 cap_mim_2f0_m4m5_noshield
X$1168 \$79__t230 topn__t458 cap_mim_2f0_m4m5_noshield c_length=4U c_width=4U
* device instance $1169 r0 *1 275.2,153.8 cap_mim_2f0_m4m5_noshield
X$1169 \$81__t116 topn__t459 cap_mim_2f0_m4m5_noshield c_length=4U c_width=4U
* device instance $1170 r0 *1 281.6,153.8 cap_mim_2f0_m4m5_noshield
X$1170 \$79__t231 topn__t460 cap_mim_2f0_m4m5_noshield c_length=4U c_width=4U
* device instance $1171 r0 *1 288,153.8 cap_mim_2f0_m4m5_noshield
X$1171 \$81__t117 topn__t461 cap_mim_2f0_m4m5_noshield c_length=4U c_width=4U
* device instance $1172 r0 *1 294.4,153.8 cap_mim_2f0_m4m5_noshield
X$1172 \$79__t127 topn__t258 cap_mim_2f0_m4m5_noshield c_length=4U c_width=4U
* device instance $1173 r0 *1 300.8,153.8 cap_mim_2f0_m4m5_noshield
X$1173 \$81__t124 topn__t488 cap_mim_2f0_m4m5_noshield c_length=4U c_width=4U
* device instance $1174 r0 *1 307.2,153.8 cap_mim_2f0_m4m5_noshield
X$1174 \$79__t245 topn__t489 cap_mim_2f0_m4m5_noshield c_length=4U c_width=4U
* device instance $1175 r0 *1 313.6,153.8 cap_mim_2f0_m4m5_noshield
X$1175 \$81__t122 topn__t474 cap_mim_2f0_m4m5_noshield c_length=4U c_width=4U
* device instance $1176 r0 *1 320,153.8 cap_mim_2f0_m4m5_noshield
X$1176 \$79__t241 topn__t483 cap_mim_2f0_m4m5_noshield c_length=4U c_width=4U
* device instance $1177 r0 *1 326.4,153.8 cap_mim_2f0_m4m5_noshield
X$1177 \$81__t123 topn__t484 cap_mim_2f0_m4m5_noshield c_length=4U c_width=4U
* device instance $1178 r0 *1 332.8,153.8 cap_mim_2f0_m4m5_noshield
X$1178 \$79__t242 topn__t485 cap_mim_2f0_m4m5_noshield c_length=4U c_width=4U
* device instance $1179 r0 *1 339.2,153.8 cap_mim_2f0_m4m5_noshield
X$1179 \$81__t125 topn__t502 cap_mim_2f0_m4m5_noshield c_length=4U c_width=4U
* device instance $1180 r0 *1 345.6,153.8 cap_mim_2f0_m4m5_noshield
X$1180 \$79__t244 topn__t487 cap_mim_2f0_m4m5_noshield c_length=4U c_width=4U
* device instance $1181 r0 *1 352,153.8 cap_mim_2f0_m4m5_noshield
X$1181 \$81__t47 topn__t180 cap_mim_2f0_m4m5_noshield c_length=4U c_width=4U
* device instance $1182 r0 *1 358.4,153.8 cap_mim_2f0_m4m5_noshield
X$1182 \$79__t139 topn__t280 cap_mim_2f0_m4m5_noshield c_length=4U c_width=4U
* device instance $1183 r0 *1 364.8,153.8 cap_mim_2f0_m4m5_noshield
X$1183 \$81__t75 topn__t281 cap_mim_2f0_m4m5_noshield c_length=4U c_width=4U
* device instance $1184 r0 *1 371.2,153.8 cap_mim_2f0_m4m5_noshield
X$1184 \$79__t140 topn__t282 cap_mim_2f0_m4m5_noshield c_length=4U c_width=4U
* device instance $1185 r0 *1 377.6,153.8 cap_mim_2f0_m4m5_noshield
X$1185 \$81__t76 topn__t283 cap_mim_2f0_m4m5_noshield c_length=4U c_width=4U
* device instance $1186 r0 *1 384,153.8 cap_mim_2f0_m4m5_noshield
X$1186 \$79__t141 topn__t284 cap_mim_2f0_m4m5_noshield c_length=4U c_width=4U
* device instance $1187 r0 *1 390.4,153.8 cap_mim_2f0_m4m5_noshield
X$1187 \$81__t77 topn__t285 cap_mim_2f0_m4m5_noshield c_length=4U c_width=4U
* device instance $1188 r0 *1 396.8,153.8 cap_mim_2f0_m4m5_noshield
X$1188 \$79__t142 topn__t286 cap_mim_2f0_m4m5_noshield c_length=4U c_width=4U
* device instance $1189 r0 *1 403.2,153.8 cap_mim_2f0_m4m5_noshield
X$1189 \$81__t78 topn__t287 cap_mim_2f0_m4m5_noshield c_length=4U c_width=4U
* device instance $1190 r0 *1 409.6,153.8 cap_mim_2f0_m4m5_noshield
X$1190 \$79__t143 topn__t288 cap_mim_2f0_m4m5_noshield c_length=4U c_width=4U
* device instance $1191 r0 *1 416,153.8 cap_mim_2f0_m4m5_noshield
X$1191 \$81__t80 topn__t305 cap_mim_2f0_m4m5_noshield c_length=4U c_width=4U
* device instance $1192 r0 *1 422.4,153.8 cap_mim_2f0_m4m5_noshield
X$1192 \$79__t144 topn__t290 cap_mim_2f0_m4m5_noshield c_length=4U c_width=4U
* device instance $1193 r0 *1 2.6,160.2 cap_mim_2f0_m4m5_noshield
X$1193 \$30__t0 topp__t3 cap_mim_2f0_m4m5_noshield c_length=4U c_width=4U
* device instance $1194 r0 *1 9,160.2 cap_mim_2f0_m4m5_noshield
X$1194 \$10__t2 topp__t2 cap_mim_2f0_m4m5_noshield c_length=4U c_width=4U
* device instance $1195 r0 *1 15.4,160.2 cap_mim_2f0_m4m5_noshield
X$1195 \$30__t8 topp__t55 cap_mim_2f0_m4m5_noshield c_length=4U c_width=4U
* device instance $1196 r0 *1 21.8,160.2 cap_mim_2f0_m4m5_noshield
X$1196 \$10__t29 topp__t54 cap_mim_2f0_m4m5_noshield c_length=4U c_width=4U
* device instance $1197 r0 *1 28.2,160.2 cap_mim_2f0_m4m5_noshield
X$1197 \$30__t7 topp__t53 cap_mim_2f0_m4m5_noshield c_length=4U c_width=4U
* device instance $1198 r0 *1 34.6,160.2 cap_mim_2f0_m4m5_noshield
X$1198 \$10__t28 topp__t52 cap_mim_2f0_m4m5_noshield c_length=4U c_width=4U
* device instance $1199 r0 *1 41,160.2 cap_mim_2f0_m4m5_noshield
X$1199 \$30__t6 topp__t51 cap_mim_2f0_m4m5_noshield c_length=4U c_width=4U
* device instance $1200 r0 *1 47.4,160.2 cap_mim_2f0_m4m5_noshield
X$1200 \$10__t27 topp__t50 cap_mim_2f0_m4m5_noshield c_length=4U c_width=4U
* device instance $1201 r0 *1 53.8,160.2 cap_mim_2f0_m4m5_noshield
X$1201 \$30__t5 topp__t49 cap_mim_2f0_m4m5_noshield c_length=4U c_width=4U
* device instance $1202 r0 *1 60.2,160.2 cap_mim_2f0_m4m5_noshield
X$1202 \$10__t56 topp__t109 cap_mim_2f0_m4m5_noshield c_length=4U c_width=4U
* device instance $1203 r0 *1 66.6,160.2 cap_mim_2f0_m4m5_noshield
X$1203 \$30__t4 topp__t24 cap_mim_2f0_m4m5_noshield c_length=4U c_width=4U
* device instance $1204 r0 *1 73,160.2 cap_mim_2f0_m4m5_noshield
X$1204 \$10__t13 topp__t23 cap_mim_2f0_m4m5_noshield c_length=4U c_width=4U
* device instance $1205 r0 *1 79.4,160.2 cap_mim_2f0_m4m5_noshield
X$1205 \$30__t3 topp__t22 cap_mim_2f0_m4m5_noshield c_length=4U c_width=4U
* device instance $1206 r0 *1 85.8,160.2 cap_mim_2f0_m4m5_noshield
X$1206 \$10__t12 topp__t21 cap_mim_2f0_m4m5_noshield c_length=4U c_width=4U
* device instance $1207 r0 *1 92.2,160.2 cap_mim_2f0_m4m5_noshield
X$1207 \$30__t2 topp__t20 cap_mim_2f0_m4m5_noshield c_length=4U c_width=4U
* device instance $1208 r0 *1 98.6,160.2 cap_mim_2f0_m4m5_noshield
X$1208 \$10__t11 topp__t19 cap_mim_2f0_m4m5_noshield c_length=4U c_width=4U
* device instance $1209 r0 *1 105,160.2 cap_mim_2f0_m4m5_noshield
X$1209 \$30__t1 topp__t18 cap_mim_2f0_m4m5_noshield c_length=4U c_width=4U
* device instance $1210 r0 *1 111.4,160.2 cap_mim_2f0_m4m5_noshield
X$1210 \$10__t10 topp__t17 cap_mim_2f0_m4m5_noshield c_length=4U c_width=4U
* device instance $1211 r0 *1 117.8,160.2 cap_mim_2f0_m4m5_noshield
X$1211 \$30__t27 topp__t270 cap_mim_2f0_m4m5_noshield c_length=4U c_width=4U
* device instance $1212 r0 *1 124.2,160.2 cap_mim_2f0_m4m5_noshield
X$1212 \$10__t44 topp__t87 cap_mim_2f0_m4m5_noshield c_length=4U c_width=4U
* device instance $1213 r0 *1 130.6,160.2 cap_mim_2f0_m4m5_noshield
X$1213 \$30__t14 topp__t86 cap_mim_2f0_m4m5_noshield c_length=4U c_width=4U
* device instance $1214 r0 *1 137,160.2 cap_mim_2f0_m4m5_noshield
X$1214 \$10__t43 topp__t85 cap_mim_2f0_m4m5_noshield c_length=4U c_width=4U
* device instance $1215 r0 *1 143.4,160.2 cap_mim_2f0_m4m5_noshield
X$1215 \$30__t13 topp__t84 cap_mim_2f0_m4m5_noshield c_length=4U c_width=4U
* device instance $1216 r0 *1 149.8,160.2 cap_mim_2f0_m4m5_noshield
X$1216 \$10__t42 topp__t83 cap_mim_2f0_m4m5_noshield c_length=4U c_width=4U
* device instance $1217 r0 *1 156.2,160.2 cap_mim_2f0_m4m5_noshield
X$1217 \$30__t12 topp__t82 cap_mim_2f0_m4m5_noshield c_length=4U c_width=4U
* device instance $1218 r0 *1 162.6,160.2 cap_mim_2f0_m4m5_noshield
X$1218 \$10__t41 topp__t81 cap_mim_2f0_m4m5_noshield c_length=4U c_width=4U
* device instance $1219 r0 *1 169,160.2 cap_mim_2f0_m4m5_noshield
X$1219 \$30__t11 topp__t80 cap_mim_2f0_m4m5_noshield c_length=4U c_width=4U
* device instance $1220 r0 *1 175.4,160.2 cap_mim_2f0_m4m5_noshield
X$1220 \$10__t40 topp__t79 cap_mim_2f0_m4m5_noshield c_length=4U c_width=4U
* device instance $1221 r0 *1 181.8,160.2 cap_mim_2f0_m4m5_noshield
X$1221 \$30__t10 topp__t78 cap_mim_2f0_m4m5_noshield c_length=4U c_width=4U
* device instance $1222 r0 *1 188.2,160.2 cap_mim_2f0_m4m5_noshield
X$1222 \$10__t47 topp__t91 cap_mim_2f0_m4m5_noshield c_length=4U c_width=4U
* device instance $1223 r0 *1 194.6,160.2 cap_mim_2f0_m4m5_noshield
X$1223 \$30__t9 topp__t76 cap_mim_2f0_m4m5_noshield c_length=4U c_width=4U
* device instance $1224 r0 *1 201,160.2 cap_mim_2f0_m4m5_noshield
X$1224 \$10__t39 topp__t75 cap_mim_2f0_m4m5_noshield c_length=4U c_width=4U
* device instance $1225 r0 *1 224,160.2 cap_mim_2f0_m4m5_noshield
X$1225 \$82__t1 topn__t2 cap_mim_2f0_m4m5_noshield c_length=4U c_width=4U
* device instance $1226 r0 *1 230.4,160.2 cap_mim_2f0_m4m5_noshield
X$1226 \$79__t0 topn__t1 cap_mim_2f0_m4m5_noshield c_length=4U c_width=4U
* device instance $1227 r0 *1 236.8,160.2 cap_mim_2f0_m4m5_noshield
X$1227 \$82__t62 topn__t501 cap_mim_2f0_m4m5_noshield c_length=4U c_width=4U
* device instance $1228 r0 *1 243.2,160.2 cap_mim_2f0_m4m5_noshield
X$1228 \$79__t243 topn__t486 cap_mim_2f0_m4m5_noshield c_length=4U c_width=4U
* device instance $1229 r0 *1 249.6,160.2 cap_mim_2f0_m4m5_noshield
X$1229 \$82__t54 topn__t447 cap_mim_2f0_m4m5_noshield c_length=4U c_width=4U
* device instance $1230 r0 *1 256,160.2 cap_mim_2f0_m4m5_noshield
X$1230 \$79__t225 topn__t448 cap_mim_2f0_m4m5_noshield c_length=4U c_width=4U
* device instance $1231 r0 *1 262.4,160.2 cap_mim_2f0_m4m5_noshield
X$1231 \$82__t55 topn__t449 cap_mim_2f0_m4m5_noshield c_length=4U c_width=4U
* device instance $1232 r0 *1 268.8,160.2 cap_mim_2f0_m4m5_noshield
X$1232 \$79__t226 topn__t450 cap_mim_2f0_m4m5_noshield c_length=4U c_width=4U
* device instance $1233 r0 *1 275.2,160.2 cap_mim_2f0_m4m5_noshield
X$1233 \$82__t56 topn__t451 cap_mim_2f0_m4m5_noshield c_length=4U c_width=4U
* device instance $1234 r0 *1 281.6,160.2 cap_mim_2f0_m4m5_noshield
X$1234 \$79__t227 topn__t452 cap_mim_2f0_m4m5_noshield c_length=4U c_width=4U
* device instance $1235 r0 *1 288,160.2 cap_mim_2f0_m4m5_noshield
X$1235 \$82__t57 topn__t453 cap_mim_2f0_m4m5_noshield c_length=4U c_width=4U
* device instance $1236 r0 *1 294.4,160.2 cap_mim_2f0_m4m5_noshield
X$1236 \$79__t128 topn__t260 cap_mim_2f0_m4m5_noshield c_length=4U c_width=4U
* device instance $1237 r0 *1 300.8,160.2 cap_mim_2f0_m4m5_noshield
X$1237 \$82__t59 topn__t490 cap_mim_2f0_m4m5_noshield c_length=4U c_width=4U
* device instance $1238 r0 *1 307.2,160.2 cap_mim_2f0_m4m5_noshield
X$1238 \$79__t246 topn__t491 cap_mim_2f0_m4m5_noshield c_length=4U c_width=4U
* device instance $1239 r0 *1 313.6,160.2 cap_mim_2f0_m4m5_noshield
X$1239 \$82__t60 topn__t492 cap_mim_2f0_m4m5_noshield c_length=4U c_width=4U
* device instance $1240 r0 *1 320,160.2 cap_mim_2f0_m4m5_noshield
X$1240 \$79__t247 topn__t493 cap_mim_2f0_m4m5_noshield c_length=4U c_width=4U
* device instance $1241 r0 *1 326.4,160.2 cap_mim_2f0_m4m5_noshield
X$1241 \$82__t61 topn__t494 cap_mim_2f0_m4m5_noshield c_length=4U c_width=4U
* device instance $1242 r0 *1 332.8,160.2 cap_mim_2f0_m4m5_noshield
X$1242 \$79__t255 topn__t510 cap_mim_2f0_m4m5_noshield c_length=4U c_width=4U
* device instance $1243 r0 *1 339.2,160.2 cap_mim_2f0_m4m5_noshield
X$1243 \$82__t58 topn__t472 cap_mim_2f0_m4m5_noshield c_length=4U c_width=4U
* device instance $1244 r0 *1 345.6,160.2 cap_mim_2f0_m4m5_noshield
X$1244 \$79__t236 topn__t473 cap_mim_2f0_m4m5_noshield c_length=4U c_width=4U
* device instance $1245 r0 *1 352,160.2 cap_mim_2f0_m4m5_noshield
X$1245 \$82__t16 topn__t181 cap_mim_2f0_m4m5_noshield c_length=4U c_width=4U
* device instance $1246 r0 *1 358.4,160.2 cap_mim_2f0_m4m5_noshield
X$1246 \$79__t146 topn__t292 cap_mim_2f0_m4m5_noshield c_length=4U c_width=4U
* device instance $1247 r0 *1 364.8,160.2 cap_mim_2f0_m4m5_noshield
X$1247 \$82__t26 topn__t293 cap_mim_2f0_m4m5_noshield c_length=4U c_width=4U
* device instance $1248 r0 *1 371.2,160.2 cap_mim_2f0_m4m5_noshield
X$1248 \$79__t147 topn__t294 cap_mim_2f0_m4m5_noshield c_length=4U c_width=4U
* device instance $1249 r0 *1 377.6,160.2 cap_mim_2f0_m4m5_noshield
X$1249 \$82__t27 topn__t295 cap_mim_2f0_m4m5_noshield c_length=4U c_width=4U
* device instance $1250 r0 *1 384,160.2 cap_mim_2f0_m4m5_noshield
X$1250 \$79__t148 topn__t296 cap_mim_2f0_m4m5_noshield c_length=4U c_width=4U
* device instance $1251 r0 *1 390.4,160.2 cap_mim_2f0_m4m5_noshield
X$1251 \$82__t28 topn__t297 cap_mim_2f0_m4m5_noshield c_length=4U c_width=4U
* device instance $1252 r0 *1 396.8,160.2 cap_mim_2f0_m4m5_noshield
X$1252 \$79__t149 topn__t298 cap_mim_2f0_m4m5_noshield c_length=4U c_width=4U
* device instance $1253 r0 *1 403.2,160.2 cap_mim_2f0_m4m5_noshield
X$1253 \$82__t29 topn__t299 cap_mim_2f0_m4m5_noshield c_length=4U c_width=4U
* device instance $1254 r0 *1 409.6,160.2 cap_mim_2f0_m4m5_noshield
X$1254 \$79__t150 topn__t300 cap_mim_2f0_m4m5_noshield c_length=4U c_width=4U
* device instance $1255 r0 *1 416,160.2 cap_mim_2f0_m4m5_noshield
X$1255 \$82__t30 topn__t301 cap_mim_2f0_m4m5_noshield c_length=4U c_width=4U
* device instance $1256 r0 *1 422.4,160.2 cap_mim_2f0_m4m5_noshield
X$1256 \$79__t151 topn__t302 cap_mim_2f0_m4m5_noshield c_length=4U c_width=4U
* device instance $1257 r0 *1 2.6,166.6 cap_mim_2f0_m4m5_noshield
X$1257 \$38__t0 topp__t1 cap_mim_2f0_m4m5_noshield c_length=4U c_width=4U
* device instance $1258 r0 *1 9,166.6 cap_mim_2f0_m4m5_noshield
X$1258 \$10__t25 topp__t47 cap_mim_2f0_m4m5_noshield c_length=4U c_width=4U
* device instance $1259 r0 *1 15.4,166.6 cap_mim_2f0_m4m5_noshield
X$1259 \$38__t7 topp__t62 cap_mim_2f0_m4m5_noshield c_length=4U c_width=4U
* device instance $1260 r0 *1 21.8,166.6 cap_mim_2f0_m4m5_noshield
X$1260 \$10__t32 topp__t61 cap_mim_2f0_m4m5_noshield c_length=4U c_width=4U
* device instance $1261 r0 *1 28.2,166.6 cap_mim_2f0_m4m5_noshield
X$1261 \$38__t6 topp__t60 cap_mim_2f0_m4m5_noshield c_length=4U c_width=4U
* device instance $1262 r0 *1 34.6,166.6 cap_mim_2f0_m4m5_noshield
X$1262 \$10__t31 topp__t59 cap_mim_2f0_m4m5_noshield c_length=4U c_width=4U
* device instance $1263 r0 *1 41,166.6 cap_mim_2f0_m4m5_noshield
X$1263 \$38__t5 topp__t58 cap_mim_2f0_m4m5_noshield c_length=4U c_width=4U
* device instance $1264 r0 *1 47.4,166.6 cap_mim_2f0_m4m5_noshield
X$1264 \$10__t30 topp__t57 cap_mim_2f0_m4m5_noshield c_length=4U c_width=4U
* device instance $1265 r0 *1 53.8,166.6 cap_mim_2f0_m4m5_noshield
X$1265 \$38__t4 topp__t56 cap_mim_2f0_m4m5_noshield c_length=4U c_width=4U
* device instance $1266 r0 *1 60.2,166.6 cap_mim_2f0_m4m5_noshield
X$1266 \$10__t48 topp__t92 cap_mim_2f0_m4m5_noshield c_length=4U c_width=4U
* device instance $1267 r0 *1 66.6,166.6 cap_mim_2f0_m4m5_noshield
X$1267 \$38__t3 topp__t31 cap_mim_2f0_m4m5_noshield c_length=4U c_width=4U
* device instance $1268 r0 *1 73,166.6 cap_mim_2f0_m4m5_noshield
X$1268 \$10__t9 topp__t15 cap_mim_2f0_m4m5_noshield c_length=4U c_width=4U
* device instance $1269 r0 *1 79.4,166.6 cap_mim_2f0_m4m5_noshield
X$1269 \$38__t2 topp__t14 cap_mim_2f0_m4m5_noshield c_length=4U c_width=4U
* device instance $1270 r0 *1 85.8,166.6 cap_mim_2f0_m4m5_noshield
X$1270 \$10__t8 topp__t13 cap_mim_2f0_m4m5_noshield c_length=4U c_width=4U
* device instance $1271 r0 *1 92.2,166.6 cap_mim_2f0_m4m5_noshield
X$1271 \$38__t1 topp__t12 cap_mim_2f0_m4m5_noshield c_length=4U c_width=4U
* device instance $1272 r0 *1 98.6,166.6 cap_mim_2f0_m4m5_noshield
X$1272 \$10__t7 topp__t11 cap_mim_2f0_m4m5_noshield c_length=4U c_width=4U
* device instance $1273 r0 *1 105,166.6 cap_mim_2f0_m4m5_noshield
X$1273 \$46__t0 topp__t10 cap_mim_2f0_m4m5_noshield c_length=4U c_width=4U
* device instance $1274 r0 *1 111.4,166.6 cap_mim_2f0_m4m5_noshield
X$1274 \$10__t6 topp__t9 cap_mim_2f0_m4m5_noshield c_length=4U c_width=4U
* device instance $1275 r0 *1 117.8,166.6 cap_mim_2f0_m4m5_noshield
X$1275 \$46__t8 topp__t268 cap_mim_2f0_m4m5_noshield c_length=4U c_width=4U
* device instance $1276 r0 *1 124.2,166.6 cap_mim_2f0_m4m5_noshield
X$1276 \$10__t37 topp__t72 cap_mim_2f0_m4m5_noshield c_length=4U c_width=4U
* device instance $1277 r0 *1 130.6,166.6 cap_mim_2f0_m4m5_noshield
X$1277 \$46__t2 topp__t71 cap_mim_2f0_m4m5_noshield c_length=4U c_width=4U
* device instance $1278 r0 *1 137,166.6 cap_mim_2f0_m4m5_noshield
X$1278 \$10__t36 topp__t70 cap_mim_2f0_m4m5_noshield c_length=4U c_width=4U
* device instance $1279 r0 *1 143.4,166.6 cap_mim_2f0_m4m5_noshield
X$1279 \$46__t1 topp__t69 cap_mim_2f0_m4m5_noshield c_length=4U c_width=4U
* device instance $1280 r0 *1 149.8,166.6 cap_mim_2f0_m4m5_noshield
X$1280 \$10__t35 topp__t68 cap_mim_2f0_m4m5_noshield c_length=4U c_width=4U
* device instance $1281 r0 *1 156.2,166.6 cap_mim_2f0_m4m5_noshield
X$1281 \$54__t1 topp__t67 cap_mim_2f0_m4m5_noshield c_length=4U c_width=4U
* device instance $1282 r0 *1 162.6,166.6 cap_mim_2f0_m4m5_noshield
X$1282 \$10__t34 topp__t66 cap_mim_2f0_m4m5_noshield c_length=4U c_width=4U
* device instance $1283 r0 *1 169,166.6 cap_mim_2f0_m4m5_noshield
X$1283 \$54__t0 topp__t65 cap_mim_2f0_m4m5_noshield c_length=4U c_width=4U
* device instance $1284 r0 *1 175.4,166.6 cap_mim_2f0_m4m5_noshield
X$1284 \$10__t33 topp__t64 cap_mim_2f0_m4m5_noshield c_length=4U c_width=4U
* device instance $1285 r0 *1 181.8,166.6 cap_mim_2f0_m4m5_noshield
X$1285 \$62__t0 topp__t107 cap_mim_2f0_m4m5_noshield c_length=4U c_width=4U
* device instance $1286 r0 *1 188.2,166.6 cap_mim_2f0_m4m5_noshield
X$1286 \$10__t60 topp__t118 cap_mim_2f0_m4m5_noshield c_length=4U c_width=4U
* device instance $1287 r0 *1 194.6,166.6 cap_mim_2f0_m4m5_noshield
X$1287 \$70__t0 topp__t117 cap_mim_2f0_m4m5_noshield c_length=4U c_width=4U
* device instance $1288 r0 *1 201,166.6 cap_mim_2f0_m4m5_noshield
X$1288 \$10__t59 topp__t116 cap_mim_2f0_m4m5_noshield c_length=4U c_width=4U
* device instance $1289 r0 *1 224,166.6 cap_mim_2f0_m4m5_noshield
X$1289 \$83__t0 topn__t8 cap_mim_2f0_m4m5_noshield c_length=4U c_width=4U
* device instance $1290 r0 *1 230.4,166.6 cap_mim_2f0_m4m5_noshield
X$1290 \$79__t3 topn__t7 cap_mim_2f0_m4m5_noshield c_length=4U c_width=4U
* device instance $1291 r0 *1 236.8,166.6 cap_mim_2f0_m4m5_noshield
X$1291 \$83__t25 topn__t462 cap_mim_2f0_m4m5_noshield c_length=4U c_width=4U
* device instance $1292 r0 *1 243.2,166.6 cap_mim_2f0_m4m5_noshield
X$1292 \$79__t232 topn__t463 cap_mim_2f0_m4m5_noshield c_length=4U c_width=4U
* device instance $1293 r0 *1 249.6,166.6 cap_mim_2f0_m4m5_noshield
X$1293 \$83__t26 topn__t464 cap_mim_2f0_m4m5_noshield c_length=4U c_width=4U
* device instance $1294 r0 *1 256,166.6 cap_mim_2f0_m4m5_noshield
X$1294 \$79__t248 topn__t495 cap_mim_2f0_m4m5_noshield c_length=4U c_width=4U
* device instance $1295 r0 *1 262.4,166.6 cap_mim_2f0_m4m5_noshield
X$1295 \$83__t29 topn__t496 cap_mim_2f0_m4m5_noshield c_length=4U c_width=4U
* device instance $1296 r0 *1 268.8,166.6 cap_mim_2f0_m4m5_noshield
X$1296 \$79__t249 topn__t497 cap_mim_2f0_m4m5_noshield c_length=4U c_width=4U
* device instance $1297 r0 *1 275.2,166.6 cap_mim_2f0_m4m5_noshield
X$1297 \$83__t30 topn__t498 cap_mim_2f0_m4m5_noshield c_length=4U c_width=4U
* device instance $1298 r0 *1 281.6,166.6 cap_mim_2f0_m4m5_noshield
X$1298 \$79__t250 topn__t499 cap_mim_2f0_m4m5_noshield c_length=4U c_width=4U
* device instance $1299 r0 *1 288,166.6 cap_mim_2f0_m4m5_noshield
X$1299 \$83__t31 topn__t500 cap_mim_2f0_m4m5_noshield c_length=4U c_width=4U
* device instance $1300 r0 *1 294.4,166.6 cap_mim_2f0_m4m5_noshield
X$1300 \$79__t129 topn__t261 cap_mim_2f0_m4m5_noshield c_length=4U c_width=4U
* device instance $1301 r0 *1 300.8,166.6 cap_mim_2f0_m4m5_noshield
X$1301 \$83__t27 topn__t475 cap_mim_2f0_m4m5_noshield c_length=4U c_width=4U
* device instance $1302 r0 *1 307.2,166.6 cap_mim_2f0_m4m5_noshield
X$1302 \$79__t237 topn__t476 cap_mim_2f0_m4m5_noshield c_length=4U c_width=4U
* device instance $1303 r0 *1 313.6,166.6 cap_mim_2f0_m4m5_noshield
X$1303 \$83__t28 topn__t477 cap_mim_2f0_m4m5_noshield c_length=4U c_width=4U
* device instance $1304 r0 *1 320,166.6 cap_mim_2f0_m4m5_noshield
X$1304 \$79__t238 topn__t478 cap_mim_2f0_m4m5_noshield c_length=4U c_width=4U
* device instance $1305 r0 *1 326.4,166.6 cap_mim_2f0_m4m5_noshield
X$1305 \$84__t14 topn__t479 cap_mim_2f0_m4m5_noshield c_length=4U c_width=4U
* device instance $1306 r0 *1 332.8,166.6 cap_mim_2f0_m4m5_noshield
X$1306 \$79__t239 topn__t480 cap_mim_2f0_m4m5_noshield c_length=4U c_width=4U
* device instance $1307 r0 *1 339.2,166.6 cap_mim_2f0_m4m5_noshield
X$1307 \$84__t15 topn__t481 cap_mim_2f0_m4m5_noshield c_length=4U c_width=4U
* device instance $1308 r0 *1 345.6,166.6 cap_mim_2f0_m4m5_noshield
X$1308 \$79__t240 topn__t482 cap_mim_2f0_m4m5_noshield c_length=4U c_width=4U
* device instance $1309 r0 *1 352,166.6 cap_mim_2f0_m4m5_noshield
X$1309 \$84__t6 topn__t182 cap_mim_2f0_m4m5_noshield c_length=4U c_width=4U
* device instance $1310 r0 *1 358.4,166.6 cap_mim_2f0_m4m5_noshield
X$1310 \$79__t152 topn__t304 cap_mim_2f0_m4m5_noshield c_length=4U c_width=4U
* device instance $1311 r0 *1 364.8,166.6 cap_mim_2f0_m4m5_noshield
X$1311 \$84__t8 topn__t289 cap_mim_2f0_m4m5_noshield c_length=4U c_width=4U
* device instance $1312 r0 *1 371.2,166.6 cap_mim_2f0_m4m5_noshield
X$1312 \$79__t119 topn__t242 cap_mim_2f0_m4m5_noshield c_length=4U c_width=4U
* device instance $1313 r0 *1 377.6,166.6 cap_mim_2f0_m4m5_noshield
X$1313 \$85__t4 topn__t243 cap_mim_2f0_m4m5_noshield c_length=4U c_width=4U
* device instance $1314 r0 *1 384,166.6 cap_mim_2f0_m4m5_noshield
X$1314 \$79__t120 topn__t244 cap_mim_2f0_m4m5_noshield c_length=4U c_width=4U
* device instance $1315 r0 *1 390.4,166.6 cap_mim_2f0_m4m5_noshield
X$1315 \$85__t5 topn__t245 cap_mim_2f0_m4m5_noshield c_length=4U c_width=4U
* device instance $1316 r0 *1 396.8,166.6 cap_mim_2f0_m4m5_noshield
X$1316 \$79__t121 topn__t246 cap_mim_2f0_m4m5_noshield c_length=4U c_width=4U
* device instance $1317 r0 *1 403.2,166.6 cap_mim_2f0_m4m5_noshield
X$1317 \$86__t2 topn__t247 cap_mim_2f0_m4m5_noshield c_length=4U c_width=4U
* device instance $1318 r0 *1 409.6,166.6 cap_mim_2f0_m4m5_noshield
X$1318 \$79__t122 topn__t248 cap_mim_2f0_m4m5_noshield c_length=4U c_width=4U
* device instance $1319 r0 *1 416,166.6 cap_mim_2f0_m4m5_noshield
X$1319 \$87__t0 topn__t249 cap_mim_2f0_m4m5_noshield c_length=4U c_width=4U
* device instance $1320 r0 *1 422.4,166.6 cap_mim_2f0_m4m5_noshield
X$1320 \$79__t123 topn__t250 cap_mim_2f0_m4m5_noshield c_length=4U c_width=4U
* device instance _10_t0 r0 *1 0,0
R_10_t0 \$10__t0 \$10 19.6806022307
* device instance _10_t1 r0 *1 0,0
R_10_t1 \$10__t1 \$10 17.174848773
* device instance _10_t2 r0 *1 0,0
R_10_t2 \$10__t2 \$10 14.2031435449
* device instance _10_t3 r0 *1 0,0
R_10_t3 \$10__t3 \$10 12.1937257142
* device instance _10_t4 r0 *1 0,0
R_10_t4 \$10__t4 \$10 5.4171139579
* device instance _10_t5 r0 *1 0,0
R_10_t5 \$10__t5 \$10 5.75188838103
* device instance _10_t6 r0 *1 0,0
R_10_t6 \$10__t6 \$10 7.4001568748
* device instance _10_t7 r0 *1 0,0
R_10_t7 \$10__t7 \$10 7.21394032887
* device instance _10_t8 r0 *1 0,0
R_10_t8 \$10__t8 \$10 7.46860304096
* device instance _10_t9 r0 *1 0,0
R_10_t9 \$10__t9 \$10 8.12278343404
* device instance _10_t10 r0 *1 0,0
R_10_t10 \$10__t10 \$10 6.52739271659
* device instance _10_t11 r0 *1 0,0
R_10_t11 \$10__t11 \$10 6.31549435701
* device instance _10_t12 r0 *1 0,0
R_10_t12 \$10__t12 \$10 6.60488949857
* device instance _10_t13 r0 *1 0,0
R_10_t13 \$10__t13 \$10 7.33649402789
* device instance _10_t14 r0 *1 0,0
R_10_t14 \$10__t14 \$10 6.57904242886
* device instance _10_t15 r0 *1 0,0
R_10_t15 \$10__t15 \$10 5.6627299367
* device instance _10_t16 r0 *1 0,0
R_10_t16 \$10__t16 \$10 4.81053902904
* device instance _10_t17 r0 *1 0,0
R_10_t17 \$10__t17 \$10 12.3650740074
* device instance _10_t18 r0 *1 0,0
R_10_t18 \$10__t18 \$10 14.0935194732
* device instance _10_t19 r0 *1 0,0
R_10_t19 \$10__t19 \$10 13.8900074897
* device instance _10_t20 r0 *1 0,0
R_10_t20 \$10__t20 \$10 6.98328450259
* device instance _10_t21 r0 *1 0,0
R_10_t21 \$10__t21 \$10 8.66700924899
* device instance _10_t22 r0 *1 0,0
R_10_t22 \$10__t22 \$10 10.3888555297
* device instance _10_t23 r0 *1 0,0
R_10_t23 \$10__t23 \$10 13.8271089247
* device instance _10_t24 r0 *1 0,0
R_10_t24 \$10__t24 \$10 9.11396768705
* device instance _10_t25 r0 *1 0,0
R_10_t25 \$10__t25 \$10 14.6247992346
* device instance _10_t26 r0 *1 0,0
R_10_t26 \$10__t26 \$10 10.6134553934
* device instance _10_t27 r0 *1 0,0
R_10_t27 \$10__t27 \$10 9.67495490125
* device instance _10_t28 r0 *1 0,0
R_10_t28 \$10__t28 \$10 11.0989089882
* device instance _10_t29 r0 *1 0,0
R_10_t29 \$10__t29 \$10 12.6185297136
* device instance _10_t30 r0 *1 0,0
R_10_t30 \$10__t30 \$10 10.283978726
* device instance _10_t31 r0 *1 0,0
R_10_t31 \$10__t31 \$10 11.6336256955
* device instance _10_t32 r0 *1 0,0
R_10_t32 \$10__t32 \$10 13.0913237768
* device instance _10_t33 r0 *1 0,0
R_10_t33 \$10__t33 \$10 12.8559908431
* device instance _10_t34 r0 *1 0,0
R_10_t34 \$10__t34 \$10 11.4128304449
* device instance _10_t35 r0 *1 0,0
R_10_t35 \$10__t35 \$10 10.0841152309
* device instance _10_t36 r0 *1 0,0
R_10_t36 \$10__t36 \$10 8.92112908952
* device instance _10_t37 r0 *1 0,0
R_10_t37 \$10__t37 \$10 7.99651120757
* device instance _10_t38 r0 *1 0,0
R_10_t38 \$10__t38 \$10 11.8568528563
* device instance _10_t39 r0 *1 0,0
R_10_t39 \$10__t39 \$10 15.5740196193
* device instance _10_t40 r0 *1 0,0
R_10_t40 \$10__t40 \$10 12.3742084378
* device instance _10_t41 r0 *1 0,0
R_10_t41 \$10__t41 \$10 10.867255066
* device instance _10_t42 r0 *1 0,0
R_10_t42 \$10__t42 \$10 9.46223619944
* device instance _10_t43 r0 *1 0,0
R_10_t43 \$10__t43 \$10 8.21164284031
* device instance _10_t44 r0 *1 0,0
R_10_t44 \$10__t44 \$10 7.19643838282
* device instance _10_t45 r0 *1 0,0
R_10_t45 \$10__t45 \$10 10.115874473
* device instance _10_t46 r0 *1 0,0
R_10_t46 \$10__t46 \$10 15.2318659974
* device instance _10_t47 r0 *1 0,0
R_10_t47 \$10__t47 \$10 13.9501010489
* device instance _10_t48 r0 *1 0,0
R_10_t48 \$10__t48 \$10 9.09063656007
* device instance _10_t49 r0 *1 0,0
R_10_t49 \$10__t49 \$10 4.51883824083
* device instance _10_t50 r0 *1 0,0
R_10_t50 \$10__t50 \$10 4.91518009453
* device instance _10_t51 r0 *1 0,0
R_10_t51 \$10__t51 \$10 5.86161877766
* device instance _10_t52 r0 *1 0,0
R_10_t52 \$10__t52 \$10 7.14273316354
* device instance _10_t53 r0 *1 0,0
R_10_t53 \$10__t53 \$10 8.61041128022
* device instance _10_t54 r0 *1 0,0
R_10_t54 \$10__t54 \$10 10.1843119945
* device instance _10_t55 r0 *1 0,0
R_10_t55 \$10__t55 \$10 11.8220862036
* device instance _10_t56 r0 *1 0,0
R_10_t56 \$10__t56 \$10 8.39548729808
* device instance _10_t57 r0 *1 0,0
R_10_t57 \$10__t57 \$10 7.7423421283
* device instance _10_t58 r0 *1 0,0
R_10_t58 \$10__t58 \$10 13.6124753802
* device instance _10_t59 r0 *1 0,0
R_10_t59 \$10__t59 \$10 15.9594972727
* device instance _10_t60 r0 *1 0,0
R_10_t60 \$10__t60 \$10 14.3791788837
* device instance _10_t61 r0 *1 0,0
R_10_t61 \$10__t61 \$10 13.5005080138
* device instance _10_t62 r0 *1 0,0
R_10_t62 \$10__t62 \$10 7.54228025454
* device instance _10_t63 r0 *1 0,0
R_10_t63 \$10__t63 \$10 9.29876442464
* device instance _10_t64 r0 *1 0,0
R_10_t64 \$10__t64 \$10 11.0683572056
* device instance _10_t65 r0 *1 0,0
R_10_t65 \$10__t65 \$10 10.6436280847
* device instance _10_t66 r0 *1 0,0
R_10_t66 \$10__t66 \$10 14.0815768879
* device instance _10_t67 r0 *1 0,0
R_10_t67 \$10__t67 \$10 12.3514603071
* device instance _10_t68 r0 *1 0,0
R_10_t68 \$10__t68 \$10 7.35695331171
* device instance _10_t69 r0 *1 0,0
R_10_t69 \$10__t69 \$10 12.8456422826
* device instance _10_t70 r0 *1 0,0
R_10_t70 \$10__t70 \$10 10.659423169
* device instance _10_t71 r0 *1 0,0
R_10_t71 \$10__t71 \$10 10.0689480745
* device instance _10_t72 r0 *1 0,0
R_10_t72 \$10__t72 \$10 7.38277527374
* device instance _10_t73 r0 *1 0,0
R_10_t73 \$10__t73 \$10 9.16986363745
* device instance _10_t74 r0 *1 0,0
R_10_t74 \$10__t74 \$10 10.9602878856
* device instance _10_t75 r0 *1 0,0
R_10_t75 \$10__t75 \$10 12.7526430577
* device instance _10_t76 r0 *1 0,0
R_10_t76 \$10__t76 \$10 10.9253105491
* device instance _10_t77 r0 *1 0,0
R_10_t77 \$10__t77 \$10 12.7225942723
* device instance _10_t78 r0 *1 0,0
R_10_t78 \$10__t78 \$10 2.6278897209
* device instance _10_t79 r0 *1 0,0
R_10_t79 \$10__t79 \$10 3.30174890553
* device instance _10_t80 r0 *1 0,0
R_10_t80 \$10__t80 \$10 4.59359610415
* device instance _10_t81 r0 *1 0,0
R_10_t81 \$10__t81 \$10 4.56121007286
* device instance _10_t82 r0 *1 0,0
R_10_t82 \$10__t82 \$10 2.67627530726
* device instance _10_t83 r0 *1 0,0
R_10_t83 \$10__t83 \$10 3.65054032973
* device instance _10_t84 r0 *1 0,0
R_10_t84 \$10__t84 \$10 3.71958324344
* device instance _10_t85 r0 *1 0,0
R_10_t85 \$10__t85 \$10 3.1438569025
* device instance _10_t86 r0 *1 0,0
R_10_t86 \$10__t86 \$10 4.13586553434
* device instance _10_t87 r0 *1 0,0
R_10_t87 \$10__t87 \$10 5.85102197661
* device instance _10_t88 r0 *1 0,0
R_10_t88 \$10__t88 \$10 7.80267472652
* device instance _10_t89 r0 *1 0,0
R_10_t89 \$10__t89 \$10 9.5111913699
* device instance _10_t90 r0 *1 0,0
R_10_t90 \$10__t90 \$10 11.2474118214
* device instance _10_t91 r0 *1 0,0
R_10_t91 \$10__t91 \$10 13.0002410402
* device instance _10_t92 r0 *1 0,0
R_10_t92 \$10__t92 \$10 8.97081651293
* device instance _10_t93 r0 *1 0,0
R_10_t93 \$10__t93 \$10 1.87282515948
* device instance _10_t94 r0 *1 0,0
R_10_t94 \$10__t94 \$10 6.14501322366
* device instance _10_t95 r0 *1 0,0
R_10_t95 \$10__t95 \$10 5.8108042532
* device instance _10_t96 r0 *1 0,0
R_10_t96 \$10__t96 \$10 5.60221611272
* device instance _10_t97 r0 *1 0,0
R_10_t97 \$10__t97 \$10 5.5334731799
* device instance _10_t98 r0 *1 0,0
R_10_t98 \$10__t98 \$10 3.69633983686
* device instance _10_t99 r0 *1 0,0
R_10_t99 \$10__t99 \$10 3.76454286673
* device instance _10_t100 r0 *1 0,0
R_10_t100 \$10__t100 \$10 4.59794745722
* device instance _10_t101 r0 *1 0,0
R_10_t101 \$10__t101 \$10 2.82275487998
* device instance _10_t102 r0 *1 0,0
R_10_t102 \$10__t102 \$10 3.93015747041
* device instance _10_t103 r0 *1 0,0
R_10_t103 \$10__t103 \$10 2.91149444759
* device instance _10_t104 r0 *1 0,0
R_10_t104 \$10__t104 \$10 5.37363550905
* device instance _10_t105 r0 *1 0,0
R_10_t105 \$10__t105 \$10 12.1326036831
* device instance _10_t106 r0 *1 0,0
R_10_t106 \$10__t106 \$10 7.37978627883
* device instance _10_t107 r0 *1 0,0
R_10_t107 \$10__t107 \$10 8.9895512902
* device instance _10_t108 r0 *1 0,0
R_10_t108 \$10__t108 \$10 5.87970591622
* device instance _10_t109 r0 *1 0,0
R_10_t109 \$10__t109 \$10 11.8598258099
* device instance _10_t110 r0 *1 0,0
R_10_t110 \$10__t110 \$10 7.33074831116
* device instance _10_t111 r0 *1 0,0
R_10_t111 \$10__t111 \$10 9.12802822019
* device instance _10_t112 r0 *1 0,0
R_10_t112 \$10__t112 \$10 13.6523882223
* device instance _10_t113 r0 *1 0,0
R_10_t113 \$10__t113 \$10 6.497819523
* device instance _10_t114 r0 *1 0,0
R_10_t114 \$10__t114 \$10 8.28084811063
* device instance _10_t115 r0 *1 0,0
R_10_t115 \$10__t115 \$10 0.886615686121
* device instance _10_t116 r0 *1 0,0
R_10_t116 \$10__t116 \$10 2.12724791451
* device instance _10_t117 r0 *1 0,0
R_10_t117 \$10__t117 \$10 1.93899039421
* device instance _10_t118 r0 *1 0,0
R_10_t118 \$10__t118 \$10 3.83728589275
* device instance _10_t119 r0 *1 0,0
R_10_t119 \$10__t119 \$10 3.73620972133
* device instance _10_t120 r0 *1 0,0
R_10_t120 \$10__t120 \$10 1.19303865059
* device instance _10_t121 r0 *1 0,0
R_10_t121 \$10__t121 \$10 1.39003454191
* device instance _10_t122 r0 *1 0,0
R_10_t122 \$10__t122 \$10 2.98354384107
* device instance _10_t123 r0 *1 0,0
R_10_t123 \$10__t123 \$10 4.72560627788
* device instance _10_t124 r0 *1 0,0
R_10_t124 \$10__t124 \$10 1.65589073826
* device instance _10_t125 r0 *1 0,0
R_10_t125 \$10__t125 \$10 0.143483218318
* device instance _10_t126 r0 *1 0,0
R_10_t126 \$10__t126 \$10 13.820074857
* device instance _10_t127 r0 *1 0,0
R_10_t127 \$10__t127 \$10 12.0946245387
* device instance _10_t128 r0 *1 0,0
R_10_t128 \$10__t128 \$10 10.3935508576
* device instance _10_t129 r0 *1 0,0
R_10_t129 \$10__t129 \$10 8.73111328217
* device instance _10_t130 r0 *1 0,0
R_10_t130 \$10__t130 \$10 7.13437186302
* device instance _10_t131 r0 *1 0,0
R_10_t131 \$10__t131 \$10 5.65921086652
* device instance _10_t132 r0 *1 0,0
R_10_t132 \$10__t132 \$10 5.13144078741
* device instance _10_t133 r0 *1 0,0
R_10_t133 \$10__t133 \$10 11.9632859119
* device instance _10_t134 r0 *1 0,0
R_10_t134 \$10__t134 \$10 13.7423595405
* device instance _10_t135 r0 *1 0,0
R_10_t135 \$10__t135 \$10 2.71568949512
* device instance _10_t136 r0 *1 0,0
R_10_t136 \$10__t136 \$10 4.3906802333
* device instance _10_t137 r0 *1 0,0
R_10_t137 \$10__t137 \$10 4.4288323971
* device instance _10_t138 r0 *1 0,0
R_10_t138 \$10__t138 \$10 3.73089444029
* device instance _10_t139 r0 *1 0,0
R_10_t139 \$10__t139 \$10 10.1906063066
* device instance _10_t140 r0 *1 0,0
R_10_t140 \$10__t140 \$10 13.5670547258
* device instance _10_t141 r0 *1 0,0
R_10_t141 \$10__t141 \$10 11.9407156034
* device instance _10_t142 r0 *1 0,0
R_10_t142 \$10__t142 \$10 10.3709636644
* device instance _10_t143 r0 *1 0,0
R_10_t143 \$10__t143 \$10 8.88783261281
* device instance _10_t144 r0 *1 0,0
R_10_t144 \$10__t144 \$10 7.54259456661
* device instance _10_t145 r0 *1 0,0
R_10_t145 \$10__t145 \$10 6.42249017571
* device instance _10_t146 r0 *1 0,0
R_10_t146 \$10__t146 \$10 8.39865203881
* device instance _10_t147 r0 *1 0,0
R_10_t147 \$10__t147 \$10 6.72341273483
* device instance _10_t148 r0 *1 0,0
R_10_t148 \$10__t148 \$10 14.9360140994
* device instance _10_t149 r0 *1 0,0
R_10_t149 \$10__t149 \$10 13.2340375301
* device instance _10_t150 r0 *1 0,0
R_10_t150 \$10__t150 \$10 11.5609456592
* device instance _10_t151 r0 *1 0,0
R_10_t151 \$10__t151 \$10 9.93134747869
* device instance _10_t152 r0 *1 0,0
R_10_t152 \$10__t152 \$10 8.37068360215
* device instance _10_t153 r0 *1 0,0
R_10_t153 \$10__t153 \$10 6.92571355242
* device instance _10_t154 r0 *1 0,0
R_10_t154 \$10__t154 \$10 5.68534567736
* device instance _10_t155 r0 *1 0,0
R_10_t155 \$10__t155 \$10 13.4617838214
* device instance _10_t156 r0 *1 0,0
R_10_t156 \$10__t156 \$10 11.6835395892
* device instance _10_t157 r0 *1 0,0
R_10_t157 \$10__t157 \$10 9.91216696947
* device instance _10_t158 r0 *1 0,0
R_10_t158 \$10__t158 \$10 8.15214657292
* device instance _10_t159 r0 *1 0,0
R_10_t159 \$10__t159 \$10 6.41283217309
* device instance _10_t160 r0 *1 0,0
R_10_t160 \$10__t160 \$10 4.71718371829
* device instance _10_t161 r0 *1 0,0
R_10_t161 \$10__t161 \$10 8.42835612676
* device instance _10_t162 r0 *1 0,0
R_10_t162 \$10__t162 \$10 6.68478871181
* device instance _10_t163 r0 *1 0,0
R_10_t163 \$10__t163 \$10 3.13683136333
* device instance _10_t164 r0 *1 0,0
R_10_t164 \$10__t164 \$10 4.979567879
* device instance _10_t165 r0 *1 0,0
R_10_t165 \$10__t165 \$10 3.37139072486
* device instance _10_t166 r0 *1 0,0
R_10_t166 \$10__t166 \$10 2.09688759731
* device instance _10_t167 r0 *1 0,0
R_10_t167 \$10__t167 \$10 1.97182220037
* device instance _10_t168 r0 *1 0,0
R_10_t168 \$10__t168 \$10 14.3358568146
* device instance _10_t169 r0 *1 0,0
R_10_t169 \$10__t169 \$10 12.6405915478
* device instance _10_t170 r0 *1 0,0
R_10_t170 \$10__t170 \$10 10.9778322889
* device instance _10_t171 r0 *1 0,0
R_10_t171 \$10__t171 \$10 9.36490960274
* device instance _10_t172 r0 *1 0,0
R_10_t172 \$10__t172 \$10 7.83267163806
* device instance _10_t173 r0 *1 0,0
R_10_t173 \$10__t173 \$10 6.43897826753
* device instance _10_t174 r0 *1 0,0
R_10_t174 \$10__t174 \$10 5.29439517676
* device instance _10_t175 r0 *1 0,0
R_10_t175 \$10__t175 \$10 4.58925728891
* device instance _10_t176 r0 *1 0,0
R_10_t176 \$10__t176 \$10 4.53347853838
* device instance _10_t177 r0 *1 0,0
R_10_t177 \$10__t177 \$10 5.14820899635
* device instance _10_t178 r0 *1 0,0
R_10_t178 \$10__t178 \$10 6.23828238381
* device instance _10_t179 r0 *1 0,0
R_10_t179 \$10__t179 \$10 7.60189195848
* device instance _10_t180 r0 *1 0,0
R_10_t180 \$10__t180 \$10 9.11711788969
* device instance _10_t181 r0 *1 0,0
R_10_t181 \$10__t181 \$10 10.7198600223
* device instance _10_t182 r0 *1 0,0
R_10_t182 \$10__t182 \$10 12.3761642766
* device instance _10_t183 r0 *1 0,0
R_10_t183 \$10__t183 \$10 14.0671236762
* device instance _10_t184 r0 *1 0,0
R_10_t184 \$10__t184 \$10 12.4394709588
* device instance _10_t185 r0 *1 0,0
R_10_t185 \$10__t185 \$10 10.6421874125
* device instance _10_t186 r0 *1 0,0
R_10_t186 \$10__t186 \$10 8.84490537709
* device instance _10_t187 r0 *1 0,0
R_10_t187 \$10__t187 \$10 7.04762600841
* device instance _10_t188 r0 *1 0,0
R_10_t188 \$10__t188 \$10 5.25035204508
* device instance _10_t189 r0 *1 0,0
R_10_t189 \$10__t189 \$10 3.45309192727
* device instance _10_t190 r0 *1 0,0
R_10_t190 \$10__t190 \$10 9.23981673065
* device instance _10_t191 r0 *1 0,0
R_10_t191 \$10__t191 \$10 7.53730020901
* device instance _10_t192 r0 *1 0,0
R_10_t192 \$10__t192 \$10 13.8078957688
* device instance _10_t193 r0 *1 0,0
R_10_t193 \$10__t193 \$10 12.0807060738
* device instance _10_t194 r0 *1 0,0
R_10_t194 \$10__t194 \$10 10.3773511042
* device instance _10_t195 r0 *1 0,0
R_10_t195 \$10__t195 \$10 14.3468228608
* device instance _10_t196 r0 *1 0,0
R_10_t196 \$10__t196 \$10 12.565291814
* device instance _10_t197 r0 *1 0,0
R_10_t197 \$10__t197 \$10 5.94517952492
* device instance _10_t198 r0 *1 0,0
R_10_t198 \$10__t198 \$10 6.76767198167
* device instance _10_t199 r0 *1 0,0
R_10_t199 \$10__t199 \$10 5.62940353335
* device instance _10_t200 r0 *1 0,0
R_10_t200 \$10__t200 \$10 10.7889885327
* device instance _10_t201 r0 *1 0,0
R_10_t201 \$10__t201 \$10 9.02100170524
* device instance _10_t202 r0 *1 0,0
R_10_t202 \$10__t202 \$10 7.2674034559
* device instance _10_t203 r0 *1 0,0
R_10_t203 \$10__t203 \$10 13.3699245355
* device instance _10_t204 r0 *1 0,0
R_10_t204 \$10__t204 \$10 11.5775798751
* device instance _10_t205 r0 *1 0,0
R_10_t205 \$10__t205 \$10 7.99954699832
* device instance _10_t206 r0 *1 0,0
R_10_t206 \$10__t206 \$10 6.21769048057
* device instance _10_t207 r0 *1 0,0
R_10_t207 \$10__t207 \$10 4.44826715295
* device instance _10_t208 r0 *1 0,0
R_10_t208 \$10__t208 \$10 4.3664294274
* device instance _10_t209 r0 *1 0,0
R_10_t209 \$10__t209 \$10 14.2367554437
* device instance _10_t210 r0 *1 0,0
R_10_t210 \$10__t210 \$10 2.42653967069
* device instance _10_t211 r0 *1 0,0
R_10_t211 \$10__t211 \$10 9.78704819966
* device instance _10_t212 r0 *1 0,0
R_10_t212 \$10__t212 \$10 14.4854087843
* device instance _10_t213 r0 *1 0,0
R_10_t213 \$10__t213 \$10 12.7232975215
* device instance _10_t214 r0 *1 0,0
R_10_t214 \$10__t214 \$10 10.9726029277
* device instance _10_t215 r0 *1 0,0
R_10_t215 \$10__t215 \$10 14.2636147419
* device instance _10_t216 r0 *1 0,0
R_10_t216 \$10__t216 \$10 12.4702019901
* device instance _10_t217 r0 *1 0,0
R_10_t217 \$10__t217 \$10 10.6780921921
* device instance _10_t218 r0 *1 0,0
R_10_t218 \$10__t218 \$10 7.11075090194
* device instance _10_t219 r0 *1 0,0
R_10_t219 \$10__t219 \$10 7.1017274163
* device instance _10_t220 r0 *1 0,0
R_10_t220 \$10__t220 \$10 5.32275272188
* device instance _10_t221 r0 *1 0,0
R_10_t221 \$10__t221 \$10 3.56221052145
* device instance _10_t222 r0 *1 0,0
R_10_t222 \$10__t222 \$10 5.8913545712
* device instance _10_t223 r0 *1 0,0
R_10_t223 \$10__t223 \$10 8.71182275161
* device instance _10_t224 r0 *1 0,0
R_10_t224 \$10__t224 \$10 5.54186947101
* device instance _10_t225 r0 *1 0,0
R_10_t225 \$10__t225 \$10 3.88200521568
* device instance _10_t226 r0 *1 0,0
R_10_t226 \$10__t226 \$10 8.88807352977
* device instance _10_t227 r0 *1 0,0
R_10_t227 \$10__t227 \$10 11.3733858405
* device instance _10_t228 r0 *1 0,0
R_10_t228 \$10__t228 \$10 12.9855942641
* device instance _10_t229 r0 *1 0,0
R_10_t229 \$10__t229 \$10 14.6409663043
* device instance _10_t230 r0 *1 0,0
R_10_t230 \$10__t230 \$10 1.77952467539
* device instance _10_t231 r0 *1 0,0
R_10_t231 \$10__t231 \$10 10.1202355109
* device instance _10_t232 r0 *1 0,0
R_10_t232 \$10__t232 \$10 8.77986842326
* device instance _10_t233 r0 *1 0,0
R_10_t233 \$10__t233 \$10 7.62977688282
* device instance _10_t234 r0 *1 0,0
R_10_t234 \$10__t234 \$10 14.3779369951
* device instance _10_t235 r0 *1 0,0
R_10_t235 \$10__t235 \$10 12.7283363373
* device instance _10_t236 r0 *1 0,0
R_10_t236 \$10__t236 \$10 11.1245899975
* device instance _10_t237 r0 *1 0,0
R_10_t237 \$10__t237 \$10 9.58973108736
* device instance _10_t238 r0 *1 0,0
R_10_t238 \$10__t238 \$10 8.16271186934
* device instance _10_t239 r0 *1 0,0
R_10_t239 \$10__t239 \$10 6.91066355813
* device instance _10_t240 r0 *1 0,0
R_10_t240 \$10__t240 \$10 14.737072189
* device instance _10_t241 r0 *1 0,0
R_10_t241 \$10__t241 \$10 13.1326604457
* device instance _10_t242 r0 *1 0,0
R_10_t242 \$10__t242 \$10 6.87953112277
* device instance _10_t243 r0 *1 0,0
R_10_t243 \$10__t243 \$10 7.79472701966
* device instance _10_t244 r0 *1 0,0
R_10_t244 \$10__t244 \$10 8.98042722653
* device instance _10_t245 r0 *1 0,0
R_10_t245 \$10__t245 \$10 10.344025331
* device instance _10_t246 r0 *1 0,0
R_10_t246 \$10__t246 \$10 11.8241333697
* device instance _10_t247 r0 *1 0,0
R_10_t247 \$10__t247 \$10 13.3821479165
* device instance _10_t248 r0 *1 0,0
R_10_t248 \$10__t248 \$10 14.9938026795
* device instance _10_t249 r0 *1 0,0
R_10_t249 \$10__t249 \$10 6.35284272159
* device instance _10_t250 r0 *1 0,0
R_10_t250 \$10__t250 \$10 9.82561120648
* device instance _10_t251 r0 *1 0,0
R_10_t251 \$10__t251 \$10 8.37805757339
* device instance _10_t252 r0 *1 0,0
R_10_t252 \$10__t252 \$10 7.09235820042
* device instance _10_t253 r0 *1 0,0
R_10_t253 \$10__t253 \$10 6.07220915328
* device instance _10_t254 r0 *1 0,0
R_10_t254 \$10__t254 \$10 5.46830743259
* device instance _10_t255 r0 *1 0,0
R_10_t255 \$10__t255 \$10 5.42158015448
* device instance _10_t256 r0 *1 0,0
R_10_t256 \$10__t256 \$10 11.5850216694
* device instance _10_t257 r0 *1 0,0
R_10_t257 \$10__t257 \$10 6.31266630192
* device instance _10_t258 r0 *1 0,0
R_10_t258 \$10__t258 \$10 16.7770271186
* device instance _10_t259 r0 *1 0,0
R_10_t259 \$10__t259 \$10 16.5893289842
* device instance _10_t260 r0 *1 0,0
R_10_t260 \$10__t260 \$10 16.9722863422
* device instance _10_t261 r0 *1 0,0
R_10_t261 \$10__t261 \$10 19.1916208898
* device instance _10_t262 r0 *1 0,0
R_10_t262 \$10__t262 \$10 19.43344224
* device instance _10_t263 r0 *1 0,0
R_10_t263 \$10__t263 \$10 18.9553425032
* device instance _10 r0 *1 0,0
C_10 \$10 vsubs 5.64037401e-13
* device instance _100_t0 r0 *1 0,0
R_100_t0 \$100__t0 \$100 162.444438203
* device instance _100_t1 r0 *1 0,0
R_100_t1 \$100__t1 \$100 43.7126105743
* device instance _100_t2 r0 *1 0,0
R_100_t2 \$100__t2 \$100 200.179851222
* device instance _100 r0 *1 0,0
C_100 \$100 vsubs 7.547896e-15
* device instance _102_t0 r0 *1 0,0
R_102_t0 \$102__t0 \$102 135.591504929
* device instance _102_t1 r0 *1 0,0
R_102_t1 \$102__t1 \$102 36.2048686624
* device instance _102_t2 r0 *1 0,0
R_102_t2 \$102__t2 \$102 166.824926409
* device instance _102 r0 *1 0,0
C_102 \$102 vsubs 7.017453e-15
* device instance _104_t0 r0 *1 0,0
R_104_t0 \$104__t0 \$104 162.444438203
* device instance _104_t1 r0 *1 0,0
R_104_t1 \$104__t1 \$104 43.7126105743
* device instance _104_t2 r0 *1 0,0
R_104_t2 \$104__t2 \$104 200.179851222
* device instance _104 r0 *1 0,0
C_104 \$104 vsubs 7.547896e-15
* device instance _106_t0 r0 *1 0,0
R_106_t0 \$106__t0 \$106 135.591504929
* device instance _106_t1 r0 *1 0,0
R_106_t1 \$106__t1 \$106 36.2048686624
* device instance _106_t2 r0 *1 0,0
R_106_t2 \$106__t2 \$106 166.824926409
* device instance _106 r0 *1 0,0
C_106 \$106 vsubs 7.006437e-15
* device instance _108_t0 r0 *1 0,0
R_108_t0 \$108__t0 \$108 162.444438203
* device instance _108_t1 r0 *1 0,0
R_108_t1 \$108__t1 \$108 43.7126105743
* device instance _108_t2 r0 *1 0,0
R_108_t2 \$108__t2 \$108 200.179851222
* device instance _108 r0 *1 0,0
C_108 \$108 vsubs 7.53688e-15
* device instance _110_t0 r0 *1 0,0
R_110_t0 \$110__t0 \$110 135.591504929
* device instance _110_t1 r0 *1 0,0
R_110_t1 \$110__t1 \$110 36.2048686624
* device instance _110_t2 r0 *1 0,0
R_110_t2 \$110__t2 \$110 166.824926409
* device instance _110 r0 *1 0,0
C_110 \$110 vsubs 7.017453e-15
* device instance _112_t0 r0 *1 0,0
R_112_t0 \$112__t0 \$112 162.444438203
* device instance _112_t1 r0 *1 0,0
R_112_t1 \$112__t1 \$112 43.7126105743
* device instance _112_t2 r0 *1 0,0
R_112_t2 \$112__t2 \$112 200.179851222
* device instance _112 r0 *1 0,0
C_112 \$112 vsubs 7.547896e-15
* device instance _114_t0 r0 *1 0,0
R_114_t0 \$114__t0 \$114 135.591504929
* device instance _114_t1 r0 *1 0,0
R_114_t1 \$114__t1 \$114 36.2048686624
* device instance _114_t2 r0 *1 0,0
R_114_t2 \$114__t2 \$114 166.824926409
* device instance _114 r0 *1 0,0
C_114 \$114 vsubs 7.017453e-15
* device instance _116_t0 r0 *1 0,0
R_116_t0 \$116__t0 \$116 162.444438203
* device instance _116_t1 r0 *1 0,0
R_116_t1 \$116__t1 \$116 43.7126105743
* device instance _116_t2 r0 *1 0,0
R_116_t2 \$116__t2 \$116 200.179851222
* device instance _116 r0 *1 0,0
C_116 \$116 vsubs 7.547896e-15
* device instance _118_t0 r0 *1 0,0
R_118_t0 \$118__t0 \$118 135.591504929
* device instance _118_t1 r0 *1 0,0
R_118_t1 \$118__t1 \$118 36.2048686624
* device instance _118_t2 r0 *1 0,0
R_118_t2 \$118__t2 \$118 166.824926409
* device instance _118 r0 *1 0,0
C_118 \$118 vsubs 7.017453e-15
* device instance _120_t0 r0 *1 0,0
R_120_t0 \$120__t0 \$120 162.444438203
* device instance _120_t1 r0 *1 0,0
R_120_t1 \$120__t1 \$120 43.7126105743
* device instance _120_t2 r0 *1 0,0
R_120_t2 \$120__t2 \$120 200.179851222
* device instance _120 r0 *1 0,0
C_120 \$120 vsubs 7.547896e-15
* device instance _122_t0 r0 *1 0,0
R_122_t0 \$122__t0 \$122 135.591504929
* device instance _122_t1 r0 *1 0,0
R_122_t1 \$122__t1 \$122 36.2048686624
* device instance _122_t2 r0 *1 0,0
R_122_t2 \$122__t2 \$122 166.824926409
* device instance _122 r0 *1 0,0
C_122 \$122 vsubs 7.017453e-15
* device instance _124_t0 r0 *1 0,0
R_124_t0 \$124__t0 \$124 162.444438203
* device instance _124_t1 r0 *1 0,0
R_124_t1 \$124__t1 \$124 43.7126105743
* device instance _124_t2 r0 *1 0,0
R_124_t2 \$124__t2 \$124 200.179851222
* device instance _124 r0 *1 0,0
C_124 \$124 vsubs 7.547896e-15
* device instance _125_t0 r0 *1 0,0
R_125_t0 \$125__t0 \$125 81.7777390336
* device instance _125_t1 r0 *1 0,0
R_125_t1 \$125__t1 \$125 21.4987692264
* device instance _125_t2 r0 *1 0,0
R_125_t2 \$125__t2 \$125 100.29899174
* device instance _125 r0 *1 0,0
C_125 \$125 vsubs 5.956568e-15
* device instance _127_t0 r0 *1 0,0
R_127_t0 \$127__t0 \$127 108.687402234
* device instance _127_t1 r0 *1 0,0
R_127_t1 \$127__t1 \$127 28.7964709909
* device instance _127_t2 r0 *1 0,0
R_127_t2 \$127__t2 \$127 133.512826775
* device instance _127 r0 *1 0,0
C_127 \$127 vsubs 6.487011e-15
* device instance _128_t0 r0 *1 0,0
R_128_t0 \$128__t0 \$128 81.7777390336
* device instance _128_t1 r0 *1 0,0
R_128_t1 \$128__t1 \$128 21.4987692264
* device instance _128_t2 r0 *1 0,0
R_128_t2 \$128__t2 \$128 100.29899174
* device instance _128 r0 *1 0,0
C_128 \$128 vsubs 5.956568e-15
* device instance _130_t0 r0 *1 0,0
R_130_t0 \$130__t0 \$130 108.687402234
* device instance _130_t1 r0 *1 0,0
R_130_t1 \$130__t1 \$130 28.7964709909
* device instance _130_t2 r0 *1 0,0
R_130_t2 \$130__t2 \$130 133.512826775
* device instance _130 r0 *1 0,0
C_130 \$130 vsubs 6.487011e-15
* device instance _131_t0 r0 *1 0,0
R_131_t0 \$131__t0 \$131 81.7777390336
* device instance _131_t1 r0 *1 0,0
R_131_t1 \$131__t1 \$131 21.4987692264
* device instance _131_t2 r0 *1 0,0
R_131_t2 \$131__t2 \$131 100.29899174
* device instance _131 r0 *1 0,0
C_131 \$131 vsubs 5.956568e-15
* device instance _133_t0 r0 *1 0,0
R_133_t0 \$133__t0 \$133 108.687402234
* device instance _133_t1 r0 *1 0,0
R_133_t1 \$133__t1 \$133 28.7964709909
* device instance _133_t2 r0 *1 0,0
R_133_t2 \$133__t2 \$133 133.512826775
* device instance _133 r0 *1 0,0
C_133 \$133 vsubs 6.487011e-15
* device instance _134_t0 r0 *1 0,0
R_134_t0 \$134__t0 \$134 81.7777390336
* device instance _134_t1 r0 *1 0,0
R_134_t1 \$134__t1 \$134 21.4987692264
* device instance _134_t2 r0 *1 0,0
R_134_t2 \$134__t2 \$134 100.29899174
* device instance _134 r0 *1 0,0
C_134 \$134 vsubs 5.956568e-15
* device instance _136_t0 r0 *1 0,0
R_136_t0 \$136__t0 \$136 108.687402234
* device instance _136_t1 r0 *1 0,0
R_136_t1 \$136__t1 \$136 28.7964709909
* device instance _136_t2 r0 *1 0,0
R_136_t2 \$136__t2 \$136 133.512826775
* device instance _136 r0 *1 0,0
C_136 \$136 vsubs 6.487011e-15
* device instance _137_t0 r0 *1 0,0
R_137_t0 \$137__t0 \$137 81.7777390336
* device instance _137_t1 r0 *1 0,0
R_137_t1 \$137__t1 \$137 21.4987692264
* device instance _137_t2 r0 *1 0,0
R_137_t2 \$137__t2 \$137 100.29899174
* device instance _137 r0 *1 0,0
C_137 \$137 vsubs 5.95106e-15
* device instance _139_t0 r0 *1 0,0
R_139_t0 \$139__t0 \$139 108.687402234
* device instance _139_t1 r0 *1 0,0
R_139_t1 \$139__t1 \$139 28.7964709909
* device instance _139_t2 r0 *1 0,0
R_139_t2 \$139__t2 \$139 133.512826775
* device instance _139 r0 *1 0,0
C_139 \$139 vsubs 6.467838e-15
* device instance _140_t0 r0 *1 0,0
R_140_t0 \$140__t0 \$140 81.7777390336
* device instance _140_t1 r0 *1 0,0
R_140_t1 \$140__t1 \$140 21.4987692264
* device instance _140_t2 r0 *1 0,0
R_140_t2 \$140__t2 \$140 100.29899174
* device instance _140 r0 *1 0,0
C_140 \$140 vsubs 5.956568e-15
* device instance _142_t0 r0 *1 0,0
R_142_t0 \$142__t0 \$142 108.687402234
* device instance _142_t1 r0 *1 0,0
R_142_t1 \$142__t1 \$142 28.7964709909
* device instance _142_t2 r0 *1 0,0
R_142_t2 \$142__t2 \$142 133.512826775
* device instance _142 r0 *1 0,0
C_142 \$142 vsubs 6.487011e-15
* device instance _143_t0 r0 *1 0,0
R_143_t0 \$143__t0 \$143 81.7777390336
* device instance _143_t1 r0 *1 0,0
R_143_t1 \$143__t1 \$143 21.4987692264
* device instance _143_t2 r0 *1 0,0
R_143_t2 \$143__t2 \$143 100.29899174
* device instance _143 r0 *1 0,0
C_143 \$143 vsubs 5.956568e-15
* device instance _145_t0 r0 *1 0,0
R_145_t0 \$145__t0 \$145 108.687402234
* device instance _145_t1 r0 *1 0,0
R_145_t1 \$145__t1 \$145 28.7964709909
* device instance _145_t2 r0 *1 0,0
R_145_t2 \$145__t2 \$145 133.512826775
* device instance _145 r0 *1 0,0
C_145 \$145 vsubs 6.487011e-15
* device instance _146_t0 r0 *1 0,0
R_146_t0 \$146__t0 \$146 81.7777390336
* device instance _146_t1 r0 *1 0,0
R_146_t1 \$146__t1 \$146 21.4987692264
* device instance _146_t2 r0 *1 0,0
R_146_t2 \$146__t2 \$146 100.29899174
* device instance _146 r0 *1 0,0
C_146 \$146 vsubs 5.956568e-15
* device instance _148_t0 r0 *1 0,0
R_148_t0 \$148__t0 \$148 108.687402234
* device instance _148_t1 r0 *1 0,0
R_148_t1 \$148__t1 \$148 28.7964709909
* device instance _148_t2 r0 *1 0,0
R_148_t2 \$148__t2 \$148 133.512826775
* device instance _148 r0 *1 0,0
C_148 \$148 vsubs 6.487011e-15
* device instance _149_t0 r0 *1 0,0
R_149_t0 \$149__t0 \$149 81.7777390336
* device instance _149_t1 r0 *1 0,0
R_149_t1 \$149__t1 \$149 21.4987692264
* device instance _149_t2 r0 *1 0,0
R_149_t2 \$149__t2 \$149 100.29899174
* device instance _149 r0 *1 0,0
C_149 \$149 vsubs 5.956568e-15
* device instance _15_t0 r0 *1 0,0
R_15_t0 \$15__t0 \$15 81.7777390336
* device instance _15_t1 r0 *1 0,0
R_15_t1 \$15__t1 \$15 21.4987692264
* device instance _15_t2 r0 *1 0,0
R_15_t2 \$15__t2 \$15 100.29899174
* device instance _15 r0 *1 0,0
C_15 \$15 vsubs 5.962076e-15
* device instance _151_t0 r0 *1 0,0
R_151_t0 \$151__t0 \$151 108.687402234
* device instance _151_t1 r0 *1 0,0
R_151_t1 \$151__t1 \$151 28.7964709909
* device instance _151_t2 r0 *1 0,0
R_151_t2 \$151__t2 \$151 133.512826775
* device instance _151 r0 *1 0,0
C_151 \$151 vsubs 6.487011e-15
* device instance _155_t0 r0 *1 0,0
R_155_t0 \$155__t0 \$155 84.9620979822
* device instance _155_t1 r0 *1 0,0
R_155_t1 \$155__t1 \$155 24.9695335856
* device instance _155_t2 r0 *1 0,0
R_155_t2 \$155__t2 \$155 86.6725684323
* device instance _155 r0 *1 0,0
C_155 \$155 vsubs 3.621691e-15
* device instance _156_t0 r0 *1 0,0
R_156_t0 \$156__t0 \$156 84.9620979822
* device instance _156_t1 r0 *1 0,0
R_156_t1 \$156__t1 \$156 24.9695335856
* device instance _156_t2 r0 *1 0,0
R_156_t2 \$156__t2 \$156 86.6725684323
* device instance _156 r0 *1 0,0
C_156 \$156 vsubs 3.621691e-15
* device instance _17_t0 r0 *1 0,0
R_17_t0 \$17__t0 \$17 108.687402234
* device instance _17_t1 r0 *1 0,0
R_17_t1 \$17__t1 \$17 28.7964709909
* device instance _17_t2 r0 *1 0,0
R_17_t2 \$17__t2 \$17 133.512826775
* device instance _17 r0 *1 0,0
C_17 \$17 vsubs 6.492519e-15
* device instance _19_t0 r0 *1 0,0
R_19_t0 \$19__t0 \$19 135.591504929
* device instance _19_t1 r0 *1 0,0
R_19_t1 \$19__t1 \$19 36.2048686624
* device instance _19_t2 r0 *1 0,0
R_19_t2 \$19__t2 \$19 166.824926409
* device instance _19 r0 *1 0,0
C_19 \$19 vsubs 7.022961e-15
* device instance _21_t0 r0 *1 0,0
R_21_t0 \$21__t0 \$21 162.444438203
* device instance _21_t1 r0 *1 0,0
R_21_t1 \$21__t1 \$21 43.7126105743
* device instance _21_t2 r0 *1 0,0
R_21_t2 \$21__t2 \$21 200.179851222
* device instance _21 r0 *1 0,0
C_21 \$21 vsubs 7.553404e-15
* device instance _22_t0 r0 *1 0,0
R_22_t0 \$22__t0 \$22 20.5348083509
* device instance _22_t1 r0 *1 0,0
R_22_t1 \$22__t1 \$22 17.2841938976
* device instance _22_t2 r0 *1 0,0
R_22_t2 \$22__t2 \$22 8.81561118035
* device instance _22_t3 r0 *1 0,0
R_22_t3 \$22__t3 \$22 9.68328915444
* device instance _22_t4 r0 *1 0,0
R_22_t4 \$22__t4 \$22 11.1307892286
* device instance _22_t5 r0 *1 0,0
R_22_t5 \$22__t5 \$22 8.70294224706
* device instance _22_t6 r0 *1 0,0
R_22_t6 \$22__t6 \$22 10.2652957245
* device instance _22_t7 r0 *1 0,0
R_22_t7 \$22__t7 \$22 17.359179808
* device instance _22_t8 r0 *1 0,0
R_22_t8 \$22__t8 \$22 19.8700104676
* device instance _22_t9 r0 *1 0,0
R_22_t9 \$22__t9 \$22 11.9360347135
* device instance _22_t10 r0 *1 0,0
R_22_t10 \$22__t10 \$22 14.4149413381
* device instance _22_t11 r0 *1 0,0
R_22_t11 \$22__t11 \$22 22.0385059258
* device instance _22_t12 r0 *1 0,0
R_22_t12 \$22__t12 \$22 19.6260262215
* device instance _22_t13 r0 *1 0,0
R_22_t13 \$22__t13 \$22 12.9653438247
* device instance _22_t14 r0 *1 0,0
R_22_t14 \$22__t14 \$22 15.0460328251
* device instance _22_t15 r0 *1 0,0
R_22_t15 \$22__t15 \$22 16.232802401
* device instance _22_t16 r0 *1 0,0
R_22_t16 \$22__t16 \$22 7.38585599964
* device instance _22_t17 r0 *1 0,0
R_22_t17 \$22__t17 \$22 13.7132259701
* device instance _22_t18 r0 *1 0,0
R_22_t18 \$22__t18 \$22 7.51828873979
* device instance _22_t19 r0 *1 0,0
R_22_t19 \$22__t19 \$22 8.51914044609
* device instance _22_t20 r0 *1 0,0
R_22_t20 \$22__t20 \$22 10.1343048081
* device instance _22_t21 r0 *1 0,0
R_22_t21 \$22__t21 \$22 12.1206355273
* device instance _22_t22 r0 *1 0,0
R_22_t22 \$22__t22 \$22 14.3245512622
* device instance _22_t23 r0 *1 0,0
R_22_t23 \$22__t23 \$22 16.6599226824
* device instance _22_t24 r0 *1 0,0
R_22_t24 \$22__t24 \$22 19.0785369024
* device instance _22_t25 r0 *1 0,0
R_22_t25 \$22__t25 \$22 21.5523875367
* device instance _22_t26 r0 *1 0,0
R_22_t26 \$22__t26 \$22 9.55115737603
* device instance _22_t27 r0 *1 0,0
R_22_t27 \$22__t27 \$22 6.79429131622
* device instance _22_t28 r0 *1 0,0
R_22_t28 \$22__t28 \$22 21.369098326
* device instance _22_t29 r0 *1 0,0
R_22_t29 \$22__t29 \$22 18.7891583821
* device instance _22_t30 r0 *1 0,0
R_22_t30 \$22__t30 \$22 12.4660124327
* device instance _22_t31 r0 *1 0,0
R_22_t31 \$22__t31 \$22 15.0917765982
* device instance _22_t32 r0 *1 0,0
R_22_t32 \$22__t32 \$22 17.7256669112
* device instance _22_t33 r0 *1 0,0
R_22_t33 \$22__t33 \$22 14.3968660347
* device instance _22_t34 r0 *1 0,0
R_22_t34 \$22__t34 \$22 19.4973035247
* device instance _22_t35 r0 *1 0,0
R_22_t35 \$22__t35 \$22 16.9312921054
* device instance _22_t36 r0 *1 0,0
R_22_t36 \$22__t36 \$22 11.9141991977
* device instance _22_t37 r0 *1 0,0
R_22_t37 \$22__t37 \$22 4.77330609208
* device instance _22_t38 r0 *1 0,0
R_22_t38 \$22__t38 \$22 5.45423683172
* device instance _22_t39 r0 *1 0,0
R_22_t39 \$22__t39 \$22 7.73802813512
* device instance _22_t40 r0 *1 0,0
R_22_t40 \$22__t40 \$22 5.14776374765
* device instance _22_t41 r0 *1 0,0
R_22_t41 \$22__t41 \$22 4.62975404422
* device instance _22_t42 r0 *1 0,0
R_22_t42 \$22__t42 \$22 7.31688453105
* device instance _22_t43 r0 *1 0,0
R_22_t43 \$22__t43 \$22 3.7010283775
* device instance _22_t44 r0 *1 0,0
R_22_t44 \$22__t44 \$22 9.85487202827
* device instance _22_t45 r0 *1 0,0
R_22_t45 \$22__t45 \$22 7.27412063772
* device instance _22_t46 r0 *1 0,0
R_22_t46 \$22__t46 \$22 5.51788592273
* device instance _22_t47 r0 *1 0,0
R_22_t47 \$22__t47 \$22 20.3645305774
* device instance _22_t48 r0 *1 0,0
R_22_t48 \$22__t48 \$22 10.202095425
* device instance _22_t49 r0 *1 0,0
R_22_t49 \$22__t49 \$22 12.7422805785
* device instance _22_t50 r0 *1 0,0
R_22_t50 \$22__t50 \$22 15.3207692124
* device instance _22_t51 r0 *1 0,0
R_22_t51 \$22__t51 \$22 17.9210355676
* device instance _22_t52 r0 *1 0,0
R_22_t52 \$22__t52 \$22 3.42400559633
* device instance _22_t53 r0 *1 0,0
R_22_t53 \$22__t53 \$22 9.52385557761
* device instance _22_t54 r0 *1 0,0
R_22_t54 \$22__t54 \$22 5.19810097632
* device instance _22_t55 r0 *1 0,0
R_22_t55 \$22__t55 \$22 6.00891785246
* device instance _22_t56 r0 *1 0,0
R_22_t56 \$22__t56 \$22 6.71710773354
* device instance _22_t57 r0 *1 0,0
R_22_t57 \$22__t57 \$22 8.25889039087
* device instance _22_t58 r0 *1 0,0
R_22_t58 \$22__t58 \$22 4.68565946996
* device instance _22_t59 r0 *1 0,0
R_22_t59 \$22__t59 \$22 6.41653667092
* device instance _22_t60 r0 *1 0,0
R_22_t60 \$22__t60 \$22 5.5648762084
* device instance _22_t61 r0 *1 0,0
R_22_t61 \$22__t61 \$22 7.35238610243
* device instance _22_t62 r0 *1 0,0
R_22_t62 \$22__t62 \$22 16.9466644068
* device instance _22_t63 r0 *1 0,0
R_22_t63 \$22__t63 \$22 19.5106541892
* device instance _22_t64 r0 *1 0,0
R_22_t64 \$22__t64 \$22 12.5148157706
* device instance _22_t65 r0 *1 0,0
R_22_t65 \$22__t65 \$22 14.897725426
* device instance _22_t66 r0 *1 0,0
R_22_t66 \$22__t66 \$22 21.3562354484
* device instance _22_t67 r0 *1 0,0
R_22_t67 \$22__t67 \$22 21.6976969367
* device instance _22_t68 r0 *1 0,0
R_22_t68 \$22__t68 \$22 19.1620500416
* device instance _22_t69 r0 *1 0,0
R_22_t69 \$22__t69 \$22 16.6629998163
* device instance _22_t70 r0 *1 0,0
R_22_t70 \$22__t70 \$22 14.2198542748
* device instance _22_t71 r0 *1 0,0
R_22_t71 \$22__t71 \$22 11.8671917467
* device instance _22_t72 r0 *1 0,0
R_22_t72 \$22__t72 \$22 9.67127271597
* device instance _22_t73 r0 *1 0,0
R_22_t73 \$22__t73 \$22 7.76621423726
* device instance _22_t74 r0 *1 0,0
R_22_t74 \$22__t74 \$22 4.10646573912
* device instance _22_t75 r0 *1 0,0
R_22_t75 \$22__t75 \$22 9.37255027548
* device instance _22_t76 r0 *1 0,0
R_22_t76 \$22__t76 \$22 8.16421237831
* device instance _22_t77 r0 *1 0,0
R_22_t77 \$22__t77 \$22 18.9610534462
* device instance _22_t78 r0 *1 0,0
R_22_t78 \$22__t78 \$22 16.6442661205
* device instance _22_t79 r0 *1 0,0
R_22_t79 \$22__t79 \$22 14.4436468119
* device instance _22_t80 r0 *1 0,0
R_22_t80 \$22__t80 \$22 12.4210934866
* device instance _22_t81 r0 *1 0,0
R_22_t81 \$22__t81 \$22 10.6782716399
* device instance _22_t82 r0 *1 0,0
R_22_t82 \$22__t82 \$22 11.2551566343
* device instance _22_t83 r0 *1 0,0
R_22_t83 \$22__t83 \$22 20.8542191803
* device instance _22_t84 r0 *1 0,0
R_22_t84 \$22__t84 \$22 18.3937819081
* device instance _22_t85 r0 *1 0,0
R_22_t85 \$22__t85 \$22 15.9950385989
* device instance _22_t86 r0 *1 0,0
R_22_t86 \$22__t86 \$22 13.6904564686
* device instance _22_t87 r0 *1 0,0
R_22_t87 \$22__t87 \$22 11.5366038544
* device instance _22_t88 r0 *1 0,0
R_22_t88 \$22__t88 \$22 9.63509991161
* device instance _22_t89 r0 *1 0,0
R_22_t89 \$22__t89 \$22 8.90964796484
* device instance _22_t90 r0 *1 0,0
R_22_t90 \$22__t90 \$22 4.88132248825
* device instance _22_t91 r0 *1 0,0
R_22_t91 \$22__t91 \$22 19.8531543821
* device instance _22_t92 r0 *1 0,0
R_22_t92 \$22__t92 \$22 17.339883118
* device instance _22_t93 r0 *1 0,0
R_22_t93 \$22__t93 \$22 14.8752359917
* device instance _22_t94 r0 *1 0,0
R_22_t94 \$22__t94 \$22 12.4880357427
* device instance _22_t95 r0 *1 0,0
R_22_t95 \$22__t95 \$22 10.2326301238
* device instance _22_t96 r0 *1 0,0
R_22_t96 \$22__t96 \$22 8.21825367262
* device instance _22_t97 r0 *1 0,0
R_22_t97 \$22__t97 \$22 6.66708026374
* device instance _22_t98 r0 *1 0,0
R_22_t98 \$22__t98 \$22 21.6822617661
* device instance _22_t99 r0 *1 0,0
R_22_t99 \$22__t99 \$22 6.36414690185
* device instance _22_t100 r0 *1 0,0
R_22_t100 \$22__t100 \$22 7.72298559613
* device instance _22_t101 r0 *1 0,0
R_22_t101 \$22__t101 \$22 9.63659373875
* device instance _22_t102 r0 *1 0,0
R_22_t102 \$22__t102 \$22 11.8389468658
* device instance _22_t103 r0 *1 0,0
R_22_t103 \$22__t103 \$22 14.1962910133
* device instance _22_t104 r0 *1 0,0
R_22_t104 \$22__t104 \$22 16.6428959564
* device instance _22_t105 r0 *1 0,0
R_22_t105 \$22__t105 \$22 19.1445706334
* device instance _22_t106 r0 *1 0,0
R_22_t106 \$22__t106 \$22 5.95294185229
* device instance _22_t107 r0 *1 0,0
R_22_t107 \$22__t107 \$22 21.3569094465
* device instance _22_t108 r0 *1 0,0
R_22_t108 \$22__t108 \$22 18.7752946861
* device instance _22_t109 r0 *1 0,0
R_22_t109 \$22__t109 \$22 16.2167534245
* device instance _22_t110 r0 *1 0,0
R_22_t110 \$22__t110 \$22 19.6241472357
* device instance _22_t111 r0 *1 0,0
R_22_t111 \$22__t111 \$22 12.0250382035
* device instance _22_t112 r0 *1 0,0
R_22_t112 \$22__t112 \$22 8.88037413057
* device instance _22_t113 r0 *1 0,0
R_22_t113 \$22__t113 \$22 14.3544403196
* device instance _22_t114 r0 *1 0,0
R_22_t114 \$22__t114 \$22 11.7318922356
* device instance _22_t115 r0 *1 0,0
R_22_t115 \$22__t115 \$22 9.12698885734
* device instance _22_t116 r0 *1 0,0
R_22_t116 \$22__t116 \$22 16.9864625508
* device instance _22_t117 r0 *1 0,0
R_22_t117 \$22__t117 \$22 6.75585763107
* device instance _22_t118 r0 *1 0,0
R_22_t118 \$22__t118 \$22 2.18164294876
* device instance _22_t119 r0 *1 0,0
R_22_t119 \$22__t119 \$22 2.59487238285
* device instance _22_t120 r0 *1 0,0
R_22_t120 \$22__t120 \$22 19.8007929916
* device instance _22_t121 r0 *1 0,0
R_22_t121 \$22__t121 \$22 17.1902343893
* device instance _22_t122 r0 *1 0,0
R_22_t122 \$22__t122 \$22 14.5950061753
* device instance _22_t123 r0 *1 0,0
R_22_t123 \$22__t123 \$22 9.50085122343
* device instance _22_t124 r0 *1 0,0
R_22_t124 \$22__t124 \$22 7.071640247
* device instance _22_t125 r0 *1 0,0
R_22_t125 \$22__t125 \$22 13.6942244888
* device instance _22_t126 r0 *1 0,0
R_22_t126 \$22__t126 \$22 11.2319975385
* device instance _22_t127 r0 *1 0,0
R_22_t127 \$22__t127 \$22 6.5607810065
* device instance _22_t128 r0 *1 0,0
R_22_t128 \$22__t128 \$22 21.1920515705
* device instance _22_t129 r0 *1 0,0
R_22_t129 \$22__t129 \$22 21.2357630582
* device instance _22_t130 r0 *1 0,0
R_22_t130 \$22__t130 \$22 21.2961235546
* device instance _22_t131 r0 *1 0,0
R_22_t131 \$22__t131 \$22 21.3729920023
* device instance _22_t132 r0 *1 0,0
R_22_t132 \$22__t132 \$22 23.6115870328
* device instance _22_t133 r0 *1 0,0
R_22_t133 \$22__t133 \$22 23.4143937909
* device instance _22_t134 r0 *1 0,0
R_22_t134 \$22__t134 \$22 23.230869417
* device instance _22_t135 r0 *1 0,0
R_22_t135 \$22__t135 \$22 23.061340248
* device instance _22 r0 *1 0,0
C_22 \$22 vsubs 3.07467522e-13
* device instance _23_t0 r0 *1 0,0
R_23_t0 \$23__t0 \$23 81.7777390336
* device instance _23_t1 r0 *1 0,0
R_23_t1 \$23__t1 \$23 21.4987692264
* device instance _23_t2 r0 *1 0,0
R_23_t2 \$23__t2 \$23 100.29899174
* device instance _23 r0 *1 0,0
C_23 \$23 vsubs 5.962076e-15
* device instance _25_t0 r0 *1 0,0
R_25_t0 \$25__t0 \$25 108.687402234
* device instance _25_t1 r0 *1 0,0
R_25_t1 \$25__t1 \$25 28.7964709909
* device instance _25_t2 r0 *1 0,0
R_25_t2 \$25__t2 \$25 133.512826775
* device instance _25 r0 *1 0,0
C_25 \$25 vsubs 6.492519e-15
* device instance _27_t0 r0 *1 0,0
R_27_t0 \$27__t0 \$27 135.591504929
* device instance _27_t1 r0 *1 0,0
R_27_t1 \$27__t1 \$27 36.2048686624
* device instance _27_t2 r0 *1 0,0
R_27_t2 \$27__t2 \$27 166.824926409
* device instance _27 r0 *1 0,0
C_27 \$27 vsubs 7.022961e-15
* device instance _29_t0 r0 *1 0,0
R_29_t0 \$29__t0 \$29 162.444438203
* device instance _29_t1 r0 *1 0,0
R_29_t1 \$29__t1 \$29 43.7126105743
* device instance _29_t2 r0 *1 0,0
R_29_t2 \$29__t2 \$29 200.179851222
* device instance _29 r0 *1 0,0
C_29 \$29 vsubs 7.553404e-15
* device instance _3_t0 r0 *1 0,0
R_3_t0 \$3__t0 \$3 100.29899174
* device instance _3_t1 r0 *1 0,0
R_3_t1 \$3__t1 \$3 21.4987692264
* device instance _3_t2 r0 *1 0,0
R_3_t2 \$3__t2 \$3 81.7777390336
* device instance _3 r0 *1 0,0
C_3 \$3 vsubs 5.962076e-15
* device instance _30_t0 r0 *1 0,0
R_30_t0 \$30__t0 \$30 35.7620392391
* device instance _30_t1 r0 *1 0,0
R_30_t1 \$30__t1 \$30 16.7290645481
* device instance _30_t2 r0 *1 0,0
R_30_t2 \$30__t2 \$30 17.1596833046
* device instance _30_t3 r0 *1 0,0
R_30_t3 \$30__t3 \$30 18.4542454758
* device instance _30_t4 r0 *1 0,0
R_30_t4 \$30__t4 \$30 20.4493260416
* device instance _30_t5 r0 *1 0,0
R_30_t5 \$30__t5 \$30 22.9630574954
* device instance _30_t6 r0 *1 0,0
R_30_t6 \$30__t6 \$30 25.8445429061
* device instance _30_t7 r0 *1 0,0
R_30_t7 \$30__t7 \$30 28.984307841
* device instance _30_t8 r0 *1 0,0
R_30_t8 \$30__t8 \$30 32.3071372691
* device instance _30_t9 r0 *1 0,0
R_30_t9 \$30__t9 \$30 32.5580480625
* device instance _30_t10 r0 *1 0,0
R_30_t10 \$30__t10 \$30 29.2239699998
* device instance _30_t11 r0 *1 0,0
R_30_t11 \$30__t11 \$30 26.0684803156
* device instance _30_t12 r0 *1 0,0
R_30_t12 \$30__t12 \$30 23.1646762094
* device instance _30_t13 r0 *1 0,0
R_30_t13 \$30__t13 \$30 20.6191681772
* device instance _30_t14 r0 *1 0,0
R_30_t14 \$30__t14 \$30 18.5798084828
* device instance _30_t15 r0 *1 0,0
R_30_t15 \$30__t15 \$30 15.7539253748
* device instance _30_t16 r0 *1 0,0
R_30_t16 \$30__t16 \$30 19.7186346689
* device instance _30_t17 r0 *1 0,0
R_30_t17 \$30__t17 \$30 23.6848951064
* device instance _30_t18 r0 *1 0,0
R_30_t18 \$30__t18 \$30 27.6520392323
* device instance _30_t19 r0 *1 0,0
R_30_t19 \$30__t19 \$30 31.6197344346
* device instance _30_t20 r0 *1 0,0
R_30_t20 \$30__t20 \$30 0.86357155652
* device instance _30_t21 r0 *1 0,0
R_30_t21 \$30__t21 \$30 3.91648902628
* device instance _30_t22 r0 *1 0,0
R_30_t22 \$30__t22 \$30 11.7923318616
* device instance _30_t23 r0 *1 0,0
R_30_t23 \$30__t23 \$30 7.83857967109
* device instance _30_t24 r0 *1 0,0
R_30_t24 \$30__t24 \$30 22.7276311457
* device instance _30_t25 r0 *1 0,0
R_30_t25 \$30__t25 \$30 26.5414878586
* device instance _30_t26 r0 *1 0,0
R_30_t26 \$30__t26 \$30 30.3951846927
* device instance _30_t27 r0 *1 0,0
R_30_t27 \$30__t27 \$30 17.227297661
* device instance _30_t28 r0 *1 0,0
R_30_t28 \$30__t28 \$30 4.20284901951
* device instance _30_t29 r0 *1 0,0
R_30_t29 \$30__t29 \$30 30.6806967719
* device instance _30_t30 r0 *1 0,0
R_30_t30 \$30__t30 \$30 26.8246794215
* device instance _30_t31 r0 *1 0,0
R_30_t31 \$30__t31 \$30 23.0072382573
* device instance _30_t32 r0 *1 0,0
R_30_t32 \$30__t32 \$30 19.2513353536
* device instance _30_t33 r0 *1 0,0
R_30_t33 \$30__t33 \$30 15.6014783939
* device instance _30_t34 r0 *1 0,0
R_30_t34 \$30__t34 \$30 12.1535862098
* device instance _30_t35 r0 *1 0,0
R_30_t35 \$30__t35 \$30 9.13917403003
* device instance _30_t36 r0 *1 0,0
R_30_t36 \$30__t36 \$30 18.9776492684
* device instance _30_t37 r0 *1 0,0
R_30_t37 \$30__t37 \$30 11.9120537184
* device instance _30_t38 r0 *1 0,0
R_30_t38 \$30__t38 \$30 8.94633565039
* device instance _30_t39 r0 *1 0,0
R_30_t39 \$30__t39 \$30 7.0489810509
* device instance _30_t40 r0 *1 0,0
R_30_t40 \$30__t40 \$30 7.13096491717
* device instance _30_t41 r0 *1 0,0
R_30_t41 \$30__t41 \$30 15.3384627821
* device instance _30_t42 r0 *1 0,0
R_30_t42 \$30__t42 \$30 27.9447785609
* device instance _30_t43 r0 *1 0,0
R_30_t43 \$30__t43 \$30 23.9775849019
* device instance _30_t44 r0 *1 0,0
R_30_t44 \$30__t44 \$30 20.0112423688
* device instance _30_t45 r0 *1 0,0
R_30_t45 \$30__t45 \$30 16.0463821177
* device instance _30_t46 r0 *1 0,0
R_30_t46 \$30__t46 \$30 12.0844632275
* device instance _30_t47 r0 *1 0,0
R_30_t47 \$30__t47 \$30 8.12978710888
* device instance _30_t48 r0 *1 0,0
R_30_t48 \$30__t48 \$30 23.506222958
* device instance _30_t49 r0 *1 0,0
R_30_t49 \$30__t49 \$30 27.2111719336
* device instance _30_t50 r0 *1 0,0
R_30_t50 \$30__t50 \$30 30.9816809221
* device instance _30_t51 r0 *1 0,0
R_30_t51 \$30__t51 \$30 31.2618370328
* device instance _30_t52 r0 *1 0,0
R_30_t52 \$30__t52 \$30 27.4874648944
* device instance _30_t53 r0 *1 0,0
R_30_t53 \$30__t53 \$30 23.7766758081
* device instance _30_t54 r0 *1 0,0
R_30_t54 \$30__t54 \$30 20.1646029753
* device instance _30_t55 r0 *1 0,0
R_30_t55 \$30__t55 \$30 13.5538539911
* device instance _30_t56 r0 *1 0,0
R_30_t56 \$30__t56 \$30 10.9326027187
* device instance _30_t57 r0 *1 0,0
R_30_t57 \$30__t57 \$30 16.7153650373
* device instance _30_t58 r0 *1 0,0
R_30_t58 \$30__t58 \$30 19.9034788921
* device instance _30_t59 r0 *1 0,0
R_30_t59 \$30__t59 \$30 16.4701469566
* device instance _30_t60 r0 *1 0,0
R_30_t60 \$30__t60 \$30 13.3377031022
* device instance _30_t61 r0 *1 0,0
R_30_t61 \$30__t61 \$30 10.7719182053
* device instance _30_t62 r0 *1 0,0
R_30_t62 \$30__t62 \$30 9.25664270182
* device instance _30_t63 r0 *1 0,0
R_30_t63 \$30__t63 \$30 9.31922533814
* device instance _30_t64 r0 *1 0,0
R_30_t64 \$30__t64 \$30 32.1199641948
* device instance _30_t65 r0 *1 0,0
R_30_t65 \$30__t65 \$30 31.8009661534
* device instance _30_t66 r0 *1 0,0
R_30_t66 \$30__t66 \$30 31.5040641348
* device instance _30_t67 r0 *1 0,0
R_30_t67 \$30__t67 \$30 31.2298883447
* device instance _30_t68 r0 *1 0,0
R_30_t68 \$30__t68 \$30 31.4443122035
* device instance _30_t69 r0 *1 0,0
R_30_t69 \$30__t69 \$30 31.5044315132
* device instance _30_t70 r0 *1 0,0
R_30_t70 \$30__t70 \$30 31.6999030897
* device instance _30_t71 r0 *1 0,0
R_30_t71 \$30__t71 \$30 31.5896961094
* device instance _30 r0 *1 0,0
C_30 \$30 vsubs 1.74844138e-13
* device instance _31_t0 r0 *1 0,0
R_31_t0 \$31__t0 \$31 81.7777390336
* device instance _31_t1 r0 *1 0,0
R_31_t1 \$31__t1 \$31 21.4987692264
* device instance _31_t2 r0 *1 0,0
R_31_t2 \$31__t2 \$31 100.29899174
* device instance _31 r0 *1 0,0
C_31 \$31 vsubs 5.962076e-15
* device instance _33_t0 r0 *1 0,0
R_33_t0 \$33__t0 \$33 108.687402234
* device instance _33_t1 r0 *1 0,0
R_33_t1 \$33__t1 \$33 28.7964709909
* device instance _33_t2 r0 *1 0,0
R_33_t2 \$33__t2 \$33 133.512826775
* device instance _33 r0 *1 0,0
C_33 \$33 vsubs 6.492519e-15
* device instance _35_t0 r0 *1 0,0
R_35_t0 \$35__t0 \$35 135.591504929
* device instance _35_t1 r0 *1 0,0
R_35_t1 \$35__t1 \$35 36.2048686624
* device instance _35_t2 r0 *1 0,0
R_35_t2 \$35__t2 \$35 166.824926409
* device instance _35 r0 *1 0,0
C_35 \$35 vsubs 7.022961e-15
* device instance _37_t0 r0 *1 0,0
R_37_t0 \$37__t0 \$37 162.444438203
* device instance _37_t1 r0 *1 0,0
R_37_t1 \$37__t1 \$37 43.7126105743
* device instance _37_t2 r0 *1 0,0
R_37_t2 \$37__t2 \$37 200.179851222
* device instance _37 r0 *1 0,0
C_37 \$37 vsubs 7.553404e-15
* device instance _38_t0 r0 *1 0,0
R_38_t0 \$38__t0 \$38 63.5750648064
* device instance _38_t1 r0 *1 0,0
R_38_t1 \$38__t1 \$38 35.3118507277
* device instance _38_t2 r0 *1 0,0
R_38_t2 \$38__t2 \$38 37.7357410999
* device instance _38_t3 r0 *1 0,0
R_38_t3 \$38__t3 \$38 40.9281614018
* device instance _38_t4 r0 *1 0,0
R_38_t4 \$38__t4 \$38 44.7248423133
* device instance _38_t5 r0 *1 0,0
R_38_t5 \$38__t5 \$38 48.9854828392
* device instance _38_t6 r0 *1 0,0
R_38_t6 \$38__t6 \$38 53.5995561817
* device instance _38_t7 r0 *1 0,0
R_38_t7 \$38__t7 \$38 58.4834694729
* device instance _38_t8 r0 *1 0,0
R_38_t8 \$38__t8 \$38 42.8965547564
* device instance _38_t9 r0 *1 0,0
R_38_t9 \$38__t9 \$38 48.8622368367
* device instance _38_t10 r0 *1 0,0
R_38_t10 \$38__t10 \$38 54.8542692252
* device instance _38_t11 r0 *1 0,0
R_38_t11 \$38__t11 \$38 31.1048791516
* device instance _38_t12 r0 *1 0,0
R_38_t12 \$38__t12 \$38 36.9699812833
* device instance _38_t13 r0 *1 0,0
R_38_t13 \$38__t13 \$38 25.3439614667
* device instance _38_t14 r0 *1 0,0
R_38_t14 \$38__t14 \$38 12.3169961247
* device instance _38_t15 r0 *1 0,0
R_38_t15 \$38__t15 \$38 14.6331400903
* device instance _38_t16 r0 *1 0,0
R_38_t16 \$38__t16 \$38 19.7784767727
* device instance _38_t17 r0 *1 0,0
R_38_t17 \$38__t17 \$38 41.9993449693
* device instance _38_t18 r0 *1 0,0
R_38_t18 \$38__t18 \$38 36.2135169695
* device instance _38_t19 r0 *1 0,0
R_38_t19 \$38__t19 \$38 30.5444189598
* device instance _38_t20 r0 *1 0,0
R_38_t20 \$38__t20 \$38 25.0713608069
* device instance _38_t21 r0 *1 0,0
R_38_t21 \$38__t21 \$38 19.9562927585
* device instance _38_t22 r0 *1 0,0
R_38_t22 \$38__t22 \$38 15.5564453991
* device instance _38_t23 r0 *1 0,0
R_38_t23 \$38__t23 \$38 12.6420429946
* device instance _38_t24 r0 *1 0,0
R_38_t24 \$38__t24 \$38 20.0604086558
* device instance _38_t25 r0 *1 0,0
R_38_t25 \$38__t25 \$38 15.6897854742
* device instance _38_t26 r0 *1 0,0
R_38_t26 \$38__t26 \$38 25.1543138941
* device instance _38_t27 r0 *1 0,0
R_38_t27 \$38__t27 \$38 12.8057653363
* device instance _38_t28 r0 *1 0,0
R_38_t28 \$38__t28 \$38 42.0489161884
* device instance _38_t29 r0 *1 0,0
R_38_t29 \$38__t29 \$38 36.2709964858
* device instance _38_t30 r0 *1 0,0
R_38_t30 \$38__t30 \$38 12.4849817103
* device instance _38_t31 r0 *1 0,0
R_38_t31 \$38__t31 \$38 30.6125448854
* device instance _38_t32 r0 *1 0,0
R_38_t32 \$38__t32 \$38 51.736545064
* device instance _38_t33 r0 *1 0,0
R_38_t33 \$38__t33 \$38 52.5805420858
* device instance _38_t34 r0 *1 0,0
R_38_t34 \$38__t34 \$38 53.4462950467
* device instance _38_t35 r0 *1 0,0
R_38_t35 \$38__t35 \$38 54.3327639614
* device instance _38_t36 r0 *1 0,0
R_38_t36 \$38__t36 \$38 49.661812123
* device instance _38_t37 r0 *1 0,0
R_38_t37 \$38__t37 \$38 47.8071039279
* device instance _38_t38 r0 *1 0,0
R_38_t38 \$38__t38 \$38 48.3945063803
* device instance _38_t39 r0 *1 0,0
R_38_t39 \$38__t39 \$38 49.0131313723
* device instance _38 r0 *1 0,0
C_38 \$38 vsubs 1.4581235e-13
* device instance _39_t0 r0 *1 0,0
R_39_t0 \$39__t0 \$39 81.7777390336
* device instance _39_t1 r0 *1 0,0
R_39_t1 \$39__t1 \$39 21.4987692264
* device instance _39_t2 r0 *1 0,0
R_39_t2 \$39__t2 \$39 100.29899174
* device instance _39 r0 *1 0,0
C_39 \$39 vsubs 5.956568e-15
* device instance _41_t0 r0 *1 0,0
R_41_t0 \$41__t0 \$41 108.687402234
* device instance _41_t1 r0 *1 0,0
R_41_t1 \$41__t1 \$41 28.7964709909
* device instance _41_t2 r0 *1 0,0
R_41_t2 \$41__t2 \$41 133.512826775
* device instance _41 r0 *1 0,0
C_41 \$41 vsubs 6.473346e-15
* device instance _43_t0 r0 *1 0,0
R_43_t0 \$43__t0 \$43 135.591504929
* device instance _43_t1 r0 *1 0,0
R_43_t1 \$43__t1 \$43 36.2048686624
* device instance _43_t2 r0 *1 0,0
R_43_t2 \$43__t2 \$43 166.824926409
* device instance _43 r0 *1 0,0
C_43 \$43 vsubs 7.017453e-15
* device instance _45_t0 r0 *1 0,0
R_45_t0 \$45__t0 \$45 162.444438203
* device instance _45_t1 r0 *1 0,0
R_45_t1 \$45__t1 \$45 43.7126105743
* device instance _45_t2 r0 *1 0,0
R_45_t2 \$45__t2 \$45 200.179851222
* device instance _45 r0 *1 0,0
C_45 \$45 vsubs 7.547896e-15
* device instance _46_t0 r0 *1 0,0
R_46_t0 \$46__t0 \$46 68.6564414303
* device instance _46_t1 r0 *1 0,0
R_46_t1 \$46__t1 \$46 62.8853192817
* device instance _46_t2 r0 *1 0,0
R_46_t2 \$46__t2 \$46 63.4699084418
* device instance _46_t3 r0 *1 0,0
R_46_t3 \$46__t3 \$46 67.5932309337
* device instance _46_t4 r0 *1 0,0
R_46_t4 \$46__t4 \$46 43.9123071765
* device instance _46_t5 r0 *1 0,0
R_46_t5 \$46__t5 \$46 51.2766367586
* device instance _46_t6 r0 *1 0,0
R_46_t6 \$46__t6 \$46 59.2408490213
* device instance _46_t7 r0 *1 0,0
R_46_t7 \$46__t7 \$46 37.2260035799
* device instance _46_t8 r0 *1 0,0
R_46_t8 \$46__t8 \$46 65.4329972861
* device instance _46_t9 r0 *1 0,0
R_46_t9 \$46__t9 \$46 30.8795324853
* device instance _46_t10 r0 *1 0,0
R_46_t10 \$46__t10 \$46 25.0326142029
* device instance _46_t11 r0 *1 0,0
R_46_t11 \$46__t11 \$46 26.4669165237
* device instance _46_t12 r0 *1 0,0
R_46_t12 \$46__t12 \$46 33.3002485168
* device instance _46_t13 r0 *1 0,0
R_46_t13 \$46__t13 \$46 42.5430288882
* device instance _46_t14 r0 *1 0,0
R_46_t14 \$46__t14 \$46 51.8661163235
* device instance _46_t15 r0 *1 0,0
R_46_t15 \$46__t15 \$46 61.232840027
* device instance _46_t16 r0 *1 0,0
R_46_t16 \$46__t16 \$46 85.9718503238
* device instance _46_t17 r0 *1 0,0
R_46_t17 \$46__t17 \$46 87.6600196013
* device instance _46_t18 r0 *1 0,0
R_46_t18 \$46__t18 \$46 89.3670527186
* device instance _46_t19 r0 *1 0,0
R_46_t19 \$46__t19 \$46 84.303678131
* device instance _46_t20 r0 *1 0,0
R_46_t20 \$46__t20 \$46 75.4322511095
* device instance _46_t21 r0 *1 0,0
R_46_t21 \$46__t21 \$46 76.856093944
* device instance _46_t22 r0 *1 0,0
R_46_t22 \$46__t22 \$46 78.3119718301
* device instance _46_t23 r0 *1 0,0
R_46_t23 \$46__t23 \$46 74.0422914643
* device instance _46 r0 *1 0,0
C_46 \$46 vsubs 1.32779351e-13
* device instance _47_t0 r0 *1 0,0
R_47_t0 \$47__t0 \$47 81.7777390336
* device instance _47_t1 r0 *1 0,0
R_47_t1 \$47__t1 \$47 21.4987692264
* device instance _47_t2 r0 *1 0,0
R_47_t2 \$47__t2 \$47 100.29899174
* device instance _47 r0 *1 0,0
C_47 \$47 vsubs 5.962076e-15
* device instance _49_t0 r0 *1 0,0
R_49_t0 \$49__t0 \$49 108.687402234
* device instance _49_t1 r0 *1 0,0
R_49_t1 \$49__t1 \$49 28.7964709909
* device instance _49_t2 r0 *1 0,0
R_49_t2 \$49__t2 \$49 133.512826775
* device instance _49 r0 *1 0,0
C_49 \$49 vsubs 6.492519e-15
* device instance _5_t0 r0 *1 0,0
R_5_t0 \$5__t0 \$5 108.687402234
* device instance _5_t1 r0 *1 0,0
R_5_t1 \$5__t1 \$5 28.7964709909
* device instance _5_t2 r0 *1 0,0
R_5_t2 \$5__t2 \$5 133.512826775
* device instance _5 r0 *1 0,0
C_5 \$5 vsubs 6.492519e-15
* device instance _51_t0 r0 *1 0,0
R_51_t0 \$51__t0 \$51 135.591504929
* device instance _51_t1 r0 *1 0,0
R_51_t1 \$51__t1 \$51 36.2048686624
* device instance _51_t2 r0 *1 0,0
R_51_t2 \$51__t2 \$51 166.824926409
* device instance _51 r0 *1 0,0
C_51 \$51 vsubs 7.022961e-15
* device instance _53_t0 r0 *1 0,0
R_53_t0 \$53__t0 \$53 162.444438203
* device instance _53_t1 r0 *1 0,0
R_53_t1 \$53__t1 \$53 43.7126105743
* device instance _53_t2 r0 *1 0,0
R_53_t2 \$53__t2 \$53 200.179851222
* device instance _53 r0 *1 0,0
C_53 \$53 vsubs 7.553404e-15
* device instance _54_t0 r0 *1 0,0
R_54_t0 \$54__t0 \$54 86.3849133
* device instance _54_t1 r0 *1 0,0
R_54_t1 \$54__t1 \$54 88.7698933301
* device instance _54_t2 r0 *1 0,0
R_54_t2 \$54__t2 \$54 134.098215711
* device instance _54_t3 r0 *1 0,0
R_54_t3 \$54__t3 \$54 124.337752899
* device instance _54_t4 r0 *1 0,0
R_54_t4 \$54__t4 \$54 45.4484549899
* device instance _54_t5 r0 *1 0,0
R_54_t5 \$54__t5 \$54 49.8327480374
* device instance _54_t6 r0 *1 0,0
R_54_t6 \$54__t6 \$54 114.737828634
* device instance _54_t7 r0 *1 0,0
R_54_t7 \$54__t7 \$54 125.248648618
* device instance _54_t8 r0 *1 0,0
R_54_t8 \$54__t8 \$54 87.8405388707
* device instance _54_t9 r0 *1 0,0
R_54_t9 \$54__t9 \$54 89.9037133955
* device instance _54_t10 r0 *1 0,0
R_54_t10 \$54__t10 \$54 91.9815797066
* device instance _54_t11 r0 *1 0,0
R_54_t11 \$54__t11 \$54 94.0731642829
* device instance _54_t12 r0 *1 0,0
R_54_t12 \$54__t12 \$54 73.8330875536
* device instance _54_t13 r0 *1 0,0
R_54_t13 \$54__t13 \$54 75.655267792
* device instance _54_t14 r0 *1 0,0
R_54_t14 \$54__t14 \$54 77.5069685996
* device instance _54_t15 r0 *1 0,0
R_54_t15 \$54__t15 \$54 79.3861242797
* device instance _54 r0 *1 0,0
C_54 \$54 vsubs 1.26906803e-13
* device instance _55_t0 r0 *1 0,0
R_55_t0 \$55__t0 \$55 81.7777390336
* device instance _55_t1 r0 *1 0,0
R_55_t1 \$55__t1 \$55 21.4987692264
* device instance _55_t2 r0 *1 0,0
R_55_t2 \$55__t2 \$55 100.29899174
* device instance _55 r0 *1 0,0
C_55 \$55 vsubs 5.962076e-15
* device instance _57_t0 r0 *1 0,0
R_57_t0 \$57__t0 \$57 108.687402234
* device instance _57_t1 r0 *1 0,0
R_57_t1 \$57__t1 \$57 28.7964709909
* device instance _57_t2 r0 *1 0,0
R_57_t2 \$57__t2 \$57 133.512826775
* device instance _57 r0 *1 0,0
C_57 \$57 vsubs 6.492519e-15
* device instance _59_t0 r0 *1 0,0
R_59_t0 \$59__t0 \$59 135.591504929
* device instance _59_t1 r0 *1 0,0
R_59_t1 \$59__t1 \$59 36.2048686624
* device instance _59_t2 r0 *1 0,0
R_59_t2 \$59__t2 \$59 166.824926409
* device instance _59 r0 *1 0,0
C_59 \$59 vsubs 7.022961e-15
* device instance _61_t0 r0 *1 0,0
R_61_t0 \$61__t0 \$61 162.444438203
* device instance _61_t1 r0 *1 0,0
R_61_t1 \$61__t1 \$61 43.7126105743
* device instance _61_t2 r0 *1 0,0
R_61_t2 \$61__t2 \$61 200.179851222
* device instance _61 r0 *1 0,0
C_61 \$61 vsubs 7.553404e-15
* device instance _62_t0 r0 *1 0,0
R_62_t0 \$62__t0 \$62 146.949644361
* device instance _62_t1 r0 *1 0,0
R_62_t1 \$62__t1 \$62 252.863932211
* device instance _62_t2 r0 *1 0,0
R_62_t2 \$62__t2 \$62 102.380518794
* device instance _62_t3 r0 *1 0,0
R_62_t3 \$62__t3 \$62 240.807918259
* device instance _62_t4 r0 *1 0,0
R_62_t4 \$62__t4 \$62 92.9642864051
* device instance _62_t5 r0 *1 0,0
R_62_t5 \$62__t5 \$62 95.7793979853
* device instance _62_t6 r0 *1 0,0
R_62_t6 \$62__t6 \$62 98.6087679444
* device instance _62_t7 r0 *1 0,0
R_62_t7 \$62__t7 \$62 101.451203335
* device instance _62_t8 r0 *1 0,0
R_62_t8 \$62__t8 \$62 80.6730035165
* device instance _62_t9 r0 *1 0,0
R_62_t9 \$62__t9 \$62 78.0795365719
* device instance _62_t10 r0 *1 0,0
R_62_t10 \$62__t10 \$62 75.5205672098
* device instance _62_t11 r0 *1 0,0
R_62_t11 \$62__t11 \$62 72.9997234076
* device instance _62 r0 *1 0,0
C_62 \$62 vsubs 1.24716345e-13
* device instance _63_t0 r0 *1 0,0
R_63_t0 \$63__t0 \$63 81.7777390336
* device instance _63_t1 r0 *1 0,0
R_63_t1 \$63__t1 \$63 21.4987692264
* device instance _63_t2 r0 *1 0,0
R_63_t2 \$63__t2 \$63 100.29899174
* device instance _63 r0 *1 0,0
C_63 \$63 vsubs 5.962076e-15
* device instance _65_t0 r0 *1 0,0
R_65_t0 \$65__t0 \$65 108.687402234
* device instance _65_t1 r0 *1 0,0
R_65_t1 \$65__t1 \$65 28.7964709909
* device instance _65_t2 r0 *1 0,0
R_65_t2 \$65__t2 \$65 133.512826775
* device instance _65 r0 *1 0,0
C_65 \$65 vsubs 6.492519e-15
* device instance _67_t0 r0 *1 0,0
R_67_t0 \$67__t0 \$67 135.591504929
* device instance _67_t1 r0 *1 0,0
R_67_t1 \$67__t1 \$67 36.2048686624
* device instance _67_t2 r0 *1 0,0
R_67_t2 \$67__t2 \$67 166.824926409
* device instance _67 r0 *1 0,0
C_67 \$67 vsubs 7.022961e-15
* device instance _69_t0 r0 *1 0,0
R_69_t0 \$69__t0 \$69 162.444438203
* device instance _69_t1 r0 *1 0,0
R_69_t1 \$69__t1 \$69 43.7126105743
* device instance _69_t2 r0 *1 0,0
R_69_t2 \$69__t2 \$69 200.179851222
* device instance _69 r0 *1 0,0
C_69 \$69 vsubs 7.553404e-15
* device instance _7_t0 r0 *1 0,0
R_7_t0 \$7__t0 \$7 135.591504929
* device instance _7_t1 r0 *1 0,0
R_7_t1 \$7__t1 \$7 36.2048686624
* device instance _7_t2 r0 *1 0,0
R_7_t2 \$7__t2 \$7 166.824926409
* device instance _7 r0 *1 0,0
C_7 \$7 vsubs 7.022961e-15
* device instance _70_t0 r0 *1 0,0
R_70_t0 \$70__t0 \$70 254.061525599
* device instance _70_t1 r0 *1 0,0
R_70_t1 \$70__t1 \$70 430.2150524
* device instance _70_t2 r0 *1 0,0
R_70_t2 \$70__t2 \$70 89.466427095
* device instance _70_t3 r0 *1 0,0
R_70_t3 \$70__t3 \$70 93.2917599877
* device instance _70_t4 r0 *1 0,0
R_70_t4 \$70__t4 \$70 97.1320607937
* device instance _70_t5 r0 *1 0,0
R_70_t5 \$70__t5 \$70 100.985621919
* device instance _70_t6 r0 *1 0,0
R_70_t6 \$70__t6 \$70 61.8779217555
* device instance _70_t7 r0 *1 0,0
R_70_t7 \$70__t7 \$70 65.2488695775
* device instance _70_t8 r0 *1 0,0
R_70_t8 \$70__t8 \$70 68.6886206694
* device instance _70_t9 r0 *1 0,0
R_70_t9 \$70__t9 \$70 72.187340204
* device instance _70 r0 *1 0,0
C_70 \$70 vsubs 8.8233851e-14
* device instance _71_t0 r0 *1 0,0
R_71_t0 \$71__t0 \$71 81.7777390336
* device instance _71_t1 r0 *1 0,0
R_71_t1 \$71__t1 \$71 21.4987692264
* device instance _71_t2 r0 *1 0,0
R_71_t2 \$71__t2 \$71 100.29899174
* device instance _71 r0 *1 0,0
C_71 \$71 vsubs 5.962076e-15
* device instance _73_t0 r0 *1 0,0
R_73_t0 \$73__t0 \$73 108.687402234
* device instance _73_t1 r0 *1 0,0
R_73_t1 \$73__t1 \$73 28.7964709909
* device instance _73_t2 r0 *1 0,0
R_73_t2 \$73__t2 \$73 133.512826775
* device instance _73 r0 *1 0,0
C_73 \$73 vsubs 6.492519e-15
* device instance _75_t0 r0 *1 0,0
R_75_t0 \$75__t0 \$75 135.591504929
* device instance _75_t1 r0 *1 0,0
R_75_t1 \$75__t1 \$75 36.2048686624
* device instance _75_t2 r0 *1 0,0
R_75_t2 \$75__t2 \$75 166.824926409
* device instance _75 r0 *1 0,0
C_75 \$75 vsubs 7.022961e-15
* device instance _77_t0 r0 *1 0,0
R_77_t0 \$77__t0 \$77 162.444438203
* device instance _77_t1 r0 *1 0,0
R_77_t1 \$77__t1 \$77 43.7126105743
* device instance _77_t2 r0 *1 0,0
R_77_t2 \$77__t2 \$77 200.179851222
* device instance _77 r0 *1 0,0
C_77 \$77 vsubs 7.553404e-15
* device instance _78_t0 r0 *1 0,0
R_78_t0 \$78__t0 \$78 623.00385451
* device instance _78_t1 r0 *1 0,0
R_78_t1 \$78__t1 \$78 95.9998829198
* device instance _78_t2 r0 *1 0,0
R_78_t2 \$78__t2 \$78 103.86395309
* device instance _78_t3 r0 *1 0,0
R_78_t3 \$78__t3 \$78 111.771352504
* device instance _78_t4 r0 *1 0,0
R_78_t4 \$78__t4 \$78 119.71349543
* device instance _78_t5 r0 *1 0,0
R_78_t5 \$78__t5 \$78 63.1623495827
* device instance _78_t6 r0 *1 0,0
R_78_t6 \$78__t6 \$78 57.2067469074
* device instance _78_t7 r0 *1 0,0
R_78_t7 \$78__t7 \$78 51.856654702
* device instance _78_t8 r0 *1 0,0
R_78_t8 \$78__t8 \$78 47.3179103542
* device instance _78 r0 *1 0,0
C_78 \$78 vsubs 6.7094976e-14
* device instance _79_t0 r0 *1 0,0
R_79_t0 \$79__t0 \$79 12.3358471278
* device instance _79_t1 r0 *1 0,0
R_79_t1 \$79__t1 \$79 11.9719163261
* device instance _79_t2 r0 *1 0,0
R_79_t2 \$79__t2 \$79 12.0017182001
* device instance _79_t3 r0 *1 0,0
R_79_t3 \$79__t3 \$79 12.7439906512
* device instance _79_t4 r0 *1 0,0
R_79_t4 \$79__t4 \$79 2.71678527375
* device instance _79_t5 r0 *1 0,0
R_79_t5 \$79__t5 \$79 4.44853839778
* device instance _79_t6 r0 *1 0,0
R_79_t6 \$79__t6 \$79 2.99574500126
* device instance _79_t7 r0 *1 0,0
R_79_t7 \$79__t7 \$79 1.92841914921
* device instance _79_t8 r0 *1 0,0
R_79_t8 \$79__t8 \$79 2.00559985637
* device instance _79_t9 r0 *1 0,0
R_79_t9 \$79__t9 \$79 2.77210255808
* device instance _79_t10 r0 *1 0,0
R_79_t10 \$79__t10 \$79 3.4481551553
* device instance _79_t11 r0 *1 0,0
R_79_t11 \$79__t11 \$79 3.86950428053
* device instance _79_t12 r0 *1 0,0
R_79_t12 \$79__t12 \$79 4.73298524931
* device instance _79_t13 r0 *1 0,0
R_79_t13 \$79__t13 \$79 3.79022461596
* device instance _79_t14 r0 *1 0,0
R_79_t14 \$79__t14 \$79 4.84268682502
* device instance _79_t15 r0 *1 0,0
R_79_t15 \$79__t15 \$79 4.61602055029
* device instance _79_t16 r0 *1 0,0
R_79_t16 \$79__t16 \$79 6.18782920648
* device instance _79_t17 r0 *1 0,0
R_79_t17 \$79__t17 \$79 7.79936746941
* device instance _79_t18 r0 *1 0,0
R_79_t18 \$79__t18 \$79 9.43028915907
* device instance _79_t19 r0 *1 0,0
R_79_t19 \$79__t19 \$79 8.93661557642
* device instance _79_t20 r0 *1 0,0
R_79_t20 \$79__t20 \$79 7.42629093362
* device instance _79_t21 r0 *1 0,0
R_79_t21 \$79__t21 \$79 14.0808541213
* device instance _79_t22 r0 *1 0,0
R_79_t22 \$79__t22 \$79 12.4136835236
* device instance _79_t23 r0 *1 0,0
R_79_t23 \$79__t23 \$79 10.7465316511
* device instance _79_t24 r0 *1 0,0
R_79_t24 \$79__t24 \$79 9.07940881881
* device instance _79_t25 r0 *1 0,0
R_79_t25 \$79__t25 \$79 7.41233462116
* device instance _79_t26 r0 *1 0,0
R_79_t26 \$79__t26 \$79 13.6879110586
* device instance _79_t27 r0 *1 0,0
R_79_t27 \$79__t27 \$79 14.3208704227
* device instance _79_t28 r0 *1 0,0
R_79_t28 \$79__t28 \$79 12.6852834222
* device instance _79_t29 r0 *1 0,0
R_79_t29 \$79__t29 \$79 14.1924348811
* device instance _79_t30 r0 *1 0,0
R_79_t30 \$79__t30 \$79 12.5401074035
* device instance _79_t31 r0 *1 0,0
R_79_t31 \$79__t31 \$79 10.8923228742
* device instance _79_t32 r0 *1 0,0
R_79_t32 \$79__t32 \$79 9.25150904267
* device instance _79_t33 r0 *1 0,0
R_79_t33 \$79__t33 \$79 3.55480096788
* device instance _79_t34 r0 *1 0,0
R_79_t34 \$79__t34 \$79 5.7453513939
* device instance _79_t35 r0 *1 0,0
R_79_t35 \$79__t35 \$79 6.00141133373
* device instance _79_t36 r0 *1 0,0
R_79_t36 \$79__t36 \$79 7.65230949655
* device instance _79_t37 r0 *1 0,0
R_79_t37 \$79__t37 \$79 9.30903117041
* device instance _79_t38 r0 *1 0,0
R_79_t38 \$79__t38 \$79 4.26062092343
* device instance _79_t39 r0 *1 0,0
R_79_t39 \$79__t39 \$79 5.92743411782
* device instance _79_t40 r0 *1 0,0
R_79_t40 \$79__t40 \$79 0.726851095343
* device instance _79_t41 r0 *1 0,0
R_79_t41 \$79__t41 \$79 1.9004215103
* device instance _79_t42 r0 *1 0,0
R_79_t42 \$79__t42 \$79 2.41241228755
* device instance _79_t43 r0 *1 0,0
R_79_t43 \$79__t43 \$79 0.751029525081
* device instance _79_t44 r0 *1 0,0
R_79_t44 \$79__t44 \$79 0.931491125222
* device instance _79_t45 r0 *1 0,0
R_79_t45 \$79__t45 \$79 4.18535561028
* device instance _79_t46 r0 *1 0,0
R_79_t46 \$79__t46 \$79 2.58885994611
* device instance _79_t47 r0 *1 0,0
R_79_t47 \$79__t47 \$79 1.2027086609
* device instance _79_t48 r0 *1 0,0
R_79_t48 \$79__t48 \$79 1.32292799948
* device instance _79_t49 r0 *1 0,0
R_79_t49 \$79__t49 \$79 4.07857068212
* device instance _79_t50 r0 *1 0,0
R_79_t50 \$79__t50 \$79 6.1496013188
* device instance _79_t51 r0 *1 0,0
R_79_t51 \$79__t51 \$79 7.58807221772
* device instance _79_t52 r0 *1 0,0
R_79_t52 \$79__t52 \$79 4.99697583837
* device instance _79_t53 r0 *1 0,0
R_79_t53 \$79__t53 \$79 6.47698634376
* device instance _79_t54 r0 *1 0,0
R_79_t54 \$79__t54 \$79 8.03070698828
* device instance _79_t55 r0 *1 0,0
R_79_t55 \$79__t55 \$79 9.62249839867
* device instance _79_t56 r0 *1 0,0
R_79_t56 \$79__t56 \$79 10.6667371479
* device instance _79_t57 r0 *1 0,0
R_79_t57 \$79__t57 \$79 4.85959574918
* device instance _79_t58 r0 *1 0,0
R_79_t58 \$79__t58 \$79 9.10491085343
* device instance _79_t59 r0 *1 0,0
R_79_t59 \$79__t59 \$79 7.59443071306
* device instance _79_t60 r0 *1 0,0
R_79_t60 \$79__t60 \$79 9.2615116777
* device instance _79_t61 r0 *1 0,0
R_79_t61 \$79__t61 \$79 3.50060128909
* device instance _79_t62 r0 *1 0,0
R_79_t62 \$79__t62 \$79 5.14355275272
* device instance _79_t63 r0 *1 0,0
R_79_t63 \$79__t63 \$79 6.79833645248
* device instance _79_t64 r0 *1 0,0
R_79_t64 \$79__t64 \$79 8.4580104155
* device instance _79_t65 r0 *1 0,0
R_79_t65 \$79__t65 \$79 10.1201689671
* device instance _79_t66 r0 *1 0,0
R_79_t66 \$79__t66 \$79 4.36295237524
* device instance _79_t67 r0 *1 0,0
R_79_t67 \$79__t67 \$79 11.6563401716
* device instance _79_t68 r0 *1 0,0
R_79_t68 \$79__t68 \$79 12.1950028719
* device instance _79_t69 r0 *1 0,0
R_79_t69 \$79__t69 \$79 14.1121548873
* device instance _79_t70 r0 *1 0,0
R_79_t70 \$79__t70 \$79 12.4491767358
* device instance _79_t71 r0 *1 0,0
R_79_t71 \$79__t71 \$79 10.7875115436
* device instance _79_t72 r0 *1 0,0
R_79_t72 \$79__t72 \$79 13.2664029672
* device instance _79_t73 r0 *1 0,0
R_79_t73 \$79__t73 \$79 11.6019908877
* device instance _79_t74 r0 *1 0,0
R_79_t74 \$79__t74 \$79 9.93852380873
* device instance _79_t75 r0 *1 0,0
R_79_t75 \$79__t75 \$79 8.27657154264
* device instance _79_t76 r0 *1 0,0
R_79_t76 \$79__t76 \$79 6.61727553987
* device instance _79_t77 r0 *1 0,0
R_79_t77 \$79__t77 \$79 9.12787638362
* device instance _79_t78 r0 *1 0,0
R_79_t78 \$79__t78 \$79 7.47162414148
* device instance _79_t79 r0 *1 0,0
R_79_t79 \$79__t79 \$79 5.82164284501
* device instance _79_t80 r0 *1 0,0
R_79_t80 \$79__t80 \$79 9.44735631673
* device instance _79_t81 r0 *1 0,0
R_79_t81 \$79__t81 \$79 7.85872644976
* device instance _79_t82 r0 *1 0,0
R_79_t82 \$79__t82 \$79 6.31077962818
* device instance _79_t83 r0 *1 0,0
R_79_t83 \$79__t83 \$79 12.0817074133
* device instance _79_t84 r0 *1 0,0
R_79_t84 \$79__t84 \$79 10.4945565393
* device instance _79_t85 r0 *1 0,0
R_79_t85 \$79__t85 \$79 11.8639881145
* device instance _79_t86 r0 *1 0,0
R_79_t86 \$79__t86 \$79 11.0591509351
* device instance _79_t87 r0 *1 0,0
R_79_t87 \$79__t87 \$79 6.01363598057
* device instance _79_t88 r0 *1 0,0
R_79_t88 \$79__t88 \$79 7.62216895664
* device instance _79_t89 r0 *1 0,0
R_79_t89 \$79__t89 \$79 10.1960030173
* device instance _79_t90 r0 *1 0,0
R_79_t90 \$79__t90 \$79 11.8232996491
* device instance _79_t91 r0 *1 0,0
R_79_t91 \$79__t91 \$79 13.4603740557
* device instance _79_t92 r0 *1 0,0
R_79_t92 \$79__t92 \$79 7.32457595316
* device instance _79_t93 r0 *1 0,0
R_79_t93 \$79__t93 \$79 4.15966399942
* device instance _79_t94 r0 *1 0,0
R_79_t94 \$79__t94 \$79 10.4228274868
* device instance _79_t95 r0 *1 0,0
R_79_t95 \$79__t95 \$79 12.0194538097
* device instance _79_t96 r0 *1 0,0
R_79_t96 \$79__t96 \$79 13.6329939856
* device instance _79_t97 r0 *1 0,0
R_79_t97 \$79__t97 \$79 6.99803955423
* device instance _79_t98 r0 *1 0,0
R_79_t98 \$79__t98 \$79 7.0316563846
* device instance _79_t99 r0 *1 0,0
R_79_t99 \$79__t99 \$79 8.44854031225
* device instance _79_t100 r0 *1 0,0
R_79_t100 \$79__t100 \$79 9.94337937377
* device instance _79_t101 r0 *1 0,0
R_79_t101 \$79__t101 \$79 11.4857769176
* device instance _79_t102 r0 *1 0,0
R_79_t102 \$79__t102 \$79 8.85227167587
* device instance _79_t103 r0 *1 0,0
R_79_t103 \$79__t103 \$79 11.3160360808
* device instance _79_t104 r0 *1 0,0
R_79_t104 \$79__t104 \$79 8.33205786292
* device instance _79_t105 r0 *1 0,0
R_79_t105 \$79__t105 \$79 14.5208037045
* device instance _79_t106 r0 *1 0,0
R_79_t106 \$79__t106 \$79 10.0335164202
* device instance _79_t107 r0 *1 0,0
R_79_t107 \$79__t107 \$79 11.6834664726
* device instance _79_t108 r0 *1 0,0
R_79_t108 \$79__t108 \$79 13.3377150947
* device instance _79_t109 r0 *1 0,0
R_79_t109 \$79__t109 \$79 13.0177757353
* device instance _79_t110 r0 *1 0,0
R_79_t110 \$79__t110 \$79 5.87328102767
* device instance _79_t111 r0 *1 0,0
R_79_t111 \$79__t111 \$79 11.5598679937
* device instance _79_t112 r0 *1 0,0
R_79_t112 \$79__t112 \$79 10.16651017
* device instance _79_t113 r0 *1 0,0
R_79_t113 \$79__t113 \$79 8.86818065367
* device instance _79_t114 r0 *1 0,0
R_79_t114 \$79__t114 \$79 14.1997288829
* device instance _79_t115 r0 *1 0,0
R_79_t115 \$79__t115 \$79 12.6586352037
* device instance _79_t116 r0 *1 0,0
R_79_t116 \$79__t116 \$79 11.1538830977
* device instance _79_t117 r0 *1 0,0
R_79_t117 \$79__t117 \$79 9.70239605257
* device instance _79_t118 r0 *1 0,0
R_79_t118 \$79__t118 \$79 5.46063867502
* device instance _79_t119 r0 *1 0,0
R_79_t119 \$79__t119 \$79 9.89529509059
* device instance _79_t120 r0 *1 0,0
R_79_t120 \$79__t120 \$79 11.198652816
* device instance _79_t121 r0 *1 0,0
R_79_t121 \$79__t121 \$79 12.5881731368
* device instance _79_t122 r0 *1 0,0
R_79_t122 \$79__t122 \$79 14.0382940209
* device instance _79_t123 r0 *1 0,0
R_79_t123 \$79__t123 \$79 15.5320511582
* device instance _79_t124 r0 *1 0,0
R_79_t124 \$79__t124 \$79 4.12300548377
* device instance _79_t125 r0 *1 0,0
R_79_t125 \$79__t125 \$79 4.71750590002
* device instance _79_t126 r0 *1 0,0
R_79_t126 \$79__t126 \$79 5.7506406322
* device instance _79_t127 r0 *1 0,0
R_79_t127 \$79__t127 \$79 5.53373900246
* device instance _79_t128 r0 *1 0,0
R_79_t128 \$79__t128 \$79 6.2824048889
* device instance _79_t129 r0 *1 0,0
R_79_t129 \$79__t129 \$79 7.05016202263
* device instance _79_t130 r0 *1 0,0
R_79_t130 \$79__t130 \$79 10.1099321179
* device instance _79_t131 r0 *1 0,0
R_79_t131 \$79__t131 \$79 8.60874594393
* device instance _79_t132 r0 *1 0,0
R_79_t132 \$79__t132 \$79 7.18119795666
* device instance _79_t133 r0 *1 0,0
R_79_t133 \$79__t133 \$79 5.88115800883
* device instance _79_t134 r0 *1 0,0
R_79_t134 \$79__t134 \$79 4.81308144781
* device instance _79_t135 r0 *1 0,0
R_79_t135 \$79__t135 \$79 13.0588922768
* device instance _79_t136 r0 *1 0,0
R_79_t136 \$79__t136 \$79 7.09007795215
* device instance _79_t137 r0 *1 0,0
R_79_t137 \$79__t137 \$79 7.71301790757
* device instance _79_t138 r0 *1 0,0
R_79_t138 \$79__t138 \$79 14.6528352771
* device instance _79_t139 r0 *1 0,0
R_79_t139 \$79__t139 \$79 7.54325565225
* device instance _79_t140 r0 *1 0,0
R_79_t140 \$79__t140 \$79 8.87887085906
* device instance _79_t141 r0 *1 0,0
R_79_t141 \$79__t141 \$79 10.3115133562
* device instance _79_t142 r0 *1 0,0
R_79_t142 \$79__t142 \$79 11.8059131677
* device instance _79_t143 r0 *1 0,0
R_79_t143 \$79__t143 \$79 13.3413335848
* device instance _79_t144 r0 *1 0,0
R_79_t144 \$79__t144 \$79 14.9051030182
* device instance _79_t145 r0 *1 0,0
R_79_t145 \$79__t145 \$79 8.58404674571
* device instance _79_t146 r0 *1 0,0
R_79_t146 \$79__t146 \$79 8.10845544329
* device instance _79_t147 r0 *1 0,0
R_79_t147 \$79__t147 \$79 9.36379685665
* device instance _79_t148 r0 *1 0,0
R_79_t148 \$79__t148 \$79 10.7318987852
* device instance _79_t149 r0 *1 0,0
R_79_t149 \$79__t149 \$79 12.1748071675
* device instance _79_t150 r0 *1 0,0
R_79_t150 \$79__t150 \$79 13.66885239
* device instance _79_t151 r0 *1 0,0
R_79_t151 \$79__t151 \$79 15.1989618008
* device instance _79_t152 r0 *1 0,0
R_79_t152 \$79__t152 \$79 8.71683560893
* device instance _79_t153 r0 *1 0,0
R_79_t153 \$79__t153 \$79 12.5163996431
* device instance _79_t154 r0 *1 0,0
R_79_t154 \$79__t154 \$79 10.9645365714
* device instance _79_t155 r0 *1 0,0
R_79_t155 \$79__t155 \$79 9.45204647104
* device instance _79_t156 r0 *1 0,0
R_79_t156 \$79__t156 \$79 8.00128869765
* device instance _79_t157 r0 *1 0,0
R_79_t157 \$79__t157 \$79 6.65277214566
* device instance _79_t158 r0 *1 0,0
R_79_t158 \$79__t158 \$79 5.48246766404
* device instance _79_t159 r0 *1 0,0
R_79_t159 \$79__t159 \$79 4.62761755322
* device instance _79_t160 r0 *1 0,0
R_79_t160 \$79__t160 \$79 4.28153650187
* device instance _79_t161 r0 *1 0,0
R_79_t161 \$79__t161 \$79 4.56153301876
* device instance _79_t162 r0 *1 0,0
R_79_t162 \$79__t162 \$79 5.3705614429
* device instance _79_t163 r0 *1 0,0
R_79_t163 \$79__t163 \$79 6.51441440262
* device instance _79_t164 r0 *1 0,0
R_79_t164 \$79__t164 \$79 7.8480301906
* device instance _79_t165 r0 *1 0,0
R_79_t165 \$79__t165 \$79 9.29004191608
* device instance _79_t166 r0 *1 0,0
R_79_t166 \$79__t166 \$79 10.7971059918
* device instance _79_t167 r0 *1 0,0
R_79_t167 \$79__t167 \$79 12.3454216154
* device instance _79_t168 r0 *1 0,0
R_79_t168 \$79__t168 \$79 13.9212316262
* device instance _79_t169 r0 *1 0,0
R_79_t169 \$79__t169 \$79 6.86370904983
* device instance _79_t170 r0 *1 0,0
R_79_t170 \$79__t170 \$79 7.83022524935
* device instance _79_t171 r0 *1 0,0
R_79_t171 \$79__t171 \$79 9.00409190628
* device instance _79_t172 r0 *1 0,0
R_79_t172 \$79__t172 \$79 10.3147580061
* device instance _79_t173 r0 *1 0,0
R_79_t173 \$79__t173 \$79 11.7164035633
* device instance _79_t174 r0 *1 0,0
R_79_t174 \$79__t174 \$79 6.77465721977
* device instance _79_t175 r0 *1 0,0
R_79_t175 \$79__t175 \$79 6.15309952095
* device instance _79_t176 r0 *1 0,0
R_79_t176 \$79__t176 \$79 5.94849603264
* device instance _79_t177 r0 *1 0,0
R_79_t177 \$79__t177 \$79 6.0559508395
* device instance _79_t178 r0 *1 0,0
R_79_t178 \$79__t178 \$79 5.35155994451
* device instance _79_t179 r0 *1 0,0
R_79_t179 \$79__t179 \$79 5.11499415203
* device instance _79_t180 r0 *1 0,0
R_79_t180 \$79__t180 \$79 5.40799912882
* device instance _79_t181 r0 *1 0,0
R_79_t181 \$79__t181 \$79 6.15540916964
* device instance _79_t182 r0 *1 0,0
R_79_t182 \$79__t182 \$79 7.21740864719
* device instance _79_t183 r0 *1 0,0
R_79_t183 \$79__t183 \$79 8.4765695409
* device instance _79_t184 r0 *1 0,0
R_79_t184 \$79__t184 \$79 9.85762612647
* device instance _79_t185 r0 *1 0,0
R_79_t185 \$79__t185 \$79 5.99965117047
* device instance _79_t186 r0 *1 0,0
R_79_t186 \$79__t186 \$79 4.96330058601
* device instance _79_t187 r0 *1 0,0
R_79_t187 \$79__t187 \$79 10.2134722881
* device instance _79_t188 r0 *1 0,0
R_79_t188 \$79__t188 \$79 8.5694303455
* device instance _79_t189 r0 *1 0,0
R_79_t189 \$79__t189 \$79 6.93646702428
* device instance _79_t190 r0 *1 0,0
R_79_t190 \$79__t190 \$79 5.32478461327
* device instance _79_t191 r0 *1 0,0
R_79_t191 \$79__t191 \$79 3.76183540881
* device instance _79_t192 r0 *1 0,0
R_79_t192 \$79__t192 \$79 2.34708290747
* device instance _79_t193 r0 *1 0,0
R_79_t193 \$79__t193 \$79 1.55740449869
* device instance _79_t194 r0 *1 0,0
R_79_t194 \$79__t194 \$79 2.21394160648
* device instance _79_t195 r0 *1 0,0
R_79_t195 \$79__t195 \$79 3.59678803485
* device instance _79_t196 r0 *1 0,0
R_79_t196 \$79__t196 \$79 5.15087846535
* device instance _79_t197 r0 *1 0,0
R_79_t197 \$79__t197 \$79 6.75910732481
* device instance _79_t198 r0 *1 0,0
R_79_t198 \$79__t198 \$79 8.39040122748
* device instance _79_t199 r0 *1 0,0
R_79_t199 \$79__t199 \$79 6.20224914465
* device instance _79_t200 r0 *1 0,0
R_79_t200 \$79__t200 \$79 3.3226025808
* device instance _79_t201 r0 *1 0,0
R_79_t201 \$79__t201 \$79 4.70268930594
* device instance _79_t202 r0 *1 0,0
R_79_t202 \$79__t202 \$79 12.2563648438
* device instance _79_t203 r0 *1 0,0
R_79_t203 \$79__t203 \$79 11.2361921575
* device instance _79_t204 r0 *1 0,0
R_79_t204 \$79__t204 \$79 11.0720319901
* device instance _79_t205 r0 *1 0,0
R_79_t205 \$79__t205 \$79 4.17593479562
* device instance _79_t206 r0 *1 0,0
R_79_t206 \$79__t206 \$79 5.62497617347
* device instance _79_t207 r0 *1 0,0
R_79_t207 \$79__t207 \$79 10.5961737078
* device instance _79_t208 r0 *1 0,0
R_79_t208 \$79__t208 \$79 9.02214040634
* device instance _79_t209 r0 *1 0,0
R_79_t209 \$79__t209 \$79 3.6705148467
* device instance _79_t210 r0 *1 0,0
R_79_t210 \$79__t210 \$79 3.22325764372
* device instance _79_t211 r0 *1 0,0
R_79_t211 \$79__t211 \$79 3.58683962593
* device instance _79_t212 r0 *1 0,0
R_79_t212 \$79__t212 \$79 1.73330354502
* device instance _79_t213 r0 *1 0,0
R_79_t213 \$79__t213 \$79 2.86156656593
* device instance _79_t214 r0 *1 0,0
R_79_t214 \$79__t214 \$79 4.02789150077
* device instance _79_t215 r0 *1 0,0
R_79_t215 \$79__t215 \$79 4.57173547276
* device instance _79_t216 r0 *1 0,0
R_79_t216 \$79__t216 \$79 2.96577543804
* device instance _79_t217 r0 *1 0,0
R_79_t217 \$79__t217 \$79 3.68069300916
* device instance _79_t218 r0 *1 0,0
R_79_t218 \$79__t218 \$79 3.14410229145
* device instance _79_t219 r0 *1 0,0
R_79_t219 \$79__t219 \$79 2.75918229318
* device instance _79_t220 r0 *1 0,0
R_79_t220 \$79__t220 \$79 2.5943446478
* device instance _79_t221 r0 *1 0,0
R_79_t221 \$79__t221 \$79 2.39009090766
* device instance _79_t222 r0 *1 0,0
R_79_t222 \$79__t222 \$79 11.7837607631
* device instance _79_t223 r0 *1 0,0
R_79_t223 \$79__t223 \$79 10.9286384021
* device instance _79_t224 r0 *1 0,0
R_79_t224 \$79__t224 \$79 10.9689379659
* device instance _79_t225 r0 *1 0,0
R_79_t225 \$79__t225 \$79 9.50859426477
* device instance _79_t226 r0 *1 0,0
R_79_t226 \$79__t226 \$79 8.23847451035
* device instance _79_t227 r0 *1 0,0
R_79_t227 \$79__t227 \$79 7.13378424748
* device instance _79_t228 r0 *1 0,0
R_79_t228 \$79__t228 \$79 10.4722128393
* device instance _79_t229 r0 *1 0,0
R_79_t229 \$79__t229 \$79 9.03144623254
* device instance _79_t230 r0 *1 0,0
R_79_t230 \$79__t230 \$79 7.68284572388
* device instance _79_t231 r0 *1 0,0
R_79_t231 \$79__t231 \$79 6.48417564914
* device instance _79_t232 r0 *1 0,0
R_79_t232 \$79__t232 \$79 11.346795096
* device instance _79_t233 r0 *1 0,0
R_79_t233 \$79__t233 \$79 10.3731404095
* device instance _79_t234 r0 *1 0,0
R_79_t234 \$79__t234 \$79 8.75911880389
* device instance _79_t235 r0 *1 0,0
R_79_t235 \$79__t235 \$79 7.16949095496
* device instance _79_t236 r0 *1 0,0
R_79_t236 \$79__t236 \$79 7.02657283784
* device instance _79_t237 r0 *1 0,0
R_79_t237 \$79__t237 \$79 6.62131679579
* device instance _79_t238 r0 *1 0,0
R_79_t238 \$79__t238 \$79 6.59834871323
* device instance _79_t239 r0 *1 0,0
R_79_t239 \$79__t239 \$79 6.98526258912
* device instance _79_t240 r0 *1 0,0
R_79_t240 \$79__t240 \$79 7.72067997024
* device instance _79_t241 r0 *1 0,0
R_79_t241 \$79__t241 \$79 4.94526930948
* device instance _79_t242 r0 *1 0,0
R_79_t242 \$79__t242 \$79 5.4508142732
* device instance _79_t243 r0 *1 0,0
R_79_t243 \$79__t243 \$79 10.8863945176
* device instance _79_t244 r0 *1 0,0
R_79_t244 \$79__t244 \$79 6.36603345929
* device instance _79_t245 r0 *1 0,0
R_79_t245 \$79__t245 \$79 4.9758736833
* device instance _79_t246 r0 *1 0,0
R_79_t246 \$79__t246 \$79 5.79703913674
* device instance _79_t247 r0 *1 0,0
R_79_t247 \$79__t247 \$79 5.77079131351
* device instance _79_t248 r0 *1 0,0
R_79_t248 \$79__t248 \$79 10.0324243456
* device instance _79_t249 r0 *1 0,0
R_79_t249 \$79__t249 \$79 8.83790900694
* device instance _79_t250 r0 *1 0,0
R_79_t250 \$79__t250 \$79 7.81837905496
* device instance _79_t251 r0 *1 0,0
R_79_t251 \$79__t251 \$79 12.825438409
* device instance _79_t252 r0 *1 0,0
R_79_t252 \$79__t252 \$79 13.1800345318
* device instance _79_t253 r0 *1 0,0
R_79_t253 \$79__t253 \$79 7.48855499039
* device instance _79_t254 r0 *1 0,0
R_79_t254 \$79__t254 \$79 6.02637637747
* device instance _79_t255 r0 *1 0,0
R_79_t255 \$79__t255 \$79 6.20948629772
* device instance _79_t256 r0 *1 0,0
R_79_t256 \$79__t256 \$79 37.292404809
* device instance _79_t257 r0 *1 0,0
R_79_t257 \$79__t257 \$79 36.9295444756
* device instance _79_t258 r0 *1 0,0
R_79_t258 \$79__t258 \$79 36.566931706
* device instance _79_t259 r0 *1 0,0
R_79_t259 \$79__t259 \$79 36.2045739387
* device instance _79_t260 r0 *1 0,0
R_79_t260 \$79__t260 \$79 39.7834005291
* device instance _79_t261 r0 *1 0,0
R_79_t261 \$79__t261 \$79 40.5096975078
* device instance _79_t262 r0 *1 0,0
R_79_t262 \$79__t262 \$79 39.4205885435
* device instance _79_t263 r0 *1 0,0
R_79_t263 \$79__t263 \$79 40.1464388791
* device instance _79 r0 *1 0,0
C_79 \$79 vsubs 5.73982947e-13
* device instance _81_t0 r0 *1 0,0
R_81_t0 \$81__t0 \$81 17.1609607957
* device instance _81_t1 r0 *1 0,0
R_81_t1 \$81__t1 \$81 14.8504690887
* device instance _81_t2 r0 *1 0,0
R_81_t2 \$81__t2 \$81 5.96038696917
* device instance _81_t3 r0 *1 0,0
R_81_t3 \$81__t3 \$81 3.85461658926
* device instance _81_t4 r0 *1 0,0
R_81_t4 \$81__t4 \$81 2.28028786581
* device instance _81_t5 r0 *1 0,0
R_81_t5 \$81__t5 \$81 2.55952025284
* device instance _81_t6 r0 *1 0,0
R_81_t6 \$81__t6 \$81 3.39213210481
* device instance _81_t7 r0 *1 0,0
R_81_t7 \$81__t7 \$81 3.58580414834
* device instance _81_t8 r0 *1 0,0
R_81_t8 \$81__t8 \$81 4.45705583351
* device instance _81_t9 r0 *1 0,0
R_81_t9 \$81__t9 \$81 6.25955743654
* device instance _81_t10 r0 *1 0,0
R_81_t10 \$81__t10 \$81 4.90089882223
* device instance _81_t11 r0 *1 0,0
R_81_t11 \$81__t11 \$81 4.34883462221
* device instance _81_t12 r0 *1 0,0
R_81_t12 \$81__t12 \$81 6.50256631576
* device instance _81_t13 r0 *1 0,0
R_81_t13 \$81__t13 \$81 8.75580734618
* device instance _81_t14 r0 *1 0,0
R_81_t14 \$81__t14 \$81 10.6465661685
* device instance _81_t15 r0 *1 0,0
R_81_t15 \$81__t15 \$81 11.0478388542
* device instance _81_t16 r0 *1 0,0
R_81_t16 \$81__t16 \$81 13.3587092149
* device instance _81_t17 r0 *1 0,0
R_81_t17 \$81__t17 \$81 8.08424992253
* device instance _81_t18 r0 *1 0,0
R_81_t18 \$81__t18 \$81 12.2772364254
* device instance _81_t19 r0 *1 0,0
R_81_t19 \$81__t19 \$81 10.1261010163
* device instance _81_t20 r0 *1 0,0
R_81_t20 \$81__t20 \$81 21.2978604276
* device instance _81_t21 r0 *1 0,0
R_81_t21 \$81__t21 \$81 4.60053437284
* device instance _81_t22 r0 *1 0,0
R_81_t22 \$81__t22 \$81 19.0096579782
* device instance _81_t23 r0 *1 0,0
R_81_t23 \$81__t23 \$81 19.9260497804
* device instance _81_t24 r0 *1 0,0
R_81_t24 \$81__t24 \$81 19.7671599474
* device instance _81_t25 r0 *1 0,0
R_81_t25 \$81__t25 \$81 17.4359898995
* device instance _81_t26 r0 *1 0,0
R_81_t26 \$81__t26 \$81 15.1094891588
* device instance _81_t27 r0 *1 0,0
R_81_t27 \$81__t27 \$81 12.7902059786
* device instance _81_t28 r0 *1 0,0
R_81_t28 \$81__t28 \$81 6.4678481961
* device instance _81_t29 r0 *1 0,0
R_81_t29 \$81__t29 \$81 12.815804539
* device instance _81_t30 r0 *1 0,0
R_81_t30 \$81__t30 \$81 5.02187316017
* device instance _81_t31 r0 *1 0,0
R_81_t31 \$81__t31 \$81 6.97066827187
* device instance _81_t32 r0 *1 0,0
R_81_t32 \$81__t32 \$81 9.10884239346
* device instance _81_t33 r0 *1 0,0
R_81_t33 \$81__t33 \$81 11.3296774365
* device instance _81_t34 r0 *1 0,0
R_81_t34 \$81__t34 \$81 13.5927171438
* device instance _81_t35 r0 *1 0,0
R_81_t35 \$81__t35 \$81 8.57109583731
* device instance _81_t36 r0 *1 0,0
R_81_t36 \$81__t36 \$81 6.67740847906
* device instance _81_t37 r0 *1 0,0
R_81_t37 \$81__t37 \$81 14.4890625705
* device instance _81_t38 r0 *1 0,0
R_81_t38 \$81__t38 \$81 15.1902687895
* device instance _81_t39 r0 *1 0,0
R_81_t39 \$81__t39 \$81 16.696881384
* device instance _81_t40 r0 *1 0,0
R_81_t40 \$81__t40 \$81 15.316772183
* device instance _81_t41 r0 *1 0,0
R_81_t41 \$81__t41 \$81 13.034424285
* device instance _81_t42 r0 *1 0,0
R_81_t42 \$81__t42 \$81 10.7795505588
* device instance _81_t43 r0 *1 0,0
R_81_t43 \$81__t43 \$81 16.7375363054
* device instance _81_t44 r0 *1 0,0
R_81_t44 \$81__t44 \$81 17.6159186886
* device instance _81_t45 r0 *1 0,0
R_81_t45 \$81__t45 \$81 10.4829319747
* device instance _81_t46 r0 *1 0,0
R_81_t46 \$81__t46 \$81 10.0062342627
* device instance _81_t47 r0 *1 0,0
R_81_t47 \$81__t47 \$81 10.7627808488
* device instance _81_t48 r0 *1 0,0
R_81_t48 \$81__t48 \$81 16.5689904783
* device instance _81_t49 r0 *1 0,0
R_81_t49 \$81__t49 \$81 18.8614267844
* device instance _81_t50 r0 *1 0,0
R_81_t50 \$81__t50 \$81 21.1656604596
* device instance _81_t51 r0 *1 0,0
R_81_t51 \$81__t51 \$81 9.84501120812
* device instance _81_t52 r0 *1 0,0
R_81_t52 \$81__t52 \$81 10.3504627641
* device instance _81_t53 r0 *1 0,0
R_81_t53 \$81__t53 \$81 12.4629327161
* device instance _81_t54 r0 *1 0,0
R_81_t54 \$81__t54 \$81 14.6467433859
* device instance _81_t55 r0 *1 0,0
R_81_t55 \$81__t55 \$81 16.8742193661
* device instance _81_t56 r0 *1 0,0
R_81_t56 \$81__t56 \$81 19.1301138022
* device instance _81_t57 r0 *1 0,0
R_81_t57 \$81__t57 \$81 21.4054436168
* device instance _81_t58 r0 *1 0,0
R_81_t58 \$81__t58 \$81 11.950416011
* device instance _81_t59 r0 *1 0,0
R_81_t59 \$81__t59 \$81 14.0182006345
* device instance _81_t60 r0 *1 0,0
R_81_t60 \$81__t60 \$81 16.1622165154
* device instance _81_t61 r0 *1 0,0
R_81_t61 \$81__t61 \$81 6.17416332815
* device instance _81_t62 r0 *1 0,0
R_81_t62 \$81__t62 \$81 6.91221014596
* device instance _81_t63 r0 *1 0,0
R_81_t63 \$81__t63 \$81 8.27325769416
* device instance _81_t64 r0 *1 0,0
R_81_t64 \$81__t64 \$81 18.355770859
* device instance _81_t65 r0 *1 0,0
R_81_t65 \$81__t65 \$81 5.59605479365
* device instance _81_t66 r0 *1 0,0
R_81_t66 \$81__t66 \$81 14.5387651449
* device instance _81_t67 r0 *1 0,0
R_81_t67 \$81__t67 \$81 12.4489085225
* device instance _81_t68 r0 *1 0,0
R_81_t68 \$81__t68 \$81 10.4682731305
* device instance _81_t69 r0 *1 0,0
R_81_t69 \$81__t69 \$81 8.67202102988
* device instance _81_t70 r0 *1 0,0
R_81_t70 \$81__t70 \$81 7.1995098877
* device instance _81_t71 r0 *1 0,0
R_81_t71 \$81__t71 \$81 6.28265262261
* device instance _81_t72 r0 *1 0,0
R_81_t72 \$81__t72 \$81 4.59434386063
* device instance _81_t73 r0 *1 0,0
R_81_t73 \$81__t73 \$81 20.5830316629
* device instance _81_t74 r0 *1 0,0
R_81_t74 \$81__t74 \$81 12.0464458718
* device instance _81_t75 r0 *1 0,0
R_81_t75 \$81__t75 \$81 12.5906779133
* device instance _81_t76 r0 *1 0,0
R_81_t76 \$81__t76 \$81 14.5678645143
* device instance _81_t77 r0 *1 0,0
R_81_t77 \$81__t77 \$81 16.6412130018
* device instance _81_t78 r0 *1 0,0
R_81_t78 \$81__t78 \$81 18.7788990974
* device instance _81_t79 r0 *1 0,0
R_81_t79 \$81__t79 \$81 14.2940287557
* device instance _81_t80 r0 *1 0,0
R_81_t80 \$81__t80 \$81 20.9612480525
* device instance _81_t81 r0 *1 0,0
R_81_t81 \$81__t81 \$81 15.4260121049
* device instance _81_t82 r0 *1 0,0
R_81_t82 \$81__t82 \$81 13.2686316998
* device instance _81_t83 r0 *1 0,0
R_81_t83 \$81__t83 \$81 11.1875427321
* device instance _81_t84 r0 *1 0,0
R_81_t84 \$81__t84 \$81 9.23446939755
* device instance _81_t85 r0 *1 0,0
R_81_t85 \$81__t85 \$81 7.50996173081
* device instance _81_t86 r0 *1 0,0
R_81_t86 \$81__t86 \$81 6.20752872045
* device instance _81_t87 r0 *1 0,0
R_81_t87 \$81__t87 \$81 5.62824021387
* device instance _81_t88 r0 *1 0,0
R_81_t88 \$81__t88 \$81 7.14099436377
* device instance _81_t89 r0 *1 0,0
R_81_t89 \$81__t89 \$81 8.78446572149
* device instance _81_t90 r0 *1 0,0
R_81_t90 \$81__t90 \$81 10.6934401852
* device instance _81_t91 r0 *1 0,0
R_81_t91 \$81__t91 \$81 12.7492068556
* device instance _81_t92 r0 *1 0,0
R_81_t92 \$81__t92 \$81 14.8910938274
* device instance _81_t93 r0 *1 0,0
R_81_t93 \$81__t93 \$81 17.0867452365
* device instance _81_t94 r0 *1 0,0
R_81_t94 \$81__t94 \$81 19.3178372922
* device instance _81_t95 r0 *1 0,0
R_81_t95 \$81__t95 \$81 5.98586255002
* device instance _81_t96 r0 *1 0,0
R_81_t96 \$81__t96 \$81 21.5733771115
* device instance _81_t97 r0 *1 0,0
R_81_t97 \$81__t97 \$81 8.57385511499
* device instance _81_t98 r0 *1 0,0
R_81_t98 \$81__t98 \$81 8.1978133711
* device instance _81_t99 r0 *1 0,0
R_81_t99 \$81__t99 \$81 15.038288076
* device instance _81_t100 r0 *1 0,0
R_81_t100 \$81__t100 \$81 15.6800914506
* device instance _81_t101 r0 *1 0,0
R_81_t101 \$81__t101 \$81 6.24292462655
* device instance _81_t102 r0 *1 0,0
R_81_t102 \$81__t102 \$81 12.9938063562
* device instance _81_t103 r0 *1 0,0
R_81_t103 \$81__t103 \$81 10.8601808835
* device instance _81_t104 r0 *1 0,0
R_81_t104 \$81__t104 \$81 4.94565509749
* device instance _81_t105 r0 *1 0,0
R_81_t105 \$81__t105 \$81 5.34910898245
* device instance _81_t106 r0 *1 0,0
R_81_t106 \$81__t106 \$81 6.61635979537
* device instance _81_t107 r0 *1 0,0
R_81_t107 \$81__t107 \$81 4.29012041349
* device instance _81_t108 r0 *1 0,0
R_81_t108 \$81__t108 \$81 5.79382284834
* device instance _81_t109 r0 *1 0,0
R_81_t109 \$81__t109 \$81 7.72925744858
* device instance _81_t110 r0 *1 0,0
R_81_t110 \$81__t110 \$81 8.36356708889
* device instance _81_t111 r0 *1 0,0
R_81_t111 \$81__t111 \$81 3.77513848746
* device instance _81_t112 r0 *1 0,0
R_81_t112 \$81__t112 \$81 5.16930088244
* device instance _81_t113 r0 *1 0,0
R_81_t113 \$81__t113 \$81 15.8799280654
* device instance _81_t114 r0 *1 0,0
R_81_t114 \$81__t114 \$81 13.0647637132
* device instance _81_t115 r0 *1 0,0
R_81_t115 \$81__t115 \$81 11.1936352368
* device instance _81_t116 r0 *1 0,0
R_81_t116 \$81__t116 \$81 9.53502366137
* device instance _81_t117 r0 *1 0,0
R_81_t117 \$81__t117 \$81 8.21861728659
* device instance _81_t118 r0 *1 0,0
R_81_t118 \$81__t118 \$81 12.5948866561
* device instance _81_t119 r0 *1 0,0
R_81_t119 \$81__t119 \$81 10.3795806793
* device instance _81_t120 r0 *1 0,0
R_81_t120 \$81__t120 \$81 8.23711161444
* device instance _81_t121 r0 *1 0,0
R_81_t121 \$81__t121 \$81 15.0694531891
* device instance _81_t122 r0 *1 0,0
R_81_t122 \$81__t122 \$81 7.337098901
* device instance _81_t123 r0 *1 0,0
R_81_t123 \$81__t123 \$81 7.96814762553
* device instance _81_t124 r0 *1 0,0
R_81_t124 \$81__t124 \$81 7.42862379292
* device instance _81_t125 r0 *1 0,0
R_81_t125 \$81__t125 \$81 9.17384981097
* device instance _81_t126 r0 *1 0,0
R_81_t126 \$81__t126 \$81 8.83503488916
* device instance _81_t127 r0 *1 0,0
R_81_t127 \$81__t127 \$81 7.01298378985
* device instance _81_t128 r0 *1 0,0
R_81_t128 \$81__t128 \$81 42.8586309091
* device instance _81_t129 r0 *1 0,0
R_81_t129 \$81__t129 \$81 42.3552788565
* device instance _81_t130 r0 *1 0,0
R_81_t130 \$81__t130 \$81 41.8525318363
* device instance _81_t131 r0 *1 0,0
R_81_t131 \$81__t131 \$81 41.3504119169
* device instance _81_t132 r0 *1 0,0
R_81_t132 \$81__t132 \$81 45.857865185
* device instance _81_t133 r0 *1 0,0
R_81_t133 \$81__t133 \$81 46.3617189688
* device instance _81_t134 r0 *1 0,0
R_81_t134 \$81__t134 \$81 46.8661022771
* device instance _81_t135 r0 *1 0,0
R_81_t135 \$81__t135 \$81 47.3709981955
* device instance _81 r0 *1 0,0
C_81 \$81 vsubs 3.13607775e-13
* device instance _82_t0 r0 *1 0,0
R_82_t0 \$82__t0 \$82 0.310015967392
* device instance _82_t1 r0 *1 0,0
R_82_t1 \$82__t1 \$82 24.6276605345
* device instance _82_t2 r0 *1 0,0
R_82_t2 \$82__t2 \$82 10.4045026778
* device instance _82_t3 r0 *1 0,0
R_82_t3 \$82__t3 \$82 13.8235382067
* device instance _82_t4 r0 *1 0,0
R_82_t4 \$82__t4 \$82 17.242933231
* device instance _82_t5 r0 *1 0,0
R_82_t5 \$82__t5 \$82 10.1225782947
* device instance _82_t6 r0 *1 0,0
R_82_t6 \$82__t6 \$82 6.70455757253
* device instance _82_t7 r0 *1 0,0
R_82_t7 \$82__t7 \$82 3.29053163373
* device instance _82_t8 r0 *1 0,0
R_82_t8 \$82__t8 \$82 6.98635446205
* device instance _82_t9 r0 *1 0,0
R_82_t9 \$82__t9 \$82 3.57164200973
* device instance _82_t10 r0 *1 0,0
R_82_t10 \$82__t10 \$82 30.639707843
* device instance _82_t11 r0 *1 0,0
R_82_t11 \$82__t11 \$82 27.2199222253
* device instance _82_t12 r0 *1 0,0
R_82_t12 \$82__t12 \$82 23.8001815218
* device instance _82_t13 r0 *1 0,0
R_82_t13 \$82__t13 \$82 20.3805083417
* device instance _82_t14 r0 *1 0,0
R_82_t14 \$82__t14 \$82 16.9609435275
* device instance _82_t15 r0 *1 0,0
R_82_t15 \$82__t15 \$82 19.5624231019
* device instance _82_t16 r0 *1 0,0
R_82_t16 \$82__t16 \$82 19.0514164711
* device instance _82_t17 r0 *1 0,0
R_82_t17 \$82__t17 \$82 17.6187658219
* device instance _82_t18 r0 *1 0,0
R_82_t18 \$82__t18 \$82 25.9662431408
* device instance _82_t19 r0 *1 0,0
R_82_t19 \$82__t19 \$82 29.3328708272
* device instance _82_t20 r0 *1 0,0
R_82_t20 \$82__t20 \$82 32.7105616638
* device instance _82_t21 r0 *1 0,0
R_82_t21 \$82__t21 \$82 33.5308592686
* device instance _82_t22 r0 *1 0,0
R_82_t22 \$82__t22 \$82 30.2449167612
* device instance _82_t23 r0 *1 0,0
R_82_t23 \$82__t23 \$82 26.992285227
* device instance _82_t24 r0 *1 0,0
R_82_t24 \$82__t24 \$82 23.7866336192
* device instance _82_t25 r0 *1 0,0
R_82_t25 \$82__t25 \$82 20.6498528172
* device instance _82_t26 r0 *1 0,0
R_82_t26 \$82__t26 \$82 21.6161046259
* device instance _82_t27 r0 *1 0,0
R_82_t27 \$82__t27 \$82 24.391545546
* device instance _82_t28 r0 *1 0,0
R_82_t28 \$82__t28 \$82 27.3135683191
* device instance _82_t29 r0 *1 0,0
R_82_t29 \$82__t29 \$82 30.3398506885
* device instance _82_t30 r0 *1 0,0
R_82_t30 \$82__t30 \$82 33.4421002714
* device instance _82_t31 r0 *1 0,0
R_82_t31 \$82__t31 \$82 17.863413337
* device instance _82_t32 r0 *1 0,0
R_82_t32 \$82__t32 \$82 12.1904019767
* device instance _82_t33 r0 *1 0,0
R_82_t33 \$82__t33 \$82 10.1383629795
* device instance _82_t34 r0 *1 0,0
R_82_t34 \$82__t34 \$82 8.96431328841
* device instance _82_t35 r0 *1 0,0
R_82_t35 \$82__t35 \$82 9.01795025708
* device instance _82_t36 r0 *1 0,0
R_82_t36 \$82__t36 \$82 10.2800752052
* device instance _82_t37 r0 *1 0,0
R_82_t37 \$82__t37 \$82 12.3866246769
* device instance _82_t38 r0 *1 0,0
R_82_t38 \$82__t38 \$82 14.9856264743
* device instance _82_t39 r0 *1 0,0
R_82_t39 \$82__t39 \$82 14.7586382191
* device instance _82_t40 r0 *1 0,0
R_82_t40 \$82__t40 \$82 13.5415691742
* device instance _82_t41 r0 *1 0,0
R_82_t41 \$82__t41 \$82 16.2715659087
* device instance _82_t42 r0 *1 0,0
R_82_t42 \$82__t42 \$82 13.0472725847
* device instance _82_t43 r0 *1 0,0
R_82_t43 \$82__t43 \$82 9.95443579312
* device instance _82_t44 r0 *1 0,0
R_82_t44 \$82__t44 \$82 7.16535186132
* device instance _82_t45 r0 *1 0,0
R_82_t45 \$82__t45 \$82 5.10110123457
* device instance _82_t46 r0 *1 0,0
R_82_t46 \$82__t46 \$82 6.96051183297
* device instance _82_t47 r0 *1 0,0
R_82_t47 \$82__t47 \$82 9.70918232534
* device instance _82_t48 r0 *1 0,0
R_82_t48 \$82__t48 \$82 12.7859189406
* device instance _82_t49 r0 *1 0,0
R_82_t49 \$82__t49 \$82 16.0026007312
* device instance _82_t50 r0 *1 0,0
R_82_t50 \$82__t50 \$82 19.2893427168
* device instance _82_t51 r0 *1 0,0
R_82_t51 \$82__t51 \$82 22.6156198236
* device instance _82_t52 r0 *1 0,0
R_82_t52 \$82__t52 \$82 5.19478083386
* device instance _82_t53 r0 *1 0,0
R_82_t53 \$82__t53 \$82 20.6625092752
* device instance _82_t54 r0 *1 0,0
R_82_t54 \$82__t54 \$82 19.2528590709
* device instance _82_t55 r0 *1 0,0
R_82_t55 \$82__t55 \$82 16.9657316325
* device instance _82_t56 r0 *1 0,0
R_82_t56 \$82__t56 \$82 15.1126279159
* device instance _82_t57 r0 *1 0,0
R_82_t57 \$82__t57 \$82 13.8686336926
* device instance _82_t58 r0 *1 0,0
R_82_t58 \$82__t58 \$82 16.7943134777
* device instance _82_t59 r0 *1 0,0
R_82_t59 \$82__t59 \$82 13.4044203065
* device instance _82_t60 r0 *1 0,0
R_82_t60 \$82__t60 \$82 13.7989119965
* device instance _82_t61 r0 *1 0,0
R_82_t61 \$82__t61 \$82 14.9844408003
* device instance _82_t62 r0 *1 0,0
R_82_t62 \$82__t62 \$82 21.8380658545
* device instance _82_t63 r0 *1 0,0
R_82_t63 \$82__t63 \$82 20.9051686562
* device instance _82_t64 r0 *1 0,0
R_82_t64 \$82__t64 \$82 45.8884686221
* device instance _82_t65 r0 *1 0,0
R_82_t65 \$82__t65 \$82 46.5997483009
* device instance _82_t66 r0 *1 0,0
R_82_t66 \$82__t66 \$82 47.3128497471
* device instance _82_t67 r0 *1 0,0
R_82_t67 \$82__t67 \$82 48.0276918136
* device instance _82_t68 r0 *1 0,0
R_82_t68 \$82__t68 \$82 53.1088436745
* device instance _82_t69 r0 *1 0,0
R_82_t69 \$82__t69 \$82 52.3908897016
* device instance _82_t70 r0 *1 0,0
R_82_t70 \$82__t70 \$82 53.8282216818
* device instance _82_t71 r0 *1 0,0
R_82_t71 \$82__t71 \$82 54.5489673842
* device instance _82 r0 *1 0,0
C_82 \$82 vsubs 1.77182155e-13
* device instance _83_t0 r0 *1 0,0
R_83_t0 \$83__t0 \$83 40.6643409023
* device instance _83_t1 r0 *1 0,0
R_83_t1 \$83__t1 \$83 5.79415215427
* device instance _83_t2 r0 *1 0,0
R_83_t2 \$83__t2 \$83 9.51566602732
* device instance _83_t3 r0 *1 0,0
R_83_t3 \$83__t3 \$83 14.4470006713
* device instance _83_t4 r0 *1 0,0
R_83_t4 \$83__t4 \$83 10.158616085
* device instance _83_t5 r0 *1 0,0
R_83_t5 \$83__t5 \$83 6.14725354337
* device instance _83_t6 r0 *1 0,0
R_83_t6 \$83__t6 \$83 23.9017597558
* device instance _83_t7 r0 *1 0,0
R_83_t7 \$83__t7 \$83 19.6996442746
* device instance _83_t8 r0 *1 0,0
R_83_t8 \$83__t8 \$83 25.072462352
* device instance _83_t9 r0 *1 0,0
R_83_t9 \$83__t9 \$83 56.2731449656
* device instance _83_t10 r0 *1 0,0
R_83_t10 \$83__t10 \$83 50.8047650743
* device instance _83_t11 r0 *1 0,0
R_83_t11 \$83__t11 \$83 45.3516669142
* device instance _83_t12 r0 *1 0,0
R_83_t12 \$83__t12 \$83 39.9201134422
* device instance _83_t13 r0 *1 0,0
R_83_t13 \$83__t13 \$83 29.1697732422
* device instance _83_t14 r0 *1 0,0
R_83_t14 \$83__t14 \$83 34.5202759298
* device instance _83_t15 r0 *1 0,0
R_83_t15 \$83__t15 \$83 31.3743719883
* device instance _83_t16 r0 *1 0,0
R_83_t16 \$83__t16 \$83 57.4468658064
* device instance _83_t17 r0 *1 0,0
R_83_t17 \$83__t17 \$83 52.1018205145
* device instance _83_t18 r0 *1 0,0
R_83_t18 \$83__t18 \$83 41.5582844196
* device instance _83_t19 r0 *1 0,0
R_83_t19 \$83__t19 \$83 36.4022663708
* device instance _83_t20 r0 *1 0,0
R_83_t20 \$83__t20 \$83 46.8000987025
* device instance _83_t21 r0 *1 0,0
R_83_t21 \$83__t21 \$83 26.5474983019
* device instance _83_t22 r0 *1 0,0
R_83_t22 \$83__t22 \$83 22.0540323345
* device instance _83_t23 r0 *1 0,0
R_83_t23 \$83__t23 \$83 18.7857604464
* device instance _83_t24 r0 *1 0,0
R_83_t24 \$83__t24 \$83 30.5020159979
* device instance _83_t25 r0 *1 0,0
R_83_t25 \$83__t25 \$83 36.7674313691
* device instance _83_t26 r0 *1 0,0
R_83_t26 \$83__t26 \$83 33.3360409412
* device instance _83_t27 r0 *1 0,0
R_83_t27 \$83__t27 \$83 27.5863076038
* device instance _83_t28 r0 *1 0,0
R_83_t28 \$83__t28 \$83 28.7474020017
* device instance _83_t29 r0 *1 0,0
R_83_t29 \$83__t29 \$83 30.5275526285
* device instance _83_t30 r0 *1 0,0
R_83_t30 \$83__t30 \$83 28.5265409931
* device instance _83_t31 r0 *1 0,0
R_83_t31 \$83__t31 \$83 27.509777176
* device instance _83_t32 r0 *1 0,0
R_83_t32 \$83__t32 \$83 51.0713235356
* device instance _83_t33 r0 *1 0,0
R_83_t33 \$83__t33 \$83 52.1523279446
* device instance _83_t34 r0 *1 0,0
R_83_t34 \$83__t34 \$83 53.2404769788
* device instance _83_t35 r0 *1 0,0
R_83_t35 \$83__t35 \$83 54.3353413936
* device instance _83_t36 r0 *1 0,0
R_83_t36 \$83__t36 \$83 61.3056594771
* device instance _83_t37 r0 *1 0,0
R_83_t37 \$83__t37 \$83 63.5354736422
* device instance _83_t38 r0 *1 0,0
R_83_t38 \$83__t38 \$83 62.4181161136
* device instance _83_t39 r0 *1 0,0
R_83_t39 \$83__t39 \$83 64.6574779839
* device instance _83 r0 *1 0,0
C_83 \$83 vsubs 1.44349639e-13
* device instance _84_t0 r0 *1 0,0
R_84_t0 \$84__t0 \$84 72.8318372444
* device instance _84_t1 r0 *1 0,0
R_84_t1 \$84__t1 \$84 31.3697488842
* device instance _84_t2 r0 *1 0,0
R_84_t2 \$84__t2 \$84 38.864779931
* device instance _84_t3 r0 *1 0,0
R_84_t3 \$84__t3 \$84 50.472760055
* device instance _84_t4 r0 *1 0,0
R_84_t4 \$84__t4 \$84 39.9380804289
* device instance _84_t5 r0 *1 0,0
R_84_t5 \$84__t5 \$84 27.9878496386
* device instance _84_t6 r0 *1 0,0
R_84_t6 \$84__t6 \$84 89.73986513
* device instance _84_t7 r0 *1 0,0
R_84_t7 \$84__t7 \$84 26.289905862
* device instance _84_t8 r0 *1 0,0
R_84_t8 \$84__t8 \$84 97.8455159237
* device instance _84_t9 r0 *1 0,0
R_84_t9 \$84__t9 \$84 22.145377228
* device instance _84_t10 r0 *1 0,0
R_84_t10 \$84__t10 \$84 34.893683157
* device instance _84_t11 r0 *1 0,0
R_84_t11 \$84__t11 \$84 61.5140221704
* device instance _84_t12 r0 *1 0,0
R_84_t12 \$84__t12 \$84 21.1843185636
* device instance _84_t13 r0 *1 0,0
R_84_t13 \$84__t13 \$84 27.2337538328
* device instance _84_t14 r0 *1 0,0
R_84_t14 \$84__t14 \$84 76.5788400168
* device instance _84_t15 r0 *1 0,0
R_84_t15 \$84__t15 \$84 82.5637207104
* device instance _84_t16 r0 *1 0,0
R_84_t16 \$84__t16 \$84 67.203594104
* device instance _84_t17 r0 *1 0,0
R_84_t17 \$84__t17 \$84 65.2565669157
* device instance _84_t18 r0 *1 0,0
R_84_t18 \$84__t18 \$84 71.2409054255
* device instance _84_t19 r0 *1 0,0
R_84_t19 \$84__t19 \$84 69.1997501482
* device instance _84_t20 r0 *1 0,0
R_84_t20 \$84__t20 \$84 89.960378837
* device instance _84_t21 r0 *1 0,0
R_84_t21 \$84__t21 \$84 87.7477377179
* device instance _84_t22 r0 *1 0,0
R_84_t22 \$84__t22 \$84 92.1979005812
* device instance _84_t23 r0 *1 0,0
R_84_t23 \$84__t23 \$84 85.5619074935
* device instance _84 r0 *1 0,0
C_84 \$84 vsubs 1.2749138e-13
* device instance _85_t0 r0 *1 0,0
R_85_t0 \$85__t0 \$85 141.920059825
* device instance _85_t1 r0 *1 0,0
R_85_t1 \$85__t1 \$85 125.016727085
* device instance _85_t2 r0 *1 0,0
R_85_t2 \$85__t2 \$85 72.2396640895
* device instance _85_t3 r0 *1 0,0
R_85_t3 \$85__t3 \$85 83.9329276865
* device instance _85_t4 r0 *1 0,0
R_85_t4 \$85__t4 \$85 168.33607375
* device instance _85_t5 r0 *1 0,0
R_85_t5 \$85__t5 \$85 181.243358652
* device instance _85_t6 r0 *1 0,0
R_85_t6 \$85__t6 \$85 43.0273545853
* device instance _85_t7 r0 *1 0,0
R_85_t7 \$85__t7 \$85 60.6425636404
* device instance _85_t8 r0 *1 0,0
R_85_t8 \$85__t8 \$85 53.137056906
* device instance _85_t9 r0 *1 0,0
R_85_t9 \$85__t9 \$85 54.3131212759
* device instance _85_t10 r0 *1 0,0
R_85_t10 \$85__t10 \$85 55.7679108023
* device instance _85_t11 r0 *1 0,0
R_85_t11 \$85__t11 \$85 57.4802663024
* device instance _85_t12 r0 *1 0,0
R_85_t12 \$85__t12 \$85 75.6541556398
* device instance _85_t13 r0 *1 0,0
R_85_t13 \$85__t13 \$85 78.3196641165
* device instance _85_t14 r0 *1 0,0
R_85_t14 \$85__t14 \$85 81.1058858252
* device instance _85_t15 r0 *1 0,0
R_85_t15 \$85__t15 \$85 84.0008098181
* device instance _85 r0 *1 0,0
C_85 \$85 vsubs 1.17770046e-13
* device instance _86_t0 r0 *1 0,0
R_86_t0 \$86__t0 \$86 213.906295844
* device instance _86_t1 r0 *1 0,0
R_86_t1 \$86__t1 \$86 213.891180066
* device instance _86_t2 r0 *1 0,0
R_86_t2 \$86__t2 \$86 289.713773711
* device instance _86_t3 r0 *1 0,0
R_86_t3 \$86__t3 \$86 175.348726988
* device instance _86_t4 r0 *1 0,0
R_86_t4 \$86__t4 \$86 54.3141014677
* device instance _86_t5 r0 *1 0,0
R_86_t5 \$86__t5 \$86 56.4680012372
* device instance _86_t6 r0 *1 0,0
R_86_t6 \$86__t6 \$86 59.2541512659
* device instance _86_t7 r0 *1 0,0
R_86_t7 \$86__t7 \$86 62.588173434
* device instance _86_t8 r0 *1 0,0
R_86_t8 \$86__t8 \$86 66.4116942459
* device instance _86_t9 r0 *1 0,0
R_86_t9 \$86__t9 \$86 68.6226715932
* device instance _86_t10 r0 *1 0,0
R_86_t10 \$86__t10 \$86 71.3542900855
* device instance _86_t11 r0 *1 0,0
R_86_t11 \$86__t11 \$86 74.5493400619
* device instance _86 r0 *1 0,0
C_86 \$86 vsubs 1.11718715e-13
* device instance _87_t0 r0 *1 0,0
R_87_t0 \$87__t0 \$87 373.996867344
* device instance _87_t1 r0 *1 0,0
R_87_t1 \$87__t1 \$87 393.445773919
* device instance _87_t2 r0 *1 0,0
R_87_t2 \$87__t2 \$87 64.3840584941
* device instance _87_t3 r0 *1 0,0
R_87_t3 \$87__t3 \$87 71.5104978885
* device instance _87_t4 r0 *1 0,0
R_87_t4 \$87__t4 \$87 78.9595246804
* device instance _87_t5 r0 *1 0,0
R_87_t5 \$87__t5 \$87 86.6479813766
* device instance _87_t6 r0 *1 0,0
R_87_t6 \$87__t6 \$87 58.7201977431
* device instance _87_t7 r0 *1 0,0
R_87_t7 \$87__t7 \$87 54.4557350201
* device instance _87_t8 r0 *1 0,0
R_87_t8 \$87__t8 \$87 54.5334241482
* device instance _87_t9 r0 *1 0,0
R_87_t9 \$87__t9 \$87 55.9890393869
* device instance _87 r0 *1 0,0
C_87 \$87 vsubs 7.219247e-14
* device instance _88_t0 r0 *1 0,0
R_88_t0 \$88__t0 \$88 438.262254277
* device instance _88_t1 r0 *1 0,0
R_88_t1 \$88__t1 \$88 81.3844454092
* device instance _88_t2 r0 *1 0,0
R_88_t2 \$88__t2 \$88 98.772428992
* device instance _88_t3 r0 *1 0,0
R_88_t3 \$88__t3 \$88 116.734047769
* device instance _88_t4 r0 *1 0,0
R_88_t4 \$88__t4 \$88 65.0318659218
* device instance _88_t5 r0 *1 0,0
R_88_t5 \$88__t5 \$88 87.9257278374
* device instance _88_t6 r0 *1 0,0
R_88_t6 \$88__t6 \$88 100.343517804
* device instance _88_t7 r0 *1 0,0
R_88_t7 \$88__t7 \$88 114.651602343
* device instance _88_t8 r0 *1 0,0
R_88_t8 \$88__t8 \$88 130.228409648
* device instance _88 r0 *1 0,0
C_88 \$88 vsubs 5.1062839e-14
* device instance _9_t0 r0 *1 0,0
R_9_t0 \$9__t0 \$9 162.444438203
* device instance _9_t1 r0 *1 0,0
R_9_t1 \$9__t1 \$9 43.7126105743
* device instance _9_t2 r0 *1 0,0
R_9_t2 \$9__t2 \$9 200.179851222
* device instance _9 r0 *1 0,0
C_9 \$9 vsubs 7.553404e-15
* device instance _90_t0 r0 *1 0,0
R_90_t0 \$90__t0 \$90 135.591504929
* device instance _90_t1 r0 *1 0,0
R_90_t1 \$90__t1 \$90 36.2048686624
* device instance _90_t2 r0 *1 0,0
R_90_t2 \$90__t2 \$90 166.824926409
* device instance _90 r0 *1 0,0
C_90 \$90 vsubs 7.017453e-15
* device instance _92_t0 r0 *1 0,0
R_92_t0 \$92__t0 \$92 162.444438203
* device instance _92_t1 r0 *1 0,0
R_92_t1 \$92__t1 \$92 43.7126105743
* device instance _92_t2 r0 *1 0,0
R_92_t2 \$92__t2 \$92 200.179851222
* device instance _92 r0 *1 0,0
C_92 \$92 vsubs 7.547896e-15
* device instance _94_t0 r0 *1 0,0
R_94_t0 \$94__t0 \$94 135.591504929
* device instance _94_t1 r0 *1 0,0
R_94_t1 \$94__t1 \$94 36.2048686624
* device instance _94_t2 r0 *1 0,0
R_94_t2 \$94__t2 \$94 166.824926409
* device instance _94 r0 *1 0,0
C_94 \$94 vsubs 7.017453e-15
* device instance _96_t0 r0 *1 0,0
R_96_t0 \$96__t0 \$96 162.444438203
* device instance _96_t1 r0 *1 0,0
R_96_t1 \$96__t1 \$96 43.7126105743
* device instance _96_t2 r0 *1 0,0
R_96_t2 \$96__t2 \$96 200.179851222
* device instance _96 r0 *1 0,0
C_96 \$96 vsubs 7.547896e-15
* device instance _98_t0 r0 *1 0,0
R_98_t0 \$98__t0 \$98 135.591504929
* device instance _98_t1 r0 *1 0,0
R_98_t1 \$98__t1 \$98 36.2048686624
* device instance _98_t2 r0 *1 0,0
R_98_t2 \$98__t2 \$98 166.824926409
* device instance _98 r0 *1 0,0
C_98 \$98 vsubs 7.017453e-15
* device instance hi_128_n_t0 r0 *1 0,0
Rhi_128_n_t0 hi_128_n__t0 hi_128_n 159.628415411
* device instance hi_128_n_t1 r0 *1 0,0
Rhi_128_n_t1 hi_128_n__t1 hi_128_n 17.8399437493
* device instance hi_128_n_t2 r0 *1 0,0
Rhi_128_n_t2 hi_128_n__t2 hi_128_n 156.869440839
* device instance hi_128_n r0 *1 0,0
Chi_128_n hi_128_n vsubs 4.857429e-15
* device instance hi_128_p_t0 r0 *1 0,0
Rhi_128_p_t0 hi_128_p__t0 hi_128_p 159.628415411
* device instance hi_128_p_t1 r0 *1 0,0
Rhi_128_p_t1 hi_128_p__t1 hi_128_p 17.8399437493
* device instance hi_128_p_t2 r0 *1 0,0
Rhi_128_p_t2 hi_128_p__t2 hi_128_p 156.869440839
* device instance hi_128_p r0 *1 0,0
Chi_128_p hi_128_p vsubs 4.857429e-15
* device instance hi_16_n_t0 r0 *1 0,0
Rhi_16_n_t0 hi_16_n__t0 hi_16_n 159.628415411
* device instance hi_16_n_t1 r0 *1 0,0
Rhi_16_n_t1 hi_16_n__t1 hi_16_n 17.8399437493
* device instance hi_16_n_t2 r0 *1 0,0
Rhi_16_n_t2 hi_16_n__t2 hi_16_n 156.869440839
* device instance hi_16_n r0 *1 0,0
Chi_16_n hi_16_n vsubs 4.851921e-15
* device instance hi_16_p_t0 r0 *1 0,0
Rhi_16_p_t0 hi_16_p__t0 hi_16_p 159.628415411
* device instance hi_16_p_t1 r0 *1 0,0
Rhi_16_p_t1 hi_16_p__t1 hi_16_p 17.8399437493
* device instance hi_16_p_t2 r0 *1 0,0
Rhi_16_p_t2 hi_16_p__t2 hi_16_p 156.869440839
* device instance hi_16_p r0 *1 0,0
Chi_16_p hi_16_p vsubs 4.851921e-15
* device instance hi_1_n_t0 r0 *1 0,0
Rhi_1_n_t0 hi_1_n__t0 hi_1_n 159.628415411
* device instance hi_1_n_t1 r0 *1 0,0
Rhi_1_n_t1 hi_1_n__t1 hi_1_n 17.8399437493
* device instance hi_1_n_t2 r0 *1 0,0
Rhi_1_n_t2 hi_1_n__t2 hi_1_n 156.869440839
* device instance hi_1_n r0 *1 0,0
Chi_1_n hi_1_n vsubs 4.857429e-15
* device instance hi_1_p_t0 r0 *1 0,0
Rhi_1_p_t0 hi_1_p__t0 hi_1_p 159.628415411
* device instance hi_1_p_t1 r0 *1 0,0
Rhi_1_p_t1 hi_1_p__t1 hi_1_p 17.8399437493
* device instance hi_1_p_t2 r0 *1 0,0
Rhi_1_p_t2 hi_1_p__t2 hi_1_p 156.869440839
* device instance hi_1_p r0 *1 0,0
Chi_1_p hi_1_p vsubs 4.857429e-15
* device instance hi_256_n_t0 r0 *1 0,0
Rhi_256_n_t0 hi_256_n__t0 hi_256_n 159.628415411
* device instance hi_256_n_t1 r0 *1 0,0
Rhi_256_n_t1 hi_256_n__t1 hi_256_n 17.8399437493
* device instance hi_256_n_t2 r0 *1 0,0
Rhi_256_n_t2 hi_256_n__t2 hi_256_n 156.869440839
* device instance hi_256_n r0 *1 0,0
Chi_256_n hi_256_n vsubs 4.857429e-15
* device instance hi_256_p_t0 r0 *1 0,0
Rhi_256_p_t0 hi_256_p__t0 hi_256_p 159.628415411
* device instance hi_256_p_t1 r0 *1 0,0
Rhi_256_p_t1 hi_256_p__t1 hi_256_p 17.8399437493
* device instance hi_256_p_t2 r0 *1 0,0
Rhi_256_p_t2 hi_256_p__t2 hi_256_p 156.869440839
* device instance hi_256_p r0 *1 0,0
Chi_256_p hi_256_p vsubs 4.857429e-15
* device instance hi_2_n_t0 r0 *1 0,0
Rhi_2_n_t0 hi_2_n__t0 hi_2_n 159.628415411
* device instance hi_2_n_t1 r0 *1 0,0
Rhi_2_n_t1 hi_2_n__t1 hi_2_n 17.8399437493
* device instance hi_2_n_t2 r0 *1 0,0
Rhi_2_n_t2 hi_2_n__t2 hi_2_n 156.869440839
* device instance hi_2_n r0 *1 0,0
Chi_2_n hi_2_n vsubs 4.857429e-15
* device instance hi_2_p_t0 r0 *1 0,0
Rhi_2_p_t0 hi_2_p__t0 hi_2_p 159.628415411
* device instance hi_2_p_t1 r0 *1 0,0
Rhi_2_p_t1 hi_2_p__t1 hi_2_p 17.8399437493
* device instance hi_2_p_t2 r0 *1 0,0
Rhi_2_p_t2 hi_2_p__t2 hi_2_p 156.869440839
* device instance hi_2_p r0 *1 0,0
Chi_2_p hi_2_p vsubs 4.857429e-15
* device instance hi_32_n_t0 r0 *1 0,0
Rhi_32_n_t0 hi_32_n__t0 hi_32_n 159.628415411
* device instance hi_32_n_t1 r0 *1 0,0
Rhi_32_n_t1 hi_32_n__t1 hi_32_n 17.8399437493
* device instance hi_32_n_t2 r0 *1 0,0
Rhi_32_n_t2 hi_32_n__t2 hi_32_n 156.869440839
* device instance hi_32_n r0 *1 0,0
Chi_32_n hi_32_n vsubs 4.857429e-15
* device instance hi_32_p_t0 r0 *1 0,0
Rhi_32_p_t0 hi_32_p__t0 hi_32_p 159.628415411
* device instance hi_32_p_t1 r0 *1 0,0
Rhi_32_p_t1 hi_32_p__t1 hi_32_p 17.8399437493
* device instance hi_32_p_t2 r0 *1 0,0
Rhi_32_p_t2 hi_32_p__t2 hi_32_p 156.869440839
* device instance hi_32_p r0 *1 0,0
Chi_32_p hi_32_p vsubs 4.857429e-15
* device instance hi_4_n_t0 r0 *1 0,0
Rhi_4_n_t0 hi_4_n__t0 hi_4_n 159.628415411
* device instance hi_4_n_t1 r0 *1 0,0
Rhi_4_n_t1 hi_4_n__t1 hi_4_n 17.8399437493
* device instance hi_4_n_t2 r0 *1 0,0
Rhi_4_n_t2 hi_4_n__t2 hi_4_n 156.869440839
* device instance hi_4_n r0 *1 0,0
Chi_4_n hi_4_n vsubs 4.857429e-15
* device instance hi_4_p_t0 r0 *1 0,0
Rhi_4_p_t0 hi_4_p__t0 hi_4_p 159.628415411
* device instance hi_4_p_t1 r0 *1 0,0
Rhi_4_p_t1 hi_4_p__t1 hi_4_p 17.8399437493
* device instance hi_4_p_t2 r0 *1 0,0
Rhi_4_p_t2 hi_4_p__t2 hi_4_p 156.869440839
* device instance hi_4_p r0 *1 0,0
Chi_4_p hi_4_p vsubs 4.857429e-15
* device instance hi_64_n_t0 r0 *1 0,0
Rhi_64_n_t0 hi_64_n__t0 hi_64_n 159.628415411
* device instance hi_64_n_t1 r0 *1 0,0
Rhi_64_n_t1 hi_64_n__t1 hi_64_n 17.8399437493
* device instance hi_64_n_t2 r0 *1 0,0
Rhi_64_n_t2 hi_64_n__t2 hi_64_n 156.869440839
* device instance hi_64_n r0 *1 0,0
Chi_64_n hi_64_n vsubs 4.857429e-15
* device instance hi_64_p_t0 r0 *1 0,0
Rhi_64_p_t0 hi_64_p__t0 hi_64_p 159.628415411
* device instance hi_64_p_t1 r0 *1 0,0
Rhi_64_p_t1 hi_64_p__t1 hi_64_p 17.8399437493
* device instance hi_64_p_t2 r0 *1 0,0
Rhi_64_p_t2 hi_64_p__t2 hi_64_p 156.869440839
* device instance hi_64_p r0 *1 0,0
Chi_64_p hi_64_p vsubs 4.857429e-15
* device instance hi_8_n_t0 r0 *1 0,0
Rhi_8_n_t0 hi_8_n__t0 hi_8_n 159.628415411
* device instance hi_8_n_t1 r0 *1 0,0
Rhi_8_n_t1 hi_8_n__t1 hi_8_n 17.8399437493
* device instance hi_8_n_t2 r0 *1 0,0
Rhi_8_n_t2 hi_8_n__t2 hi_8_n 156.869440839
* device instance hi_8_n r0 *1 0,0
Chi_8_n hi_8_n vsubs 4.857429e-15
* device instance hi_8_p_t0 r0 *1 0,0
Rhi_8_p_t0 hi_8_p__t0 hi_8_p 159.628415411
* device instance hi_8_p_t1 r0 *1 0,0
Rhi_8_p_t1 hi_8_p__t1 hi_8_p 17.8399437493
* device instance hi_8_p_t2 r0 *1 0,0
Rhi_8_p_t2 hi_8_p__t2 hi_8_p 156.869440839
* device instance hi_8_p r0 *1 0,0
Chi_8_p hi_8_p vsubs 4.857429e-15
* device instance lo_128_n_t0 r0 *1 0,0
Rlo_128_n_t0 lo_128_n__t0 lo_128_n 192.317036104
* device instance lo_128_n_t1 r0 *1 0,0
Rlo_128_n_t1 lo_128_n__t1 lo_128_n 21.6360274196
* device instance lo_128_n_t2 r0 *1 0,0
Rlo_128_n_t2 lo_128_n__t2 lo_128_n 188.273336477
* device instance lo_128_n r0 *1 0,0
Clo_128_n lo_128_n vsubs 5.390587e-15
* device instance lo_128_p_t0 r0 *1 0,0
Rlo_128_p_t0 lo_128_p__t0 lo_128_p 192.317036104
* device instance lo_128_p_t1 r0 *1 0,0
Rlo_128_p_t1 lo_128_p__t1 lo_128_p 21.6360274196
* device instance lo_128_p_t2 r0 *1 0,0
Rlo_128_p_t2 lo_128_p__t2 lo_128_p 188.273336477
* device instance lo_128_p r0 *1 0,0
Clo_128_p lo_128_p vsubs 5.394106e-15
* device instance lo_16_n_t0 r0 *1 0,0
Rlo_16_n_t0 lo_16_n__t0 lo_16_n 192.317036104
* device instance lo_16_n_t1 r0 *1 0,0
Rlo_16_n_t1 lo_16_n__t1 lo_16_n 21.6360274196
* device instance lo_16_n_t2 r0 *1 0,0
Rlo_16_n_t2 lo_16_n__t2 lo_16_n 188.273336477
* device instance lo_16_n r0 *1 0,0
Clo_16_n lo_16_n vsubs 5.385079e-15
* device instance lo_16_p_t0 r0 *1 0,0
Rlo_16_p_t0 lo_16_p__t0 lo_16_p 192.317036104
* device instance lo_16_p_t1 r0 *1 0,0
Rlo_16_p_t1 lo_16_p__t1 lo_16_p 21.6360274196
* device instance lo_16_p_t2 r0 *1 0,0
Rlo_16_p_t2 lo_16_p__t2 lo_16_p 188.273336477
* device instance lo_16_p r0 *1 0,0
Clo_16_p lo_16_p vsubs 5.388598e-15
* device instance lo_1_n_t0 r0 *1 0,0
Rlo_1_n_t0 lo_1_n__t0 lo_1_n 192.317036104
* device instance lo_1_n_t1 r0 *1 0,0
Rlo_1_n_t1 lo_1_n__t1 lo_1_n 21.6360274196
* device instance lo_1_n_t2 r0 *1 0,0
Rlo_1_n_t2 lo_1_n__t2 lo_1_n 188.273336477
* device instance lo_1_n r0 *1 0,0
Clo_1_n lo_1_n vsubs 5.390587e-15
* device instance lo_1_p_t0 r0 *1 0,0
Rlo_1_p_t0 lo_1_p__t0 lo_1_p 192.317036104
* device instance lo_1_p_t1 r0 *1 0,0
Rlo_1_p_t1 lo_1_p__t1 lo_1_p 21.6360274196
* device instance lo_1_p_t2 r0 *1 0,0
Rlo_1_p_t2 lo_1_p__t2 lo_1_p 188.273336477
* device instance lo_1_p r0 *1 0,0
Clo_1_p lo_1_p vsubs 5.394106e-15
* device instance lo_256_n_t0 r0 *1 0,0
Rlo_256_n_t0 lo_256_n__t0 lo_256_n 192.317036104
* device instance lo_256_n_t1 r0 *1 0,0
Rlo_256_n_t1 lo_256_n__t1 lo_256_n 21.6360274196
* device instance lo_256_n_t2 r0 *1 0,0
Rlo_256_n_t2 lo_256_n__t2 lo_256_n 188.273336477
* device instance lo_256_n r0 *1 0,0
Clo_256_n lo_256_n vsubs 5.390587e-15
* device instance lo_256_p_t0 r0 *1 0,0
Rlo_256_p_t0 lo_256_p__t0 lo_256_p 192.317036104
* device instance lo_256_p_t1 r0 *1 0,0
Rlo_256_p_t1 lo_256_p__t1 lo_256_p 21.6360274196
* device instance lo_256_p_t2 r0 *1 0,0
Rlo_256_p_t2 lo_256_p__t2 lo_256_p 188.273336477
* device instance lo_256_p r0 *1 0,0
Clo_256_p lo_256_p vsubs 5.394106e-15
* device instance lo_2_n_t0 r0 *1 0,0
Rlo_2_n_t0 lo_2_n__t0 lo_2_n 192.317036104
* device instance lo_2_n_t1 r0 *1 0,0
Rlo_2_n_t1 lo_2_n__t1 lo_2_n 21.6360274196
* device instance lo_2_n_t2 r0 *1 0,0
Rlo_2_n_t2 lo_2_n__t2 lo_2_n 188.273336477
* device instance lo_2_n r0 *1 0,0
Clo_2_n lo_2_n vsubs 5.390587e-15
* device instance lo_2_p_t0 r0 *1 0,0
Rlo_2_p_t0 lo_2_p__t0 lo_2_p 192.317036104
* device instance lo_2_p_t1 r0 *1 0,0
Rlo_2_p_t1 lo_2_p__t1 lo_2_p 21.6360274196
* device instance lo_2_p_t2 r0 *1 0,0
Rlo_2_p_t2 lo_2_p__t2 lo_2_p 188.273336477
* device instance lo_2_p r0 *1 0,0
Clo_2_p lo_2_p vsubs 5.394106e-15
* device instance lo_32_n_t0 r0 *1 0,0
Rlo_32_n_t0 lo_32_n__t0 lo_32_n 192.317036104
* device instance lo_32_n_t1 r0 *1 0,0
Rlo_32_n_t1 lo_32_n__t1 lo_32_n 21.6360274196
* device instance lo_32_n_t2 r0 *1 0,0
Rlo_32_n_t2 lo_32_n__t2 lo_32_n 188.273336477
* device instance lo_32_n r0 *1 0,0
Clo_32_n lo_32_n vsubs 5.390587e-15
* device instance lo_32_p_t0 r0 *1 0,0
Rlo_32_p_t0 lo_32_p__t0 lo_32_p 192.317036104
* device instance lo_32_p_t1 r0 *1 0,0
Rlo_32_p_t1 lo_32_p__t1 lo_32_p 21.6360274196
* device instance lo_32_p_t2 r0 *1 0,0
Rlo_32_p_t2 lo_32_p__t2 lo_32_p 188.273336477
* device instance lo_32_p r0 *1 0,0
Clo_32_p lo_32_p vsubs 5.394106e-15
* device instance lo_4_n_t0 r0 *1 0,0
Rlo_4_n_t0 lo_4_n__t0 lo_4_n 192.317036104
* device instance lo_4_n_t1 r0 *1 0,0
Rlo_4_n_t1 lo_4_n__t1 lo_4_n 21.6360274196
* device instance lo_4_n_t2 r0 *1 0,0
Rlo_4_n_t2 lo_4_n__t2 lo_4_n 188.273336477
* device instance lo_4_n r0 *1 0,0
Clo_4_n lo_4_n vsubs 5.390587e-15
* device instance lo_4_p_t0 r0 *1 0,0
Rlo_4_p_t0 lo_4_p__t0 lo_4_p 192.317036104
* device instance lo_4_p_t1 r0 *1 0,0
Rlo_4_p_t1 lo_4_p__t1 lo_4_p 21.6360274196
* device instance lo_4_p_t2 r0 *1 0,0
Rlo_4_p_t2 lo_4_p__t2 lo_4_p 188.273336477
* device instance lo_4_p r0 *1 0,0
Clo_4_p lo_4_p vsubs 5.394106e-15
* device instance lo_64_n_t0 r0 *1 0,0
Rlo_64_n_t0 lo_64_n__t0 lo_64_n 192.317036104
* device instance lo_64_n_t1 r0 *1 0,0
Rlo_64_n_t1 lo_64_n__t1 lo_64_n 21.6360274196
* device instance lo_64_n_t2 r0 *1 0,0
Rlo_64_n_t2 lo_64_n__t2 lo_64_n 188.273336477
* device instance lo_64_n r0 *1 0,0
Clo_64_n lo_64_n vsubs 5.390587e-15
* device instance lo_64_p_t0 r0 *1 0,0
Rlo_64_p_t0 lo_64_p__t0 lo_64_p 192.317036104
* device instance lo_64_p_t1 r0 *1 0,0
Rlo_64_p_t1 lo_64_p__t1 lo_64_p 21.6360274196
* device instance lo_64_p_t2 r0 *1 0,0
Rlo_64_p_t2 lo_64_p__t2 lo_64_p 188.273336477
* device instance lo_64_p r0 *1 0,0
Clo_64_p lo_64_p vsubs 5.394106e-15
* device instance lo_8_n_t0 r0 *1 0,0
Rlo_8_n_t0 lo_8_n__t0 lo_8_n 192.317036104
* device instance lo_8_n_t1 r0 *1 0,0
Rlo_8_n_t1 lo_8_n__t1 lo_8_n 21.6360274196
* device instance lo_8_n_t2 r0 *1 0,0
Rlo_8_n_t2 lo_8_n__t2 lo_8_n 188.273336477
* device instance lo_8_n r0 *1 0,0
Clo_8_n lo_8_n vsubs 5.390587e-15
* device instance lo_8_p_t0 r0 *1 0,0
Rlo_8_p_t0 lo_8_p__t0 lo_8_p 192.317036104
* device instance lo_8_p_t1 r0 *1 0,0
Rlo_8_p_t1 lo_8_p__t1 lo_8_p 21.6360274196
* device instance lo_8_p_t2 r0 *1 0,0
Rlo_8_p_t2 lo_8_p__t2 lo_8_p 188.273336477
* device instance lo_8_p r0 *1 0,0
Clo_8_p lo_8_p vsubs 5.394106e-15
* device instance pinn_t0 r0 *1 0,0
Rpinn_t0 vinn__t0 vinn 161.958109832
* device instance pinn_t1 r0 *1 0,0
Rpinn_t1 vinn__t1 vinn 233.907460461
* device instance pinn_t2 r0 *1 0,0
Rpinn_t2 vinn__t2 vinn 90.0297060612
* device instance pinn_t3 r0 *1 0,0
Rpinn_t3 vinn__t3 vinn 305.862976071
* device instance pinn_t4 r0 *1 0,0
Rpinn_t4 vinn__t4 vinn 18.3699743913
* device instance pinn_t5 r0 *1 0,0
Rpinn_t5 vinn__t5 vinn 54.0994759425
* device instance pinn_t6 r0 *1 0,0
Rpinn_t6 vinn__t6 vinn 125.989047095
* device instance pinn_t7 r0 *1 0,0
Rpinn_t7 vinn__t7 vinn 269.884755824
* device instance pinn_t8 r0 *1 0,0
Rpinn_t8 vinn__t8 vinn 197.931594322
* device instance pinn_t9 r0 *1 0,0
Rpinn_t9 vinn__t9 vinn 18.3699743913
* device instance pinn_t10 r0 *1 0,0
Rpinn_t10 vinn__t10 vinn 125.989047095
* device instance pinn_t11 r0 *1 0,0
Rpinn_t11 vinn__t11 vinn 197.931594322
* device instance pinn_t12 r0 *1 0,0
Rpinn_t12 vinn__t12 vinn 90.0297060612
* device instance pinn_t13 r0 *1 0,0
Rpinn_t13 vinn__t13 vinn 305.862976071
* device instance pinn_t14 r0 *1 0,0
Rpinn_t14 vinn__t14 vinn 161.958109832
* device instance pinn_t15 r0 *1 0,0
Rpinn_t15 vinn__t15 vinn 269.884755824
* device instance pinn_t16 r0 *1 0,0
Rpinn_t16 vinn__t16 vinn 54.0994759425
* device instance pinn_t17 r0 *1 0,0
Rpinn_t17 vinn__t17 vinn 233.907460461
* device instance pinn r0 *1 0,0
Cpinn vinn vsubs 8.37261e-14
* device instance pinp_t0 r0 *1 0,0
Rpinp_t0 vinp__t0 vinp 305.862976071
* device instance pinp_t1 r0 *1 0,0
Rpinp_t1 vinp__t1 vinp 269.884755824
* device instance pinp_t2 r0 *1 0,0
Rpinp_t2 vinp__t2 vinp 161.958109832
* device instance pinp_t3 r0 *1 0,0
Rpinp_t3 vinp__t3 vinp 54.0994759425
* device instance pinp_t4 r0 *1 0,0
Rpinp_t4 vinp__t4 vinp 90.0297060612
* device instance pinp_t5 r0 *1 0,0
Rpinp_t5 vinp__t5 vinp 305.862976071
* device instance pinp_t6 r0 *1 0,0
Rpinp_t6 vinp__t6 vinp 197.931594322
* device instance pinp_t7 r0 *1 0,0
Rpinp_t7 vinp__t7 vinp 18.3699743913
* device instance pinp_t8 r0 *1 0,0
Rpinp_t8 vinp__t8 vinp 233.907460461
* device instance pinp_t9 r0 *1 0,0
Rpinp_t9 vinp__t9 vinp 125.989047095
* device instance pinp_t10 r0 *1 0,0
Rpinp_t10 vinp__t10 vinp 197.931594322
* device instance pinp_t11 r0 *1 0,0
Rpinp_t11 vinp__t11 vinp 54.0994759425
* device instance pinp_t12 r0 *1 0,0
Rpinp_t12 vinp__t12 vinp 233.907460461
* device instance pinp_t13 r0 *1 0,0
Rpinp_t13 vinp__t13 vinp 161.958109832
* device instance pinp_t14 r0 *1 0,0
Rpinp_t14 vinp__t14 vinp 125.989047095
* device instance pinp_t15 r0 *1 0,0
Rpinp_t15 vinp__t15 vinp 269.884755824
* device instance pinp_t16 r0 *1 0,0
Rpinp_t16 vinp__t16 vinp 90.0297060612
* device instance pinp_t17 r0 *1 0,0
Rpinp_t17 vinp__t17 vinp 18.3699743913
* device instance pinp r0 *1 0,0
Cpinp vinp vsubs 8.378118e-14
* device instance rel_128_n_t0 r0 *1 0,0
Rrel_128_n_t0 rel_128_n__t0 rel_128_n 127.025622285
* device instance rel_128_n_t1 r0 *1 0,0
Rrel_128_n_t1 rel_128_n__t1 rel_128_n 14.1171220219
* device instance rel_128_n_t2 r0 *1 0,0
Rrel_128_n_t2 rel_128_n__t2 rel_128_n 125.307355693
* device instance rel_128_n r0 *1 0,0
Crel_128_n rel_128_n vsubs 4.320752e-15
* device instance rel_128_p_t0 r0 *1 0,0
Rrel_128_p_t0 rel_128_p__t0 rel_128_p 127.025622285
* device instance rel_128_p_t1 r0 *1 0,0
Rrel_128_p_t1 rel_128_p__t1 rel_128_p 14.1171220219
* device instance rel_128_p_t2 r0 *1 0,0
Rrel_128_p_t2 rel_128_p__t2 rel_128_p 125.307355693
* device instance rel_128_p r0 *1 0,0
Crel_128_p rel_128_p vsubs 4.320752e-15
* device instance rel_16_n_t0 r0 *1 0,0
Rrel_16_n_t0 rel_16_n__t0 rel_16_n 127.025622285
* device instance rel_16_n_t1 r0 *1 0,0
Rrel_16_n_t1 rel_16_n__t1 rel_16_n 14.1171220219
* device instance rel_16_n_t2 r0 *1 0,0
Rrel_16_n_t2 rel_16_n__t2 rel_16_n 125.307355693
* device instance rel_16_n r0 *1 0,0
Crel_16_n rel_16_n vsubs 4.320701e-15
* device instance rel_16_p_t0 r0 *1 0,0
Rrel_16_p_t0 rel_16_p__t0 rel_16_p 127.025622285
* device instance rel_16_p_t1 r0 *1 0,0
Rrel_16_p_t1 rel_16_p__t1 rel_16_p 14.1171220219
* device instance rel_16_p_t2 r0 *1 0,0
Rrel_16_p_t2 rel_16_p__t2 rel_16_p 125.307355693
* device instance rel_16_p r0 *1 0,0
Crel_16_p rel_16_p vsubs 4.320701e-15
* device instance rel_1_n_t0 r0 *1 0,0
Rrel_1_n_t0 rel_1_n__t0 rel_1_n 127.025622285
* device instance rel_1_n_t1 r0 *1 0,0
Rrel_1_n_t1 rel_1_n__t1 rel_1_n 14.1171220219
* device instance rel_1_n_t2 r0 *1 0,0
Rrel_1_n_t2 rel_1_n__t2 rel_1_n 125.307355693
* device instance rel_1_n r0 *1 0,0
Crel_1_n rel_1_n vsubs 4.320752e-15
* device instance rel_1_p_t0 r0 *1 0,0
Rrel_1_p_t0 rel_1_p__t0 rel_1_p 127.025622285
* device instance rel_1_p_t1 r0 *1 0,0
Rrel_1_p_t1 rel_1_p__t1 rel_1_p 14.1171220219
* device instance rel_1_p_t2 r0 *1 0,0
Rrel_1_p_t2 rel_1_p__t2 rel_1_p 125.307355693
* device instance rel_1_p r0 *1 0,0
Crel_1_p rel_1_p vsubs 4.320752e-15
* device instance rel_256_n_t0 r0 *1 0,0
Rrel_256_n_t0 rel_256_n__t0 rel_256_n 127.025622285
* device instance rel_256_n_t1 r0 *1 0,0
Rrel_256_n_t1 rel_256_n__t1 rel_256_n 14.1171220219
* device instance rel_256_n_t2 r0 *1 0,0
Rrel_256_n_t2 rel_256_n__t2 rel_256_n 125.307355693
* device instance rel_256_n r0 *1 0,0
Crel_256_n rel_256_n vsubs 4.320752e-15
* device instance rel_256_p_t0 r0 *1 0,0
Rrel_256_p_t0 rel_256_p__t0 rel_256_p 127.025622285
* device instance rel_256_p_t1 r0 *1 0,0
Rrel_256_p_t1 rel_256_p__t1 rel_256_p 14.1171220219
* device instance rel_256_p_t2 r0 *1 0,0
Rrel_256_p_t2 rel_256_p__t2 rel_256_p 125.307355693
* device instance rel_256_p r0 *1 0,0
Crel_256_p rel_256_p vsubs 4.320752e-15
* device instance rel_2_n_t0 r0 *1 0,0
Rrel_2_n_t0 rel_2_n__t0 rel_2_n 127.025622285
* device instance rel_2_n_t1 r0 *1 0,0
Rrel_2_n_t1 rel_2_n__t1 rel_2_n 14.1171220219
* device instance rel_2_n_t2 r0 *1 0,0
Rrel_2_n_t2 rel_2_n__t2 rel_2_n 125.307355693
* device instance rel_2_n r0 *1 0,0
Crel_2_n rel_2_n vsubs 4.320752e-15
* device instance rel_2_p_t0 r0 *1 0,0
Rrel_2_p_t0 rel_2_p__t0 rel_2_p 127.025622285
* device instance rel_2_p_t1 r0 *1 0,0
Rrel_2_p_t1 rel_2_p__t1 rel_2_p 14.1171220219
* device instance rel_2_p_t2 r0 *1 0,0
Rrel_2_p_t2 rel_2_p__t2 rel_2_p 125.307355693
* device instance rel_2_p r0 *1 0,0
Crel_2_p rel_2_p vsubs 4.320752e-15
* device instance rel_32_n_t0 r0 *1 0,0
Rrel_32_n_t0 rel_32_n__t0 rel_32_n 127.025622285
* device instance rel_32_n_t1 r0 *1 0,0
Rrel_32_n_t1 rel_32_n__t1 rel_32_n 14.1171220219
* device instance rel_32_n_t2 r0 *1 0,0
Rrel_32_n_t2 rel_32_n__t2 rel_32_n 125.307355693
* device instance rel_32_n r0 *1 0,0
Crel_32_n rel_32_n vsubs 4.320752e-15
* device instance rel_32_p_t0 r0 *1 0,0
Rrel_32_p_t0 rel_32_p__t0 rel_32_p 127.025622285
* device instance rel_32_p_t1 r0 *1 0,0
Rrel_32_p_t1 rel_32_p__t1 rel_32_p 14.1171220219
* device instance rel_32_p_t2 r0 *1 0,0
Rrel_32_p_t2 rel_32_p__t2 rel_32_p 125.307355693
* device instance rel_32_p r0 *1 0,0
Crel_32_p rel_32_p vsubs 4.320752e-15
* device instance rel_4_n_t0 r0 *1 0,0
Rrel_4_n_t0 rel_4_n__t0 rel_4_n 127.025622285
* device instance rel_4_n_t1 r0 *1 0,0
Rrel_4_n_t1 rel_4_n__t1 rel_4_n 14.1171220219
* device instance rel_4_n_t2 r0 *1 0,0
Rrel_4_n_t2 rel_4_n__t2 rel_4_n 125.307355693
* device instance rel_4_n r0 *1 0,0
Crel_4_n rel_4_n vsubs 4.320752e-15
* device instance rel_4_p_t0 r0 *1 0,0
Rrel_4_p_t0 rel_4_p__t0 rel_4_p 127.025622285
* device instance rel_4_p_t1 r0 *1 0,0
Rrel_4_p_t1 rel_4_p__t1 rel_4_p 14.1171220219
* device instance rel_4_p_t2 r0 *1 0,0
Rrel_4_p_t2 rel_4_p__t2 rel_4_p 125.307355693
* device instance rel_4_p r0 *1 0,0
Crel_4_p rel_4_p vsubs 4.320752e-15
* device instance rel_64_n_t0 r0 *1 0,0
Rrel_64_n_t0 rel_64_n__t0 rel_64_n 127.025622285
* device instance rel_64_n_t1 r0 *1 0,0
Rrel_64_n_t1 rel_64_n__t1 rel_64_n 14.1171220219
* device instance rel_64_n_t2 r0 *1 0,0
Rrel_64_n_t2 rel_64_n__t2 rel_64_n 125.307355693
* device instance rel_64_n r0 *1 0,0
Crel_64_n rel_64_n vsubs 4.320752e-15
* device instance rel_64_p_t0 r0 *1 0,0
Rrel_64_p_t0 rel_64_p__t0 rel_64_p 127.025622285
* device instance rel_64_p_t1 r0 *1 0,0
Rrel_64_p_t1 rel_64_p__t1 rel_64_p 14.1171220219
* device instance rel_64_p_t2 r0 *1 0,0
Rrel_64_p_t2 rel_64_p__t2 rel_64_p 125.307355693
* device instance rel_64_p r0 *1 0,0
Crel_64_p rel_64_p vsubs 4.320752e-15
* device instance rel_8_n_t0 r0 *1 0,0
Rrel_8_n_t0 rel_8_n__t0 rel_8_n 127.025622285
* device instance rel_8_n_t1 r0 *1 0,0
Rrel_8_n_t1 rel_8_n__t1 rel_8_n 14.1171220219
* device instance rel_8_n_t2 r0 *1 0,0
Rrel_8_n_t2 rel_8_n__t2 rel_8_n 125.307355693
* device instance rel_8_n r0 *1 0,0
Crel_8_n rel_8_n vsubs 4.320752e-15
* device instance rel_8_p_t0 r0 *1 0,0
Rrel_8_p_t0 rel_8_p__t0 rel_8_p 127.025622285
* device instance rel_8_p_t1 r0 *1 0,0
Rrel_8_p_t1 rel_8_p__t1 rel_8_p 14.1171220219
* device instance rel_8_p_t2 r0 *1 0,0
Rrel_8_p_t2 rel_8_p__t2 rel_8_p 125.307355693
* device instance rel_8_p r0 *1 0,0
Crel_8_p rel_8_p vsubs 4.320752e-15
* device instance sel_in_t0 r0 *1 0,0
Rsel_in_t0 sel_in__t0 sel_in 157.797645186
* device instance sel_in_t1 r0 *1 0,0
Rsel_in_t1 sel_in__t1 sel_in 148.648729445
* device instance sel_in_t2 r0 *1 0,0
Rsel_in_t2 sel_in__t2 sel_in 139.236537157
* device instance sel_in_t3 r0 *1 0,0
Rsel_in_t3 sel_in__t3 sel_in 30.6654078867
* device instance sel_in_t4 r0 *1 0,0
Rsel_in_t4 sel_in__t4 sel_in 30.4490443407
* device instance sel_in_t5 r0 *1 0,0
Rsel_in_t5 sel_in__t5 sel_in 16.2004021299
* device instance sel_in_t6 r0 *1 0,0
Rsel_in_t6 sel_in__t6 sel_in 121.056337038
* device instance sel_in_t7 r0 *1 0,0
Rsel_in_t7 sel_in__t7 sel_in 65.9995139608
* device instance sel_in_t8 r0 *1 0,0
Rsel_in_t8 sel_in__t8 sel_in 157.883944996
* device instance sel_in_t9 r0 *1 0,0
Rsel_in_t9 sel_in__t9 sel_in 157.842063937
* device instance sel_in_t10 r0 *1 0,0
Rsel_in_t10 sel_in__t10 sel_in 121.001709895
* device instance sel_in_t11 r0 *1 0,0
Rsel_in_t11 sel_in__t11 sel_in 84.2992576345
* device instance sel_in_t12 r0 *1 0,0
Rsel_in_t12 sel_in__t12 sel_in 48.1891399383
* device instance sel_in_t13 r0 *1 0,0
Rsel_in_t13 sel_in__t13 sel_in 84.37764975
* device instance sel_in_t14 r0 *1 0,0
Rsel_in_t14 sel_in__t14 sel_in 48.0517457372
* device instance sel_in_t15 r0 *1 0,0
Rsel_in_t15 sel_in__t15 sel_in 102.514188461
* device instance sel_in_t16 r0 *1 0,0
Rsel_in_t16 sel_in__t16 sel_in 65.8992632998
* device instance sel_in_t17 r0 *1 0,0
Rsel_in_t17 sel_in__t17 sel_in 139.28401279
* device instance sel_in_t18 r0 *1 0,0
Rsel_in_t18 sel_in__t18 sel_in 15.7870228217
* device instance sel_in_t19 r0 *1 0,0
Rsel_in_t19 sel_in__t19 sel_in 102.449674944
* device instance sel_in_t20 r0 *1 0,0
Rsel_in_t20 sel_in__t20 sel_in 14.003796355
* device instance sel_in_t21 r0 *1 0,0
Rsel_in_t21 sel_in__t21 sel_in 75.1359937022
* device instance sel_in_t22 r0 *1 0,0
Rsel_in_t22 sel_in__t22 sel_in 111.698499336
* device instance sel_in_t23 r0 *1 0,0
Rsel_in_t23 sel_in__t23 sel_in 111.461486602
* device instance sel_in_t24 r0 *1 0,0
Rsel_in_t24 sel_in__t24 sel_in 38.7174763814
* device instance sel_in_t25 r0 *1 0,0
Rsel_in_t25 sel_in__t25 sel_in 111.810802818
* device instance sel_in_t26 r0 *1 0,0
Rsel_in_t26 sel_in__t26 sel_in 75.1300264791
* device instance sel_in_t27 r0 *1 0,0
Rsel_in_t27 sel_in__t27 sel_in 39.7231957361
* device instance sel_in_t28 r0 *1 0,0
Rsel_in_t28 sel_in__t28 sel_in 74.7831919032
* device instance sel_in_t29 r0 *1 0,0
Rsel_in_t29 sel_in__t29 sel_in 148.826531653
* device instance sel_in_t30 r0 *1 0,0
Rsel_in_t30 sel_in__t30 sel_in 148.29853199
* device instance sel_in_t31 r0 *1 0,0
Rsel_in_t31 sel_in__t31 sel_in 39.0517671956
* device instance sel_in_t32 r0 *1 0,0
Rsel_in_t32 sel_in__t32 sel_in 11.9672283327
* device instance sel_in_t33 r0 *1 0,0
Rsel_in_t33 sel_in__t33 sel_in 75.4812071785
* device instance sel_in_t34 r0 *1 0,0
Rsel_in_t34 sel_in__t34 sel_in 148.476753564
* device instance sel_in_t35 r0 *1 0,0
Rsel_in_t35 sel_in__t35 sel_in 39.3946028756
* device instance sel_in_t36 r0 *1 0,0
Rsel_in_t36 sel_in__t36 sel_in 112.047076648
* device instance sel_in_t37 r0 *1 0,0
Rsel_in_t37 sel_in__t37 sel_in 102.502645232
* device instance sel_in_t38 r0 *1 0,0
Rsel_in_t38 sel_in__t38 sel_in 31.2748755219
* device instance sel_in_t39 r0 *1 0,0
Rsel_in_t39 sel_in__t39 sel_in 139.559245959
* device instance sel_in_t40 r0 *1 0,0
Rsel_in_t40 sel_in__t40 sel_in 139.322174957
* device instance sel_in_t41 r0 *1 0,0
Rsel_in_t41 sel_in__t41 sel_in 65.8830062688
* device instance sel_in_t42 r0 *1 0,0
Rsel_in_t42 sel_in__t42 sel_in 83.9775408175
* device instance sel_in_t43 r0 *1 0,0
Rsel_in_t43 sel_in__t43 sel_in 120.723972556
* device instance sel_in_t44 r0 *1 0,0
Rsel_in_t44 sel_in__t44 sel_in 14.8691007584
* device instance sel_in_t45 r0 *1 0,0
Rsel_in_t45 sel_in__t45 sel_in 16.9471193819
* device instance sel_in_t46 r0 *1 0,0
Rsel_in_t46 sel_in__t46 sel_in 48.3109331548
* device instance sel_in_t47 r0 *1 0,0
Rsel_in_t47 sel_in__t47 sel_in 47.6217551578
* device instance sel_in_t48 r0 *1 0,0
Rsel_in_t48 sel_in__t48 sel_in 30.1993897444
* device instance sel_in_t49 r0 *1 0,0
Rsel_in_t49 sel_in__t49 sel_in 102.824641879
* device instance sel_in_t50 r0 *1 0,0
Rsel_in_t50 sel_in__t50 sel_in 120.997488601
* device instance sel_in_t51 r0 *1 0,0
Rsel_in_t51 sel_in__t51 sel_in 66.3828683697
* device instance sel_in_t52 r0 *1 0,0
Rsel_in_t52 sel_in__t52 sel_in 84.3702676287
* device instance sel_in_t53 r0 *1 0,0
Rsel_in_t53 sel_in__t53 sel_in 157.58801391
* device instance sel_in r0 *1 0,0
Csel_in sel_in vsubs 1.11280818e-13
* device instance topn_t0 r0 *1 0,0
Rtopn_t0 topn__t0 topn 0.382165226954
* device instance topn_t1 r0 *1 0,0
Rtopn_t1 topn__t1 topn 1.57526024694
* device instance topn_t2 r0 *1 0,0
Rtopn_t2 topn__t2 topn 1.66573298021
* device instance topn_t3 r0 *1 0,0
Rtopn_t3 topn__t3 topn 1.53763181266
* device instance topn_t4 r0 *1 0,0
Rtopn_t4 topn__t4 topn 1.63019419306
* device instance topn_t5 r0 *1 0,0
Rtopn_t5 topn__t5 topn 1.45929289424
* device instance topn_t6 r0 *1 0,0
Rtopn_t6 topn__t6 topn 1.55652088549
* device instance topn_t7 r0 *1 0,0
Rtopn_t7 topn__t7 topn 1.61802825078
* device instance topn_t8 r0 *1 0,0
Rtopn_t8 topn__t8 topn 1.7062347248
* device instance topn_t9 r0 *1 0,0
Rtopn_t9 topn__t9 topn 0.347288281445
* device instance topn_t10 r0 *1 0,0
Rtopn_t10 topn__t10 topn 0.415672476475
* device instance topn_t11 r0 *1 0,0
Rtopn_t11 topn__t11 topn 0.340783443309
* device instance topn_t12 r0 *1 0,0
Rtopn_t12 topn__t12 topn 0.280927790058
* device instance topn_t13 r0 *1 0,0
Rtopn_t13 topn__t13 topn 0.247274769597
* device instance topn_t14 r0 *1 0,0
Rtopn_t14 topn__t14 topn 0.250612291378
* device instance topn_t15 r0 *1 0,0
Rtopn_t15 topn__t15 topn 0.289664547294
* device instance topn_t16 r0 *1 0,0
Rtopn_t16 topn__t16 topn 0.352763234744
* device instance topn_t17 r0 *1 0,0
Rtopn_t17 topn__t17 topn 0.429436339955
* device instance topn_t18 r0 *1 0,0
Rtopn_t18 topn__t18 topn 0.376441469286
* device instance topn_t19 r0 *1 0,0
Rtopn_t19 topn__t19 topn 0.426901077096
* device instance topn_t20 r0 *1 0,0
Rtopn_t20 topn__t20 topn 0.49215668228
* device instance topn_t21 r0 *1 0,0
Rtopn_t21 topn__t21 topn 0.467918935389
* device instance topn_t22 r0 *1 0,0
Rtopn_t22 topn__t22 topn 0.509396191509
* device instance topn_t23 r0 *1 0,0
Rtopn_t23 topn__t23 topn 0.56520628996
* device instance topn_t24 r0 *1 0,0
Rtopn_t24 topn__t24 topn 0.501174555789
* device instance topn_t25 r0 *1 0,0
Rtopn_t25 topn__t25 topn 0.462561350919
* device instance topn_t26 r0 *1 0,0
Rtopn_t26 topn__t26 topn 0.442930459345
* device instance topn_t27 r0 *1 0,0
Rtopn_t27 topn__t27 topn 0.444802316458
* device instance topn_t28 r0 *1 0,0
Rtopn_t28 topn__t28 topn 0.480193958248
* device instance topn_t29 r0 *1 0,0
Rtopn_t29 topn__t29 topn 0.60222493474
* device instance topn_t30 r0 *1 0,0
Rtopn_t30 topn__t30 topn 0.693513160426
* device instance topn_t31 r0 *1 0,0
Rtopn_t31 topn__t31 topn 0.786564336724
* device instance topn_t32 r0 *1 0,0
Rtopn_t32 topn__t32 topn 0.88081991825
* device instance topn_t33 r0 *1 0,0
Rtopn_t33 topn__t33 topn 0.975931002389
* device instance topn_t34 r0 *1 0,0
Rtopn_t34 topn__t34 topn 1.13292489383
* device instance topn_t35 r0 *1 0,0
Rtopn_t35 topn__t35 topn 1.07166983485
* device instance topn_t36 r0 *1 0,0
Rtopn_t36 topn__t36 topn 1.16788204408
* device instance topn_t37 r0 *1 0,0
Rtopn_t37 topn__t37 topn 1.26445957756
* device instance topn_t38 r0 *1 0,0
Rtopn_t38 topn__t38 topn 1.36132468506
* device instance topn_t39 r0 *1 0,0
Rtopn_t39 topn__t39 topn 0.554820861031
* device instance topn_t40 r0 *1 0,0
Rtopn_t40 topn__t40 topn 0.939487763114
* device instance topn_t41 r0 *1 0,0
Rtopn_t41 topn__t41 topn 0.853698074428
* device instance topn_t42 r0 *1 0,0
Rtopn_t42 topn__t42 topn 0.770973973609
* device instance topn_t43 r0 *1 0,0
Rtopn_t43 topn__t43 topn 0.692415088037
* device instance topn_t44 r0 *1 0,0
Rtopn_t44 topn__t44 topn 1.5823211473
* device instance topn_t45 r0 *1 0,0
Rtopn_t45 topn__t45 topn 1.52033033738
* device instance topn_t46 r0 *1 0,0
Rtopn_t46 topn__t46 topn 1.42179683386
* device instance topn_t47 r0 *1 0,0
Rtopn_t47 topn__t47 topn 1.323270743
* device instance topn_t48 r0 *1 0,0
Rtopn_t48 topn__t48 topn 1.22475385373
* device instance topn_t49 r0 *1 0,0
Rtopn_t49 topn__t49 topn 1.12624858074
* device instance topn_t50 r0 *1 0,0
Rtopn_t50 topn__t50 topn 1.02775826413
* device instance topn_t51 r0 *1 0,0
Rtopn_t51 topn__t51 topn 0.929287659349
* device instance topn_t52 r0 *1 0,0
Rtopn_t52 topn__t52 topn 0.830843775087
* device instance topn_t53 r0 *1 0,0
Rtopn_t53 topn__t53 topn 0.732437385613
* device instance topn_t54 r0 *1 0,0
Rtopn_t54 topn__t54 topn 0.634085948073
* device instance topn_t55 r0 *1 0,0
Rtopn_t55 topn__t55 topn 0.344887578086
* device instance topn_t56 r0 *1 0,0
Rtopn_t56 topn__t56 topn 1.48789855676
* device instance topn_t57 r0 *1 0,0
Rtopn_t57 topn__t57 topn 1.39405212876
* device instance topn_t58 r0 *1 0,0
Rtopn_t58 topn__t58 topn 1.55772278114
* device instance topn_t59 r0 *1 0,0
Rtopn_t59 topn__t59 topn 1.46171206635
* device instance topn_t60 r0 *1 0,0
Rtopn_t60 topn__t60 topn 1.36606785608
* device instance topn_t61 r0 *1 0,0
Rtopn_t61 topn__t61 topn 1.53905738459
* device instance topn_t62 r0 *1 0,0
Rtopn_t62 topn__t62 topn 1.44180426379
* device instance topn_t63 r0 *1 0,0
Rtopn_t63 topn__t63 topn 1.34474486709
* device instance topn_t64 r0 *1 0,0
Rtopn_t64 topn__t64 topn 1.24792439696
* device instance topn_t65 r0 *1 0,0
Rtopn_t65 topn__t65 topn 1.15140312833
* device instance topn_t66 r0 *1 0,0
Rtopn_t66 topn__t66 topn 1.05526316518
* device instance topn_t67 r0 *1 0,0
Rtopn_t67 topn__t67 topn 0.959619118255
* device instance topn_t68 r0 *1 0,0
Rtopn_t68 topn__t68 topn 0.864635574623
* device instance topn_t69 r0 *1 0,0
Rtopn_t69 topn__t69 topn 0.417056333212
* device instance topn_t70 r0 *1 0,0
Rtopn_t70 topn__t70 topn 0.369760805205
* device instance topn_t71 r0 *1 0,0
Rtopn_t71 topn__t71 topn 0.535819723137
* device instance topn_t72 r0 *1 0,0
Rtopn_t72 topn__t72 topn 0.858765636833
* device instance topn_t73 r0 *1 0,0
Rtopn_t73 topn__t73 topn 0.956073225252
* device instance topn_t74 r0 *1 0,0
Rtopn_t74 topn__t74 topn 1.0536180169
* device instance topn_t75 r0 *1 0,0
Rtopn_t75 topn__t75 topn 1.15133972375
* device instance topn_t76 r0 *1 0,0
Rtopn_t76 topn__t76 topn 1.24919682753
* device instance topn_t77 r0 *1 0,0
Rtopn_t77 topn__t77 topn 1.34715982303
* device instance topn_t78 r0 *1 0,0
Rtopn_t78 topn__t78 topn 0.552613403493
* device instance topn_t79 r0 *1 0,0
Rtopn_t79 topn__t79 topn 0.650897231045
* device instance topn_t80 r0 *1 0,0
Rtopn_t80 topn__t80 topn 0.749259739679
* device instance topn_t81 r0 *1 0,0
Rtopn_t81 topn__t81 topn 0.847673539804
* device instance topn_t82 r0 *1 0,0
Rtopn_t82 topn__t82 topn 0.946122625837
* device instance topn_t83 r0 *1 0,0
Rtopn_t83 topn__t83 topn 0.164686317567
* device instance topn_t84 r0 *1 0,0
Rtopn_t84 topn__t84 topn 0.260111385798
* device instance topn_t85 r0 *1 0,0
Rtopn_t85 topn__t85 topn 0.35725565539
* device instance topn_t86 r0 *1 0,0
Rtopn_t86 topn__t86 topn 0.0776051146797
* device instance topn_t87 r0 *1 0,0
Rtopn_t87 topn__t87 topn 1.31677659587
* device instance topn_t88 r0 *1 0,0
Rtopn_t88 topn__t88 topn 0.242569694998
* device instance topn_t89 r0 *1 0,0
Rtopn_t89 topn__t89 topn 0.147061636482
* device instance topn_t90 r0 *1 0,0
Rtopn_t90 topn__t90 topn 0.0620605621708
* device instance topn_t91 r0 *1 0,0
Rtopn_t91 topn__t91 topn 0.0742510760032
* device instance topn_t92 r0 *1 0,0
Rtopn_t92 topn__t92 topn 0.163132619843
* device instance topn_t93 r0 *1 0,0
Rtopn_t93 topn__t93 topn 0.259130471934
* device instance topn_t94 r0 *1 0,0
Rtopn_t94 topn__t94 topn 0.356542103785
* device instance topn_t95 r0 *1 0,0
Rtopn_t95 topn__t95 topn 0.34058720019
* device instance topn_t96 r0 *1 0,0
Rtopn_t96 topn__t96 topn 0.366631011125
* device instance topn_t97 r0 *1 0,0
Rtopn_t97 topn__t97 topn 0.278869227154
* device instance topn_t98 r0 *1 0,0
Rtopn_t98 topn__t98 topn 0.201383002874
* device instance topn_t99 r0 *1 0,0
Rtopn_t99 topn__t99 topn 0.150928798772
* device instance topn_t100 r0 *1 0,0
Rtopn_t100 topn__t100 topn 0.156336851732
* device instance topn_t101 r0 *1 0,0
Rtopn_t101 topn__t101 topn 0.213401594602
* device instance topn_t102 r0 *1 0,0
Rtopn_t102 topn__t102 topn 0.29338812247
* device instance topn_t103 r0 *1 0,0
Rtopn_t103 topn__t103 topn 0.339838652005
* device instance topn_t104 r0 *1 0,0
Rtopn_t104 topn__t104 topn 0.868173966404
* device instance topn_t105 r0 *1 0,0
Rtopn_t105 topn__t105 topn 0.648442365875
* device instance topn_t106 r0 *1 0,0
Rtopn_t106 topn__t106 topn 1.04282496209
* device instance topn_t107 r0 *1 0,0
Rtopn_t107 topn__t107 topn 0.734004859333
* device instance topn_t108 r0 *1 0,0
Rtopn_t108 topn__t108 topn 0.822487741942
* device instance topn_t109 r0 *1 0,0
Rtopn_t109 topn__t109 topn 0.913042363872
* device instance topn_t110 r0 *1 0,0
Rtopn_t110 topn__t110 topn 1.00510892507
* device instance topn_t111 r0 *1 0,0
Rtopn_t111 topn__t111 topn 1.09830727247
* device instance topn_t112 r0 *1 0,0
Rtopn_t112 topn__t112 topn 1.1923720471
* device instance topn_t113 r0 *1 0,0
Rtopn_t113 topn__t113 topn 1.28711330237
* device instance topn_t114 r0 *1 0,0
Rtopn_t114 topn__t114 topn 1.38239195889
* device instance topn_t115 r0 *1 0,0
Rtopn_t115 topn__t115 topn 1.4100522963
* device instance topn_t116 r0 *1 0,0
Rtopn_t116 topn__t116 topn 0.95440364025
* device instance topn_t117 r0 *1 0,0
Rtopn_t117 topn__t117 topn 0.705490929891
* device instance topn_t118 r0 *1 0,0
Rtopn_t118 topn__t118 topn 1.22433289959
* device instance topn_t119 r0 *1 0,0
Rtopn_t119 topn__t119 topn 0.761786155312
* device instance topn_t120 r0 *1 0,0
Rtopn_t120 topn__t120 topn 1.04459702116
* device instance topn_t121 r0 *1 0,0
Rtopn_t121 topn__t121 topn 1.14309018479
* device instance topn_t122 r0 *1 0,0
Rtopn_t122 topn__t122 topn 1.2415976502
* device instance topn_t123 r0 *1 0,0
Rtopn_t123 topn__t123 topn 1.34011626356
* device instance topn_t124 r0 *1 0,0
Rtopn_t124 topn__t124 topn 0.553074050428
* device instance topn_t125 r0 *1 0,0
Rtopn_t125 topn__t125 topn 0.651288366946
* device instance topn_t126 r0 *1 0,0
Rtopn_t126 topn__t126 topn 0.749599552455
* device instance topn_t127 r0 *1 0,0
Rtopn_t127 topn__t127 topn 0.847973915648
* device instance topn_t128 r0 *1 0,0
Rtopn_t128 topn__t128 topn 0.946391755384
* device instance topn_t129 r0 *1 0,0
Rtopn_t129 topn__t129 topn 1.04484078603
* device instance topn_t130 r0 *1 0,0
Rtopn_t130 topn__t130 topn 1.14331295021
* device instance topn_t131 r0 *1 0,0
Rtopn_t131 topn__t131 topn 1.24180274461
* device instance topn_t132 r0 *1 0,0
Rtopn_t132 topn__t132 topn 1.34030628268
* device instance topn_t133 r0 *1 0,0
Rtopn_t133 topn__t133 topn 0.569481836973
* device instance topn_t134 r0 *1 0,0
Rtopn_t134 topn__t134 topn 0.665278283355
* device instance topn_t135 r0 *1 0,0
Rtopn_t135 topn__t135 topn 0.784858639388
* device instance topn_t136 r0 *1 0,0
Rtopn_t136 topn__t136 topn 1.02757551171
* device instance topn_t137 r0 *1 0,0
Rtopn_t137 topn__t137 topn 1.50552836488
* device instance topn_t138 r0 *1 0,0
Rtopn_t138 topn__t138 topn 1.57530268834
* device instance topn_t139 r0 *1 0,0
Rtopn_t139 topn__t139 topn 1.47930965119
* device instance topn_t140 r0 *1 0,0
Rtopn_t140 topn__t140 topn 1.59994911583
* device instance topn_t141 r0 *1 0,0
Rtopn_t141 topn__t141 topn 1.08230447548
* device instance topn_t142 r0 *1 0,0
Rtopn_t142 topn__t142 topn 1.5265426046
* device instance topn_t143 r0 *1 0,0
Rtopn_t143 topn__t143 topn 1.42843768702
* device instance topn_t144 r0 *1 0,0
Rtopn_t144 topn__t144 topn 1.33040349075
* device instance topn_t145 r0 *1 0,0
Rtopn_t145 topn__t145 topn 1.2324568922
* device instance topn_t146 r0 *1 0,0
Rtopn_t146 topn__t146 topn 1.13462057735
* device instance topn_t147 r0 *1 0,0
Rtopn_t147 topn__t147 topn 1.03692576321
* device instance topn_t148 r0 *1 0,0
Rtopn_t148 topn__t148 topn 1.52049783502
* device instance topn_t149 r0 *1 0,0
Rtopn_t149 topn__t149 topn 1.42197593802
* device instance topn_t150 r0 *1 0,0
Rtopn_t150 topn__t150 topn 1.32346318075
* device instance topn_t151 r0 *1 0,0
Rtopn_t151 topn__t151 topn 1.22496176828
* device instance topn_t152 r0 *1 0,0
Rtopn_t152 topn__t152 topn 1.12647467666
* device instance topn_t153 r0 *1 0,0
Rtopn_t153 topn__t153 topn 1.02800602188
* device instance topn_t154 r0 *1 0,0
Rtopn_t154 topn__t154 topn 0.929561663019
* device instance topn_t155 r0 *1 0,0
Rtopn_t155 topn__t155 topn 0.831150233194
* device instance topn_t156 r0 *1 0,0
Rtopn_t156 topn__t156 topn 0.634487447536
* device instance topn_t157 r0 *1 0,0
Rtopn_t157 topn__t157 topn 0.536294795089
* device instance topn_t158 r0 *1 0,0
Rtopn_t158 topn__t158 topn 0.939416597011
* device instance topn_t159 r0 *1 0,0
Rtopn_t159 topn__t159 topn 0.842157566922
* device instance topn_t160 r0 *1 0,0
Rtopn_t160 topn__t160 topn 0.745246612045
* device instance topn_t161 r0 *1 0,0
Rtopn_t161 topn__t161 topn 0.648839717084
* device instance topn_t162 r0 *1 0,0
Rtopn_t162 topn__t162 topn 0.553200474172
* device instance topn_t163 r0 *1 0,0
Rtopn_t163 topn__t163 topn 0.989278263159
* device instance topn_t164 r0 *1 0,0
Rtopn_t164 topn__t164 topn 0.897439305325
* device instance topn_t165 r0 *1 0,0
Rtopn_t165 topn__t165 topn 0.807192945946
* device instance topn_t166 r0 *1 0,0
Rtopn_t166 topn__t166 topn 0.719139011377
* device instance topn_t167 r0 *1 0,0
Rtopn_t167 topn__t167 topn 0.634191377932
* device instance topn_t168 r0 *1 0,0
Rtopn_t168 topn__t168 topn 1.30090656108
* device instance topn_t169 r0 *1 0,0
Rtopn_t169 topn__t169 topn 1.20862390514
* device instance topn_t170 r0 *1 0,0
Rtopn_t170 topn__t170 topn 1.11741797369
* device instance topn_t171 r0 *1 0,0
Rtopn_t171 topn__t171 topn 0.732784999424
* device instance topn_t172 r0 *1 0,0
Rtopn_t172 topn__t172 topn 1.4457357223
* device instance topn_t173 r0 *1 0,0
Rtopn_t173 topn__t173 topn 1.54381776597
* device instance topn_t174 r0 *1 0,0
Rtopn_t174 topn__t174 topn 1.17623628314
* device instance topn_t175 r0 *1 0,0
Rtopn_t175 topn__t175 topn 1.27087290095
* device instance topn_t176 r0 *1 0,0
Rtopn_t176 topn__t176 topn 0.586852685096
* device instance topn_t177 r0 *1 0,0
Rtopn_t177 topn__t177 topn 0.677759756732
* device instance topn_t178 r0 *1 0,0
Rtopn_t178 topn__t178 topn 0.770556826033
* device instance topn_t179 r0 *1 0,0
Rtopn_t179 topn__t179 topn 0.623295872432
* device instance topn_t180 r0 *1 0,0
Rtopn_t180 topn__t180 topn 0.69727589835
* device instance topn_t181 r0 *1 0,0
Rtopn_t181 topn__t181 topn 0.776741226348
* device instance topn_t182 r0 *1 0,0
Rtopn_t182 topn__t182 topn 0.86017295206
* device instance topn_t183 r0 *1 0,0
Rtopn_t183 topn__t183 topn 1.05646912188
* device instance topn_t184 r0 *1 0,0
Rtopn_t184 topn__t184 topn 1.15250849091
* device instance topn_t185 r0 *1 0,0
Rtopn_t185 topn__t185 topn 1.24894433751
* device instance topn_t186 r0 *1 0,0
Rtopn_t186 topn__t186 topn 1.34569142646
* device instance topn_t187 r0 *1 0,0
Rtopn_t187 topn__t187 topn 1.44268714307
* device instance topn_t188 r0 *1 0,0
Rtopn_t188 topn__t188 topn 1.53988450565
* device instance topn_t189 r0 *1 0,0
Rtopn_t189 topn__t189 topn 0.589018447664
* device instance topn_t190 r0 *1 0,0
Rtopn_t190 topn__t190 topn 0.636996094652
* device instance topn_t191 r0 *1 0,0
Rtopn_t191 topn__t191 topn 0.721613635156
* device instance topn_t192 r0 *1 0,0
Rtopn_t192 topn__t192 topn 0.809398401742
* device instance topn_t193 r0 *1 0,0
Rtopn_t193 topn__t193 topn 0.513875922529
* device instance topn_t194 r0 *1 0,0
Rtopn_t194 topn__t194 topn 0.991078605721
* device instance topn_t195 r0 *1 0,0
Rtopn_t195 topn__t195 topn 1.083950321
* device instance topn_t196 r0 *1 0,0
Rtopn_t196 topn__t196 topn 1.17775087116
* device instance topn_t197 r0 *1 0,0
Rtopn_t197 topn__t197 topn 1.27227483317
* device instance topn_t198 r0 *1 0,0
Rtopn_t198 topn__t198 topn 1.3673721908
* device instance topn_t199 r0 *1 0,0
Rtopn_t199 topn__t199 topn 1.46293112814
* device instance topn_t200 r0 *1 0,0
Rtopn_t200 topn__t200 topn 1.55886676264
* device instance topn_t201 r0 *1 0,0
Rtopn_t201 topn__t201 topn 0.679635891879
* device instance topn_t202 r0 *1 0,0
Rtopn_t202 topn__t202 topn 0.695717354946
* device instance topn_t203 r0 *1 0,0
Rtopn_t203 topn__t203 topn 0.773941116503
* device instance topn_t204 r0 *1 0,0
Rtopn_t204 topn__t204 topn 0.856378646461
* device instance topn_t205 r0 *1 0,0
Rtopn_t205 topn__t205 topn 0.941924222468
* device instance topn_t206 r0 *1 0,0
Rtopn_t206 topn__t206 topn 1.02980358131
* device instance topn_t207 r0 *1 0,0
Rtopn_t207 topn__t207 topn 1.11946724461
* device instance topn_t208 r0 *1 0,0
Rtopn_t208 topn__t208 topn 1.21051878461
* device instance topn_t209 r0 *1 0,0
Rtopn_t209 topn__t209 topn 0.899423497303
* device instance topn_t210 r0 *1 0,0
Rtopn_t210 topn__t210 topn 1.48359001758
* device instance topn_t211 r0 *1 0,0
Rtopn_t211 topn__t211 topn 0.779633409731
* device instance topn_t212 r0 *1 0,0
Rtopn_t212 topn__t212 topn 0.898439051886
* device instance topn_t213 r0 *1 0,0
Rtopn_t213 topn__t213 topn 0.832003915924
* device instance topn_t214 r0 *1 0,0
Rtopn_t214 topn__t214 topn 0.90982549304
* device instance topn_t215 r0 *1 0,0
Rtopn_t215 topn__t215 topn 1.68881141245
* device instance topn_t216 r0 *1 0,0
Rtopn_t216 topn__t216 topn 1.60068294452
* device instance topn_t217 r0 *1 0,0
Rtopn_t217 topn__t217 topn 1.03766229238
* device instance topn_t218 r0 *1 0,0
Rtopn_t218 topn__t218 topn 1.51384448057
* device instance topn_t219 r0 *1 0,0
Rtopn_t219 topn__t219 topn 1.13529372814
* device instance topn_t220 r0 *1 0,0
Rtopn_t220 topn__t220 topn 1.23307663418
* device instance topn_t221 r0 *1 0,0
Rtopn_t221 topn__t221 topn 1.33097762671
* device instance topn_t222 r0 *1 0,0
Rtopn_t222 topn__t222 topn 1.42897243511
* device instance topn_t223 r0 *1 0,0
Rtopn_t223 topn__t223 topn 1.52704299818
* device instance topn_t224 r0 *1 0,0
Rtopn_t224 topn__t224 topn 1.42853129273
* device instance topn_t225 r0 *1 0,0
Rtopn_t225 topn__t225 topn 0.55699114106
* device instance topn_t226 r0 *1 0,0
Rtopn_t226 topn__t226 topn 1.26371147877
* device instance topn_t227 r0 *1 0,0
Rtopn_t227 topn__t227 topn 1.18501274504
* device instance topn_t228 r0 *1 0,0
Rtopn_t228 topn__t228 topn 1.10949584528
* device instance topn_t229 r0 *1 0,0
Rtopn_t229 topn__t229 topn 1.03785556602
* device instance topn_t230 r0 *1 0,0
Rtopn_t230 topn__t230 topn 0.97095038062
* device instance topn_t231 r0 *1 0,0
Rtopn_t231 topn__t231 topn 1.64819054577
* device instance topn_t232 r0 *1 0,0
Rtopn_t232 topn__t232 topn 1.55776570035
* device instance topn_t233 r0 *1 0,0
Rtopn_t233 topn__t233 topn 1.46839136462
* device instance topn_t234 r0 *1 0,0
Rtopn_t234 topn__t234 topn 1.38027161915
* device instance topn_t235 r0 *1 0,0
Rtopn_t235 topn__t235 topn 1.29366286413
* device instance topn_t236 r0 *1 0,0
Rtopn_t236 topn__t236 topn 1.20888989983
* device instance topn_t237 r0 *1 0,0
Rtopn_t237 topn__t237 topn 1.12636729988
* device instance topn_t238 r0 *1 0,0
Rtopn_t238 topn__t238 topn 1.04662749773
* device instance topn_t239 r0 *1 0,0
Rtopn_t239 topn__t239 topn 0.970356771633
* device instance topn_t240 r0 *1 0,0
Rtopn_t240 topn__t240 topn 0.501415833722
* device instance topn_t241 r0 *1 0,0
Rtopn_t241 topn__t241 topn 1.34503364929
* device instance topn_t242 r0 *1 0,0
Rtopn_t242 topn__t242 topn 1.04152971584
* device instance topn_t243 r0 *1 0,0
Rtopn_t243 topn__t243 topn 1.11293351272
* device instance topn_t244 r0 *1 0,0
Rtopn_t244 topn__t244 topn 1.18823195503
* device instance topn_t245 r0 *1 0,0
Rtopn_t245 topn__t245 topn 1.26673070328
* device instance topn_t246 r0 *1 0,0
Rtopn_t246 topn__t246 topn 1.3478707248
* device instance topn_t247 r0 *1 0,0
Rtopn_t247 topn__t247 topn 1.43120286031
* device instance topn_t248 r0 *1 0,0
Rtopn_t248 topn__t248 topn 1.51636574889
* device instance topn_t249 r0 *1 0,0
Rtopn_t249 topn__t249 topn 1.60306764109
* device instance topn_t250 r0 *1 0,0
Rtopn_t250 topn__t250 topn 1.69107183759
* device instance topn_t251 r0 *1 0,0
Rtopn_t251 topn__t251 topn 0.472791829379
* device instance topn_t252 r0 *1 0,0
Rtopn_t252 topn__t252 topn 0.449925643365
* device instance topn_t253 r0 *1 0,0
Rtopn_t253 topn__t253 topn 0.448075189725
* device instance topn_t254 r0 *1 0,0
Rtopn_t254 topn__t254 topn 0.467490093152
* device instance topn_t255 r0 *1 0,0
Rtopn_t255 topn__t255 topn 0.505727119306
* device instance topn_t256 r0 *1 0,0
Rtopn_t256 topn__t256 topn 0.558936643697
* device instance topn_t257 r0 *1 0,0
Rtopn_t257 topn__t257 topn 1.30266721172
* device instance topn_t258 r0 *1 0,0
Rtopn_t258 topn__t258 topn 0.707918822053
* device instance topn_t259 r0 *1 0,0
Rtopn_t259 topn__t259 topn 0.570258284828
* device instance topn_t260 r0 *1 0,0
Rtopn_t260 topn__t260 topn 0.786309298498
* device instance topn_t261 r0 *1 0,0
Rtopn_t261 topn__t261 topn 0.868822702081
* device instance topn_t262 r0 *1 0,0
Rtopn_t262 topn__t262 topn 1.41167682638
* device instance topn_t263 r0 *1 0,0
Rtopn_t263 topn__t263 topn 1.31851605499
* device instance topn_t264 r0 *1 0,0
Rtopn_t264 topn__t264 topn 1.22620350385
* device instance topn_t265 r0 *1 0,0
Rtopn_t265 topn__t265 topn 1.13494616563
* device instance topn_t266 r0 *1 0,0
Rtopn_t266 topn__t266 topn 1.04502051912
* device instance topn_t267 r0 *1 0,0
Rtopn_t267 topn__t267 topn 0.956802117657
* device instance topn_t268 r0 *1 0,0
Rtopn_t268 topn__t268 topn 0.870809979142
* device instance topn_t269 r0 *1 0,0
Rtopn_t269 topn__t269 topn 0.787773487528
* device instance topn_t270 r0 *1 0,0
Rtopn_t270 topn__t270 topn 0.708732273846
* device instance topn_t271 r0 *1 0,0
Rtopn_t271 topn__t271 topn 0.635179600418
* device instance topn_t272 r0 *1 0,0
Rtopn_t272 topn__t272 topn 0.56924698861
* device instance topn_t273 r0 *1 0,0
Rtopn_t273 topn__t273 topn 0.516113571322
* device instance topn_t274 r0 *1 0,0
Rtopn_t274 topn__t274 topn 1.39569528248
* device instance topn_t275 r0 *1 0,0
Rtopn_t275 topn__t275 topn 1.48943818235
* device instance topn_t276 r0 *1 0,0
Rtopn_t276 topn__t276 topn 0.772467230846
* device instance topn_t277 r0 *1 0,0
Rtopn_t277 topn__t277 topn 0.855720476793
* device instance topn_t278 r0 *1 0,0
Rtopn_t278 topn__t278 topn 1.58376898474
* device instance topn_t279 r0 *1 0,0
Rtopn_t279 topn__t279 topn 0.77220753676
* device instance topn_t280 r0 *1 0,0
Rtopn_t280 topn__t280 topn 0.762704773686
* device instance topn_t281 r0 *1 0,0
Rtopn_t281 topn__t281 topn 0.834674059525
* device instance topn_t282 r0 *1 0,0
Rtopn_t282 topn__t282 topn 0.911636067707
* device instance topn_t283 r0 *1 0,0
Rtopn_t283 topn__t283 topn 0.992429934404
* device instance topn_t284 r0 *1 0,0
Rtopn_t284 topn__t284 topn 1.07619298916
* device instance topn_t285 r0 *1 0,0
Rtopn_t285 topn__t285 topn 1.16228346181
* device instance topn_t286 r0 *1 0,0
Rtopn_t286 topn__t286 topn 1.25022064522
* device instance topn_t287 r0 *1 0,0
Rtopn_t287 topn__t287 topn 1.33964092141
* device instance topn_t288 r0 *1 0,0
Rtopn_t288 topn__t288 topn 1.43026614844
* device instance topn_t289 r0 *1 0,0
Rtopn_t289 topn__t289 topn 0.974876717682
* device instance topn_t290 r0 *1 0,0
Rtopn_t290 topn__t290 topn 1.61431723365
* device instance topn_t291 r0 *1 0,0
Rtopn_t291 topn__t291 topn 0.866106999503
* device instance topn_t292 r0 *1 0,0
Rtopn_t292 topn__t292 topn 0.835973579781
* device instance topn_t293 r0 *1 0,0
Rtopn_t293 topn__t293 topn 0.902116422604
* device instance topn_t294 r0 *1 0,0
Rtopn_t294 topn__t294 topn 0.973762586174
* device instance topn_t295 r0 *1 0,0
Rtopn_t295 topn__t295 topn 1.04978589674
* device instance topn_t296 r0 *1 0,0
Rtopn_t296 topn__t296 topn 1.12930270707
* device instance topn_t297 r0 *1 0,0
Rtopn_t297 topn__t297 topn 1.21162539586
* device instance topn_t298 r0 *1 0,0
Rtopn_t298 topn__t298 topn 1.29621947062
* device instance topn_t299 r0 *1 0,0
Rtopn_t299 topn__t299 topn 1.38266809199
* device instance topn_t300 r0 *1 0,0
Rtopn_t300 topn__t300 topn 1.47064424986
* device instance topn_t301 r0 *1 0,0
Rtopn_t301 topn__t301 topn 1.55988951121
* device instance topn_t302 r0 *1 0,0
Rtopn_t302 topn__t302 topn 1.65019798362
* device instance topn_t303 r0 *1 0,0
Rtopn_t303 topn__t303 topn 0.960945112795
* device instance topn_t304 r0 *1 0,0
Rtopn_t304 topn__t304 topn 0.914014442358
* device instance topn_t305 r0 *1 0,0
Rtopn_t305 topn__t305 topn 1.52188108369
* device instance topn_t306 r0 *1 0,0
Rtopn_t306 topn__t306 topn 1.62847488779
* device instance topn_t307 r0 *1 0,0
Rtopn_t307 topn__t307 topn 1.53580888928
* device instance topn_t308 r0 *1 0,0
Rtopn_t308 topn__t308 topn 1.44392685031
* device instance topn_t309 r0 *1 0,0
Rtopn_t309 topn__t309 topn 1.35298849743
* device instance topn_t310 r0 *1 0,0
Rtopn_t310 topn__t310 topn 1.26319765665
* device instance topn_t311 r0 *1 0,0
Rtopn_t311 topn__t311 topn 1.17481746915
* device instance topn_t312 r0 *1 0,0
Rtopn_t312 topn__t312 topn 1.08819169833
* device instance topn_t313 r0 *1 0,0
Rtopn_t313 topn__t313 topn 1.00377466559
* device instance topn_t314 r0 *1 0,0
Rtopn_t314 topn__t314 topn 0.922173143557
* device instance topn_t315 r0 *1 0,0
Rtopn_t315 topn__t315 topn 0.844203976879
* device instance topn_t316 r0 *1 0,0
Rtopn_t316 topn__t316 topn 0.770969988336
* device instance topn_t317 r0 *1 0,0
Rtopn_t317 topn__t317 topn 0.703950574765
* device instance topn_t318 r0 *1 0,0
Rtopn_t318 topn__t318 topn 0.645085591969
* device instance topn_t319 r0 *1 0,0
Rtopn_t319 topn__t319 topn 0.596792887592
* device instance topn_t320 r0 *1 0,0
Rtopn_t320 topn__t320 topn 0.56180548311
* device instance topn_t321 r0 *1 0,0
Rtopn_t321 topn__t321 topn 1.3952392144
* device instance topn_t322 r0 *1 0,0
Rtopn_t322 topn__t322 topn 0.541169716976
* device instance topn_t323 r0 *1 0,0
Rtopn_t323 topn__t323 topn 0.55735112283
* device instance topn_t324 r0 *1 0,0
Rtopn_t324 topn__t324 topn 0.589790815566
* device instance topn_t325 r0 *1 0,0
Rtopn_t325 topn__t325 topn 0.636005863646
* device instance topn_t326 r0 *1 0,0
Rtopn_t326 topn__t326 topn 0.693246732063
* device instance topn_t327 r0 *1 0,0
Rtopn_t327 topn__t327 topn 0.75902300683
* device instance topn_t328 r0 *1 0,0
Rtopn_t328 topn__t328 topn 0.831311096244
* device instance topn_t329 r0 *1 0,0
Rtopn_t329 topn__t329 topn 0.908558018532
* device instance topn_t330 r0 *1 0,0
Rtopn_t330 topn__t330 topn 0.989603217354
* device instance topn_t331 r0 *1 0,0
Rtopn_t331 topn__t331 topn 1.07358684
* device instance topn_t332 r0 *1 0,0
Rtopn_t332 topn__t332 topn 1.1598707681
* device instance topn_t333 r0 *1 0,0
Rtopn_t333 topn__t333 topn 1.24797797049
* device instance topn_t334 r0 *1 0,0
Rtopn_t334 topn__t334 topn 1.33754818658
* device instance topn_t335 r0 *1 0,0
Rtopn_t335 topn__t335 topn 1.42830620263
* device instance topn_t336 r0 *1 0,0
Rtopn_t336 topn__t336 topn 1.5200392712
* device instance topn_t337 r0 *1 0,0
Rtopn_t337 topn__t337 topn 0.542702839022
* device instance topn_t338 r0 *1 0,0
Rtopn_t338 topn__t338 topn 0.919815865162
* device instance topn_t339 r0 *1 0,0
Rtopn_t339 topn__t339 topn 0.982011638152
* device instance topn_t340 r0 *1 0,0
Rtopn_t340 topn__t340 topn 1.04979512744
* device instance topn_t341 r0 *1 0,0
Rtopn_t341 topn__t341 topn 1.12215421497
* device instance topn_t342 r0 *1 0,0
Rtopn_t342 topn__t342 topn 1.19826027023
* device instance topn_t343 r0 *1 0,0
Rtopn_t343 topn__t343 topn 1.27744377125
* device instance topn_t344 r0 *1 0,0
Rtopn_t344 topn__t344 topn 1.35916695908
* device instance topn_t345 r0 *1 0,0
Rtopn_t345 topn__t345 topn 1.44299839815
* device instance topn_t346 r0 *1 0,0
Rtopn_t346 topn__t346 topn 1.52859126386
* device instance topn_t347 r0 *1 0,0
Rtopn_t347 topn__t347 topn 0.810043184948
* device instance topn_t348 r0 *1 0,0
Rtopn_t348 topn__t348 topn 0.774286580676
* device instance topn_t349 r0 *1 0,0
Rtopn_t349 topn__t349 topn 0.749871173608
* device instance topn_t350 r0 *1 0,0
Rtopn_t350 topn__t350 topn 0.737923549875
* device instance topn_t351 r0 *1 0,0
Rtopn_t351 topn__t351 topn 0.73904862788
* device instance topn_t352 r0 *1 0,0
Rtopn_t352 topn__t352 topn 0.753187827663
* device instance topn_t353 r0 *1 0,0
Rtopn_t353 topn__t353 topn 1.61258100074
* device instance topn_t354 r0 *1 0,0
Rtopn_t354 topn__t354 topn 0.681151816662
* device instance topn_t355 r0 *1 0,0
Rtopn_t355 topn__t355 topn 0.653264774295
* device instance topn_t356 r0 *1 0,0
Rtopn_t356 topn__t356 topn 0.639514858144
* device instance topn_t357 r0 *1 0,0
Rtopn_t357 topn__t357 topn 0.640812736061
* device instance topn_t358 r0 *1 0,0
Rtopn_t358 topn__t358 topn 0.657069244499
* device instance topn_t359 r0 *1 0,0
Rtopn_t359 topn__t359 topn 0.687223647654
* device instance topn_t360 r0 *1 0,0
Rtopn_t360 topn__t360 topn 0.729554667027
* device instance topn_t361 r0 *1 0,0
Rtopn_t361 topn__t361 topn 0.782087592873
* device instance topn_t362 r0 *1 0,0
Rtopn_t362 topn__t362 topn 0.842917145472
* device instance topn_t363 r0 *1 0,0
Rtopn_t363 topn__t363 topn 0.910381758271
* device instance topn_t364 r0 *1 0,0
Rtopn_t364 topn__t364 topn 0.983116421343
* device instance topn_t365 r0 *1 0,0
Rtopn_t365 topn__t365 topn 1.06003687223
* device instance topn_t366 r0 *1 0,0
Rtopn_t366 topn__t366 topn 1.14029634899
* device instance topn_t367 r0 *1 0,0
Rtopn_t367 topn__t367 topn 1.22323778434
* device instance topn_t368 r0 *1 0,0
Rtopn_t368 topn__t368 topn 1.30835121851
* device instance topn_t369 r0 *1 0,0
Rtopn_t369 topn__t369 topn 0.721538668268
* device instance topn_t370 r0 *1 0,0
Rtopn_t370 topn__t370 topn 0.619607747498
* device instance topn_t371 r0 *1 0,0
Rtopn_t371 topn__t371 topn 0.553781374246
* device instance topn_t372 r0 *1 0,0
Rtopn_t372 topn__t372 topn 0.498869903504
* device instance topn_t373 r0 *1 0,0
Rtopn_t373 topn__t373 topn 0.458809188271
* device instance topn_t374 r0 *1 0,0
Rtopn_t374 topn__t374 topn 0.437696107271
* device instance topn_t375 r0 *1 0,0
Rtopn_t375 topn__t375 topn 0.438277553449
* device instance topn_t376 r0 *1 0,0
Rtopn_t376 topn__t376 topn 1.34772682076
* device instance topn_t377 r0 *1 0,0
Rtopn_t377 topn__t377 topn 1.2498082687
* device instance topn_t378 r0 *1 0,0
Rtopn_t378 topn__t378 topn 1.15200310508
* device instance topn_t379 r0 *1 0,0
Rtopn_t379 topn__t379 topn 1.05434288547
* device instance topn_t380 r0 *1 0,0
Rtopn_t380 topn__t380 topn 0.956871990735
* device instance topn_t381 r0 *1 0,0
Rtopn_t381 topn__t381 topn 0.859654822365
* device instance topn_t382 r0 *1 0,0
Rtopn_t382 topn__t382 topn 0.762788398598
* device instance topn_t383 r0 *1 0,0
Rtopn_t383 topn__t383 topn 0.666425681464
* device instance topn_t384 r0 *1 0,0
Rtopn_t384 topn__t384 topn 0.570821826188
* device instance topn_t385 r0 *1 0,0
Rtopn_t385 topn__t385 topn 0.864414781572
* device instance topn_t386 r0 *1 0,0
Rtopn_t386 topn__t386 topn 0.384159153612
* device instance topn_t387 r0 *1 0,0
Rtopn_t387 topn__t387 topn 0.295980717306
* device instance topn_t388 r0 *1 0,0
Rtopn_t388 topn__t388 topn 0.216952149538
* device instance topn_t389 r0 *1 0,0
Rtopn_t389 topn__t389 topn 0.161149637976
* device instance topn_t390 r0 *1 0,0
Rtopn_t390 topn__t390 topn 0.155908617174
* device instance topn_t391 r0 *1 0,0
Rtopn_t391 topn__t391 topn 0.205141678986
* device instance topn_t392 r0 *1 0,0
Rtopn_t392 topn__t392 topn 0.281595526356
* device instance topn_t393 r0 *1 0,0
Rtopn_t393 topn__t393 topn 0.368708954229
* device instance topn_t394 r0 *1 0,0
Rtopn_t394 topn__t394 topn 0.460471351826
* device instance topn_t395 r0 *1 0,0
Rtopn_t395 topn__t395 topn 0.554579804208
* device instance topn_t396 r0 *1 0,0
Rtopn_t396 topn__t396 topn 0.650016132935
* device instance topn_t397 r0 *1 0,0
Rtopn_t397 topn__t397 topn 0.746271068296
* device instance topn_t398 r0 *1 0,0
Rtopn_t398 topn__t398 topn 0.843064269278
* device instance topn_t399 r0 *1 0,0
Rtopn_t399 topn__t399 topn 0.940229513125
* device instance topn_t400 r0 *1 0,0
Rtopn_t400 topn__t400 topn 0.817191485427
* device instance topn_t401 r0 *1 0,0
Rtopn_t401 topn__t401 topn 0.476433884237
* device instance topn_t402 r0 *1 0,0
Rtopn_t402 topn__t402 topn 0.148783253297
* device instance topn_t403 r0 *1 0,0
Rtopn_t403 topn__t403 topn 0.243617299197
* device instance topn_t404 r0 *1 0,0
Rtopn_t404 topn__t404 topn 0.651185705171
* device instance topn_t405 r0 *1 0,0
Rtopn_t405 topn__t405 topn 1.50400521064
* device instance topn_t406 r0 *1 0,0
Rtopn_t406 topn__t406 topn 1.59851593343
* device instance topn_t407 r0 *1 0,0
Rtopn_t407 topn__t407 topn 1.4781040976
* device instance topn_t408 r0 *1 0,0
Rtopn_t408 topn__t408 topn 1.45842006757
* device instance topn_t409 r0 *1 0,0
Rtopn_t409 topn__t409 topn 1.55570260953
* device instance topn_t410 r0 *1 0,0
Rtopn_t410 topn__t410 topn 0.695346792161
* device instance topn_t411 r0 *1 0,0
Rtopn_t411 topn__t411 topn 0.604335610159
* device instance topn_t412 r0 *1 0,0
Rtopn_t412 topn__t412 topn 0.788181523185
* device instance topn_t413 r0 *1 0,0
Rtopn_t413 topn__t413 topn 1.38368090569
* device instance topn_t414 r0 *1 0,0
Rtopn_t414 topn__t414 topn 1.28849756456
* device instance topn_t415 r0 *1 0,0
Rtopn_t415 topn__t415 topn 1.19386616481
* device instance topn_t416 r0 *1 0,0
Rtopn_t416 topn__t416 topn 1.09992917295
* device instance topn_t417 r0 *1 0,0
Rtopn_t417 topn__t417 topn 0.495765590446
* device instance topn_t418 r0 *1 0,0
Rtopn_t418 topn__t418 topn 0.431056667254
* device instance topn_t419 r0 *1 0,0
Rtopn_t419 topn__t419 topn 0.381147609931
* device instance topn_t420 r0 *1 0,0
Rtopn_t420 topn__t420 topn 0.352383982591
* device instance topn_t421 r0 *1 0,0
Rtopn_t421 topn__t421 topn 0.350018231348
* device instance topn_t422 r0 *1 0,0
Rtopn_t422 topn__t422 topn 0.374550896173
* device instance topn_t423 r0 *1 0,0
Rtopn_t423 topn__t423 topn 0.066036693692
* device instance topn_t424 r0 *1 0,0
Rtopn_t424 topn__t424 topn 0.255642676942
* device instance topn_t425 r0 *1 0,0
Rtopn_t425 topn__t425 topn 0.25237168891
* device instance topn_t426 r0 *1 0,0
Rtopn_t426 topn__t426 topn 0.28542438738
* device instance topn_t427 r0 *1 0,0
Rtopn_t427 topn__t427 topn 0.344499655904
* device instance topn_t428 r0 *1 0,0
Rtopn_t428 topn__t428 topn 0.418724569834
* device instance topn_t429 r0 *1 0,0
Rtopn_t429 topn__t429 topn 0.421309038392
* device instance topn_t430 r0 *1 0,0
Rtopn_t430 topn__t430 topn 0.483892093649
* device instance topn_t431 r0 *1 0,0
Rtopn_t431 topn__t431 topn 0.432391290104
* device instance topn_t432 r0 *1 0,0
Rtopn_t432 topn__t432 topn 0.356354539007
* device instance topn_t433 r0 *1 0,0
Rtopn_t433 topn__t433 topn 0.631560876682
* device instance topn_t434 r0 *1 0,0
Rtopn_t434 topn__t434 topn 0.567123611444
* device instance topn_t435 r0 *1 0,0
Rtopn_t435 topn__t435 topn 0.513640497643
* device instance topn_t436 r0 *1 0,0
Rtopn_t436 topn__t436 topn 0.474827601807
* device instance topn_t437 r0 *1 0,0
Rtopn_t437 topn__t437 topn 0.454459307877
* device instance topn_t438 r0 *1 0,0
Rtopn_t438 topn__t438 topn 0.455019333714
* device instance topn_t439 r0 *1 0,0
Rtopn_t439 topn__t439 topn 0.294027562727
* device instance topn_t440 r0 *1 0,0
Rtopn_t440 topn__t440 topn 1.43882074169
* device instance topn_t441 r0 *1 0,0
Rtopn_t441 topn__t441 topn 1.53734402218
* device instance topn_t442 r0 *1 0,0
Rtopn_t442 topn__t442 topn 1.43864373463
* device instance topn_t443 r0 *1 0,0
Rtopn_t443 topn__t443 topn 1.53717836017
* device instance topn_t444 r0 *1 0,0
Rtopn_t444 topn__t444 topn 1.57417065121
* device instance topn_t445 r0 *1 0,0
Rtopn_t445 topn__t445 topn 1.44520717688
* device instance topn_t446 r0 *1 0,0
Rtopn_t446 topn__t446 topn 1.54332281131
* device instance topn_t447 r0 *1 0,0
Rtopn_t447 topn__t447 topn 1.31087917863
* device instance topn_t448 r0 *1 0,0
Rtopn_t448 topn__t448 topn 1.22594126572
* device instance topn_t449 r0 *1 0,0
Rtopn_t449 topn__t449 topn 1.14319599086
* device instance topn_t450 r0 *1 0,0
Rtopn_t450 topn__t450 topn 1.06315543571
* device instance topn_t451 r0 *1 0,0
Rtopn_t451 topn__t451 topn 0.986478184195
* device instance topn_t452 r0 *1 0,0
Rtopn_t452 topn__t452 topn 0.91401108077
* device instance topn_t453 r0 *1 0,0
Rtopn_t453 topn__t453 topn 0.846835653541
* device instance topn_t454 r0 *1 0,0
Rtopn_t454 topn__t454 topn 1.35505738664
* device instance topn_t455 r0 *1 0,0
Rtopn_t455 topn__t455 topn 1.26541335803
* device instance topn_t456 r0 *1 0,0
Rtopn_t456 topn__t456 topn 1.1771995297
* device instance topn_t457 r0 *1 0,0
Rtopn_t457 topn__t457 topn 1.09076295281
* device instance topn_t458 r0 *1 0,0
Rtopn_t458 topn__t458 topn 1.00656158589
* device instance topn_t459 r0 *1 0,0
Rtopn_t459 topn__t459 topn 0.925205897951
* device instance topn_t460 r0 *1 0,0
Rtopn_t460 topn__t460 topn 0.847515782439
* device instance topn_t461 r0 *1 0,0
Rtopn_t461 topn__t461 topn 0.774594971466
* device instance topn_t462 r0 *1 0,0
Rtopn_t462 topn__t462 topn 1.5310882486
* device instance topn_t463 r0 *1 0,0
Rtopn_t463 topn__t463 topn 1.44564323058
* device instance topn_t464 r0 *1 0,0
Rtopn_t464 topn__t464 topn 1.36197459437
* device instance topn_t465 r0 *1 0,0
Rtopn_t465 topn__t465 topn 1.36225972408
* device instance topn_t466 r0 *1 0,0
Rtopn_t466 topn__t466 topn 1.26546619116
* device instance topn_t467 r0 *1 0,0
Rtopn_t467 topn__t467 topn 1.16897182454
* device instance topn_t468 r0 *1 0,0
Rtopn_t468 topn__t468 topn 1.07285734961
* device instance topn_t469 r0 *1 0,0
Rtopn_t469 topn__t469 topn 0.977234863842
* device instance topn_t470 r0 *1 0,0
Rtopn_t470 topn__t470 topn 0.88226435158
* device instance topn_t471 r0 *1 0,0
Rtopn_t471 topn__t471 topn 1.44586562168
* device instance topn_t472 r0 *1 0,0
Rtopn_t472 topn__t472 topn 0.685994976162
* device instance topn_t473 r0 *1 0,0
Rtopn_t473 topn__t473 topn 0.726112498023
* device instance topn_t474 r0 *1 0,0
Rtopn_t474 topn__t474 topn 0.566769836668
* device instance topn_t475 r0 *1 0,0
Rtopn_t475 topn__t475 topn 0.821852722151
* device instance topn_t476 r0 *1 0,0
Rtopn_t476 topn__t476 topn 0.784517830658
* device instance topn_t477 r0 *1 0,0
Rtopn_t477 topn__t477 topn 0.758242623962
* device instance topn_t478 r0 *1 0,0
Rtopn_t478 topn__t478 topn 0.744199467497
* device instance topn_t479 r0 *1 0,0
Rtopn_t479 topn__t479 topn 0.743082188262
* device instance topn_t480 r0 *1 0,0
Rtopn_t480 topn__t480 topn 0.75494817707
* device instance topn_t481 r0 *1 0,0
Rtopn_t481 topn__t481 topn 0.779204518767
* device instance topn_t482 r0 *1 0,0
Rtopn_t482 topn__t482 topn 0.814745318816
* device instance topn_t483 r0 *1 0,0
Rtopn_t483 topn__t483 topn 0.547840321981
* device instance topn_t484 r0 *1 0,0
Rtopn_t484 topn__t484 topn 0.546321617252
* device instance topn_t485 r0 *1 0,0
Rtopn_t485 topn__t485 topn 0.562354799948
* device instance topn_t486 r0 *1 0,0
Rtopn_t486 topn__t486 topn 1.39761002264
* device instance topn_t487 r0 *1 0,0
Rtopn_t487 topn__t487 topn 0.640395272856
* device instance topn_t488 r0 *1 0,0
Rtopn_t488 topn__t488 topn 0.649413633882
* device instance topn_t489 r0 *1 0,0
Rtopn_t489 topn__t489 topn 0.60146853416
* device instance topn_t490 r0 *1 0,0
Rtopn_t490 topn__t490 topn 0.734078553126
* device instance topn_t491 r0 *1 0,0
Rtopn_t491 topn__t491 topn 0.69202431451
* device instance topn_t492 r0 *1 0,0
Rtopn_t492 topn__t492 topn 0.662088590783
* device instance topn_t493 r0 *1 0,0
Rtopn_t493 topn__t493 topn 0.645958414046
* device instance topn_t494 r0 *1 0,0
Rtopn_t494 topn__t494 topn 0.644670895702
* device instance topn_t495 r0 *1 0,0
Rtopn_t495 topn__t495 topn 1.28043061575
* device instance topn_t496 r0 *1 0,0
Rtopn_t496 topn__t496 topn 1.20144398465
* device instance topn_t497 r0 *1 0,0
Rtopn_t497 topn__t497 topn 1.12555322185
* device instance topn_t498 r0 *1 0,0
Rtopn_t498 topn__t498 topn 1.05342763522
* device instance topn_t499 r0 *1 0,0
Rtopn_t499 topn__t499 topn 0.985893924577
* device instance topn_t500 r0 *1 0,0
Rtopn_t500 topn__t500 topn 0.923959522304
* device instance topn_t501 r0 *1 0,0
Rtopn_t501 topn__t501 topn 1.48581985794
* device instance topn_t502 r0 *1 0,0
Rtopn_t502 topn__t502 topn 0.594521532858
* device instance topn_t503 r0 *1 0,0
Rtopn_t503 topn__t503 topn 1.57315718719
* device instance topn_t504 r0 *1 0,0
Rtopn_t504 topn__t504 topn 1.66374428666
* device instance topn_t505 r0 *1 0,0
Rtopn_t505 topn__t505 topn 1.61566563598
* device instance topn_t506 r0 *1 0,0
Rtopn_t506 topn__t506 topn 1.70399441404
* device instance topn_t507 r0 *1 0,0
Rtopn_t507 topn__t507 topn 1.00688096219
* device instance topn_t508 r0 *1 0,0
Rtopn_t508 topn__t508 topn 0.914992720726
* device instance topn_t509 r0 *1 0,0
Rtopn_t509 topn__t509 topn 0.824652294244
* device instance topn_t510 r0 *1 0,0
Rtopn_t510 topn__t510 topn 0.65831312862
* device instance topn_t511 r0 *1 0,0
Rtopn_t511 topn__t511 topn 0.736429531104
* device instance topn_t512 r0 *1 0,0
Rtopn_t512 topn__t512 topn 2.29549083234
* device instance topn_t513 r0 *1 0,0
Rtopn_t513 topn__t513 topn 2.21896652295
* device instance topn r0 *1 0,0
Ctopn topn vsubs 2.23477193e-13
* device instance topp_t0 r0 *1 0,0
Rtopp_t0 topp__t0 topp 1.58745075242
* device instance topp_t1 r0 *1 0,0
Rtopp_t1 topp__t1 topp 1.58951057708
* device instance topp_t2 r0 *1 0,0
Rtopp_t2 topp__t2 topp 1.46843544617
* device instance topp_t3 r0 *1 0,0
Rtopp_t3 topp__t3 topp 1.55227735463
* device instance topp_t4 r0 *1 0,0
Rtopp_t4 topp__t4 topp 1.18155804581
* device instance topp_t5 r0 *1 0,0
Rtopp_t5 topp__t5 topp 1.26467185592
* device instance topp_t6 r0 *1 0,0
Rtopp_t6 topp__t6 topp 0.508369453957
* device instance topp_t7 r0 *1 0,0
Rtopp_t7 topp__t7 topp 0.527841435552
* device instance topp_t8 r0 *1 0,0
Rtopp_t8 topp__t8 topp 0.561642774949
* device instance topp_t9 r0 *1 0,0
Rtopp_t9 topp__t9 topp 0.696664204074
* device instance topp_t10 r0 *1 0,0
Rtopp_t10 topp__t10 topp 0.687182799707
* device instance topp_t11 r0 *1 0,0
Rtopp_t11 topp__t11 topp 0.689745122045
* device instance topp_t12 r0 *1 0,0
Rtopp_t12 topp__t12 topp 0.70421971909
* device instance topp_t13 r0 *1 0,0
Rtopp_t13 topp__t13 topp 0.729898238333
* device instance topp_t14 r0 *1 0,0
Rtopp_t14 topp__t14 topp 0.76565423664
* device instance topp_t15 r0 *1 0,0
Rtopp_t15 topp__t15 topp 0.810154508749
* device instance topp_t16 r0 *1 0,0
Rtopp_t16 topp__t16 topp 0.607385856286
* device instance topp_t17 r0 *1 0,0
Rtopp_t17 topp__t17 topp 0.606928434253
* device instance topp_t18 r0 *1 0,0
Rtopp_t18 topp__t18 topp 0.596021233917
* device instance topp_t19 r0 *1 0,0
Rtopp_t19 topp__t19 topp 0.598973659231
* device instance topp_t20 r0 *1 0,0
Rtopp_t20 topp__t20 topp 0.615586325239
* device instance topp_t21 r0 *1 0,0
Rtopp_t21 topp__t21 topp 0.644804272154
* device instance topp_t22 r0 *1 0,0
Rtopp_t22 topp__t22 topp 0.6850164386
* device instance topp_t23 r0 *1 0,0
Rtopp_t23 topp__t23 topp 0.734419116795
* device instance topp_t24 r0 *1 0,0
Rtopp_t24 topp__t24 topp 0.791292805017
* device instance topp_t25 r0 *1 0,0
Rtopp_t25 topp__t25 topp 0.662602064876
* device instance topp_t26 r0 *1 0,0
Rtopp_t26 topp__t26 topp 0.725130581713
* device instance topp_t27 r0 *1 0,0
Rtopp_t27 topp__t27 topp 0.51771824535
* device instance topp_t28 r0 *1 0,0
Rtopp_t28 topp__t28 topp 0.504887481073
* device instance topp_t29 r0 *1 0,0
Rtopp_t29 topp__t29 topp 0.691753658473
* device instance topp_t30 r0 *1 0,0
Rtopp_t30 topp__t30 topp 0.429361368814
* device instance topp_t31 r0 *1 0,0
Rtopp_t31 topp__t31 topp 0.86204593393
* device instance topp_t32 r0 *1 0,0
Rtopp_t32 topp__t32 topp 1.20361200405
* device instance topp_t33 r0 *1 0,0
Rtopp_t33 topp__t33 topp 1.29176092603
* device instance topp_t34 r0 *1 0,0
Rtopp_t34 topp__t34 topp 1.38031143948
* device instance topp_t35 r0 *1 0,0
Rtopp_t35 topp__t35 topp 1.46919093248
* device instance topp_t36 r0 *1 0,0
Rtopp_t36 topp__t36 topp 1.45194314349
* device instance topp_t37 r0 *1 0,0
Rtopp_t37 topp__t37 topp 0.740412571759
* device instance topp_t38 r0 *1 0,0
Rtopp_t38 topp__t38 topp 0.827605267727
* device instance topp_t39 r0 *1 0,0
Rtopp_t39 topp__t39 topp 0.915586767115
* device instance topp_t40 r0 *1 0,0
Rtopp_t40 topp__t40 topp 1.00414975141
* device instance topp_t41 r0 *1 0,0
Rtopp_t41 topp__t41 topp 1.09315290083
* device instance topp_t42 r0 *1 0,0
Rtopp_t42 topp__t42 topp 1.4338663525
* device instance topp_t43 r0 *1 0,0
Rtopp_t43 topp__t43 topp 1.51961674213
* device instance topp_t44 r0 *1 0,0
Rtopp_t44 topp__t44 topp 1.34883628988
* device instance topp_t45 r0 *1 0,0
Rtopp_t45 topp__t45 topp 0.865625165672
* device instance topp_t46 r0 *1 0,0
Rtopp_t46 topp__t46 topp 0.941289875752
* device instance topp_t47 r0 *1 0,0
Rtopp_t47 topp__t47 topp 1.50774054416
* device instance topp_t48 r0 *1 0,0
Rtopp_t48 topp__t48 topp 1.09973309229
* device instance topp_t49 r0 *1 0,0
Rtopp_t49 topp__t49 topp 0.921757489896
* device instance topp_t50 r0 *1 0,0
Rtopp_t50 topp__t50 topp 0.993154858484
* device instance topp_t51 r0 *1 0,0
Rtopp_t51 topp__t51 topp 1.0675791408
* device instance topp_t52 r0 *1 0,0
Rtopp_t52 topp__t52 topp 1.14443995781
* device instance topp_t53 r0 *1 0,0
Rtopp_t53 topp__t53 topp 1.22327811979
* device instance topp_t54 r0 *1 0,0
Rtopp_t54 topp__t54 topp 1.30373495999
* device instance topp_t55 r0 *1 0,0
Rtopp_t55 topp__t55 topp 1.38552851997
* device instance topp_t56 r0 *1 0,0
Rtopp_t56 topp__t56 topp 0.983166190994
* device instance topp_t57 r0 *1 0,0
Rtopp_t57 topp__t57 topp 1.05039776364
* device instance topp_t58 r0 *1 0,0
Rtopp_t58 topp__t58 topp 1.12102814898
* device instance topp_t59 r0 *1 0,0
Rtopp_t59 topp__t59 topp 1.19445456421
* device instance topp_t60 r0 *1 0,0
Rtopp_t60 topp__t60 topp 1.2701922088
* device instance topp_t61 r0 *1 0,0
Rtopp_t61 topp__t61 topp 1.34785152552
* device instance topp_t62 r0 *1 0,0
Rtopp_t62 topp__t62 topp 1.42711883478
* device instance topp_t63 r0 *1 0,0
Rtopp_t63 topp__t63 topp 1.01950737081
* device instance topp_t64 r0 *1 0,0
Rtopp_t64 topp__t64 topp 1.23783730124
* device instance topp_t65 r0 *1 0,0
Rtopp_t65 topp__t65 topp 1.16302661592
* device instance topp_t66 r0 *1 0,0
Rtopp_t66 topp__t66 topp 1.09071975344
* device instance topp_t67 r0 *1 0,0
Rtopp_t67 topp__t67 topp 1.02144857821
* device instance topp_t68 r0 *1 0,0
Rtopp_t68 topp__t68 topp 0.955873297843
* device instance topp_t69 r0 *1 0,0
Rtopp_t69 topp__t69 topp 0.894806834641
* device instance topp_t70 r0 *1 0,0
Rtopp_t70 topp__t70 topp 0.839234012246
* device instance topp_t71 r0 *1 0,0
Rtopp_t71 topp__t71 topp 0.79031457629
* device instance topp_t72 r0 *1 0,0
Rtopp_t72 topp__t72 topp 0.749352705927
* device instance topp_t73 r0 *1 0,0
Rtopp_t73 topp__t73 topp 1.14459399913
* device instance topp_t74 r0 *1 0,0
Rtopp_t74 topp__t74 topp 1.05538438573
* device instance topp_t75 r0 *1 0,0
Rtopp_t75 topp__t75 topp 1.51663867067
* device instance topp_t76 r0 *1 0,0
Rtopp_t76 topp__t76 topp 1.43317368019
* device instance topp_t77 r0 *1 0,0
Rtopp_t77 topp__t77 topp 0.413799917841
* device instance topp_t78 r0 *1 0,0
Rtopp_t78 topp__t78 topp 1.26945717399
* device instance topp_t79 r0 *1 0,0
Rtopp_t79 topp__t79 topp 1.18964797121
* device instance topp_t80 r0 *1 0,0
Rtopp_t80 topp__t80 topp 1.11159885768
* device instance topp_t81 r0 *1 0,0
Rtopp_t81 topp__t81 topp 1.03570782154
* device instance topp_t82 r0 *1 0,0
Rtopp_t82 topp__t82 topp 0.962485485086
* device instance topp_t83 r0 *1 0,0
Rtopp_t83 topp__t83 topp 0.892588859776
* device instance topp_t84 r0 *1 0,0
Rtopp_t84 topp__t84 topp 0.8268617674
* device instance topp_t85 r0 *1 0,0
Rtopp_t85 topp__t85 topp 0.766377738701
* device instance topp_t86 r0 *1 0,0
Rtopp_t86 topp__t86 topp 0.712473326211
* device instance topp_t87 r0 *1 0,0
Rtopp_t87 topp__t87 topp 0.66674627029
* device instance topp_t88 r0 *1 0,0
Rtopp_t88 topp__t88 topp 0.966553633609
* device instance topp_t89 r0 *1 0,0
Rtopp_t89 topp__t89 topp 0.878216714623
* device instance topp_t90 r0 *1 0,0
Rtopp_t90 topp__t90 topp 1.48319348523
* device instance topp_t91 r0 *1 0,0
Rtopp_t91 topp__t91 topp 1.35071450869
* device instance topp_t92 r0 *1 0,0
Rtopp_t92 topp__t92 topp 0.920078802365
* device instance topp_t93 r0 *1 0,0
Rtopp_t93 topp__t93 topp 0.418041272098
* device instance topp_t94 r0 *1 0,0
Rtopp_t94 topp__t94 topp 0.441515101154
* device instance topp_t95 r0 *1 0,0
Rtopp_t95 topp__t95 topp 0.481416254517
* device instance topp_t96 r0 *1 0,0
Rtopp_t96 topp__t96 topp 0.534075445866
* device instance topp_t97 r0 *1 0,0
Rtopp_t97 topp__t97 topp 0.596121212371
* device instance topp_t98 r0 *1 0,0
Rtopp_t98 topp__t98 topp 0.66493109718
* device instance topp_t99 r0 *1 0,0
Rtopp_t99 topp__t99 topp 0.73861706882
* device instance topp_t100 r0 *1 0,0
Rtopp_t100 topp__t100 topp 0.81585901411
* device instance topp_t101 r0 *1 0,0
Rtopp_t101 topp__t101 topp 0.895737480323
* device instance topp_t102 r0 *1 0,0
Rtopp_t102 topp__t102 topp 0.977606404747
* device instance topp_t103 r0 *1 0,0
Rtopp_t103 topp__t103 topp 1.06100512616
* device instance topp_t104 r0 *1 0,0
Rtopp_t104 topp__t104 topp 1.14559958934
* device instance topp_t105 r0 *1 0,0
Rtopp_t105 topp__t105 topp 1.2311433331
* device instance topp_t106 r0 *1 0,0
Rtopp_t106 topp__t106 topp 1.31745145655
* device instance topp_t107 r0 *1 0,0
Rtopp_t107 topp__t107 topp 1.31472445993
* device instance topp_t108 r0 *1 0,0
Rtopp_t108 topp__t108 topp 1.49182909424
* device instance topp_t109 r0 *1 0,0
Rtopp_t109 topp__t109 topp 0.854146423997
* device instance topp_t110 r0 *1 0,0
Rtopp_t110 topp__t110 topp 0.654324093907
* device instance topp_t111 r0 *1 0,0
Rtopp_t111 topp__t111 topp 0.793244080275
* device instance topp_t112 r0 *1 0,0
Rtopp_t112 topp__t112 topp 0.378317981578
* device instance topp_t113 r0 *1 0,0
Rtopp_t113 topp__t113 topp 1.41377748023
* device instance topp_t114 r0 *1 0,0
Rtopp_t114 topp__t114 topp 1.3238431568
* device instance topp_t115 r0 *1 0,0
Rtopp_t115 topp__t115 topp 1.23410031611
* device instance topp_t116 r0 *1 0,0
Rtopp_t116 topp__t116 topp 1.55472561769
* device instance topp_t117 r0 *1 0,0
Rtopp_t117 topp__t117 topp 1.47341972517
* device instance topp_t118 r0 *1 0,0
Rtopp_t118 topp__t118 topp 1.39334438418
* device instance topp_t119 r0 *1 0,0
Rtopp_t119 topp__t119 topp 1.40438303902
* device instance topp_t120 r0 *1 0,0
Rtopp_t120 topp__t120 topp 0.826286361624
* device instance topp_t121 r0 *1 0,0
Rtopp_t121 topp__t121 topp 0.914394772707
* device instance topp_t122 r0 *1 0,0
Rtopp_t122 topp__t122 topp 1.00306300674
* device instance topp_t123 r0 *1 0,0
Rtopp_t123 topp__t123 topp 1.09215472202
* device instance topp_t124 r0 *1 0,0
Rtopp_t124 topp__t124 topp 1.18157412987
* device instance topp_t125 r0 *1 0,0
Rtopp_t125 topp__t125 topp 1.27125208284
* device instance topp_t126 r0 *1 0,0
Rtopp_t126 topp__t126 topp 1.05915319372
* device instance topp_t127 r0 *1 0,0
Rtopp_t127 topp__t127 topp 1.14388462229
* device instance topp_t128 r0 *1 0,0
Rtopp_t128 topp__t128 topp 1.40298443695
* device instance topp_t129 r0 *1 0,0
Rtopp_t129 topp__t129 topp 1.49051254824
* device instance topp_t130 r0 *1 0,0
Rtopp_t130 topp__t130 topp 1.22954768783
* device instance topp_t131 r0 *1 0,0
Rtopp_t131 topp__t131 topp 1.31596046688
* device instance topp_t132 r0 *1 0,0
Rtopp_t132 topp__t132 topp 0.813449163089
* device instance topp_t133 r0 *1 0,0
Rtopp_t133 topp__t133 topp 0.893543084401
* device instance topp_t134 r0 *1 0,0
Rtopp_t134 topp__t134 topp 1.36113747948
* device instance topp_t135 r0 *1 0,0
Rtopp_t135 topp__t135 topp 1.11595984191
* device instance topp_t136 r0 *1 0,0
Rtopp_t136 topp__t136 topp 1.06965597035
* device instance topp_t137 r0 *1 0,0
Rtopp_t137 topp__t137 topp 1.16080979598
* device instance topp_t138 r0 *1 0,0
Rtopp_t138 topp__t138 topp 1.06945202293
* device instance topp_t139 r0 *1 0,0
Rtopp_t139 topp__t139 topp 0.716357328303
* device instance topp_t140 r0 *1 0,0
Rtopp_t140 topp__t140 topp 0.806156017508
* device instance topp_t141 r0 *1 0,0
Rtopp_t141 topp__t141 topp 0.89624559888
* device instance topp_t142 r0 *1 0,0
Rtopp_t142 topp__t142 topp 0.986546384442
* device instance topp_t143 r0 *1 0,0
Rtopp_t143 topp__t143 topp 1.07700525068
* device instance topp_t144 r0 *1 0,0
Rtopp_t144 topp__t144 topp 1.1675854562
* device instance topp_t145 r0 *1 0,0
Rtopp_t145 topp__t145 topp 1.25826079621
* device instance topp_t146 r0 *1 0,0
Rtopp_t146 topp__t146 topp 1.34901208712
* device instance topp_t147 r0 *1 0,0
Rtopp_t147 topp__t147 topp 1.4398249676
* device instance topp_t148 r0 *1 0,0
Rtopp_t148 topp__t148 topp 1.16062186645
* device instance topp_t149 r0 *1 0,0
Rtopp_t149 topp__t149 topp 1.25180172177
* device instance topp_t150 r0 *1 0,0
Rtopp_t150 topp__t150 topp 1.34298954968
* device instance topp_t151 r0 *1 0,0
Rtopp_t151 topp__t151 topp 0.978517937272
* device instance topp_t152 r0 *1 0,0
Rtopp_t152 topp__t152 topp 0.334910626681
* device instance topp_t153 r0 *1 0,0
Rtopp_t153 topp__t153 topp 0.406989065735
* device instance topp_t154 r0 *1 0,0
Rtopp_t154 topp__t154 topp 0.402089170338
* device instance topp_t155 r0 *1 0,0
Rtopp_t155 topp__t155 topp 0.463843370834
* device instance topp_t156 r0 *1 0,0
Rtopp_t156 topp__t156 topp 0.534111028371
* device instance topp_t157 r0 *1 0,0
Rtopp_t157 topp__t157 topp 0.609956928632
* device instance topp_t158 r0 *1 0,0
Rtopp_t158 topp__t158 topp 0.530386832324
* device instance topp_t159 r0 *1 0,0
Rtopp_t159 topp__t159 topp 0.323531445097
* device instance topp_t160 r0 *1 0,0
Rtopp_t160 topp__t160 topp 0.424764399468
* device instance topp_t161 r0 *1 0,0
Rtopp_t161 topp__t161 topp 0.409028094427
* device instance topp_t162 r0 *1 0,0
Rtopp_t162 topp__t162 topp 0.413318418659
* device instance topp_t163 r0 *1 0,0
Rtopp_t163 topp__t163 topp 0.437045986794
* device instance topp_t164 r0 *1 0,0
Rtopp_t164 topp__t164 topp 0.592818783326
* device instance topp_t165 r0 *1 0,0
Rtopp_t165 topp__t165 topp 0.353340735461
* device instance topp_t166 r0 *1 0,0
Rtopp_t166 topp__t166 topp 0.33803147164
* device instance topp_t167 r0 *1 0,0
Rtopp_t167 topp__t167 topp 0.738938054681
* device instance topp_t168 r0 *1 0,0
Rtopp_t168 topp__t168 topp 0.485555370261
* device instance topp_t169 r0 *1 0,0
Rtopp_t169 topp__t169 topp 0.56792330622
* device instance topp_t170 r0 *1 0,0
Rtopp_t170 topp__t170 topp 0.66197203417
* device instance topp_t171 r0 *1 0,0
Rtopp_t171 topp__t171 topp 0.477320877544
* device instance topp_t172 r0 *1 0,0
Rtopp_t172 topp__t172 topp 1.45119177374
* device instance topp_t173 r0 *1 0,0
Rtopp_t173 topp__t173 topp 0.771712395711
* device instance topp_t174 r0 *1 0,0
Rtopp_t174 topp__t174 topp 0.85572175644
* device instance topp_t175 r0 *1 0,0
Rtopp_t175 topp__t175 topp 0.941078303539
* device instance topp_t176 r0 *1 0,0
Rtopp_t176 topp__t176 topp 1.02744633365
* device instance topp_t177 r0 *1 0,0
Rtopp_t177 topp__t177 topp 1.11459073649
* device instance topp_t178 r0 *1 0,0
Rtopp_t178 topp__t178 topp 1.20234271213
* device instance topp_t179 r0 *1 0,0
Rtopp_t179 topp__t179 topp 1.29057833205
* device instance topp_t180 r0 *1 0,0
Rtopp_t180 topp__t180 topp 1.37920477489
* device instance topp_t181 r0 *1 0,0
Rtopp_t181 topp__t181 topp 1.4681512651
* device instance topp_t182 r0 *1 0,0
Rtopp_t182 topp__t182 topp 0.975596172926
* device instance topp_t183 r0 *1 0,0
Rtopp_t183 topp__t183 topp 0.318032172578
* device instance topp_t184 r0 *1 0,0
Rtopp_t184 topp__t184 topp 0.178586326293
* device instance topp_t185 r0 *1 0,0
Rtopp_t185 topp__t185 topp 0.137011907927
* device instance topp_t186 r0 *1 0,0
Rtopp_t186 topp__t186 topp 0.689542794279
* device instance topp_t187 r0 *1 0,0
Rtopp_t187 topp__t187 topp 0.652655109612
* device instance topp_t188 r0 *1 0,0
Rtopp_t188 topp__t188 topp 0.626974533184
* device instance topp_t189 r0 *1 0,0
Rtopp_t189 topp__t189 topp 0.613909101266
* device instance topp_t190 r0 *1 0,0
Rtopp_t190 topp__t190 topp 0.735954335797
* device instance topp_t191 r0 *1 0,0
Rtopp_t191 topp__t191 topp 0.61426431621
* device instance topp_t192 r0 *1 0,0
Rtopp_t192 topp__t192 topp 0.322797648169
* device instance topp_t193 r0 *1 0,0
Rtopp_t193 topp__t193 topp 0.258719984817
* device instance topp_t194 r0 *1 0,0
Rtopp_t194 topp__t194 topp 0.328217084923
* device instance topp_t195 r0 *1 0,0
Rtopp_t195 topp__t195 topp 0.357636035943
* device instance topp_t196 r0 *1 0,0
Rtopp_t196 topp__t196 topp 0.405868894807
* device instance topp_t197 r0 *1 0,0
Rtopp_t197 topp__t197 topp 0.467123679057
* device instance topp_t198 r0 *1 0,0
Rtopp_t198 topp__t198 topp 0.536962242152
* device instance topp_t199 r0 *1 0,0
Rtopp_t199 topp__t199 topp 1.43418382946
* device instance topp_t200 r0 *1 0,0
Rtopp_t200 topp__t200 topp 0.231981071467
* device instance topp_t201 r0 *1 0,0
Rtopp_t201 topp__t201 topp 0.239464717007
* device instance topp_t202 r0 *1 0,0
Rtopp_t202 topp__t202 topp 0.342518809248
* device instance topp_t203 r0 *1 0,0
Rtopp_t203 topp__t203 topp 0.338151527614
* device instance topp_t204 r0 *1 0,0
Rtopp_t204 topp__t204 topp 0.409660136444
* device instance topp_t205 r0 *1 0,0
Rtopp_t205 topp__t205 topp 0.487796417937
* device instance topp_t206 r0 *1 0,0
Rtopp_t206 topp__t206 topp 0.278424909196
* device instance topp_t207 r0 *1 0,0
Rtopp_t207 topp__t207 topp 0.569840512346
* device instance topp_t208 r0 *1 0,0
Rtopp_t208 topp__t208 topp 1.18249682965
* device instance topp_t209 r0 *1 0,0
Rtopp_t209 topp__t209 topp 1.27210973814
* device instance topp_t210 r0 *1 0,0
Rtopp_t210 topp__t210 topp 1.36193853232
* device instance topp_t211 r0 *1 0,0
Rtopp_t211 topp__t211 topp 0.77368849065
* device instance topp_t212 r0 *1 0,0
Rtopp_t212 topp__t212 topp 0.857504275974
* device instance topp_t213 r0 *1 0,0
Rtopp_t213 topp__t213 topp 0.942699438984
* device instance topp_t214 r0 *1 0,0
Rtopp_t214 topp__t214 topp 1.02893140073
* device instance topp_t215 r0 *1 0,0
Rtopp_t215 topp__t215 topp 0.612455152362
* device instance topp_t216 r0 *1 0,0
Rtopp_t216 topp__t216 topp 1.2519759647
* device instance topp_t217 r0 *1 0,0
Rtopp_t217 topp__t217 topp 0.704950452989
* device instance topp_t218 r0 *1 0,0
Rtopp_t218 topp__t218 topp 0.796036961403
* device instance topp_t219 r0 *1 0,0
Rtopp_t219 topp__t219 topp 0.887154717548
* device instance topp_t220 r0 *1 0,0
Rtopp_t220 topp__t220 topp 0.978294990282
* device instance topp_t221 r0 *1 0,0
Rtopp_t221 topp__t221 topp 1.34315196315
* device instance topp_t222 r0 *1 0,0
Rtopp_t222 topp__t222 topp 1.43433591681
* device instance topp_t223 r0 *1 0,0
Rtopp_t223 topp__t223 topp 0.705259815049
* device instance topp_t224 r0 *1 0,0
Rtopp_t224 topp__t224 topp 0.796310937682
* device instance topp_t225 r0 *1 0,0
Rtopp_t225 topp__t225 topp 0.887400562553
* device instance topp_t226 r0 *1 0,0
Rtopp_t226 topp__t226 topp 0.149333171419
* device instance topp_t227 r0 *1 0,0
Rtopp_t227 topp__t227 topp 0.206100643996
* device instance topp_t228 r0 *1 0,0
Rtopp_t228 topp__t228 topp 0.538214878005
* device instance topp_t229 r0 *1 0,0
Rtopp_t229 topp__t229 topp 0.281608772985
* device instance topp_t230 r0 *1 0,0
Rtopp_t230 topp__t230 topp 0.251178861327
* device instance topp_t231 r0 *1 0,0
Rtopp_t231 topp__t231 topp 0.450446878941
* device instance topp_t232 r0 *1 0,0
Rtopp_t232 topp__t232 topp 0.432076046666
* device instance topp_t233 r0 *1 0,0
Rtopp_t233 topp__t233 topp 0.522936491614
* device instance topp_t234 r0 *1 0,0
Rtopp_t234 topp__t234 topp 0.364387805485
* device instance topp_t235 r0 *1 0,0
Rtopp_t235 topp__t235 topp 0.126951411362
* device instance topp_t236 r0 *1 0,0
Rtopp_t236 topp__t236 topp 0.0547343385998
* device instance topp_t237 r0 *1 0,0
Rtopp_t237 topp__t237 topp 0.0807711643734
* device instance topp_t238 r0 *1 0,0
Rtopp_t238 topp__t238 topp 0.163404591012
* device instance topp_t239 r0 *1 0,0
Rtopp_t239 topp__t239 topp 0.252045801255
* device instance topp_t240 r0 *1 0,0
Rtopp_t240 topp__t240 topp 0.342055635379
* device instance topp_t241 r0 *1 0,0
Rtopp_t241 topp__t241 topp 0.432580600184
* device instance topp_t242 r0 *1 0,0
Rtopp_t242 topp__t242 topp 0.523353455911
* device instance topp_t243 r0 *1 0,0
Rtopp_t243 topp__t243 topp 0.125221385131
* device instance topp_t244 r0 *1 0,0
Rtopp_t244 topp__t244 topp 0.0505923143298
* device instance topp_t245 r0 *1 0,0
Rtopp_t245 topp__t245 topp 0.0780238132978
* device instance topp_t246 r0 *1 0,0
Rtopp_t246 topp__t246 topp 0.162064168807
* device instance topp_t247 r0 *1 0,0
Rtopp_t247 topp__t247 topp 0.341417328414
* device instance topp_t248 r0 *1 0,0
Rtopp_t248 topp__t248 topp 1.39773275516
* device instance topp_t249 r0 *1 0,0
Rtopp_t249 topp__t249 topp 1.43148519648
* device instance topp_t250 r0 *1 0,0
Rtopp_t250 topp__t250 topp 1.34273743076
* device instance topp_t251 r0 *1 0,0
Rtopp_t251 topp__t251 topp 1.25434711877
* device instance topp_t252 r0 *1 0,0
Rtopp_t252 topp__t252 topp 1.16639552767
* device instance topp_t253 r0 *1 0,0
Rtopp_t253 topp__t253 topp 1.07898994703
* device instance topp_t254 r0 *1 0,0
Rtopp_t254 topp__t254 topp 0.992274675071
* device instance topp_t255 r0 *1 0,0
Rtopp_t255 topp__t255 topp 0.906447848465
* device instance topp_t256 r0 *1 0,0
Rtopp_t256 topp__t256 topp 0.821787879799
* device instance topp_t257 r0 *1 0,0
Rtopp_t257 topp__t257 topp 0.738696069422
* device instance topp_t258 r0 *1 0,0
Rtopp_t258 topp__t258 topp 0.657766974522
* device instance topp_t259 r0 *1 0,0
Rtopp_t259 topp__t259 topp 0.579906758678
* device instance topp_t260 r0 *1 0,0
Rtopp_t260 topp__t260 topp 0.506532576392
* device instance topp_t261 r0 *1 0,0
Rtopp_t261 topp__t261 topp 0.439894986707
* device instance topp_t262 r0 *1 0,0
Rtopp_t262 topp__t262 topp 0.454083854373
* device instance topp_t263 r0 *1 0,0
Rtopp_t263 topp__t263 topp 0.987209484007
* device instance topp_t264 r0 *1 0,0
Rtopp_t264 topp__t264 topp 1.16814579321
* device instance topp_t265 r0 *1 0,0
Rtopp_t265 topp__t265 topp 1.2587807704
* device instance topp_t266 r0 *1 0,0
Rtopp_t266 topp__t266 topp 1.34949709443
* device instance topp_t267 r0 *1 0,0
Rtopp_t267 topp__t267 topp 1.44027939442
* device instance topp_t268 r0 *1 0,0
Rtopp_t268 topp__t268 topp 0.717712179401
* device instance topp_t269 r0 *1 0,0
Rtopp_t269 topp__t269 topp 0.214211157667
* device instance topp_t270 r0 *1 0,0
Rtopp_t270 topp__t270 topp 0.630976927888
* device instance topp_t271 r0 *1 0,0
Rtopp_t271 topp__t271 topp 0.307448307854
* device instance topp_t272 r0 *1 0,0
Rtopp_t272 topp__t272 topp 0.545712324206
* device instance topp_t273 r0 *1 0,0
Rtopp_t273 topp__t273 topp 0.458469796473
* device instance topp_t274 r0 *1 0,0
Rtopp_t274 topp__t274 topp 0.213190418444
* device instance topp_t275 r0 *1 0,0
Rtopp_t275 topp__t275 topp 0.462732043684
* device instance topp_t276 r0 *1 0,0
Rtopp_t276 topp__t276 topp 0.3835216994
* device instance topp_t277 r0 *1 0,0
Rtopp_t277 topp__t277 topp 0.248320025694
* device instance topp_t278 r0 *1 0,0
Rtopp_t278 topp__t278 topp 0.310975545286
* device instance topp_t279 r0 *1 0,0
Rtopp_t279 topp__t279 topp 1.07761268861
* device instance topp_t280 r0 *1 0,0
Rtopp_t280 topp__t280 topp 1.31304978628
* device instance topp_t281 r0 *1 0,0
Rtopp_t281 topp__t281 topp 1.22930532166
* device instance topp_t282 r0 *1 0,0
Rtopp_t282 topp__t282 topp 1.1467049981
* device instance topp_t283 r0 *1 0,0
Rtopp_t283 topp__t283 topp 1.06551493545
* device instance topp_t284 r0 *1 0,0
Rtopp_t284 topp__t284 topp 0.986083540512
* device instance topp_t285 r0 *1 0,0
Rtopp_t285 topp__t285 topp 0.908872029642
* device instance topp_t286 r0 *1 0,0
Rtopp_t286 topp__t286 topp 0.834496812373
* device instance topp_t287 r0 *1 0,0
Rtopp_t287 topp__t287 topp 0.763786907227
* device instance topp_t288 r0 *1 0,0
Rtopp_t288 topp__t288 topp 0.697857360526
* device instance topp_t289 r0 *1 0,0
Rtopp_t289 topp__t289 topp 0.638191427259
* device instance topp_t290 r0 *1 0,0
Rtopp_t290 topp__t290 topp 0.586703201125
* device instance topp_t291 r0 *1 0,0
Rtopp_t291 topp__t291 topp 0.790539192729
* device instance topp_t292 r0 *1 0,0
Rtopp_t292 topp__t292 topp 0.703767560232
* device instance topp_t293 r0 *1 0,0
Rtopp_t293 topp__t293 topp 0.618283340085
* device instance topp_t294 r0 *1 0,0
Rtopp_t294 topp__t294 topp 1.45471025228
* device instance topp_t295 r0 *1 0,0
Rtopp_t295 topp__t295 topp 1.36747060601
* device instance topp_t296 r0 *1 0,0
Rtopp_t296 topp__t296 topp 1.28078832939
* device instance topp_t297 r0 *1 0,0
Rtopp_t297 topp__t297 topp 1.194784741
* device instance topp_t298 r0 *1 0,0
Rtopp_t298 topp__t298 topp 1.10961766214
* device instance topp_t299 r0 *1 0,0
Rtopp_t299 topp__t299 topp 1.02549552955
* device instance topp_t300 r0 *1 0,0
Rtopp_t300 topp__t300 topp 0.942698123648
* device instance topp_t301 r0 *1 0,0
Rtopp_t301 topp__t301 topp 0.861607433653
* device instance topp_t302 r0 *1 0,0
Rtopp_t302 topp__t302 topp 0.782754069501
* device instance topp_t303 r0 *1 0,0
Rtopp_t303 topp__t303 topp 0.706887150196
* device instance topp_t304 r0 *1 0,0
Rtopp_t304 topp__t304 topp 0.635077868534
* device instance topp_t305 r0 *1 0,0
Rtopp_t305 topp__t305 topp 0.568864923587
* device instance topp_t306 r0 *1 0,0
Rtopp_t306 topp__t306 topp 0.5104308471
* device instance topp_t307 r0 *1 0,0
Rtopp_t307 topp__t307 topp 0.534704352531
* device instance topp_t308 r0 *1 0,0
Rtopp_t308 topp__t308 topp 0.379519479133
* device instance topp_t309 r0 *1 0,0
Rtopp_t309 topp__t309 topp 1.40179620689
* device instance topp_t310 r0 *1 0,0
Rtopp_t310 topp__t310 topp 1.31104025334
* device instance topp_t311 r0 *1 0,0
Rtopp_t311 topp__t311 topp 1.22035627268
* device instance topp_t312 r0 *1 0,0
Rtopp_t312 topp__t312 topp 1.12976159648
* device instance topp_t313 r0 *1 0,0
Rtopp_t313 topp__t313 topp 1.03927957918
* device instance topp_t314 r0 *1 0,0
Rtopp_t314 topp__t314 topp 0.948942447515
* device instance topp_t315 r0 *1 0,0
Rtopp_t315 topp__t315 topp 0.858795924476
* device instance topp_t316 r0 *1 0,0
Rtopp_t316 topp__t316 topp 0.768907053741
* device instance topp_t317 r0 *1 0,0
Rtopp_t317 topp__t317 topp 0.679378113342
* device instance topp_t318 r0 *1 0,0
Rtopp_t318 topp__t318 topp 0.590372874275
* device instance topp_t319 r0 *1 0,0
Rtopp_t319 topp__t319 topp 0.502169878297
* device instance topp_t320 r0 *1 0,0
Rtopp_t320 topp__t320 topp 0.415280614591
* device instance topp_t321 r0 *1 0,0
Rtopp_t321 topp__t321 topp 0.330742100795
* device instance topp_t322 r0 *1 0,0
Rtopp_t322 topp__t322 topp 0.896975456838
* device instance topp_t323 r0 *1 0,0
Rtopp_t323 topp__t323 topp 0.806967360692
* device instance topp_t324 r0 *1 0,0
Rtopp_t324 topp__t324 topp 0.717270254836
* device instance topp_t325 r0 *1 0,0
Rtopp_t325 topp__t325 topp 0.250941490828
* device instance topp_t326 r0 *1 0,0
Rtopp_t326 topp__t326 topp 0.539429375881
* device instance topp_t327 r0 *1 0,0
Rtopp_t327 topp__t327 topp 0.451897319538
* device instance topp_t328 r0 *1 0,0
Rtopp_t328 topp__t328 topp 0.36617928593
* device instance topp_t329 r0 *1 0,0
Rtopp_t329 topp__t329 topp 0.283923048871
* device instance topp_t330 r0 *1 0,0
Rtopp_t330 topp__t330 topp 0.209251695605
* device instance topp_t331 r0 *1 0,0
Rtopp_t331 topp__t331 topp 0.153652831878
* device instance topp_t332 r0 *1 0,0
Rtopp_t332 topp__t332 topp 0.141707655304
* device instance topp_t333 r0 *1 0,0
Rtopp_t333 topp__t333 topp 0.182213810116
* device instance topp_t334 r0 *1 0,0
Rtopp_t334 topp__t334 topp 0.628017405746
* device instance topp_t335 r0 *1 0,0
Rtopp_t335 topp__t335 topp 1.51803693034
* device instance topp_t336 r0 *1 0,0
Rtopp_t336 topp__t336 topp 1.43219195493
* device instance topp_t337 r0 *1 0,0
Rtopp_t337 topp__t337 topp 1.34705620366
* device instance topp_t338 r0 *1 0,0
Rtopp_t338 topp__t338 topp 1.26277313168
* device instance topp_t339 r0 *1 0,0
Rtopp_t339 topp__t339 topp 1.1795255379
* device instance topp_t340 r0 *1 0,0
Rtopp_t340 topp__t340 topp 1.09754906642
* device instance topp_t341 r0 *1 0,0
Rtopp_t341 topp__t341 topp 1.01715109893
* device instance topp_t342 r0 *1 0,0
Rtopp_t342 topp__t342 topp 0.938737295048
* device instance topp_t343 r0 *1 0,0
Rtopp_t343 topp__t343 topp 0.862848773751
* device instance topp_t344 r0 *1 0,0
Rtopp_t344 topp__t344 topp 0.79021342042
* device instance topp_t345 r0 *1 0,0
Rtopp_t345 topp__t345 topp 0.721813992283
* device instance topp_t346 r0 *1 0,0
Rtopp_t346 topp__t346 topp 0.65897084556
* device instance topp_t347 r0 *1 0,0
Rtopp_t347 topp__t347 topp 0.603422453457
* device instance topp_t348 r0 *1 0,0
Rtopp_t348 topp__t348 topp 0.557354183238
* device instance topp_t349 r0 *1 0,0
Rtopp_t349 topp__t349 topp 0.523275892819
* device instance topp_t350 r0 *1 0,0
Rtopp_t350 topp__t350 topp 1.48157483562
* device instance topp_t351 r0 *1 0,0
Rtopp_t351 topp__t351 topp 0.500112434822
* device instance topp_t352 r0 *1 0,0
Rtopp_t352 topp__t352 topp 0.513062628233
* device instance topp_t353 r0 *1 0,0
Rtopp_t353 topp__t353 topp 0.541297533443
* device instance topp_t354 r0 *1 0,0
Rtopp_t354 topp__t354 topp 0.582599111852
* device instance topp_t355 r0 *1 0,0
Rtopp_t355 topp__t355 topp 0.634420504671
* device instance topp_t356 r0 *1 0,0
Rtopp_t356 topp__t356 topp 0.694410523078
* device instance topp_t357 r0 *1 0,0
Rtopp_t357 topp__t357 topp 0.760638888417
* device instance topp_t358 r0 *1 0,0
Rtopp_t358 topp__t358 topp 0.831616503432
* device instance topp_t359 r0 *1 0,0
Rtopp_t359 topp__t359 topp 0.906228141908
* device instance topp_t360 r0 *1 0,0
Rtopp_t360 topp__t360 topp 0.983647206974
* device instance topp_t361 r0 *1 0,0
Rtopp_t361 topp__t361 topp 1.06326062496
* device instance topp_t362 r0 *1 0,0
Rtopp_t362 topp__t362 topp 1.1446106026
* device instance topp_t363 r0 *1 0,0
Rtopp_t363 topp__t363 topp 1.22735188629
* device instance topp_t364 r0 *1 0,0
Rtopp_t364 topp__t364 topp 1.31122111795
* device instance topp_t365 r0 *1 0,0
Rtopp_t365 topp__t365 topp 1.39601501917
* device instance topp_t366 r0 *1 0,0
Rtopp_t366 topp__t366 topp 0.503627422443
* device instance topp_t367 r0 *1 0,0
Rtopp_t367 topp__t367 topp 1.30434085597
* device instance topp_t368 r0 *1 0,0
Rtopp_t368 topp__t368 topp 1.21315619562
* device instance topp_t369 r0 *1 0,0
Rtopp_t369 topp__t369 topp 1.12198029732
* device instance topp_t370 r0 *1 0,0
Rtopp_t370 topp__t370 topp 1.0308154861
* device instance topp_t371 r0 *1 0,0
Rtopp_t371 topp__t371 topp 0.939664988915
* device instance topp_t372 r0 *1 0,0
Rtopp_t372 topp__t372 topp 0.848533418666
* device instance topp_t373 r0 *1 0,0
Rtopp_t373 topp__t373 topp 0.757427607096
* device instance topp_t374 r0 *1 0,0
Rtopp_t374 topp__t374 topp 0.666358119621
* device instance topp_t375 r0 *1 0,0
Rtopp_t375 topp__t375 topp 0.575342205454
* device instance topp_t376 r0 *1 0,0
Rtopp_t376 topp__t376 topp 0.484410063238
* device instance topp_t377 r0 *1 0,0
Rtopp_t377 topp__t377 topp 0.393619755033
* device instance topp_t378 r0 *1 0,0
Rtopp_t378 topp__t378 topp 0.303098762676
* device instance topp_t379 r0 *1 0,0
Rtopp_t379 topp__t379 topp 0.90476176042
* device instance topp_t380 r0 *1 0,0
Rtopp_t380 topp__t380 topp 0.736626108762
* device instance topp_t381 r0 *1 0,0
Rtopp_t381 topp__t381 topp 1.45336008206
* device instance topp_t382 r0 *1 0,0
Rtopp_t382 topp__t382 topp 1.36603421199
* device instance topp_t383 r0 *1 0,0
Rtopp_t383 topp__t383 topp 1.27925460904
* device instance topp_t384 r0 *1 0,0
Rtopp_t384 topp__t384 topp 1.1931404726
* device instance topp_t385 r0 *1 0,0
Rtopp_t385 topp__t385 topp 1.10784699582
* device instance topp_t386 r0 *1 0,0
Rtopp_t386 topp__t386 topp 1.02357935264
* device instance topp_t387 r0 *1 0,0
Rtopp_t387 topp__t387 topp 1.41300581592
* device instance topp_t388 r0 *1 0,0
Rtopp_t388 topp__t388 topp 1.32301903843
* device instance topp_t389 r0 *1 0,0
Rtopp_t389 topp__t389 topp 1.23321622697
* device instance topp_t390 r0 *1 0,0
Rtopp_t390 topp__t390 topp 0.819927716641
* device instance topp_t391 r0 *1 0,0
Rtopp_t391 topp__t391 topp 0.626466624284
* device instance topp_t392 r0 *1 0,0
Rtopp_t392 topp__t392 topp 0.713138688594
* device instance topp_t393 r0 *1 0,0
Rtopp_t393 topp__t393 topp 0.631979041684
* device instance topp_t394 r0 *1 0,0
Rtopp_t394 topp__t394 topp 0.565403317388
* device instance topp_t395 r0 *1 0,0
Rtopp_t395 topp__t395 topp 1.05435045117
* device instance topp_t396 r0 *1 0,0
Rtopp_t396 topp__t396 topp 0.965424569233
* device instance topp_t397 r0 *1 0,0
Rtopp_t397 topp__t397 topp 0.876973927822
* device instance topp_t398 r0 *1 0,0
Rtopp_t398 topp__t398 topp 0.789158341195
* device instance topp_t399 r0 *1 0,0
Rtopp_t399 topp__t399 topp 0.70221609998
* device instance topp_t400 r0 *1 0,0
Rtopp_t400 topp__t400 topp 0.616516796903
* device instance topp_t401 r0 *1 0,0
Rtopp_t401 topp__t401 topp 1.39568885999
* device instance topp_t402 r0 *1 0,0
Rtopp_t402 topp__t402 topp 1.30450808128
* device instance topp_t403 r0 *1 0,0
Rtopp_t403 topp__t403 topp 1.21333598831
* device instance topp_t404 r0 *1 0,0
Rtopp_t404 topp__t404 topp 1.12217469814
* device instance topp_t405 r0 *1 0,0
Rtopp_t405 topp__t405 topp 1.03102707624
* device instance topp_t406 r0 *1 0,0
Rtopp_t406 topp__t406 topp 1.1436407194
* device instance topp_t407 r0 *1 0,0
Rtopp_t407 topp__t407 topp 0.84879045008
* device instance topp_t408 r0 *1 0,0
Rtopp_t408 topp__t408 topp 0.75771554395
* device instance topp_t409 r0 *1 0,0
Rtopp_t409 topp__t409 topp 0.666685389924
* device instance topp_t410 r0 *1 0,0
Rtopp_t410 topp__t410 topp 0.575721216328
* device instance topp_t411 r0 *1 0,0
Rtopp_t411 topp__t411 topp 0.484860160169
* device instance topp_t412 r0 *1 0,0
Rtopp_t412 topp__t412 topp 0.394173536789
* device instance topp_t413 r0 *1 0,0
Rtopp_t413 topp__t413 topp 0.303817585877
* device instance topp_t414 r0 *1 0,0
Rtopp_t414 topp__t414 topp 0.506570093568
* device instance topp_t415 r0 *1 0,0
Rtopp_t415 topp__t415 topp 0.43641005999
* device instance topp_t416 r0 *1 0,0
Rtopp_t416 topp__t416 topp 1.39553256084
* device instance topp_t417 r0 *1 0,0
Rtopp_t417 topp__t417 topp 0.254469453531
* device instance topp_t418 r0 *1 0,0
Rtopp_t418 topp__t418 topp 0.227230917253
* device instance topp_t419 r0 *1 0,0
Rtopp_t419 topp__t419 topp 0.274479693779
* device instance topp_t420 r0 *1 0,0
Rtopp_t420 topp__t420 topp 0.939897099126
* device instance topp_t421 r0 *1 0,0
Rtopp_t421 topp__t421 topp 1.43041812379
* device instance topp_t422 r0 *1 0,0
Rtopp_t422 topp__t422 topp 1.34159977232
* device instance topp_t423 r0 *1 0,0
Rtopp_t423 topp__t423 topp 1.2531292174
* device instance topp_t424 r0 *1 0,0
Rtopp_t424 topp__t424 topp 1.16508569132
* device instance topp_t425 r0 *1 0,0
Rtopp_t425 topp__t425 topp 1.07757387075
* device instance topp_t426 r0 *1 0,0
Rtopp_t426 topp__t426 topp 0.990734662722
* device instance topp_t427 r0 *1 0,0
Rtopp_t427 topp__t427 topp 1.4013293007
* device instance topp_t428 r0 *1 0,0
Rtopp_t428 topp__t428 topp 1.31054101394
* device instance topp_t429 r0 *1 0,0
Rtopp_t429 topp__t429 topp 1.21981991934
* device instance topp_t430 r0 *1 0,0
Rtopp_t430 topp__t430 topp 1.12918221215
* device instance topp_t431 r0 *1 0,0
Rtopp_t431 topp__t431 topp 1.03864972297
* device instance topp_t432 r0 *1 0,0
Rtopp_t432 topp__t432 topp 0.948252588732
* device instance topp_t433 r0 *1 0,0
Rtopp_t433 topp__t433 topp 0.704104433403
* device instance topp_t434 r0 *1 0,0
Rtopp_t434 topp__t434 topp 0.76805550622
* device instance topp_t435 r0 *1 0,0
Rtopp_t435 topp__t435 topp 0.678414198134
* device instance topp_t436 r0 *1 0,0
Rtopp_t436 topp__t436 topp 0.589263382556
* device instance topp_t437 r0 *1 0,0
Rtopp_t437 topp__t437 topp 0.500865041713
* device instance topp_t438 r0 *1 0,0
Rtopp_t438 topp__t438 topp 0.413701815559
* device instance topp_t439 r0 *1 0,0
Rtopp_t439 topp__t439 topp 0.328757571137
* device instance topp_t440 r0 *1 0,0
Rtopp_t440 topp__t440 topp 0.655441480151
* device instance topp_t441 r0 *1 0,0
Rtopp_t441 topp__t441 topp 0.577267693441
* device instance topp_t442 r0 *1 0,0
Rtopp_t442 topp__t442 topp 0.503509078446
* device instance topp_t443 r0 *1 0,0
Rtopp_t443 topp__t443 topp 0.940613290548
* device instance topp_t444 r0 *1 0,0
Rtopp_t444 topp__t444 topp 0.859325886816
* device instance topp_t445 r0 *1 0,0
Rtopp_t445 topp__t445 topp 0.780241977432
* device instance topp_t446 r0 *1 0,0
Rtopp_t446 topp__t446 topp 0.532660695802
* device instance topp_t447 r0 *1 0,0
Rtopp_t447 topp__t447 topp 0.451675568344
* device instance topp_t448 r0 *1 0,0
Rtopp_t448 topp__t448 topp 0.375423983547
* device instance topp_t449 r0 *1 0,0
Rtopp_t449 topp__t449 topp 0.858033590973
* device instance topp_t450 r0 *1 0,0
Rtopp_t450 topp__t450 topp 0.684984926911
* device instance topp_t451 r0 *1 0,0
Rtopp_t451 topp__t451 topp 1.14195944098
* device instance topp_t452 r0 *1 0,0
Rtopp_t452 topp__t452 topp 1.22095778231
* device instance topp_t453 r0 *1 0,0
Rtopp_t453 topp__t453 topp 1.30155806391
* device instance topp_t454 r0 *1 0,0
Rtopp_t454 topp__t454 topp 1.38348033143
* device instance topp_t455 r0 *1 0,0
Rtopp_t455 topp__t455 topp 1.466503054
* device instance topp_t456 r0 *1 0,0
Rtopp_t456 topp__t456 topp 1.55044946177
* device instance topp_t457 r0 *1 0,0
Rtopp_t457 topp__t457 topp 0.234865968007
* device instance topp_t458 r0 *1 0,0
Rtopp_t458 topp__t458 topp 1.01824025389
* device instance topp_t459 r0 *1 0,0
Rtopp_t459 topp__t459 topp 0.952444107672
* device instance topp_t460 r0 *1 0,0
Rtopp_t460 topp__t460 topp 0.891142686684
* device instance topp_t461 r0 *1 0,0
Rtopp_t461 topp__t461 topp 0.835326130334
* device instance topp_t462 r0 *1 0,0
Rtopp_t462 topp__t462 topp 0.786163561993
* device instance topp_t463 r0 *1 0,0
Rtopp_t463 topp__t463 topp 1.51476777269
* device instance topp_t464 r0 *1 0,0
Rtopp_t464 topp__t464 topp 1.4311936785
* device instance topp_t465 r0 *1 0,0
Rtopp_t465 topp__t465 topp 1.34861344788
* device instance topp_t466 r0 *1 0,0
Rtopp_t466 topp__t466 topp 1.26722139518
* device instance topp_t467 r0 *1 0,0
Rtopp_t467 topp__t467 topp 1.18726191012
* device instance topp_t468 r0 *1 0,0
Rtopp_t468 topp__t468 topp 1.10904489008
* device instance topp_t469 r0 *1 0,0
Rtopp_t469 topp__t469 topp 1.03296623344
* device instance topp_t470 r0 *1 0,0
Rtopp_t470 topp__t470 topp 0.9595347085
* device instance topp_t471 r0 *1 0,0
Rtopp_t471 topp__t471 topp 1.08771577043
* device instance topp_t472 r0 *1 0,0
Rtopp_t472 topp__t472 topp 0.823425121187
* device instance topp_t473 r0 *1 0,0
Rtopp_t473 topp__t473 topp 0.762668595257
* device instance topp_t474 r0 *1 0,0
Rtopp_t474 topp__t474 topp 0.70848203109
* device instance topp_t475 r0 *1 0,0
Rtopp_t475 topp__t475 topp 0.662479536862
* device instance topp_t476 r0 *1 0,0
Rtopp_t476 topp__t476 topp 0.744973485829
* device instance topp_t477 r0 *1 0,0
Rtopp_t477 topp__t477 topp 1.55261964531
* device instance topp_t478 r0 *1 0,0
Rtopp_t478 topp__t478 topp 1.47119737059
* device instance topp_t479 r0 *1 0,0
Rtopp_t479 topp__t479 topp 1.39099410122
* device instance topp_t480 r0 *1 0,0
Rtopp_t480 topp__t480 topp 1.31223337187
* device instance topp_t481 r0 *1 0,0
Rtopp_t481 topp__t481 topp 0.889406217884
* device instance topp_t482 r0 *1 0,0
Rtopp_t482 topp__t482 topp 0.725401581905
* device instance topp_t483 r0 *1 0,0
Rtopp_t483 topp__t483 topp 0.761368785015
* device instance topp_t484 r0 *1 0,0
Rtopp_t484 topp__t484 topp 0.806105665999
* device instance topp_t485 r0 *1 0,0
Rtopp_t485 topp__t485 topp 0.858241929129
* device instance topp_t486 r0 *1 0,0
Rtopp_t486 topp__t486 topp 0.916515695048
* device instance topp_t487 r0 *1 0,0
Rtopp_t487 topp__t487 topp 0.979832524375
* device instance topp_t488 r0 *1 0,0
Rtopp_t488 topp__t488 topp 1.04727812857
* device instance topp_t489 r0 *1 0,0
Rtopp_t489 topp__t489 topp 1.11810559766
* device instance topp_t490 r0 *1 0,0
Rtopp_t490 topp__t490 topp 1.19171209722
* device instance topp_t491 r0 *1 0,0
Rtopp_t491 topp__t491 topp 1.2676136099
* device instance topp_t492 r0 *1 0,0
Rtopp_t492 topp__t492 topp 1.34542177459
* device instance topp_t493 r0 *1 0,0
Rtopp_t493 topp__t493 topp 1.4248242647
* device instance topp_t494 r0 *1 0,0
Rtopp_t494 topp__t494 topp 1.50556885104
* device instance topp_t495 r0 *1 0,0
Rtopp_t495 topp__t495 topp 0.691951609542
* device instance topp_t496 r0 *1 0,0
Rtopp_t496 topp__t496 topp 0.699558024373
* device instance topp_t497 r0 *1 0,0
Rtopp_t497 topp__t497 topp 1.23519115972
* device instance topp_t498 r0 *1 0,0
Rtopp_t498 topp__t498 topp 1.06491960715
* device instance topp_t499 r0 *1 0,0
Rtopp_t499 topp__t499 topp 0.990295471435
* device instance topp_t500 r0 *1 0,0
Rtopp_t500 topp__t500 topp 0.918675904764
* device instance topp_t501 r0 *1 0,0
Rtopp_t501 topp__t501 topp 0.85081999356
* device instance topp_t502 r0 *1 0,0
Rtopp_t502 topp__t502 topp 0.787700990914
* device instance topp_t503 r0 *1 0,0
Rtopp_t503 topp__t503 topp 0.730547730767
* device instance topp_t504 r0 *1 0,0
Rtopp_t504 topp__t504 topp 0.680864207436
* device instance topp_t505 r0 *1 0,0
Rtopp_t505 topp__t505 topp 0.64039136253
* device instance topp_t506 r0 *1 0,0
Rtopp_t506 topp__t506 topp 0.610962414258
* device instance topp_t507 r0 *1 0,0
Rtopp_t507 topp__t507 topp 0.594220491288
* device instance topp_t508 r0 *1 0,0
Rtopp_t508 topp__t508 topp 0.591244331131
* device instance topp_t509 r0 *1 0,0
Rtopp_t509 topp__t509 topp 0.6022380527
* device instance topp_t510 r0 *1 0,0
Rtopp_t510 topp__t510 topp 1.16020986293
* device instance topp_t511 r0 *1 0,0
Rtopp_t511 topp__t511 topp 0.682404731023
* device instance topp_t512 r0 *1 0,0
Rtopp_t512 topp__t512 topp 5.03077510656
* device instance topp_t513 r0 *1 0,0
Rtopp_t513 topp__t513 topp 4.94430761921
* device instance topp r0 *1 0,0
Ctopp topp vsubs 2.3701441e-13
* device instance tp_gn_t0 r0 *1 0,0
Rtp_gn_t0 tp_gn__t0 tp_gn 31.7522969677
* device instance tp_gn_t1 r0 *1 0,0
Rtp_gn_t1 tp_gn__t1 tp_gn 100.696431059
* device instance tp_gn_t2 r0 *1 0,0
Rtp_gn_t2 tp_gn__t2 tp_gn 64.5097300968
* device instance tp_gn_t3 r0 *1 0,0
Rtp_gn_t3 tp_gn__t3 tp_gn 70.2913261279
* device instance tp_gn_t4 r0 *1 0,0
Rtp_gn_t4 tp_gn__t4 tp_gn 99.0585228122
* device instance tp_gn_t5 r0 *1 0,0
Rtp_gn_t5 tp_gn__t5 tp_gn 38.2150929367
* device instance tp_gn r0 *1 0,0
Ctp_gn tp_gn vsubs 4.986478e-15
* device instance vcm_t0 r0 *1 0,0
Rvcm_t0 vcm__t0 vcm 412.602375568
* device instance vcm_t1 r0 *1 0,0
Rvcm_t1 vcm__t1 vcm 147.734301397
* device instance vcm_t2 r0 *1 0,0
Rvcm_t2 vcm__t2 vcm 388.410016513
* device instance vcm_t3 r0 *1 0,0
Rvcm_t3 vcm__t3 vcm 366.314563362
* device instance vcm_t4 r0 *1 0,0
Rvcm_t4 vcm__t4 vcm 41.1736191558
* device instance vcm_t5 r0 *1 0,0
Rvcm_t5 vcm__t5 vcm 158.235399068
* device instance vcm_t6 r0 *1 0,0
Rvcm_t6 vcm__t6 vcm 255.51200792
* device instance vcm_t7 r0 *1 0,0
Rvcm_t7 vcm__t7 vcm 317.760002863
* device instance vcm_t8 r0 *1 0,0
Rvcm_t8 vcm__t8 vcm 153.969811947
* device instance vcm_t9 r0 *1 0,0
Rvcm_t9 vcm__t9 vcm 234.732755553
* device instance vcm_t10 r0 *1 0,0
Rvcm_t10 vcm__t10 vcm 315.65753736
* device instance vcm_t11 r0 *1 0,0
Rvcm_t11 vcm__t11 vcm 73.9012197258
* device instance vcm_t12 r0 *1 0,0
Rvcm_t12 vcm__t12 vcm 82.4204392372
* device instance vcm_t13 r0 *1 0,0
Rvcm_t13 vcm__t13 vcm 98.7160364331
* device instance vcm_t14 r0 *1 0,0
Rvcm_t14 vcm__t14 vcm 237.552531151
* device instance vcm_t15 r0 *1 0,0
Rvcm_t15 vcm__t15 vcm 91.7230468419
* device instance vcm_t16 r0 *1 0,0
Rvcm_t16 vcm__t16 vcm 172.076021226
* device instance vcm_t17 r0 *1 0,0
Rvcm_t17 vcm__t17 vcm 19.0664204109
* device instance vcm_t18 r0 *1 0,0
Rvcm_t18 vcm__t18 vcm 175.90308584
* device instance vcm_t19 r0 *1 0,0
Rvcm_t19 vcm__t19 vcm 333.836171006
* device instance vcm_t20 r0 *1 0,0
Rvcm_t20 vcm__t20 vcm 252.892561505
* device instance vcm_t21 r0 *1 0,0
Rvcm_t21 vcm__t21 vcm 335.824846608
* device instance vcm_t22 r0 *1 0,0
Rvcm_t22 vcm__t22 vcm 375.811834767
* device instance vcm_t23 r0 *1 0,0
Rvcm_t23 vcm__t23 vcm 50.3438780536
* device instance vcm_t24 r0 *1 0,0
Rvcm_t24 vcm__t24 vcm 353.64688687
* device instance vcm_t25 r0 *1 0,0
Rvcm_t25 vcm__t25 vcm 112.82832019
* device instance vcm_t26 r0 *1 0,0
Rvcm_t26 vcm__t26 vcm 57.8179802216
* device instance vcm_t27 r0 *1 0,0
Rvcm_t27 vcm__t27 vcm 377.089836369
* device instance vcm_t28 r0 *1 0,0
Rvcm_t28 vcm__t28 vcm 122.533693892
* device instance vcm_t29 r0 *1 0,0
Rvcm_t29 vcm__t29 vcm 130.987863576
* device instance vcm_t30 r0 *1 0,0
Rvcm_t30 vcm__t30 vcm 296.868788984
* device instance vcm_t31 r0 *1 0,0
Rvcm_t31 vcm__t31 vcm 217.285208603
* device instance vcm_t32 r0 *1 0,0
Rvcm_t32 vcm__t32 vcm 199.583426829
* device instance vcm_t33 r0 *1 0,0
Rvcm_t33 vcm__t33 vcm 69.4174499633
* device instance vcm_t34 r0 *1 0,0
Rvcm_t34 vcm__t34 vcm 278.926573161
* device instance vcm_t35 r0 *1 0,0
Rvcm_t35 vcm__t35 vcm 139.43491925
* device instance vcm_t36 r0 *1 0,0
Rvcm_t36 vcm__t36 vcm 211.963642108
* device instance vcm_t37 r0 *1 0,0
Rvcm_t37 vcm__t37 vcm 274.801304425
* device instance vcm_t38 r0 *1 0,0
Rvcm_t38 vcm__t38 vcm 193.776334889
* device instance vcm_t39 r0 *1 0,0
Rvcm_t39 vcm__t39 vcm 32.5367874101
* device instance vcm_t40 r0 *1 0,0
Rvcm_t40 vcm__t40 vcm 292.996248391
* device instance vcm_t41 r0 *1 0,0
Rvcm_t41 vcm__t41 vcm 374.048751356
* device instance vcm r0 *1 0,0
Cvcm vcm vsubs 2.71382523e-13
* device instance vdd_t0 r0 *1 0,0
Rvdd_t0 vdd__t0 vdd 216.30897829
* device instance vdd_t1 r0 *1 0,0
Rvdd_t1 vdd__t1 vdd 216.30897829
* device instance vdd_t2 r0 *1 0,0
Rvdd_t2 vdd__t2 vdd 203.665576581
* device instance vdd_t3 r0 *1 0,0
Rvdd_t3 vdd__t3 vdd 247.462427696
* device instance vdd_t4 r0 *1 0,0
Rvdd_t4 vdd__t4 vdd 233.926193941
* device instance vdd_t5 r0 *1 0,0
Rvdd_t5 vdd__t5 vdd 14.8596344983
* device instance vdd_t6 r0 *1 0,0
Rvdd_t6 vdd__t6 vdd 20.5092039028
* device instance vdd_t7 r0 *1 0,0
Rvdd_t7 vdd__t7 vdd 98.3678536467
* device instance vdd_t8 r0 *1 0,0
Rvdd_t8 vdd__t8 vdd 101.311032582
* device instance vdd_t9 r0 *1 0,0
Rvdd_t9 vdd__t9 vdd 104.256094112
* device instance vdd_t10 r0 *1 0,0
Rvdd_t10 vdd__t10 vdd 107.202883083
* device instance vdd_t11 r0 *1 0,0
Rvdd_t11 vdd__t11 vdd 54.9876416723
* device instance vdd_t12 r0 *1 0,0
Rvdd_t12 vdd__t12 vdd 15.1733813242
* device instance vdd_t13 r0 *1 0,0
Rvdd_t13 vdd__t13 vdd 197.729247134
* device instance vdd_t14 r0 *1 0,0
Rvdd_t14 vdd__t14 vdd 49.4634654791
* device instance vdd_t15 r0 *1 0,0
Rvdd_t15 vdd__t15 vdd 144.897405701
* device instance vdd_t16 r0 *1 0,0
Rvdd_t16 vdd__t16 vdd 147.858364257
* device instance vdd_t17 r0 *1 0,0
Rvdd_t17 vdd__t17 vdd 150.819928151
* device instance vdd_t18 r0 *1 0,0
Rvdd_t18 vdd__t18 vdd 59.6596703087
* device instance vdd_t19 r0 *1 0,0
Rvdd_t19 vdd__t19 vdd 95.239489394
* device instance vdd_t20 r0 *1 0,0
Rvdd_t20 vdd__t20 vdd 197.918270521
* device instance vdd_t21 r0 *1 0,0
Rvdd_t21 vdd__t21 vdd 200.886329976
* device instance vdd_t22 r0 *1 0,0
Rvdd_t22 vdd__t22 vdd 194.761456489
* device instance vdd_t23 r0 *1 0,0
Rvdd_t23 vdd__t23 vdd 16.0427992955
* device instance vdd_t24 r0 *1 0,0
Rvdd_t24 vdd__t24 vdd 99.3309144978
* device instance vdd_t25 r0 *1 0,0
Rvdd_t25 vdd__t25 vdd 102.246375323
* device instance vdd_t26 r0 *1 0,0
Rvdd_t26 vdd__t26 vdd 105.165246652
* device instance vdd_t27 r0 *1 0,0
Rvdd_t27 vdd__t27 vdd 108.087252187
* device instance vdd_t28 r0 *1 0,0
Rvdd_t28 vdd__t28 vdd 148.68859978
* device instance vdd_t29 r0 *1 0,0
Rvdd_t29 vdd__t29 vdd 151.637669901
* device instance vdd_t30 r0 *1 0,0
Rvdd_t30 vdd__t30 vdd 154.587785114
* device instance vdd_t31 r0 *1 0,0
Rvdd_t31 vdd__t31 vdd 157.538886707
* device instance vdd_t32 r0 *1 0,0
Rvdd_t32 vdd__t32 vdd 21.1605140096
* device instance vdd_t33 r0 *1 0,0
Rvdd_t33 vdd__t33 vdd 201.359662085
* device instance vdd_t34 r0 *1 0,0
Rvdd_t34 vdd__t34 vdd 204.32108659
* device instance vdd_t35 r0 *1 0,0
Rvdd_t35 vdd__t35 vdd 207.282938228
* device instance vdd_t36 r0 *1 0,0
Rvdd_t36 vdd__t36 vdd 56.8695332866
* device instance vdd_t37 r0 *1 0,0
Rvdd_t37 vdd__t37 vdd 54.0992469093
* device instance vdd_t38 r0 *1 0,0
Rvdd_t38 vdd__t38 vdd 52.3099662802
* device instance vdd_t39 r0 *1 0,0
Rvdd_t39 vdd__t39 vdd 55.1701719439
* device instance vdd_t40 r0 *1 0,0
Rvdd_t40 vdd__t40 vdd 58.0420564542
* device instance vdd_t41 r0 *1 0,0
Rvdd_t41 vdd__t41 vdd 51.3520239242
* device instance vdd_t42 r0 *1 0,0
Rvdd_t42 vdd__t42 vdd 198.398683841
* device instance vdd_t43 r0 *1 0,0
Rvdd_t43 vdd__t43 vdd 153.78206241
* device instance vdd_t44 r0 *1 0,0
Rvdd_t44 vdd__t44 vdd 52.1282439598
* device instance vdd_t45 r0 *1 0,0
Rvdd_t45 vdd__t45 vdd 49.2826951884
* device instance vdd_t46 r0 *1 0,0
Rvdd_t46 vdd__t46 vdd 46.4535404115
* device instance vdd_t47 r0 *1 0,0
Rvdd_t47 vdd__t47 vdd 15.1361527171
* device instance vdd_t48 r0 *1 0,0
Rvdd_t48 vdd__t48 vdd 148.046964713
* device instance vdd_t49 r0 *1 0,0
Rvdd_t49 vdd__t49 vdd 151.008565946
* device instance vdd_t50 r0 *1 0,0
Rvdd_t50 vdd__t50 vdd 153.970735409
* device instance vdd_t51 r0 *1 0,0
Rvdd_t51 vdd__t51 vdd 156.933440926
* device instance vdd_t52 r0 *1 0,0
Rvdd_t52 vdd__t52 vdd 203.854630757
* device instance vdd_t53 r0 *1 0,0
Rvdd_t53 vdd__t53 vdd 20.481676274
* device instance vdd_t54 r0 *1 0,0
Rvdd_t54 vdd__t54 vdd 48.459543546
* device instance vdd_t55 r0 *1 0,0
Rvdd_t55 vdd__t55 vdd 51.1779248207
* device instance vdd_t56 r0 *1 0,0
Rvdd_t56 vdd__t56 vdd 53.9235547999
* device instance vdd_t57 r0 *1 0,0
Rvdd_t57 vdd__t57 vdd 56.6924746381
* device instance vdd_t58 r0 *1 0,0
Rvdd_t58 vdd__t58 vdd 96.2338624599
* device instance vdd_t59 r0 *1 0,0
Rvdd_t59 vdd__t59 vdd 99.1453551555
* device instance vdd_t60 r0 *1 0,0
Rvdd_t60 vdd__t60 vdd 102.060588666
* device instance vdd_t61 r0 *1 0,0
Rvdd_t61 vdd__t61 vdd 104.97925135
* device instance vdd_t62 r0 *1 0,0
Rvdd_t62 vdd__t62 vdd 20.2781823973
* device instance vdd_t63 r0 *1 0,0
Rvdd_t63 vdd__t63 vdd 206.823162476
* device instance vdd_t64 r0 *1 0,0
Rvdd_t64 vdd__t64 vdd 98.1804741534
* device instance vdd_t65 r0 *1 0,0
Rvdd_t65 vdd__t65 vdd 204.132464414
* device instance vdd_t66 r0 *1 0,0
Rvdd_t66 vdd__t66 vdd 101.123527505
* device instance vdd_t67 r0 *1 0,0
Rvdd_t67 vdd__t67 vdd 201.171067749
* device instance vdd_t68 r0 *1 0,0
Rvdd_t68 vdd__t68 vdd 198.210118601
* device instance vdd_t69 r0 *1 0,0
Rvdd_t69 vdd__t69 vdd 195.24963733
* device instance vdd_t70 r0 *1 0,0
Rvdd_t70 vdd__t70 vdd 154.399866137
* device instance vdd_t71 r0 *1 0,0
Rvdd_t71 vdd__t71 vdd 151.449815686
* device instance vdd_t72 r0 *1 0,0
Rvdd_t72 vdd__t72 vdd 148.500814222
* device instance vdd_t73 r0 *1 0,0
Rvdd_t73 vdd__t73 vdd 145.552925505
* device instance vdd_t74 r0 *1 0,0
Rvdd_t74 vdd__t74 vdd 200.697290852
* device instance vdd_t75 r0 *1 0,0
Rvdd_t75 vdd__t75 vdd 104.068473949
* device instance vdd_t76 r0 *1 0,0
Rvdd_t76 vdd__t76 vdd 66.6050412888
* device instance vdd_t77 r0 *1 0,0
Rvdd_t77 vdd__t77 vdd 60.6591204368
* device instance vdd_t78 r0 *1 0,0
Rvdd_t78 vdd__t78 vdd 108.086247845
* device instance vdd_t79 r0 *1 0,0
Rvdd_t79 vdd__t79 vdd 63.6284981574
* device instance vdd_t80 r0 *1 0,0
Rvdd_t80 vdd__t80 vdd 112.992376321
* device instance vdd_t81 r0 *1 0,0
Rvdd_t81 vdd__t81 vdd 22.8800674776
* device instance vdd_t82 r0 *1 0,0
Rvdd_t82 vdd__t82 vdd 21.8692678148
* device instance vdd_t83 r0 *1 0,0
Rvdd_t83 vdd__t83 vdd 68.4221245133
* device instance vdd_t84 r0 *1 0,0
Rvdd_t84 vdd__t84 vdd 15.2613655
* device instance vdd_t85 r0 *1 0,0
Rvdd_t85 vdd__t85 vdd 65.528172381
* device instance vdd_t86 r0 *1 0,0
Rvdd_t86 vdd__t86 vdd 109.96810815
* device instance vdd_t87 r0 *1 0,0
Rvdd_t87 vdd__t87 vdd 62.6488985538
* device instance vdd_t88 r0 *1 0,0
Rvdd_t88 vdd__t88 vdd 59.786423761
* device instance vdd_t89 r0 *1 0,0
Rvdd_t89 vdd__t89 vdd 106.945226052
* device instance vdd_t90 r0 *1 0,0
Rvdd_t90 vdd__t90 vdd 16.6775864545
* device instance vdd_t91 r0 *1 0,0
Rvdd_t91 vdd__t91 vdd 18.4922514772
* device instance vdd_t92 r0 *1 0,0
Rvdd_t92 vdd__t92 vdd 20.60033255
* device instance vdd_t93 r0 *1 0,0
Rvdd_t93 vdd__t93 vdd 57.6980144225
* device instance vdd_t94 r0 *1 0,0
Rvdd_t94 vdd__t94 vdd 48.9303811462
* device instance vdd_t95 r0 *1 0,0
Rvdd_t95 vdd__t95 vdd 192.454250762
* device instance vdd_t96 r0 *1 0,0
Rvdd_t96 vdd__t96 vdd 195.484903935
* device instance vdd_t97 r0 *1 0,0
Rvdd_t97 vdd__t97 vdd 135.87204909
* device instance vdd_t98 r0 *1 0,0
Rvdd_t98 vdd__t98 vdd 138.904678179
* device instance vdd_t99 r0 *1 0,0
Rvdd_t99 vdd__t99 vdd 141.937994835
* device instance vdd_t100 r0 *1 0,0
Rvdd_t100 vdd__t100 vdd 144.971955899
* device instance vdd_t101 r0 *1 0,0
Rvdd_t101 vdd__t101 vdd 116.01792217
* device instance vdd_t102 r0 *1 0,0
Rvdd_t102 vdd__t102 vdd 185.735380482
* device instance vdd_t103 r0 *1 0,0
Rvdd_t103 vdd__t103 vdd 188.77542973
* device instance vdd_t104 r0 *1 0,0
Rvdd_t104 vdd__t104 vdd 191.815752842
* device instance vdd_t105 r0 *1 0,0
Rvdd_t105 vdd__t105 vdd 194.856336999
* device instance vdd_t106 r0 *1 0,0
Rvdd_t106 vdd__t106 vdd 139.785067935
* device instance vdd_t107 r0 *1 0,0
Rvdd_t107 vdd__t107 vdd 142.799684788
* device instance vdd_t108 r0 *1 0,0
Rvdd_t108 vdd__t108 vdd 145.815717929
* device instance vdd_t109 r0 *1 0,0
Rvdd_t109 vdd__t109 vdd 186.394707974
* device instance vdd_t110 r0 *1 0,0
Rvdd_t110 vdd__t110 vdd 136.771961021
* device instance vdd_t111 r0 *1 0,0
Rvdd_t111 vdd__t111 vdd 229.591965661
* device instance vdd_t112 r0 *1 0,0
Rvdd_t112 vdd__t112 vdd 243.197142814
* device instance vdd_t113 r0 *1 0,0
Rvdd_t113 vdd__t113 vdd 87.6482766423
* device instance vdd_t114 r0 *1 0,0
Rvdd_t114 vdd__t114 vdd 90.6106002827
* device instance vdd_t115 r0 *1 0,0
Rvdd_t115 vdd__t115 vdd 93.5784709777
* device instance vdd_t116 r0 *1 0,0
Rvdd_t116 vdd__t116 vdd 96.5513771999
* device instance vdd_t117 r0 *1 0,0
Rvdd_t117 vdd__t117 vdd 37.7436722245
* device instance vdd_t118 r0 *1 0,0
Rvdd_t118 vdd__t118 vdd 46.1971795815
* device instance vdd_t119 r0 *1 0,0
Rvdd_t119 vdd__t119 vdd 43.4606005879
* device instance vdd_t120 r0 *1 0,0
Rvdd_t120 vdd__t120 vdd 46.3554376668
* device instance vdd_t121 r0 *1 0,0
Rvdd_t121 vdd__t121 vdd 86.2372587722
* device instance vdd_t122 r0 *1 0,0
Rvdd_t122 vdd__t122 vdd 89.2464301009
* device instance vdd_t123 r0 *1 0,0
Rvdd_t123 vdd__t123 vdd 92.2581954771
* device instance vdd_t124 r0 *1 0,0
Rvdd_t124 vdd__t124 vdd 95.2723088907
* device instance vdd_t125 r0 *1 0,0
Rvdd_t125 vdd__t125 vdd 40.8649041455
* device instance vdd_t126 r0 *1 0,0
Rvdd_t126 vdd__t126 vdd 43.5059244838
* device instance vdd_t127 r0 *1 0,0
Rvdd_t127 vdd__t127 vdd 40.5882971725
* device instance vdd_t128 r0 *1 0,0
Rvdd_t128 vdd__t128 vdd 114.072927132
* device instance vdd_t129 r0 *1 0,0
Rvdd_t129 vdd__t129 vdd 189.424176038
* device instance vdd_t130 r0 *1 0,0
Rvdd_t130 vdd__t130 vdd 159.745139656
* device instance vdd_t131 r0 *1 0,0
Rvdd_t131 vdd__t131 vdd 162.782177621
* device instance vdd_t132 r0 *1 0,0
Rvdd_t132 vdd__t132 vdd 165.819642745
* device instance vdd_t133 r0 *1 0,0
Rvdd_t133 vdd__t133 vdd 160.51126204
* device instance vdd_t134 r0 *1 0,0
Rvdd_t134 vdd__t134 vdd 157.489448523
* device instance vdd_t135 r0 *1 0,0
Rvdd_t135 vdd__t135 vdd 210.241430244
* device instance vdd_t136 r0 *1 0,0
Rvdd_t136 vdd__t136 vdd 213.274991758
* device instance vdd_t137 r0 *1 0,0
Rvdd_t137 vdd__t137 vdd 117.070550791
* device instance vdd_t138 r0 *1 0,0
Rvdd_t138 vdd__t138 vdd 206.615413599
* device instance vdd_t139 r0 *1 0,0
Rvdd_t139 vdd__t139 vdd 209.657109093
* device instance vdd_t140 r0 *1 0,0
Rvdd_t140 vdd__t140 vdd 212.699004491
* device instance vdd_t141 r0 *1 0,0
Rvdd_t141 vdd__t141 vdd 215.741091337
* device instance vdd_t142 r0 *1 0,0
Rvdd_t142 vdd__t142 vdd 25.8791286369
* device instance vdd_t143 r0 *1 0,0
Rvdd_t143 vdd__t143 vdd 24.2346644814
* device instance vdd_t144 r0 *1 0,0
Rvdd_t144 vdd__t144 vdd 111.078082482
* device instance vdd_t145 r0 *1 0,0
Rvdd_t145 vdd__t145 vdd 207.208312417
* device instance vdd_t146 r0 *1 0,0
Rvdd_t146 vdd__t146 vdd 163.534072746
* device instance vdd_t147 r0 *1 0,0
Rvdd_t147 vdd__t147 vdd 166.557826348
* device instance vdd_t148 r0 *1 0,0
Rvdd_t148 vdd__t148 vdd 156.708553686
* device instance vdd_t149 r0 *1 0,0
Rvdd_t149 vdd__t149 vdd 66.6050412888
* device instance vdd_t150 r0 *1 0,0
Rvdd_t150 vdd__t150 vdd 60.6591204368
* device instance vdd_t151 r0 *1 0,0
Rvdd_t151 vdd__t151 vdd 108.086247845
* device instance vdd_t152 r0 *1 0,0
Rvdd_t152 vdd__t152 vdd 63.6284981574
* device instance vdd_t153 r0 *1 0,0
Rvdd_t153 vdd__t153 vdd 112.992376321
* device instance vdd_t154 r0 *1 0,0
Rvdd_t154 vdd__t154 vdd 22.8800674776
* device instance vdd_t155 r0 *1 0,0
Rvdd_t155 vdd__t155 vdd 21.8692678148
* device instance vdd_t156 r0 *1 0,0
Rvdd_t156 vdd__t156 vdd 68.4221245133
* device instance vdd_t157 r0 *1 0,0
Rvdd_t157 vdd__t157 vdd 15.2613655
* device instance vdd_t158 r0 *1 0,0
Rvdd_t158 vdd__t158 vdd 65.528172381
* device instance vdd_t159 r0 *1 0,0
Rvdd_t159 vdd__t159 vdd 109.96810815
* device instance vdd_t160 r0 *1 0,0
Rvdd_t160 vdd__t160 vdd 62.6488985538
* device instance vdd_t161 r0 *1 0,0
Rvdd_t161 vdd__t161 vdd 59.786423761
* device instance vdd_t162 r0 *1 0,0
Rvdd_t162 vdd__t162 vdd 106.945226052
* device instance vdd_t163 r0 *1 0,0
Rvdd_t163 vdd__t163 vdd 16.6775864545
* device instance vdd_t164 r0 *1 0,0
Rvdd_t164 vdd__t164 vdd 18.4922514772
* device instance vdd_t165 r0 *1 0,0
Rvdd_t165 vdd__t165 vdd 20.60033255
* device instance vdd_t166 r0 *1 0,0
Rvdd_t166 vdd__t166 vdd 57.6980144225
* device instance vdd_t167 r0 *1 0,0
Rvdd_t167 vdd__t167 vdd 48.9303811462
* device instance vdd_t168 r0 *1 0,0
Rvdd_t168 vdd__t168 vdd 192.454250762
* device instance vdd_t169 r0 *1 0,0
Rvdd_t169 vdd__t169 vdd 195.484903935
* device instance vdd_t170 r0 *1 0,0
Rvdd_t170 vdd__t170 vdd 135.87204909
* device instance vdd_t171 r0 *1 0,0
Rvdd_t171 vdd__t171 vdd 138.904678179
* device instance vdd_t172 r0 *1 0,0
Rvdd_t172 vdd__t172 vdd 141.937994835
* device instance vdd_t173 r0 *1 0,0
Rvdd_t173 vdd__t173 vdd 144.971955899
* device instance vdd_t174 r0 *1 0,0
Rvdd_t174 vdd__t174 vdd 116.01792217
* device instance vdd_t175 r0 *1 0,0
Rvdd_t175 vdd__t175 vdd 185.735380482
* device instance vdd_t176 r0 *1 0,0
Rvdd_t176 vdd__t176 vdd 188.77542973
* device instance vdd_t177 r0 *1 0,0
Rvdd_t177 vdd__t177 vdd 191.815752842
* device instance vdd_t178 r0 *1 0,0
Rvdd_t178 vdd__t178 vdd 194.856336999
* device instance vdd_t179 r0 *1 0,0
Rvdd_t179 vdd__t179 vdd 139.785067935
* device instance vdd_t180 r0 *1 0,0
Rvdd_t180 vdd__t180 vdd 142.799684788
* device instance vdd_t181 r0 *1 0,0
Rvdd_t181 vdd__t181 vdd 145.815717929
* device instance vdd_t182 r0 *1 0,0
Rvdd_t182 vdd__t182 vdd 186.394707974
* device instance vdd_t183 r0 *1 0,0
Rvdd_t183 vdd__t183 vdd 136.771961021
* device instance vdd_t184 r0 *1 0,0
Rvdd_t184 vdd__t184 vdd 229.591965661
* device instance vdd_t185 r0 *1 0,0
Rvdd_t185 vdd__t185 vdd 243.197142814
* device instance vdd_t186 r0 *1 0,0
Rvdd_t186 vdd__t186 vdd 87.6482766423
* device instance vdd_t187 r0 *1 0,0
Rvdd_t187 vdd__t187 vdd 90.6106002827
* device instance vdd_t188 r0 *1 0,0
Rvdd_t188 vdd__t188 vdd 93.5784709777
* device instance vdd_t189 r0 *1 0,0
Rvdd_t189 vdd__t189 vdd 96.5513771999
* device instance vdd_t190 r0 *1 0,0
Rvdd_t190 vdd__t190 vdd 37.7436722245
* device instance vdd_t191 r0 *1 0,0
Rvdd_t191 vdd__t191 vdd 46.1971795815
* device instance vdd_t192 r0 *1 0,0
Rvdd_t192 vdd__t192 vdd 43.4606005879
* device instance vdd_t193 r0 *1 0,0
Rvdd_t193 vdd__t193 vdd 46.3554376668
* device instance vdd_t194 r0 *1 0,0
Rvdd_t194 vdd__t194 vdd 86.2372587722
* device instance vdd_t195 r0 *1 0,0
Rvdd_t195 vdd__t195 vdd 89.2464301009
* device instance vdd_t196 r0 *1 0,0
Rvdd_t196 vdd__t196 vdd 92.2581954771
* device instance vdd_t197 r0 *1 0,0
Rvdd_t197 vdd__t197 vdd 95.2723088907
* device instance vdd_t198 r0 *1 0,0
Rvdd_t198 vdd__t198 vdd 40.8649041455
* device instance vdd_t199 r0 *1 0,0
Rvdd_t199 vdd__t199 vdd 43.5059244838
* device instance vdd_t200 r0 *1 0,0
Rvdd_t200 vdd__t200 vdd 40.5882971725
* device instance vdd_t201 r0 *1 0,0
Rvdd_t201 vdd__t201 vdd 114.072927132
* device instance vdd_t202 r0 *1 0,0
Rvdd_t202 vdd__t202 vdd 189.424176038
* device instance vdd_t203 r0 *1 0,0
Rvdd_t203 vdd__t203 vdd 159.745139656
* device instance vdd_t204 r0 *1 0,0
Rvdd_t204 vdd__t204 vdd 162.782177621
* device instance vdd_t205 r0 *1 0,0
Rvdd_t205 vdd__t205 vdd 165.819642745
* device instance vdd_t206 r0 *1 0,0
Rvdd_t206 vdd__t206 vdd 160.51126204
* device instance vdd_t207 r0 *1 0,0
Rvdd_t207 vdd__t207 vdd 157.489448523
* device instance vdd_t208 r0 *1 0,0
Rvdd_t208 vdd__t208 vdd 210.241430244
* device instance vdd_t209 r0 *1 0,0
Rvdd_t209 vdd__t209 vdd 213.274991758
* device instance vdd_t210 r0 *1 0,0
Rvdd_t210 vdd__t210 vdd 117.070550791
* device instance vdd_t211 r0 *1 0,0
Rvdd_t211 vdd__t211 vdd 206.615413599
* device instance vdd_t212 r0 *1 0,0
Rvdd_t212 vdd__t212 vdd 209.657109093
* device instance vdd_t213 r0 *1 0,0
Rvdd_t213 vdd__t213 vdd 212.699004491
* device instance vdd_t214 r0 *1 0,0
Rvdd_t214 vdd__t214 vdd 215.741091337
* device instance vdd_t215 r0 *1 0,0
Rvdd_t215 vdd__t215 vdd 25.8791286369
* device instance vdd_t216 r0 *1 0,0
Rvdd_t216 vdd__t216 vdd 24.2346644814
* device instance vdd_t217 r0 *1 0,0
Rvdd_t217 vdd__t217 vdd 111.078082482
* device instance vdd_t218 r0 *1 0,0
Rvdd_t218 vdd__t218 vdd 207.208312417
* device instance vdd_t219 r0 *1 0,0
Rvdd_t219 vdd__t219 vdd 163.534072746
* device instance vdd_t220 r0 *1 0,0
Rvdd_t220 vdd__t220 vdd 166.557826348
* device instance vdd_t221 r0 *1 0,0
Rvdd_t221 vdd__t221 vdd 156.708553686
* device instance vdd r0 *1 0,0
Cvdd vdd vsubs 3.8521339e-13
* device instance vref_t0 r0 *1 0,0
Rvref_t0 vref__t0 vref 41.8345661207
* device instance vref_t1 r0 *1 0,0
Rvref_t1 vref__t1 vref 200.385712152
* device instance vref_t2 r0 *1 0,0
Rvref_t2 vref__t2 vref 34.4306210191
* device instance vref_t3 r0 *1 0,0
Rvref_t3 vref__t3 vref 332.112288815
* device instance vref_t4 r0 *1 0,0
Rvref_t4 vref__t4 vref 244.210803651
* device instance vref_t5 r0 *1 0,0
Rvref_t5 vref__t5 vref 201.789734361
* device instance vref_t6 r0 *1 0,0
Rvref_t6 vref__t6 vref 289.11063533
* device instance vref_t7 r0 *1 0,0
Rvref_t7 vref__t7 vref 376.879832861
* device instance vref_t8 r0 *1 0,0
Rvref_t8 vref__t8 vref 115.93455358
* device instance vref_t9 r0 *1 0,0
Rvref_t9 vref__t9 vref 113.473157421
* device instance vref_t10 r0 *1 0,0
Rvref_t10 vref__t10 vref 71.2907024852
* device instance vref_t11 r0 *1 0,0
Rvref_t11 vref__t11 vref 288.132428238
* device instance vref_t12 r0 *1 0,0
Rvref_t12 vref__t12 vref 376.129957805
* device instance vref_t13 r0 *1 0,0
Rvref_t13 vref__t13 vref 75.146706645
* device instance vref_t14 r0 *1 0,0
Rvref_t14 vref__t14 vref 158.529210258
* device instance vref_t15 r0 *1 0,0
Rvref_t15 vref__t15 vref 156.738148663
* device instance vref_t16 r0 *1 0,0
Rvref_t16 vref__t16 vref 332.961312528
* device instance vref_t17 r0 *1 0,0
Rvref_t17 vref__t17 vref 245.364178067
* device instance vref_t18 r0 *1 0,0
Rvref_t18 vref__t18 vref 34.4306210191
* device instance vref_t19 r0 *1 0,0
Rvref_t19 vref__t19 vref 156.738148663
* device instance vref_t20 r0 *1 0,0
Rvref_t20 vref__t20 vref 75.146706645
* device instance vref_t21 r0 *1 0,0
Rvref_t21 vref__t21 vref 376.879832861
* device instance vref_t22 r0 *1 0,0
Rvref_t22 vref__t22 vref 158.529210258
* device instance vref_t23 r0 *1 0,0
Rvref_t23 vref__t23 vref 289.11063533
* device instance vref_t24 r0 *1 0,0
Rvref_t24 vref__t24 vref 113.473157421
* device instance vref_t25 r0 *1 0,0
Rvref_t25 vref__t25 vref 200.385712152
* device instance vref_t26 r0 *1 0,0
Rvref_t26 vref__t26 vref 376.129957805
* device instance vref_t27 r0 *1 0,0
Rvref_t27 vref__t27 vref 245.364178067
* device instance vref_t28 r0 *1 0,0
Rvref_t28 vref__t28 vref 332.961312528
* device instance vref_t29 r0 *1 0,0
Rvref_t29 vref__t29 vref 41.8345661207
* device instance vref_t30 r0 *1 0,0
Rvref_t30 vref__t30 vref 115.93455358
* device instance vref_t31 r0 *1 0,0
Rvref_t31 vref__t31 vref 288.132428238
* device instance vref_t32 r0 *1 0,0
Rvref_t32 vref__t32 vref 201.789734361
* device instance vref_t33 r0 *1 0,0
Rvref_t33 vref__t33 vref 332.112288815
* device instance vref_t34 r0 *1 0,0
Rvref_t34 vref__t34 vref 244.210803651
* device instance vref_t35 r0 *1 0,0
Rvref_t35 vref__t35 vref 71.2907024852
* device instance vref r0 *1 0,0
Cvref vref vsubs 1.80620176e-13
* device instance vss_t0 r0 *1 0,0
Rvss_t0 vss__t0 vss 43.0280130667
* device instance vss_t1 r0 *1 0,0
Rvss_t1 vss__t1 vss 25.2707997518
* device instance vss_t2 r0 *1 0,0
Rvss_t2 vss__t2 vss 24.084415219
* device instance vss_t3 r0 *1 0,0
Rvss_t3 vss__t3 vss 15.9792025257
* device instance vss_t4 r0 *1 0,0
Rvss_t4 vss__t4 vss 14.3421189016
* device instance vss_t5 r0 *1 0,0
Rvss_t5 vss__t5 vss 33.8741568985
* device instance vss_t6 r0 *1 0,0
Rvss_t6 vss__t6 vss 6.00677224132
* device instance vss_t7 r0 *1 0,0
Rvss_t7 vss__t7 vss 25.5561988698
* device instance vss_t8 r0 *1 0,0
Rvss_t8 vss__t8 vss 35.2695400492
* device instance vss_t9 r0 *1 0,0
Rvss_t9 vss__t9 vss 7.11247448745
* device instance vss_t10 r0 *1 0,0
Rvss_t10 vss__t10 vss 45.0310823452
* device instance vss_t11 r0 *1 0,0
Rvss_t11 vss__t11 vss 15.5186640141
* device instance vss_t12 r0 *1 0,0
Rvss_t12 vss__t12 vss 4.93664461228
* device instance vss_t13 r0 *1 0,0
Rvss_t13 vss__t13 vss 35.0632924111
* device instance vss_t14 r0 *1 0,0
Rvss_t14 vss__t14 vss 6.23509748147
* device instance vss_t15 r0 *1 0,0
Rvss_t15 vss__t15 vss 14.8392167975
* device instance vss_t16 r0 *1 0,0
Rvss_t16 vss__t16 vss 44.8697269504
* device instance vss_t17 r0 *1 0,0
Rvss_t17 vss__t17 vss 34.0876001819
* device instance vss_t18 r0 *1 0,0
Rvss_t18 vss__t18 vss 24.3837043334
* device instance vss_t19 r0 *1 0,0
Rvss_t19 vss__t19 vss 20.5426346241
* device instance vss_t20 r0 *1 0,0
Rvss_t20 vss__t20 vss 9.86469098187
* device instance vss_t21 r0 *1 0,0
Rvss_t21 vss__t21 vss 40.0390028921
* device instance vss_t22 r0 *1 0,0
Rvss_t22 vss__t22 vss 10.9641889672
* device instance vss_t23 r0 *1 0,0
Rvss_t23 vss__t23 vss 20.5299645245
* device instance vss_t24 r0 *1 0,0
Rvss_t24 vss__t24 vss 38.8514469581
* device instance vss_t25 r0 *1 0,0
Rvss_t25 vss__t25 vss 29.0777767023
* device instance vss_t26 r0 *1 0,0
Rvss_t26 vss__t26 vss 19.3689552215
* device instance vss_t27 r0 *1 0,0
Rvss_t27 vss__t27 vss 3.53618399593
* device instance vss_t28 r0 *1 0,0
Rvss_t28 vss__t28 vss 9.83827902866
* device instance vss_t29 r0 *1 0,0
Rvss_t29 vss__t29 vss 19.355516848
* device instance vss_t30 r0 *1 0,0
Rvss_t30 vss__t30 vss 30.2618937665
* device instance vss_t31 r0 *1 0,0
Rvss_t31 vss__t31 vss 38.858143608
* device instance vss_t32 r0 *1 0,0
Rvss_t32 vss__t32 vss 3.46182081152
* device instance vss_t33 r0 *1 0,0
Rvss_t33 vss__t33 vss 29.0867236359
* device instance vss_t34 r0 *1 0,0
Rvss_t34 vss__t34 vss 40.0455009522
* device instance vss_t35 r0 *1 0,0
Rvss_t35 vss__t35 vss 30.2704907172
* device instance vss_t36 r0 *1 0,0
Rvss_t36 vss__t36 vss 10.987894868
* device instance vss_t37 r0 *1 0,0
Rvss_t37 vss__t37 vss 26.0898223425
* device instance vss_t38 r0 *1 0,0
Rvss_t38 vss__t38 vss 9.02133757056
* device instance vss_t39 r0 *1 0,0
Rvss_t39 vss__t39 vss 27.8744935674
* device instance vss_t40 r0 *1 0,0
Rvss_t40 vss__t40 vss 27.2794537899
* device instance vss_t41 r0 *1 0,0
Rvss_t41 vss__t41 vss 7.4573252711
* device instance vss_t42 r0 *1 0,0
Rvss_t42 vss__t42 vss 37.7644066512
* device instance vss_t43 r0 *1 0,0
Rvss_t43 vss__t43 vss 37.1695528906
* device instance vss_t44 r0 *1 0,0
Rvss_t44 vss__t44 vss 41.2412828826
* device instance vss_t45 r0 *1 0,0
Rvss_t45 vss__t45 vss 41.8367817444
* device instance vss_t46 r0 *1 0,0
Rvss_t46 vss__t46 vss 42.4323595653
* device instance vss_t47 r0 *1 0,0
Rvss_t47 vss__t47 vss 36.5748117302
* device instance vss_t48 r0 *1 0,0
Rvss_t48 vss__t48 vss 35.9801887535
* device instance vss_t49 r0 *1 0,0
Rvss_t49 vss__t49 vss 35.8706429364
* device instance vss_t50 r0 *1 0,0
Rvss_t50 vss__t50 vss 36.4670521845
* device instance vss_t51 r0 *1 0,0
Rvss_t51 vss__t51 vss 37.0635225528
* device instance vss_t52 r0 *1 0,0
Rvss_t52 vss__t52 vss 37.6600511371
* device instance vss_t53 r0 *1 0,0
Rvss_t53 vss__t53 vss 26.6845600517
* device instance vss_t54 r0 *1 0,0
Rvss_t54 vss__t54 vss 16.3612775281
* device instance vss_t55 r0 *1 0,0
Rvss_t55 vss__t55 vss 41.1457465084
* device instance vss_t56 r0 *1 0,0
Rvss_t56 vss__t56 vss 23.3689829735
* device instance vss_t57 r0 *1 0,0
Rvss_t57 vss__t57 vss 47.9727040404
* device instance vss_t58 r0 *1 0,0
Rvss_t58 vss__t58 vss 50.6484057404
* device instance vss_t59 r0 *1 0,0
Rvss_t59 vss__t59 vss 22.7753486288
* device instance vss_t60 r0 *1 0,0
Rvss_t60 vss__t60 vss 22.1819652814
* device instance vss_t61 r0 *1 0,0
Rvss_t61 vss__t61 vss 21.5888536278
* device instance vss_t62 r0 *1 0,0
Rvss_t62 vss__t62 vss 33.1406966457
* device instance vss_t63 r0 *1 0,0
Rvss_t63 vss__t63 vss 32.5446917183
* device instance vss_t64 r0 *1 0,0
Rvss_t64 vss__t64 vss 31.9487727864
* device instance vss_t65 r0 *1 0,0
Rvss_t65 vss__t65 vss 12.8165053856
* device instance vss_t66 r0 *1 0,0
Rvss_t66 vss__t66 vss 4.56364428927
* device instance vss_t67 r0 *1 0,0
Rvss_t67 vss__t67 vss 7.96785450119
* device instance vss_t68 r0 *1 0,0
Rvss_t68 vss__t68 vss 3.71226184465
* device instance vss_t69 r0 *1 0,0
Rvss_t69 vss__t69 vss 3.3662761855
* device instance vss_t70 r0 *1 0,0
Rvss_t70 vss__t70 vss 12.2498074509
* device instance vss_t71 r0 *1 0,0
Rvss_t71 vss__t71 vss 5.35703343924
* device instance vss_t72 r0 *1 0,0
Rvss_t72 vss__t72 vss 4.98165207076
* device instance vss_t73 r0 *1 0,0
Rvss_t73 vss__t73 vss 4.65315442183
* device instance vss_t74 r0 *1 0,0
Rvss_t74 vss__t74 vss 4.38209692124
* device instance vss_t75 r0 *1 0,0
Rvss_t75 vss__t75 vss 13.3859544541
* device instance vss_t76 r0 *1 0,0
Rvss_t76 vss__t76 vss 13.9578179395
* device instance vss_t77 r0 *1 0,0
Rvss_t77 vss__t77 vss 13.6729559189
* device instance vss_t78 r0 *1 0,0
Rvss_t78 vss__t78 vss 13.0886522827
* device instance vss_t79 r0 *1 0,0
Rvss_t79 vss__t79 vss 12.5056728019
* device instance vss_t80 r0 *1 0,0
Rvss_t80 vss__t80 vss 11.9242116936
* device instance vss_t81 r0 *1 0,0
Rvss_t81 vss__t81 vss 4.11653972214
* device instance vss_t82 r0 *1 0,0
Rvss_t82 vss__t82 vss 6.90946757202
* device instance vss_t83 r0 *1 0,0
Rvss_t83 vss__t83 vss 8.48985566072
* device instance vss_t84 r0 *1 0,0
Rvss_t84 vss__t84 vss 28.0153234803
* device instance vss_t85 r0 *1 0,0
Rvss_t85 vss__t85 vss 27.4233396425
* device instance vss_t86 r0 *1 0,0
Rvss_t86 vss__t86 vss 18.1309707109
* device instance vss_t87 r0 *1 0,0
Rvss_t87 vss__t87 vss 17.5405034542
* device instance vss_t88 r0 *1 0,0
Rvss_t88 vss__t88 vss 16.9505859064
* device instance vss_t89 r0 *1 0,0
Rvss_t89 vss__t89 vss 8.57400568532
* device instance vss_t90 r0 *1 0,0
Rvss_t90 vss__t90 vss 8.01290777869
* device instance vss_t91 r0 *1 0,0
Rvss_t91 vss__t91 vss 7.45759661567
* device instance vss_t92 r0 *1 0,0
Rvss_t92 vss__t92 vss 26.8316362383
* device instance vss_t93 r0 *1 0,0
Rvss_t93 vss__t93 vss 26.2402322386
* device instance vss_t94 r0 *1 0,0
Rvss_t94 vss__t94 vss 33.2592352923
* device instance vss_t95 r0 *1 0,0
Rvss_t95 vss__t95 vss 41.7426083116
* device instance vss_t96 r0 *1 0,0
Rvss_t96 vss__t96 vss 32.0717171449
* device instance vss_t97 r0 *1 0,0
Rvss_t97 vss__t97 vss 18.3467451334
* device instance vss_t98 r0 *1 0,0
Rvss_t98 vss__t98 vss 17.7634517901
* device instance vss_t99 r0 *1 0,0
Rvss_t99 vss__t99 vss 31.4782163213
* device instance vss_t100 r0 *1 0,0
Rvss_t100 vss__t100 vss 17.1811908971
* device instance vss_t101 r0 *1 0,0
Rvss_t101 vss__t101 vss 16.6000710968
* device instance vss_t102 r0 *1 0,0
Rvss_t102 vss__t102 vss 23.5367865964
* device instance vss_t103 r0 *1 0,0
Rvss_t103 vss__t103 vss 22.9474936155
* device instance vss_t104 r0 *1 0,0
Rvss_t104 vss__t104 vss 22.3586793397
* device instance vss_t105 r0 *1 0,0
Rvss_t105 vss__t105 vss 21.7703826111
* device instance vss_t106 r0 *1 0,0
Rvss_t106 vss__t106 vss 31.3529447533
* device instance vss_t107 r0 *1 0,0
Rvss_t107 vss__t107 vss 42.9364524664
* device instance vss_t108 r0 *1 0,0
Rvss_t108 vss__t108 vss 42.3395108641
* device instance vss_t109 r0 *1 0,0
Rvss_t109 vss__t109 vss 32.6653932643
* device instance vss_t110 r0 *1 0,0
Rvss_t110 vss__t110 vss 43.0280130667
* device instance vss_t111 r0 *1 0,0
Rvss_t111 vss__t111 vss 42.4323595653
* device instance vss_t112 r0 *1 0,0
Rvss_t112 vss__t112 vss 41.8367817444
* device instance vss_t113 r0 *1 0,0
Rvss_t113 vss__t113 vss 41.2412828826
* device instance vss_t114 r0 *1 0,0
Rvss_t114 vss__t114 vss 33.2592352923
* device instance vss_t115 r0 *1 0,0
Rvss_t115 vss__t115 vss 32.6653932643
* device instance vss_t116 r0 *1 0,0
Rvss_t116 vss__t116 vss 32.0717171449
* device instance vss_t117 r0 *1 0,0
Rvss_t117 vss__t117 vss 31.4782163213
* device instance vss_t118 r0 *1 0,0
Rvss_t118 vss__t118 vss 23.5367865964
* device instance vss_t119 r0 *1 0,0
Rvss_t119 vss__t119 vss 22.9474936155
* device instance vss_t120 r0 *1 0,0
Rvss_t120 vss__t120 vss 22.3586793397
* device instance vss_t121 r0 *1 0,0
Rvss_t121 vss__t121 vss 21.7703826111
* device instance vss_t122 r0 *1 0,0
Rvss_t122 vss__t122 vss 13.9578179395
* device instance vss_t123 r0 *1 0,0
Rvss_t123 vss__t123 vss 13.3859544541
* device instance vss_t124 r0 *1 0,0
Rvss_t124 vss__t124 vss 12.8165053856
* device instance vss_t125 r0 *1 0,0
Rvss_t125 vss__t125 vss 12.2498074509
* device instance vss_t126 r0 *1 0,0
Rvss_t126 vss__t126 vss 5.35703343924
* device instance vss_t127 r0 *1 0,0
Rvss_t127 vss__t127 vss 4.98165207076
* device instance vss_t128 r0 *1 0,0
Rvss_t128 vss__t128 vss 4.65315442183
* device instance vss_t129 r0 *1 0,0
Rvss_t129 vss__t129 vss 4.38209692124
* device instance vss_t130 r0 *1 0,0
Rvss_t130 vss__t130 vss 7.4573252711
* device instance vss_t131 r0 *1 0,0
Rvss_t131 vss__t131 vss 7.96785450119
* device instance vss_t132 r0 *1 0,0
Rvss_t132 vss__t132 vss 8.48985566072
* device instance vss_t133 r0 *1 0,0
Rvss_t133 vss__t133 vss 9.02133757056
* device instance vss_t134 r0 *1 0,0
Rvss_t134 vss__t134 vss 16.6000710968
* device instance vss_t135 r0 *1 0,0
Rvss_t135 vss__t135 vss 17.1811908971
* device instance vss_t136 r0 *1 0,0
Rvss_t136 vss__t136 vss 17.7634517901
* device instance vss_t137 r0 *1 0,0
Rvss_t137 vss__t137 vss 18.3467451334
* device instance vss_t138 r0 *1 0,0
Rvss_t138 vss__t138 vss 26.2402322386
* device instance vss_t139 r0 *1 0,0
Rvss_t139 vss__t139 vss 26.8316362383
* device instance vss_t140 r0 *1 0,0
Rvss_t140 vss__t140 vss 27.4233396425
* device instance vss_t141 r0 *1 0,0
Rvss_t141 vss__t141 vss 28.0153234803
* device instance vss_t142 r0 *1 0,0
Rvss_t142 vss__t142 vss 35.9801887535
* device instance vss_t143 r0 *1 0,0
Rvss_t143 vss__t143 vss 36.5748117302
* device instance vss_t144 r0 *1 0,0
Rvss_t144 vss__t144 vss 37.1695528906
* device instance vss_t145 r0 *1 0,0
Rvss_t145 vss__t145 vss 37.7644066512
* device instance vss_t146 r0 *1 0,0
Rvss_t146 vss__t146 vss 42.9364524664
* device instance vss_t147 r0 *1 0,0
Rvss_t147 vss__t147 vss 42.3395108641
* device instance vss_t148 r0 *1 0,0
Rvss_t148 vss__t148 vss 41.7426083116
* device instance vss_t149 r0 *1 0,0
Rvss_t149 vss__t149 vss 41.1457465084
* device instance vss_t150 r0 *1 0,0
Rvss_t150 vss__t150 vss 33.1406966457
* device instance vss_t151 r0 *1 0,0
Rvss_t151 vss__t151 vss 32.5446917183
* device instance vss_t152 r0 *1 0,0
Rvss_t152 vss__t152 vss 31.9487727864
* device instance vss_t153 r0 *1 0,0
Rvss_t153 vss__t153 vss 31.3529447533
* device instance vss_t154 r0 *1 0,0
Rvss_t154 vss__t154 vss 23.3689829735
* device instance vss_t155 r0 *1 0,0
Rvss_t155 vss__t155 vss 22.7753486288
* device instance vss_t156 r0 *1 0,0
Rvss_t156 vss__t156 vss 22.1819652814
* device instance vss_t157 r0 *1 0,0
Rvss_t157 vss__t157 vss 21.5888536278
* device instance vss_t158 r0 *1 0,0
Rvss_t158 vss__t158 vss 13.6729559189
* device instance vss_t159 r0 *1 0,0
Rvss_t159 vss__t159 vss 13.0886522827
* device instance vss_t160 r0 *1 0,0
Rvss_t160 vss__t160 vss 12.5056728019
* device instance vss_t161 r0 *1 0,0
Rvss_t161 vss__t161 vss 11.9242116936
* device instance vss_t162 r0 *1 0,0
Rvss_t162 vss__t162 vss 4.56364428927
* device instance vss_t163 r0 *1 0,0
Rvss_t163 vss__t163 vss 4.11653972214
* device instance vss_t164 r0 *1 0,0
Rvss_t164 vss__t164 vss 3.71226184465
* device instance vss_t165 r0 *1 0,0
Rvss_t165 vss__t165 vss 3.3662761855
* device instance vss_t166 r0 *1 0,0
Rvss_t166 vss__t166 vss 6.90946757202
* device instance vss_t167 r0 *1 0,0
Rvss_t167 vss__t167 vss 7.45759661567
* device instance vss_t168 r0 *1 0,0
Rvss_t168 vss__t168 vss 8.01290777869
* device instance vss_t169 r0 *1 0,0
Rvss_t169 vss__t169 vss 8.57400568532
* device instance vss_t170 r0 *1 0,0
Rvss_t170 vss__t170 vss 16.3612775281
* device instance vss_t171 r0 *1 0,0
Rvss_t171 vss__t171 vss 16.9505859064
* device instance vss_t172 r0 *1 0,0
Rvss_t172 vss__t172 vss 17.5405034542
* device instance vss_t173 r0 *1 0,0
Rvss_t173 vss__t173 vss 18.1309707109
* device instance vss_t174 r0 *1 0,0
Rvss_t174 vss__t174 vss 26.0898223425
* device instance vss_t175 r0 *1 0,0
Rvss_t175 vss__t175 vss 26.6845600517
* device instance vss_t176 r0 *1 0,0
Rvss_t176 vss__t176 vss 27.2794537899
* device instance vss_t177 r0 *1 0,0
Rvss_t177 vss__t177 vss 27.8744935674
* device instance vss_t178 r0 *1 0,0
Rvss_t178 vss__t178 vss 35.8706429364
* device instance vss_t179 r0 *1 0,0
Rvss_t179 vss__t179 vss 36.4670521845
* device instance vss_t180 r0 *1 0,0
Rvss_t180 vss__t180 vss 37.0635225528
* device instance vss_t181 r0 *1 0,0
Rvss_t181 vss__t181 vss 37.6600511371
* device instance vss_t182 r0 *1 0,0
Rvss_t182 vss__t182 vss 47.9727040404
* device instance vss_t183 r0 *1 0,0
Rvss_t183 vss__t183 vss 50.6484057404
* device instance vss_t184 r0 *1 0,0
Rvss_t184 vss__t184 vss 40.597300028
* device instance vss_t185 r0 *1 0,0
Rvss_t185 vss__t185 vss 40.0152861411
* device instance vss_t186 r0 *1 0,0
Rvss_t186 vss__t186 vss 39.4333341901
* device instance vss_t187 r0 *1 0,0
Rvss_t187 vss__t187 vss 38.8514469581
* device instance vss_t188 r0 *1 0,0
Rvss_t188 vss__t188 vss 30.818694589
* device instance vss_t189 r0 *1 0,0
Rvss_t189 vss__t189 vss 30.2382422069
* device instance vss_t190 r0 *1 0,0
Rvss_t190 vss__t190 vss 29.6579333797
* device instance vss_t191 r0 *1 0,0
Rvss_t191 vss__t191 vss 29.0777767023
* device instance vss_t192 r0 *1 0,0
Rvss_t192 vss__t192 vss 21.0826912433
* device instance vss_t193 r0 *1 0,0
Rvss_t193 vss__t193 vss 20.5064922856
* device instance vss_t194 r0 *1 0,0
Rvss_t194 vss__t194 vss 19.9307537905
* device instance vss_t195 r0 *1 0,0
Rvss_t195 vss__t195 vss 19.355516848
* device instance vss_t196 r0 *1 0,0
Rvss_t196 vss__t196 vss 11.4980246673
* device instance vss_t197 r0 *1 0,0
Rvss_t197 vss__t197 vss 10.9415687745
* device instance vss_t198 r0 *1 0,0
Rvss_t198 vss__t198 vss 10.388149414
* device instance vss_t199 r0 *1 0,0
Rvss_t199 vss__t199 vss 9.83827902866
* device instance vss_t200 r0 *1 0,0
Rvss_t200 vss__t200 vss 3.60083875328
* device instance vss_t201 r0 *1 0,0
Rvss_t201 vss__t201 vss 3.45780218185
* device instance vss_t202 r0 *1 0,0
Rvss_t202 vss__t202 vss 3.41014913605
* device instance vss_t203 r0 *1 0,0
Rvss_t203 vss__t203 vss 3.46182081152
* device instance vss_t204 r0 *1 0,0
Rvss_t204 vss__t204 vss 9.31473432242
* device instance vss_t205 r0 *1 0,0
Rvss_t205 vss__t205 vss 9.8606101181
* device instance vss_t206 r0 *1 0,0
Rvss_t206 vss__t206 vss 10.4106365466
* device instance vss_t207 r0 *1 0,0
Rvss_t207 vss__t207 vss 10.9641889672
* device instance vss_t208 r0 *1 0,0
Rvss_t208 vss__t208 vss 18.8042356547
* device instance vss_t209 r0 *1 0,0
Rvss_t209 vss__t209 vss 19.3789482471
* device instance vss_t210 r0 *1 0,0
Rvss_t210 vss__t210 vss 19.9542064932
* device instance vss_t211 r0 *1 0,0
Rvss_t211 vss__t211 vss 20.5299645245
* device instance vss_t212 r0 *1 0,0
Rvss_t212 vss__t212 vss 28.521413866
* device instance vss_t213 r0 *1 0,0
Rvss_t213 vss__t213 vss 29.1014158714
* device instance vss_t214 r0 *1 0,0
Rvss_t214 vss__t214 vss 29.6815789258
* device instance vss_t215 r0 *1 0,0
Rvss_t215 vss__t215 vss 30.2618937665
* device instance vss_t216 r0 *1 0,0
Rvss_t216 vss__t216 vss 38.2933360594
* device instance vss_t217 r0 *1 0,0
Rvss_t217 vss__t217 vss 38.8751584379
* device instance vss_t218 r0 *1 0,0
Rvss_t218 vss__t218 vss 39.4570483638
* device instance vss_t219 r0 *1 0,0
Rvss_t219 vss__t219 vss 40.0390028921
* device instance vss_t220 r0 *1 0,0
Rvss_t220 vss__t220 vss 40.6037087405
* device instance vss_t221 r0 *1 0,0
Rvss_t221 vss__t221 vss 40.021788052
* device instance vss_t222 r0 *1 0,0
Rvss_t222 vss__t222 vss 39.4399320394
* device instance vss_t223 r0 *1 0,0
Rvss_t223 vss__t223 vss 38.858143608
* device instance vss_t224 r0 *1 0,0
Rvss_t224 vss__t224 vss 30.8271362616
* device instance vss_t225 r0 *1 0,0
Rvss_t225 vss__t225 vss 30.2468458799
* device instance vss_t226 r0 *1 0,0
Rvss_t226 vss__t226 vss 29.6667053492
* device instance vss_t227 r0 *1 0,0
Rvss_t227 vss__t227 vss 29.0867236359
* device instance vss_t228 r0 *1 0,0
Rvss_t228 vss__t228 vss 21.0950293668
* device instance vss_t229 r0 *1 0,0
Rvss_t229 vss__t229 vss 20.5191768787
* device instance vss_t230 r0 *1 0,0
Rvss_t230 vss__t230 vss 19.9438045663
* device instance vss_t231 r0 *1 0,0
Rvss_t231 vss__t231 vss 19.3689552215
* device instance vss_t232 r0 *1 0,0
Rvss_t232 vss__t232 vss 11.5206321515
* device instance vss_t233 r0 *1 0,0
Rvss_t233 vss__t233 vss 10.965323578
* device instance vss_t234 r0 *1 0,0
Rvss_t234 vss__t234 vss 10.4131667695
* device instance vss_t235 r0 *1 0,0
Rvss_t235 vss__t235 vss 9.86469098187
* device instance vss_t236 r0 *1 0,0
Rvss_t236 vss__t236 vss 3.67238800362
* device instance vss_t237 r0 *1 0,0
Rvss_t237 vss__t237 vss 3.53224997003
* device instance vss_t238 r0 *1 0,0
Rvss_t238 vss__t238 vss 3.48561487432
* device instance vss_t239 r0 *1 0,0
Rvss_t239 vss__t239 vss 3.53618399593
* device instance vss_t240 r0 *1 0,0
Rvss_t240 vss__t240 vss 9.34262647328
* device instance vss_t241 r0 *1 0,0
Rvss_t241 vss__t241 vss 9.8869624164
* device instance vss_t242 r0 *1 0,0
Rvss_t242 vss__t242 vss 10.4355999936
* device instance vss_t243 r0 *1 0,0
Rvss_t243 vss__t243 vss 10.987894868
* device instance vss_t244 r0 *1 0,0
Rvss_t244 vss__t244 vss 18.8180677138
* device instance vss_t245 r0 *1 0,0
Rvss_t245 vss__t245 vss 19.3923703834
* device instance vss_t246 r0 *1 0,0
Rvss_t246 vss__t246 vss 19.9672419401
* device instance vss_t247 r0 *1 0,0
Rvss_t247 vss__t247 vss 20.5426346241
* device instance vss_t248 r0 *1 0,0
Rvss_t248 vss__t248 vss 28.5305352707
* device instance vss_t249 r0 *1 0,0
Rvss_t249 vss__t249 vss 29.1103555396
* device instance vss_t250 r0 *1 0,0
Rvss_t250 vss__t250 vss 29.6903439093
* device instance vss_t251 r0 *1 0,0
Rvss_t251 vss__t251 vss 30.2704907172
* device instance vss_t252 r0 *1 0,0
Rvss_t252 vss__t252 vss 38.3001302933
* device instance vss_t253 r0 *1 0,0
Rvss_t253 vss__t253 vss 38.8818510039
* device instance vss_t254 r0 *1 0,0
Rvss_t254 vss__t254 vss 39.4636422483
* device instance vss_t255 r0 *1 0,0
Rvss_t255 vss__t255 vss 40.0455009522
* device instance vss_t256 r0 *1 0,0
Rvss_t256 vss__t256 vss 48.6777841519
* device instance vss_t257 r0 *1 0,0
Rvss_t257 vss__t257 vss 51.3481762695
* device instance vss r0 *1 0,0
Cvss vss vsubs 3.90857154e-13
* device instance cc__10__125 r0 *1 0,0
Ccc__10__125 \$10 \$125 1.0837e-17
* device instance cc__10__127 r0 *1 0,0
Ccc__10__127 \$10 \$127 1.0837e-17
* device instance cc__10__22 r0 *1 0,0
Ccc__10__22 \$10 \$22 1.614766e-15
* device instance cc__10__3 r0 *1 0,0
Ccc__10__3 \$10 \$3 1.0837e-17
* device instance cc__10__30 r0 *1 0,0
Ccc__10__30 \$10 \$30 8.88663e-16
* device instance cc__10__38 r0 *1 0,0
Ccc__10__38 \$10 \$38 5.52705e-16
* device instance cc__10__46 r0 *1 0,0
Ccc__10__46 \$10 \$46 3.79308e-16
* device instance cc__10__5 r0 *1 0,0
Ccc__10__5 \$10 \$5 1.0837e-17
* device instance cc__10__54 r0 *1 0,0
Ccc__10__54 \$10 \$54 2.92609e-16
* device instance cc__10__62 r0 *1 0,0
Ccc__10__62 \$10 \$62 2.49259e-16
* device instance cc__10__7 r0 *1 0,0
Ccc__10__7 \$10 \$7 1.0837e-17
* device instance cc__10__70 r0 *1 0,0
Ccc__10__70 \$10 \$70 2.0591e-16
* device instance cc__10__78 r0 *1 0,0
Ccc__10__78 \$10 \$78 9.7536e-17
* device instance cc__10__79 r0 *1 0,0
Ccc__10__79 \$10 \$79 1.0837e-17
* device instance cc__10__9 r0 *1 0,0
Ccc__10__9 \$10 \$9 1.0837e-17
* device instance cc__10__90 r0 *1 0,0
Ccc__10__90 \$10 \$90 1.0837e-17
* device instance cc__10__92 r0 *1 0,0
Ccc__10__92 \$10 \$92 1.0837e-17
* device instance cc__10_hi_256_n r0 *1 0,0
Ccc__10_hi_256_n \$10 hi_256_n 1.0837e-17
* device instance cc__10_hi_256_p r0 *1 0,0
Ccc__10_hi_256_p \$10 hi_256_p 1.0837e-17
* device instance cc__10_lo_256_n r0 *1 0,0
Ccc__10_lo_256_n \$10 lo_256_n 1.0837e-17
* device instance cc__10_lo_256_p r0 *1 0,0
Ccc__10_lo_256_p \$10 lo_256_p 1.0837e-17
* device instance cc__10_pinn r0 *1 0,0
Ccc__10_pinn \$10 vinn 1.0837e-17
* device instance cc__10_rel_256_n r0 *1 0,0
Ccc__10_rel_256_n \$10 rel_256_n 1.0837e-17
* device instance cc__10_rel_256_p r0 *1 0,0
Ccc__10_rel_256_p \$10 rel_256_p 1.0837e-17
* device instance cc__10_sel_in r0 *1 0,0
Ccc__10_sel_in \$10 sel_in 2.1675e-17
* device instance cc__10_topp r0 *1 0,0
Ccc__10_topp \$10 topp 4.2159087e-14
* device instance cc__10_vcm r0 *1 0,0
Ccc__10_vcm \$10 vcm 1.19211e-16
* device instance cc__10_vref r0 *1 0,0
Ccc__10_vref \$10 vref 1.0837e-17
* device instance cc__10_vss r0 *1 0,0
Ccc__10_vss \$10 vss 5.20075e-16
* device instance cc__100__30 r0 *1 0,0
Ccc__100__30 \$100 \$30 1.0837e-17
* device instance cc__100__82 r0 *1 0,0
Ccc__100__82 \$100 \$82 1.0837e-17
* device instance cc__102__38 r0 *1 0,0
Ccc__102__38 \$102 \$38 1.0837e-17
* device instance cc__102__83 r0 *1 0,0
Ccc__102__83 \$102 \$83 1.0837e-17
* device instance cc__104__38 r0 *1 0,0
Ccc__104__38 \$104 \$38 1.0837e-17
* device instance cc__104__83 r0 *1 0,0
Ccc__104__83 \$104 \$83 1.0837e-17
* device instance cc__106__46 r0 *1 0,0
Ccc__106__46 \$106 \$46 1.0837e-17
* device instance cc__106__84 r0 *1 0,0
Ccc__106__84 \$106 \$84 1.0837e-17
* device instance cc__106_vcm r0 *1 0,0
Ccc__106_vcm \$106 vcm 2.1675e-17
* device instance cc__108__46 r0 *1 0,0
Ccc__108__46 \$108 \$46 1.0837e-17
* device instance cc__108__84 r0 *1 0,0
Ccc__108__84 \$108 \$84 1.0837e-17
* device instance cc__108_vcm r0 *1 0,0
Ccc__108_vcm \$108 vcm 2.1675e-17
* device instance cc__110__54 r0 *1 0,0
Ccc__110__54 \$110 \$54 1.0837e-17
* device instance cc__110__85 r0 *1 0,0
Ccc__110__85 \$110 \$85 1.0837e-17
* device instance cc__112__54 r0 *1 0,0
Ccc__112__54 \$112 \$54 1.0837e-17
* device instance cc__112__85 r0 *1 0,0
Ccc__112__85 \$112 \$85 1.0837e-17
* device instance cc__114__62 r0 *1 0,0
Ccc__114__62 \$114 \$62 1.0837e-17
* device instance cc__114__86 r0 *1 0,0
Ccc__114__86 \$114 \$86 1.0837e-17
* device instance cc__116__62 r0 *1 0,0
Ccc__116__62 \$116 \$62 1.0837e-17
* device instance cc__116__86 r0 *1 0,0
Ccc__116__86 \$116 \$86 1.0837e-17
* device instance cc__118__70 r0 *1 0,0
Ccc__118__70 \$118 \$70 1.0837e-17
* device instance cc__118__87 r0 *1 0,0
Ccc__118__87 \$118 \$87 1.0837e-17
* device instance cc__120__70 r0 *1 0,0
Ccc__120__70 \$120 \$70 1.0837e-17
* device instance cc__120__87 r0 *1 0,0
Ccc__120__87 \$120 \$87 1.0837e-17
* device instance cc__122__78 r0 *1 0,0
Ccc__122__78 \$122 \$78 1.0837e-17
* device instance cc__122__88 r0 *1 0,0
Ccc__122__88 \$122 \$88 1.0837e-17
* device instance cc__124__78 r0 *1 0,0
Ccc__124__78 \$124 \$78 1.0837e-17
* device instance cc__124__88 r0 *1 0,0
Ccc__124__88 \$124 \$88 1.0837e-17
* device instance cc__125__79 r0 *1 0,0
Ccc__125__79 \$125 \$79 1.0837e-17
* device instance cc__127__79 r0 *1 0,0
Ccc__127__79 \$127 \$79 1.0837e-17
* device instance cc__128__22 r0 *1 0,0
Ccc__128__22 \$128 \$22 1.0837e-17
* device instance cc__128__81 r0 *1 0,0
Ccc__128__81 \$128 \$81 1.0837e-17
* device instance cc__130__22 r0 *1 0,0
Ccc__130__22 \$130 \$22 1.0837e-17
* device instance cc__130__81 r0 *1 0,0
Ccc__130__81 \$130 \$81 1.0837e-17
* device instance cc__131__30 r0 *1 0,0
Ccc__131__30 \$131 \$30 1.0837e-17
* device instance cc__131__82 r0 *1 0,0
Ccc__131__82 \$131 \$82 1.0837e-17
* device instance cc__133__30 r0 *1 0,0
Ccc__133__30 \$133 \$30 1.0837e-17
* device instance cc__133__82 r0 *1 0,0
Ccc__133__82 \$133 \$82 1.0837e-17
* device instance cc__134__38 r0 *1 0,0
Ccc__134__38 \$134 \$38 1.0837e-17
* device instance cc__134__83 r0 *1 0,0
Ccc__134__83 \$134 \$83 1.0837e-17
* device instance cc__136__38 r0 *1 0,0
Ccc__136__38 \$136 \$38 1.0837e-17
* device instance cc__136__83 r0 *1 0,0
Ccc__136__83 \$136 \$83 1.0837e-17
* device instance cc__137__46 r0 *1 0,0
Ccc__137__46 \$137 \$46 1.0837e-17
* device instance cc__137__84 r0 *1 0,0
Ccc__137__84 \$137 \$84 1.0837e-17
* device instance cc__137_vcm r0 *1 0,0
Ccc__137_vcm \$137 vcm 1.0837e-17
* device instance cc__139__46 r0 *1 0,0
Ccc__139__46 \$139 \$46 1.0837e-17
* device instance cc__139__84 r0 *1 0,0
Ccc__139__84 \$139 \$84 1.0837e-17
* device instance cc__139_vcm r0 *1 0,0
Ccc__139_vcm \$139 vcm 3.7724e-17
* device instance cc__140__54 r0 *1 0,0
Ccc__140__54 \$140 \$54 1.0837e-17
* device instance cc__140__85 r0 *1 0,0
Ccc__140__85 \$140 \$85 1.0837e-17
* device instance cc__142__54 r0 *1 0,0
Ccc__142__54 \$142 \$54 1.0837e-17
* device instance cc__142__85 r0 *1 0,0
Ccc__142__85 \$142 \$85 1.0837e-17
* device instance cc__143__62 r0 *1 0,0
Ccc__143__62 \$143 \$62 1.0837e-17
* device instance cc__143__86 r0 *1 0,0
Ccc__143__86 \$143 \$86 1.0837e-17
* device instance cc__145__62 r0 *1 0,0
Ccc__145__62 \$145 \$62 1.0837e-17
* device instance cc__145__86 r0 *1 0,0
Ccc__145__86 \$145 \$86 1.0837e-17
* device instance cc__146__70 r0 *1 0,0
Ccc__146__70 \$146 \$70 1.0837e-17
* device instance cc__146__87 r0 *1 0,0
Ccc__146__87 \$146 \$87 1.0837e-17
* device instance cc__148__70 r0 *1 0,0
Ccc__148__70 \$148 \$70 1.0837e-17
* device instance cc__148__87 r0 *1 0,0
Ccc__148__87 \$148 \$87 1.0837e-17
* device instance cc__149__78 r0 *1 0,0
Ccc__149__78 \$149 \$78 1.0837e-17
* device instance cc__149__88 r0 *1 0,0
Ccc__149__88 \$149 \$88 1.0837e-17
* device instance cc__15__22 r0 *1 0,0
Ccc__15__22 \$15 \$22 1.0837e-17
* device instance cc__151__78 r0 *1 0,0
Ccc__151__78 \$151 \$78 1.0837e-17
* device instance cc__151__88 r0 *1 0,0
Ccc__151__88 \$151 \$88 1.0837e-17
* device instance cc__17__22 r0 *1 0,0
Ccc__17__22 \$17 \$22 1.0837e-17
* device instance cc__19__22 r0 *1 0,0
Ccc__19__22 \$19 \$22 1.0837e-17
* device instance cc__21__22 r0 *1 0,0
Ccc__21__22 \$21 \$22 1.0837e-17
* device instance cc__22__30 r0 *1 0,0
Ccc__22__30 \$22 \$30 1.53635e-16
* device instance cc__22__38 r0 *1 0,0
Ccc__22__38 \$22 \$38 1.53635e-16
* device instance cc__22__46 r0 *1 0,0
Ccc__22__46 \$22 \$46 1.19211e-16
* device instance cc__22__54 r0 *1 0,0
Ccc__22__54 \$22 \$54 1.19211e-16
* device instance cc__22__62 r0 *1 0,0
Ccc__22__62 \$22 \$62 1.19211e-16
* device instance cc__22__70 r0 *1 0,0
Ccc__22__70 \$22 \$70 9.7536e-17
* device instance cc__22__78 r0 *1 0,0
Ccc__22__78 \$22 \$78 5.4187e-17
* device instance cc__22__79 r0 *1 0,0
Ccc__22__79 \$22 \$79 1.7212e-17
* device instance cc__22__81 r0 *1 0,0
Ccc__22__81 \$22 \$81 1.0837e-17
* device instance cc__22__94 r0 *1 0,0
Ccc__22__94 \$22 \$94 1.0837e-17
* device instance cc__22__96 r0 *1 0,0
Ccc__22__96 \$22 \$96 1.0837e-17
* device instance cc__22_hi_128_n r0 *1 0,0
Ccc__22_hi_128_n \$22 hi_128_n 1.0837e-17
* device instance cc__22_hi_128_p r0 *1 0,0
Ccc__22_hi_128_p \$22 hi_128_p 1.0837e-17
* device instance cc__22_lo_128_n r0 *1 0,0
Ccc__22_lo_128_n \$22 lo_128_n 1.0837e-17
* device instance cc__22_lo_128_p r0 *1 0,0
Ccc__22_lo_128_p \$22 lo_128_p 1.0837e-17
* device instance cc__22_pinn r0 *1 0,0
Ccc__22_pinn \$22 vinn 1.0837e-17
* device instance cc__22_rel_128_n r0 *1 0,0
Ccc__22_rel_128_n \$22 rel_128_n 1.0837e-17
* device instance cc__22_rel_128_p r0 *1 0,0
Ccc__22_rel_128_p \$22 rel_128_p 1.0837e-17
* device instance cc__22_sel_in r0 *1 0,0
Ccc__22_sel_in \$22 sel_in 2.1675e-17
* device instance cc__22_topp r0 *1 0,0
Ccc__22_topp \$22 topp 2.1079544e-14
* device instance cc__22_vcm r0 *1 0,0
Ccc__22_vcm \$22 vcm 6.5024e-17
* device instance cc__22_vdd r0 *1 0,0
Ccc__22_vdd \$22 vdd 1.0837e-17
* device instance cc__22_vref r0 *1 0,0
Ccc__22_vref \$22 vref 1.0837e-17
* device instance cc__22_vss r0 *1 0,0
Ccc__22_vss \$22 vss 5.20075e-16
* device instance cc__23__30 r0 *1 0,0
Ccc__23__30 \$23 \$30 1.0837e-17
* device instance cc__25__30 r0 *1 0,0
Ccc__25__30 \$25 \$30 1.0837e-17
* device instance cc__27__30 r0 *1 0,0
Ccc__27__30 \$27 \$30 1.0837e-17
* device instance cc__29__30 r0 *1 0,0
Ccc__29__30 \$29 \$30 1.0837e-17
* device instance cc__30__38 r0 *1 0,0
Ccc__30__38 \$30 \$38 1.10286e-16
* device instance cc__30__46 r0 *1 0,0
Ccc__30__46 \$30 \$46 1.10286e-16
* device instance cc__30__54 r0 *1 0,0
Ccc__30__54 \$30 \$54 1.10286e-16
* device instance cc__30__62 r0 *1 0,0
Ccc__30__62 \$30 \$62 7.5862e-17
* device instance cc__30__70 r0 *1 0,0
Ccc__30__70 \$30 \$70 5.4187e-17
* device instance cc__30__78 r0 *1 0,0
Ccc__30__78 \$30 \$78 3.2512e-17
* device instance cc__30__79 r0 *1 0,0
Ccc__30__79 \$30 \$79 1.7212e-17
* device instance cc__30__81 r0 *1 0,0
Ccc__30__81 \$30 \$81 1.7212e-17
* device instance cc__30__82 r0 *1 0,0
Ccc__30__82 \$30 \$82 1.0837e-17
* device instance cc__30__98 r0 *1 0,0
Ccc__30__98 \$30 \$98 1.0837e-17
* device instance cc__30_hi_64_n r0 *1 0,0
Ccc__30_hi_64_n \$30 hi_64_n 1.0837e-17
* device instance cc__30_hi_64_p r0 *1 0,0
Ccc__30_hi_64_p \$30 hi_64_p 1.0837e-17
* device instance cc__30_lo_64_n r0 *1 0,0
Ccc__30_lo_64_n \$30 lo_64_n 1.0837e-17
* device instance cc__30_lo_64_p r0 *1 0,0
Ccc__30_lo_64_p \$30 lo_64_p 1.0837e-17
* device instance cc__30_pinn r0 *1 0,0
Ccc__30_pinn \$30 vinn 1.0837e-17
* device instance cc__30_rel_64_n r0 *1 0,0
Ccc__30_rel_64_n \$30 rel_64_n 1.0837e-17
* device instance cc__30_rel_64_p r0 *1 0,0
Ccc__30_rel_64_p \$30 rel_64_p 1.0837e-17
* device instance cc__30_sel_in r0 *1 0,0
Ccc__30_sel_in \$30 sel_in 2.1675e-17
* device instance cc__30_topp r0 *1 0,0
Ccc__30_topp \$30 topp 1.0556984e-14
* device instance cc__30_vcm r0 *1 0,0
Ccc__30_vcm \$30 vcm 4.3349e-17
* device instance cc__30_vdd r0 *1 0,0
Ccc__30_vdd \$30 vdd 1.0837e-17
* device instance cc__30_vref r0 *1 0,0
Ccc__30_vref \$30 vref 1.0837e-17
* device instance cc__30_vss r0 *1 0,0
Ccc__30_vss \$30 vss 5.20075e-16
* device instance cc__31__38 r0 *1 0,0
Ccc__31__38 \$31 \$38 1.0837e-17
* device instance cc__33__38 r0 *1 0,0
Ccc__33__38 \$33 \$38 1.0837e-17
* device instance cc__35__38 r0 *1 0,0
Ccc__35__38 \$35 \$38 1.0837e-17
* device instance cc__37__38 r0 *1 0,0
Ccc__37__38 \$37 \$38 1.0837e-17
* device instance cc__38__46 r0 *1 0,0
Ccc__38__46 \$38 \$46 2.83684e-16
* device instance cc__38__54 r0 *1 0,0
Ccc__38__54 \$38 \$54 1.96985e-16
* device instance cc__38__62 r0 *1 0,0
Ccc__38__62 \$38 \$62 1.53635e-16
* device instance cc__38__70 r0 *1 0,0
Ccc__38__70 \$38 \$70 1.10286e-16
* device instance cc__38__78 r0 *1 0,0
Ccc__38__78 \$38 \$78 6.6937e-17
* device instance cc__38__79 r0 *1 0,0
Ccc__38__79 \$38 \$79 1.7212e-17
* device instance cc__38__81 r0 *1 0,0
Ccc__38__81 \$38 \$81 1.7212e-17
* device instance cc__38__82 r0 *1 0,0
Ccc__38__82 \$38 \$82 1.7212e-17
* device instance cc__38__83 r0 *1 0,0
Ccc__38__83 \$38 \$83 1.0837e-17
* device instance cc__38_hi_32_n r0 *1 0,0
Ccc__38_hi_32_n \$38 hi_32_n 1.0837e-17
* device instance cc__38_hi_32_p r0 *1 0,0
Ccc__38_hi_32_p \$38 hi_32_p 1.0837e-17
* device instance cc__38_lo_32_n r0 *1 0,0
Ccc__38_lo_32_n \$38 lo_32_n 1.0837e-17
* device instance cc__38_lo_32_p r0 *1 0,0
Ccc__38_lo_32_p \$38 lo_32_p 1.0837e-17
* device instance cc__38_pinn r0 *1 0,0
Ccc__38_pinn \$38 vinn 1.0837e-17
* device instance cc__38_rel_32_n r0 *1 0,0
Ccc__38_rel_32_n \$38 rel_32_n 1.0837e-17
* device instance cc__38_rel_32_p r0 *1 0,0
Ccc__38_rel_32_p \$38 rel_32_p 1.0837e-17
* device instance cc__38_sel_in r0 *1 0,0
Ccc__38_sel_in \$38 sel_in 2.1675e-17
* device instance cc__38_topp r0 *1 0,0
Ccc__38_topp \$38 topp 5.180063e-15
* device instance cc__38_vcm r0 *1 0,0
Ccc__38_vcm \$38 vcm 5.4187e-17
* device instance cc__38_vdd r0 *1 0,0
Ccc__38_vdd \$38 vdd 1.0837e-17
* device instance cc__38_vref r0 *1 0,0
Ccc__38_vref \$38 vref 1.0837e-17
* device instance cc__38_vss r0 *1 0,0
Ccc__38_vss \$38 vss 5.20075e-16
* device instance cc__39__46 r0 *1 0,0
Ccc__39__46 \$39 \$46 1.0837e-17
* device instance cc__39_vcm r0 *1 0,0
Ccc__39_vcm \$39 vcm 1.0837e-17
* device instance cc__41__46 r0 *1 0,0
Ccc__41__46 \$41 \$46 1.0837e-17
* device instance cc__41_vcm r0 *1 0,0
Ccc__41_vcm \$41 vcm 3.7724e-17
* device instance cc__43__46 r0 *1 0,0
Ccc__43__46 \$43 \$46 1.0837e-17
* device instance cc__43_vcm r0 *1 0,0
Ccc__43_vcm \$43 vcm 1.0837e-17
* device instance cc__45__46 r0 *1 0,0
Ccc__45__46 \$45 \$46 1.0837e-17
* device instance cc__45_vcm r0 *1 0,0
Ccc__45_vcm \$45 vcm 1.0837e-17
* device instance cc__46__54 r0 *1 0,0
Ccc__46__54 \$46 \$54 1.96985e-16
* device instance cc__46__62 r0 *1 0,0
Ccc__46__62 \$46 \$62 1.53635e-16
* device instance cc__46__70 r0 *1 0,0
Ccc__46__70 \$46 \$70 1.10286e-16
* device instance cc__46__78 r0 *1 0,0
Ccc__46__78 \$46 \$78 6.6937e-17
* device instance cc__46__79 r0 *1 0,0
Ccc__46__79 \$46 \$79 1.7212e-17
* device instance cc__46__81 r0 *1 0,0
Ccc__46__81 \$46 \$81 1.7212e-17
* device instance cc__46__82 r0 *1 0,0
Ccc__46__82 \$46 \$82 1.7212e-17
* device instance cc__46__83 r0 *1 0,0
Ccc__46__83 \$46 \$83 1.7212e-17
* device instance cc__46__84 r0 *1 0,0
Ccc__46__84 \$46 \$84 1.0837e-17
* device instance cc__46_hi_16_n r0 *1 0,0
Ccc__46_hi_16_n \$46 hi_16_n 1.0837e-17
* device instance cc__46_hi_16_p r0 *1 0,0
Ccc__46_hi_16_p \$46 hi_16_p 1.0837e-17
* device instance cc__46_lo_16_n r0 *1 0,0
Ccc__46_lo_16_n \$46 lo_16_n 1.0837e-17
* device instance cc__46_lo_16_p r0 *1 0,0
Ccc__46_lo_16_p \$46 lo_16_p 1.0837e-17
* device instance cc__46_pinn r0 *1 0,0
Ccc__46_pinn \$46 vinn 1.0837e-17
* device instance cc__46_rel_16_n r0 *1 0,0
Ccc__46_rel_16_n \$46 rel_16_n 1.0837e-17
* device instance cc__46_rel_16_p r0 *1 0,0
Ccc__46_rel_16_p \$46 rel_16_p 1.0837e-17
* device instance cc__46_sel_in r0 *1 0,0
Ccc__46_sel_in \$46 sel_in 2.1675e-17
* device instance cc__46_topp r0 *1 0,0
Ccc__46_topp \$46 topp 2.77493e-15
* device instance cc__46_vcm r0 *1 0,0
Ccc__46_vcm \$46 vcm 9.9449e-17
* device instance cc__46_vdd r0 *1 0,0
Ccc__46_vdd \$46 vdd 1.0837e-17
* device instance cc__46_vref r0 *1 0,0
Ccc__46_vref \$46 vref 1.0837e-17
* device instance cc__46_vss r0 *1 0,0
Ccc__46_vss \$46 vss 5.20075e-16
* device instance cc__47__54 r0 *1 0,0
Ccc__47__54 \$47 \$54 1.0837e-17
* device instance cc__49__54 r0 *1 0,0
Ccc__49__54 \$49 \$54 1.0837e-17
* device instance cc__51__54 r0 *1 0,0
Ccc__51__54 \$51 \$54 1.0837e-17
* device instance cc__53__54 r0 *1 0,0
Ccc__53__54 \$53 \$54 1.0837e-17
* device instance cc__54__62 r0 *1 0,0
Ccc__54__62 \$54 \$62 1.53635e-16
* device instance cc__54__70 r0 *1 0,0
Ccc__54__70 \$54 \$70 1.10286e-16
* device instance cc__54__78 r0 *1 0,0
Ccc__54__78 \$54 \$78 6.6937e-17
* device instance cc__54__79 r0 *1 0,0
Ccc__54__79 \$54 \$79 1.7212e-17
* device instance cc__54__81 r0 *1 0,0
Ccc__54__81 \$54 \$81 1.7212e-17
* device instance cc__54__82 r0 *1 0,0
Ccc__54__82 \$54 \$82 1.7212e-17
* device instance cc__54__83 r0 *1 0,0
Ccc__54__83 \$54 \$83 1.7212e-17
* device instance cc__54__84 r0 *1 0,0
Ccc__54__84 \$54 \$84 1.7212e-17
* device instance cc__54__85 r0 *1 0,0
Ccc__54__85 \$54 \$85 1.0837e-17
* device instance cc__54_hi_8_n r0 *1 0,0
Ccc__54_hi_8_n \$54 hi_8_n 1.0837e-17
* device instance cc__54_hi_8_p r0 *1 0,0
Ccc__54_hi_8_p \$54 hi_8_p 1.0837e-17
* device instance cc__54_lo_8_n r0 *1 0,0
Ccc__54_lo_8_n \$54 lo_8_n 1.0837e-17
* device instance cc__54_lo_8_p r0 *1 0,0
Ccc__54_lo_8_p \$54 lo_8_p 1.0837e-17
* device instance cc__54_pinn r0 *1 0,0
Ccc__54_pinn \$54 vinn 1.0837e-17
* device instance cc__54_rel_8_n r0 *1 0,0
Ccc__54_rel_8_n \$54 rel_8_n 1.0837e-17
* device instance cc__54_rel_8_p r0 *1 0,0
Ccc__54_rel_8_p \$54 rel_8_p 1.0837e-17
* device instance cc__54_sel_in r0 *1 0,0
Ccc__54_sel_in \$54 sel_in 2.1675e-17
* device instance cc__54_topp r0 *1 0,0
Ccc__54_topp \$54 topp 1.326814e-15
* device instance cc__54_vcm r0 *1 0,0
Ccc__54_vcm \$54 vcm 8.8611e-17
* device instance cc__54_vdd r0 *1 0,0
Ccc__54_vdd \$54 vdd 1.0837e-17
* device instance cc__54_vref r0 *1 0,0
Ccc__54_vref \$54 vref 1.0837e-17
* device instance cc__54_vss r0 *1 0,0
Ccc__54_vss \$54 vss 5.20075e-16
* device instance cc__55__62 r0 *1 0,0
Ccc__55__62 \$55 \$62 1.0837e-17
* device instance cc__57__62 r0 *1 0,0
Ccc__57__62 \$57 \$62 1.0837e-17
* device instance cc__59__62 r0 *1 0,0
Ccc__59__62 \$59 \$62 1.0837e-17
* device instance cc__61__62 r0 *1 0,0
Ccc__61__62 \$61 \$62 1.0837e-17
* device instance cc__62__70 r0 *1 0,0
Ccc__62__70 \$62 \$70 1.10286e-16
* device instance cc__62__78 r0 *1 0,0
Ccc__62__78 \$62 \$78 6.6937e-17
* device instance cc__62__79 r0 *1 0,0
Ccc__62__79 \$62 \$79 1.7212e-17
* device instance cc__62__81 r0 *1 0,0
Ccc__62__81 \$62 \$81 1.7212e-17
* device instance cc__62__82 r0 *1 0,0
Ccc__62__82 \$62 \$82 1.7212e-17
* device instance cc__62__83 r0 *1 0,0
Ccc__62__83 \$62 \$83 1.7212e-17
* device instance cc__62__84 r0 *1 0,0
Ccc__62__84 \$62 \$84 1.7212e-17
* device instance cc__62__85 r0 *1 0,0
Ccc__62__85 \$62 \$85 1.7212e-17
* device instance cc__62__86 r0 *1 0,0
Ccc__62__86 \$62 \$86 1.0837e-17
* device instance cc__62_hi_4_n r0 *1 0,0
Ccc__62_hi_4_n \$62 hi_4_n 1.0837e-17
* device instance cc__62_hi_4_p r0 *1 0,0
Ccc__62_hi_4_p \$62 hi_4_p 1.0837e-17
* device instance cc__62_lo_4_n r0 *1 0,0
Ccc__62_lo_4_n \$62 lo_4_n 1.0837e-17
* device instance cc__62_lo_4_p r0 *1 0,0
Ccc__62_lo_4_p \$62 lo_4_p 1.0837e-17
* device instance cc__62_pinn r0 *1 0,0
Ccc__62_pinn \$62 vinn 1.0837e-17
* device instance cc__62_rel_4_n r0 *1 0,0
Ccc__62_rel_4_n \$62 rel_4_n 1.0837e-17
* device instance cc__62_rel_4_p r0 *1 0,0
Ccc__62_rel_4_p \$62 rel_4_p 1.0837e-17
* device instance cc__62_sel_in r0 *1 0,0
Ccc__62_sel_in \$62 sel_in 2.1675e-17
* device instance cc__62_topp r0 *1 0,0
Ccc__62_topp \$62 topp 6.72013e-16
* device instance cc__62_vcm r0 *1 0,0
Ccc__62_vcm \$62 vcm 8.8611e-17
* device instance cc__62_vdd r0 *1 0,0
Ccc__62_vdd \$62 vdd 2.3587e-17
* device instance cc__62_vref r0 *1 0,0
Ccc__62_vref \$62 vref 1.0837e-17
* device instance cc__62_vss r0 *1 0,0
Ccc__62_vss \$62 vss 5.20075e-16
* device instance cc__63__70 r0 *1 0,0
Ccc__63__70 \$63 \$70 1.0837e-17
* device instance cc__65__70 r0 *1 0,0
Ccc__65__70 \$65 \$70 1.0837e-17
* device instance cc__67__70 r0 *1 0,0
Ccc__67__70 \$67 \$70 1.0837e-17
* device instance cc__69__70 r0 *1 0,0
Ccc__69__70 \$69 \$70 1.0837e-17
* device instance cc__70__78 r0 *1 0,0
Ccc__70__78 \$70 \$78 5.6099e-17
* device instance cc__70__79 r0 *1 0,0
Ccc__70__79 \$70 \$79 1.7212e-17
* device instance cc__70__81 r0 *1 0,0
Ccc__70__81 \$70 \$81 1.7212e-17
* device instance cc__70__82 r0 *1 0,0
Ccc__70__82 \$70 \$82 1.7212e-17
* device instance cc__70__83 r0 *1 0,0
Ccc__70__83 \$70 \$83 1.7212e-17
* device instance cc__70__84 r0 *1 0,0
Ccc__70__84 \$70 \$84 1.7212e-17
* device instance cc__70__85 r0 *1 0,0
Ccc__70__85 \$70 \$85 1.7212e-17
* device instance cc__70__86 r0 *1 0,0
Ccc__70__86 \$70 \$86 1.7212e-17
* device instance cc__70__87 r0 *1 0,0
Ccc__70__87 \$70 \$87 1.0837e-17
* device instance cc__70_hi_2_n r0 *1 0,0
Ccc__70_hi_2_n \$70 hi_2_n 1.0837e-17
* device instance cc__70_hi_2_p r0 *1 0,0
Ccc__70_hi_2_p \$70 hi_2_p 1.0837e-17
* device instance cc__70_lo_2_n r0 *1 0,0
Ccc__70_lo_2_n \$70 lo_2_n 1.0837e-17
* device instance cc__70_lo_2_p r0 *1 0,0
Ccc__70_lo_2_p \$70 lo_2_p 1.0837e-17
* device instance cc__70_pinn r0 *1 0,0
Ccc__70_pinn \$70 vinn 1.0837e-17
* device instance cc__70_rel_2_n r0 *1 0,0
Ccc__70_rel_2_n \$70 rel_2_n 1.0837e-17
* device instance cc__70_rel_2_p r0 *1 0,0
Ccc__70_rel_2_p \$70 rel_2_p 1.0837e-17
* device instance cc__70_sel_in r0 *1 0,0
Ccc__70_sel_in \$70 sel_in 2.1675e-17
* device instance cc__70_topn r0 *1 0,0
Ccc__70_topn \$70 topn 1.7212e-17
* device instance cc__70_topp r0 *1 0,0
Ccc__70_topp \$70 topp 3.44613e-16
* device instance cc__70_vcm r0 *1 0,0
Ccc__70_vcm \$70 vcm 6.6937e-17
* device instance cc__70_vdd r0 *1 0,0
Ccc__70_vdd \$70 vdd 1.0837e-17
* device instance cc__70_vref r0 *1 0,0
Ccc__70_vref \$70 vref 1.0837e-17
* device instance cc__70_vss r0 *1 0,0
Ccc__70_vss \$70 vss 5.20075e-16
* device instance cc__71__78 r0 *1 0,0
Ccc__71__78 \$71 \$78 1.0837e-17
* device instance cc__73__78 r0 *1 0,0
Ccc__73__78 \$73 \$78 1.0837e-17
* device instance cc__75__78 r0 *1 0,0
Ccc__75__78 \$75 \$78 1.0837e-17
* device instance cc__77__78 r0 *1 0,0
Ccc__77__78 \$77 \$78 1.0837e-17
* device instance cc__78__79 r0 *1 0,0
Ccc__78__79 \$78 \$79 1.7212e-17
* device instance cc__78__81 r0 *1 0,0
Ccc__78__81 \$78 \$81 1.7212e-17
* device instance cc__78__82 r0 *1 0,0
Ccc__78__82 \$78 \$82 1.7212e-17
* device instance cc__78__83 r0 *1 0,0
Ccc__78__83 \$78 \$83 1.7212e-17
* device instance cc__78__84 r0 *1 0,0
Ccc__78__84 \$78 \$84 1.7212e-17
* device instance cc__78__85 r0 *1 0,0
Ccc__78__85 \$78 \$85 1.7212e-17
* device instance cc__78__86 r0 *1 0,0
Ccc__78__86 \$78 \$86 1.7212e-17
* device instance cc__78__87 r0 *1 0,0
Ccc__78__87 \$78 \$87 1.7212e-17
* device instance cc__78__88 r0 *1 0,0
Ccc__78__88 \$78 \$88 4.5262e-17
* device instance cc__78_hi_1_n r0 *1 0,0
Ccc__78_hi_1_n \$78 hi_1_n 1.0837e-17
* device instance cc__78_hi_1_p r0 *1 0,0
Ccc__78_hi_1_p \$78 hi_1_p 1.0837e-17
* device instance cc__78_lo_1_n r0 *1 0,0
Ccc__78_lo_1_n \$78 lo_1_n 1.0837e-17
* device instance cc__78_lo_1_p r0 *1 0,0
Ccc__78_lo_1_p \$78 lo_1_p 1.0837e-17
* device instance cc__78_pinn r0 *1 0,0
Ccc__78_pinn \$78 vinn 1.0837e-17
* device instance cc__78_rel_1_n r0 *1 0,0
Ccc__78_rel_1_n \$78 rel_1_n 1.0837e-17
* device instance cc__78_rel_1_p r0 *1 0,0
Ccc__78_rel_1_p \$78 rel_1_p 1.0837e-17
* device instance cc__78_sel_in r0 *1 0,0
Ccc__78_sel_in \$78 sel_in 2.1675e-17
* device instance cc__78_topn r0 *1 0,0
Ccc__78_topn \$78 topn 1.7212e-17
* device instance cc__78_topp r0 *1 0,0
Ccc__78_topp \$78 topp 1.80912e-16
* device instance cc__78_vcm r0 *1 0,0
Ccc__78_vcm \$78 vcm 5.6099e-17
* device instance cc__78_vdd r0 *1 0,0
Ccc__78_vdd \$78 vdd 1.0837e-17
* device instance cc__78_vref r0 *1 0,0
Ccc__78_vref \$78 vref 1.0837e-17
* device instance cc__78_vss r0 *1 0,0
Ccc__78_vss \$78 vss 5.20075e-16
* device instance cc__79__81 r0 *1 0,0
Ccc__79__81 \$79 \$81 1.614766e-15
* device instance cc__79__82 r0 *1 0,0
Ccc__79__82 \$79 \$82 8.88663e-16
* device instance cc__79__83 r0 *1 0,0
Ccc__79__83 \$79 \$83 5.52705e-16
* device instance cc__79__84 r0 *1 0,0
Ccc__79__84 \$79 \$84 3.79308e-16
* device instance cc__79__85 r0 *1 0,0
Ccc__79__85 \$79 \$85 2.92609e-16
* device instance cc__79__86 r0 *1 0,0
Ccc__79__86 \$79 \$86 2.49259e-16
* device instance cc__79__87 r0 *1 0,0
Ccc__79__87 \$79 \$87 2.0591e-16
* device instance cc__79__88 r0 *1 0,0
Ccc__79__88 \$79 \$88 9.7536e-17
* device instance cc__79__90 r0 *1 0,0
Ccc__79__90 \$79 \$90 1.0837e-17
* device instance cc__79__92 r0 *1 0,0
Ccc__79__92 \$79 \$92 1.0837e-17
* device instance cc__79_lo_256_n r0 *1 0,0
Ccc__79_lo_256_n \$79 lo_256_n 6.924e-18
* device instance cc__79_sel_in r0 *1 0,0
Ccc__79_sel_in \$79 sel_in 1.0837e-17
* device instance cc__79_topn r0 *1 0,0
Ccc__79_topn \$79 topn 4.2159087e-14
* device instance cc__79_topp r0 *1 0,0
Ccc__79_topp \$79 topp 1.7212e-17
* device instance cc__79_vcm r0 *1 0,0
Ccc__79_vcm \$79 vcm 1.25586e-16
* device instance cc__79_vdd r0 *1 0,0
Ccc__79_vdd \$79 vdd 1.275e-17
* device instance cc__79_vss r0 *1 0,0
Ccc__79_vss \$79 vss 1.0837e-17
* device instance cc__81__82 r0 *1 0,0
Ccc__81__82 \$81 \$82 1.19211e-16
* device instance cc__81__83 r0 *1 0,0
Ccc__81__83 \$81 \$83 1.19211e-16
* device instance cc__81__84 r0 *1 0,0
Ccc__81__84 \$81 \$84 1.19211e-16
* device instance cc__81__85 r0 *1 0,0
Ccc__81__85 \$81 \$85 1.19211e-16
* device instance cc__81__86 r0 *1 0,0
Ccc__81__86 \$81 \$86 1.19211e-16
* device instance cc__81__87 r0 *1 0,0
Ccc__81__87 \$81 \$87 9.7536e-17
* device instance cc__81__88 r0 *1 0,0
Ccc__81__88 \$81 \$88 5.4187e-17
* device instance cc__81__94 r0 *1 0,0
Ccc__81__94 \$81 \$94 1.0837e-17
* device instance cc__81__96 r0 *1 0,0
Ccc__81__96 \$81 \$96 1.0837e-17
* device instance cc__81_lo_128_n r0 *1 0,0
Ccc__81_lo_128_n \$81 lo_128_n 6.924e-18
* device instance cc__81_sel_in r0 *1 0,0
Ccc__81_sel_in \$81 sel_in 1.0837e-17
* device instance cc__81_topn r0 *1 0,0
Ccc__81_topn \$81 topn 2.1079544e-14
* device instance cc__81_topp r0 *1 0,0
Ccc__81_topp \$81 topp 1.7212e-17
* device instance cc__81_vcm r0 *1 0,0
Ccc__81_vcm \$81 vcm 7.1399e-17
* device instance cc__81_vss r0 *1 0,0
Ccc__81_vss \$81 vss 1.0837e-17
* device instance cc__82__83 r0 *1 0,0
Ccc__82__83 \$82 \$83 7.5862e-17
* device instance cc__82__84 r0 *1 0,0
Ccc__82__84 \$82 \$84 7.5862e-17
* device instance cc__82__85 r0 *1 0,0
Ccc__82__85 \$82 \$85 7.5862e-17
* device instance cc__82__86 r0 *1 0,0
Ccc__82__86 \$82 \$86 7.5862e-17
* device instance cc__82__87 r0 *1 0,0
Ccc__82__87 \$82 \$87 5.4187e-17
* device instance cc__82__88 r0 *1 0,0
Ccc__82__88 \$82 \$88 3.2512e-17
* device instance cc__82__98 r0 *1 0,0
Ccc__82__98 \$82 \$98 1.0837e-17
* device instance cc__82_lo_64_n r0 *1 0,0
Ccc__82_lo_64_n \$82 lo_64_n 6.924e-18
* device instance cc__82_sel_in r0 *1 0,0
Ccc__82_sel_in \$82 sel_in 1.0837e-17
* device instance cc__82_topn r0 *1 0,0
Ccc__82_topn \$82 topn 1.0539772e-14
* device instance cc__82_topp r0 *1 0,0
Ccc__82_topp \$82 topp 1.7212e-17
* device instance cc__82_vcm r0 *1 0,0
Ccc__82_vcm \$82 vcm 4.9724e-17
* device instance cc__82_vdd r0 *1 0,0
Ccc__82_vdd \$82 vdd 1.275e-17
* device instance cc__82_vss r0 *1 0,0
Ccc__82_vss \$82 vss 1.0837e-17
* device instance cc__83__84 r0 *1 0,0
Ccc__83__84 \$83 \$84 2.49259e-16
* device instance cc__83__85 r0 *1 0,0
Ccc__83__85 \$83 \$85 1.6256e-16
* device instance cc__83__86 r0 *1 0,0
Ccc__83__86 \$83 \$86 1.19211e-16
* device instance cc__83__87 r0 *1 0,0
Ccc__83__87 \$83 \$87 7.5862e-17
* device instance cc__83__88 r0 *1 0,0
Ccc__83__88 \$83 \$88 3.2512e-17
* device instance cc__83_lo_32_n r0 *1 0,0
Ccc__83_lo_32_n \$83 lo_32_n 6.924e-18
* device instance cc__83_sel_in r0 *1 0,0
Ccc__83_sel_in \$83 sel_in 1.0837e-17
* device instance cc__83_topn r0 *1 0,0
Ccc__83_topn \$83 topn 5.162851e-15
* device instance cc__83_topp r0 *1 0,0
Ccc__83_topp \$83 topp 1.7212e-17
* device instance cc__83_vcm r0 *1 0,0
Ccc__83_vcm \$83 vcm 6.0562e-17
* device instance cc__83_vss r0 *1 0,0
Ccc__83_vss \$83 vss 1.0837e-17
* device instance cc__84__85 r0 *1 0,0
Ccc__84__85 \$84 \$85 1.6256e-16
* device instance cc__84__86 r0 *1 0,0
Ccc__84__86 \$84 \$86 1.19211e-16
* device instance cc__84__87 r0 *1 0,0
Ccc__84__87 \$84 \$87 7.5862e-17
* device instance cc__84__88 r0 *1 0,0
Ccc__84__88 \$84 \$88 3.2512e-17
* device instance cc__84_lo_16_n r0 *1 0,0
Ccc__84_lo_16_n \$84 lo_16_n 6.924e-18
* device instance cc__84_sel_in r0 *1 0,0
Ccc__84_sel_in \$84 sel_in 1.0837e-17
* device instance cc__84_topn r0 *1 0,0
Ccc__84_topn \$84 topn 2.757718e-15
* device instance cc__84_topp r0 *1 0,0
Ccc__84_topp \$84 topp 1.7212e-17
* device instance cc__84_vcm r0 *1 0,0
Ccc__84_vcm \$84 vcm 6.5024e-17
* device instance cc__84_vss r0 *1 0,0
Ccc__84_vss \$84 vss 1.0837e-17
* device instance cc__85__86 r0 *1 0,0
Ccc__85__86 \$85 \$86 2.1389e-16
* device instance cc__85__87 r0 *1 0,0
Ccc__85__87 \$85 \$87 7.5862e-17
* device instance cc__85__88 r0 *1 0,0
Ccc__85__88 \$85 \$88 3.2512e-17
* device instance cc__85_lo_8_n r0 *1 0,0
Ccc__85_lo_8_n \$85 lo_8_n 6.924e-18
* device instance cc__85_sel_in r0 *1 0,0
Ccc__85_sel_in \$85 sel_in 1.0837e-17
* device instance cc__85_topn r0 *1 0,0
Ccc__85_topn \$85 topn 1.309601e-15
* device instance cc__85_topp r0 *1 0,0
Ccc__85_topp \$85 topp 1.7212e-17
* device instance cc__85_vcm r0 *1 0,0
Ccc__85_vcm \$85 vcm 6.0562e-17
* device instance cc__85_vdd r0 *1 0,0
Ccc__85_vdd \$85 vdd 1.275e-17
* device instance cc__85_vss r0 *1 0,0
Ccc__85_vss \$85 vss 1.0837e-17
* device instance cc__86__87 r0 *1 0,0
Ccc__86__87 \$86 \$87 7.5862e-17
* device instance cc__86__88 r0 *1 0,0
Ccc__86__88 \$86 \$88 3.2512e-17
* device instance cc__86_lo_4_n r0 *1 0,0
Ccc__86_lo_4_n \$86 lo_4_n 6.924e-18
* device instance cc__86_sel_in r0 *1 0,0
Ccc__86_sel_in \$86 sel_in 1.0837e-17
* device instance cc__86_topn r0 *1 0,0
Ccc__86_topn \$86 topn 6.72013e-16
* device instance cc__86_topp r0 *1 0,0
Ccc__86_topp \$86 topp 1.7212e-17
* device instance cc__86_vcm r0 *1 0,0
Ccc__86_vcm \$86 vcm 6.0562e-17
* device instance cc__86_vss r0 *1 0,0
Ccc__86_vss \$86 vss 1.0837e-17
* device instance cc__87__88 r0 *1 0,0
Ccc__87__88 \$87 \$88 2.1675e-17
* device instance cc__87_lo_2_n r0 *1 0,0
Ccc__87_lo_2_n \$87 lo_2_n 6.924e-18
* device instance cc__87_sel_in r0 *1 0,0
Ccc__87_sel_in \$87 sel_in 1.0837e-17
* device instance cc__87_topn r0 *1 0,0
Ccc__87_topn \$87 topn 3.44613e-16
* device instance cc__87_topp r0 *1 0,0
Ccc__87_topp \$87 topp 1.7212e-17
* device instance cc__87_vcm r0 *1 0,0
Ccc__87_vcm \$87 vcm 3.8887e-17
* device instance cc__87_vdd r0 *1 0,0
Ccc__87_vdd \$87 vdd 1.275e-17
* device instance cc__87_vss r0 *1 0,0
Ccc__87_vss \$87 vss 1.0837e-17
* device instance cc__88_lo_1_n r0 *1 0,0
Ccc__88_lo_1_n \$88 lo_1_n 6.924e-18
* device instance cc__88_sel_in r0 *1 0,0
Ccc__88_sel_in \$88 sel_in 1.0837e-17
* device instance cc__88_topn r0 *1 0,0
Ccc__88_topn \$88 topn 1.80912e-16
* device instance cc__88_topp r0 *1 0,0
Ccc__88_topp \$88 topp 1.7212e-17
* device instance cc__88_vcm r0 *1 0,0
Ccc__88_vcm \$88 vcm 2.805e-17
* device instance cc__88_vdd r0 *1 0,0
Ccc__88_vdd \$88 vdd 5.194e-18
* device instance cc__88_vss r0 *1 0,0
Ccc__88_vss \$88 vss 1.0837e-17
* device instance cc_hi_16_n_vcm r0 *1 0,0
Ccc_hi_16_n_vcm hi_16_n vcm 1.0837e-17
* device instance cc_hi_16_p_vcm r0 *1 0,0
Ccc_hi_16_p_vcm hi_16_p vcm 1.0837e-17
* device instance cc_lo_16_n_vcm r0 *1 0,0
Ccc_lo_16_n_vcm lo_16_n vcm 1.0837e-17
* device instance cc_lo_16_p_vcm r0 *1 0,0
Ccc_lo_16_p_vcm lo_16_p vcm 1.0837e-17
* device instance cc_pinn_vcm r0 *1 0,0
Ccc_pinn_vcm vinn vcm 2.1675e-17
* device instance cc_pinp_vcm r0 *1 0,0
Ccc_pinp_vcm vinp vcm 1.0837e-17
* device instance cc_rel_16_n_vcm r0 *1 0,0
Ccc_rel_16_n_vcm rel_16_n vcm 1e-19
* device instance cc_rel_16_p_vcm r0 *1 0,0
Ccc_rel_16_p_vcm rel_16_p vcm 1e-19
* device instance cc_sel_in_vcm r0 *1 0,0
Ccc_sel_in_vcm sel_in vcm 3.2512e-17
* device instance cc_topn_topp r0 *1 0,0
Ccc_topn_topp topn topp 5.318e-18
* device instance cc_topn_vcm r0 *1 0,0
Ccc_topn_vcm topn vcm 1.74538e-16
* device instance cc_topn_vdd r0 *1 0,0
Ccc_topn_vdd topn vdd 2.3587e-17
* device instance cc_topn_vss r0 *1 0,0
Ccc_topn_vss topn vss 2.3587e-17
* device instance cc_topp_vcm r0 *1 0,0
Ccc_topp_vcm topp vcm 2.19799e-16
* device instance cc_topp_vdd r0 *1 0,0
Ccc_topp_vdd topp vdd 3.4425e-17
* device instance cc_topp_vss r0 *1 0,0
Ccc_topp_vss topp vss 2.3587e-17
* device instance cc_vcm_vdd r0 *1 0,0
Ccc_vcm_vdd vcm vdd 6.042e-17
* device instance cc_vcm_vref r0 *1 0,0
Ccc_vcm_vref vcm vref 1.0837e-17
* device instance cc_vcm_vss r0 *1 0,0
Ccc_vcm_vss vcm vss 5.6595e-17
* device instance cc_vdd_vss r0 *1 0,0
Ccc_vdd_vss vdd vss 3.2111e-17
* device instance vsubs_dctie r0 *1 0,0
Rvsubs_dctie vsubs 0 1e+12
.ENDS ADC_TOP

* ==================================================================
* tb_dr0014_sampling_extracted -- issue #89 Sec 6.3: the DR-0012/13
* Gain-error-systematic row (Group A, terms 1+2 + sampling gain/INL)
* and the C_par-mismatch residue (Group C, term 4), against the
* PMOS-body-remediated, MiM-mapped EXTRACTED ADC_TOP core, on
* sim/dr0014-sampling/'s own schedule and LSB-referred formulas.
*
* GENERATED by
* layout/adc-top/parasitics/gen_extracted_dr0014_sampling_tb.py --
* do not edit.
*
* Group B (fourth-leg settling A/B) and Group D (isolated T-gate
* R_on) have no extracted equivalent -- see this generator's own
* module docstring for why -- and are not emitted here.
* ==================================================================

* ---- retained waveforms --------------------------------------------
* ngspice keeps a transient waveform for EVERY node unless told which
* ones matter, and this deck instantiates the in-path-extracted core
* EIGHT times (five Group A pairs + three Group C), so every leg node
* the star-split adds is paid for eight times over. Measured at
* tt_27c_3.30v: 1378.5 MB peak RSS without this line, 158.3 MB with
* it -- 8.7x. The 1.4 GB form still completed on a quiet host, so the
* honest statement is not 'it cannot run' but 'nine of these at the
* -j 9 this 27 point grid is run at want ~12 GB of waveform store' --
* the same load-dependent failure that killed every INL/DNL point in
* PR #130. These are exactly the vectors
* sim/dr0014-sampling/testbench-extracted/tb.json reads, derived from
* it rather than hand-listed. Retention only: no model, tolerance or
* timestep changes, and all 43 measurements are bit-identical with and
* without it. See gen_extracted_core_tb.saved_vectors_lines.
.save v(a0_dd) v(a0_dn) v(a0_dp) v(a1_dd) v(a1_dn) v(a1_dp) v(a2_dd) v(a2_dn) v(a2_dp) v(a3_dd) v(a3_dn) v(a3_dp) v(a4_dd) v(a4_dn) v(a4_dp) v(c0_dd) v(c0_dn) v(c0_dp) v(c1_dd) v(c1_dn) v(c1_dp) v(c2_dd) v(c2_dn) v(c2_dp)

.param vref={vdd_val}
.param vcm={vdd_val/2}
.param lsb={vdd_val/1024}
.param ibias=10u

* ---- rails ---------------------------------------------------------
vddd vddd 0 dc {vdd_val}
vddc vddc 0 dc {vdd_val}
vrefs vrefn 0 dc {vref}
vcms vcmn 0 dc {vcm}
* Comparator strobe held LOW throughout, same rationale as the
* schematic deck: the latch is in reset/preamp-tracking while a DAC
* step settles; kickback on the strobe edge is sim/comparator-kickback/.
vcmpstrobe cmpstrobe 0 dc 0

* ---- shared DR-0014 two-phase schedule (issue #89 Sec 6.3) ---------
* One physical schedule, broadcast onto every pair's Xdut via the
* SAME ctrl-tag ('d14') net names _wire_pin_for_pair() gives every
* pair for its shared (non-analog-I/O) pins -- see module docstring.
vd14_sel_hi_n_128n d14_sel_hi_n_128n 0 dc 0
vd14_sel_hi_n_128p d14_sel_hi_n_128p 0 dc 0
vd14_sel_hi_n_16n d14_sel_hi_n_16n 0 dc 0
vd14_sel_hi_n_16p d14_sel_hi_n_16p 0 dc 0
vd14_sel_hi_n_1n d14_sel_hi_n_1n 0 dc 0
vd14_sel_hi_n_1p d14_sel_hi_n_1p 0 dc 0
vd14_sel_hi_n_256n d14_sel_hi_n_256n 0 dc 0
vd14_sel_hi_n_256p d14_sel_hi_n_256p 0 pulse(0 {vdd_val} 375n 100p 100p 10u 20u)
vd14_sel_hi_n_2n d14_sel_hi_n_2n 0 dc 0
vd14_sel_hi_n_2p d14_sel_hi_n_2p 0 dc 0
vd14_sel_hi_n_32n d14_sel_hi_n_32n 0 dc 0
vd14_sel_hi_n_32p d14_sel_hi_n_32p 0 dc 0
vd14_sel_hi_n_4n d14_sel_hi_n_4n 0 dc 0
vd14_sel_hi_n_4p d14_sel_hi_n_4p 0 dc 0
vd14_sel_hi_n_64n d14_sel_hi_n_64n 0 dc 0
vd14_sel_hi_n_64p d14_sel_hi_n_64p 0 dc 0
vd14_sel_hi_n_8n d14_sel_hi_n_8n 0 dc 0
vd14_sel_hi_n_8p d14_sel_hi_n_8p 0 dc 0
vd14_sel_lo_n_128n d14_sel_lo_n_128n 0 dc 0
vd14_sel_lo_n_128p d14_sel_lo_n_128p 0 dc 0
vd14_sel_lo_n_16n d14_sel_lo_n_16n 0 dc 0
vd14_sel_lo_n_16p d14_sel_lo_n_16p 0 dc 0
vd14_sel_lo_n_1n d14_sel_lo_n_1n 0 dc 0
vd14_sel_lo_n_1p d14_sel_lo_n_1p 0 dc 0
vd14_sel_lo_n_256n d14_sel_lo_n_256n 0 pulse(0 {vdd_val} 375n 100p 100p 10u 20u)
vd14_sel_lo_n_256p d14_sel_lo_n_256p 0 dc 0
vd14_sel_lo_n_2n d14_sel_lo_n_2n 0 dc 0
vd14_sel_lo_n_2p d14_sel_lo_n_2p 0 dc 0
vd14_sel_lo_n_32n d14_sel_lo_n_32n 0 dc 0
vd14_sel_lo_n_32p d14_sel_lo_n_32p 0 dc 0
vd14_sel_lo_n_4n d14_sel_lo_n_4n 0 dc 0
vd14_sel_lo_n_4p d14_sel_lo_n_4p 0 dc 0
vd14_sel_lo_n_64n d14_sel_lo_n_64n 0 dc 0
vd14_sel_lo_n_64p d14_sel_lo_n_64p 0 dc 0
vd14_sel_lo_n_8n d14_sel_lo_n_8n 0 dc 0
vd14_sel_lo_n_8p d14_sel_lo_n_8p 0 dc 0
vd14_rel_n_128n d14_rel_n_128n 0 pulse(0 {vdd_val} 250n 100p 100p 10u 20u)
vd14_rel_n_128p d14_rel_n_128p 0 pulse(0 {vdd_val} 250n 100p 100p 10u 20u)
vd14_rel_n_16n d14_rel_n_16n 0 pulse(0 {vdd_val} 250n 100p 100p 10u 20u)
vd14_rel_n_16p d14_rel_n_16p 0 pulse(0 {vdd_val} 250n 100p 100p 10u 20u)
vd14_rel_n_1n d14_rel_n_1n 0 pulse(0 {vdd_val} 250n 100p 100p 10u 20u)
vd14_rel_n_1p d14_rel_n_1p 0 pulse(0 {vdd_val} 250n 100p 100p 10u 20u)
vd14_rel_n_256n d14_rel_n_256n 0 pwl(0 0 250n 0 250.1n {vdd_val} 375n {vdd_val} 375.1n 0)
vd14_rel_n_256p d14_rel_n_256p 0 pwl(0 0 250n 0 250.1n {vdd_val} 375n {vdd_val} 375.1n 0)
vd14_rel_n_2n d14_rel_n_2n 0 pulse(0 {vdd_val} 250n 100p 100p 10u 20u)
vd14_rel_n_2p d14_rel_n_2p 0 pulse(0 {vdd_val} 250n 100p 100p 10u 20u)
vd14_rel_n_32n d14_rel_n_32n 0 pulse(0 {vdd_val} 250n 100p 100p 10u 20u)
vd14_rel_n_32p d14_rel_n_32p 0 pulse(0 {vdd_val} 250n 100p 100p 10u 20u)
vd14_rel_n_4n d14_rel_n_4n 0 pulse(0 {vdd_val} 250n 100p 100p 10u 20u)
vd14_rel_n_4p d14_rel_n_4p 0 pulse(0 {vdd_val} 250n 100p 100p 10u 20u)
vd14_rel_n_64n d14_rel_n_64n 0 pulse(0 {vdd_val} 250n 100p 100p 10u 20u)
vd14_rel_n_64p d14_rel_n_64p 0 pulse(0 {vdd_val} 250n 100p 100p 10u 20u)
vd14_rel_n_8n d14_rel_n_8n 0 pulse(0 {vdd_val} 250n 100p 100p 10u 20u)
vd14_rel_n_8p d14_rel_n_8p 0 pulse(0 {vdd_val} 250n 100p 100p 10u 20u)
vd14_sel_in_n d14_sel_in_n 0 pulse({vdd_val} 0 250n 100p 100p 10u 20u)
vd14_samp_tp_n d14_samp_tp_n 0 pulse({vdd_val} 0 187.5n 100p 100p 10u 20u)

* ==================================================================
* GROUP A -- terms 1 and 2, plus the sampling path's own gain/INL.
* Five differential pairs, identical schedule, differing input only.
* ==================================================================
* ---- pair a0: differential input f = -0.900 x V_cm
va0srcp a0_srcp 0 dc {vcm*0.09999999999999998}
Ra0sp a0_srcp a0_pinp 25
Ca0xp a0_pinp 0 1n
va0srcn a0_srcn 0 dc {vcm*1.9}
Ra0sn a0_srcn a0_pinn 25
Ca0xn a0_pinn 0 1n
Xa0dut d14_sel_hi_n_128n d14_sel_hi_n_128p d14_sel_hi_n_16n
+ d14_sel_hi_n_16p d14_sel_hi_n_1n d14_sel_hi_n_1p d14_sel_hi_n_256n
+ d14_sel_hi_n_256p d14_sel_hi_n_2n d14_sel_hi_n_2p d14_sel_hi_n_32n
+ d14_sel_hi_n_32p d14_sel_hi_n_4n d14_sel_hi_n_4p d14_sel_hi_n_64n
+ d14_sel_hi_n_64p d14_sel_hi_n_8n d14_sel_hi_n_8p d14_sel_lo_n_128n
+ d14_sel_lo_n_128p d14_sel_lo_n_16n d14_sel_lo_n_16p d14_sel_lo_n_1n
+ d14_sel_lo_n_1p d14_sel_lo_n_256n d14_sel_lo_n_256p d14_sel_lo_n_2n
+ d14_sel_lo_n_2p d14_sel_lo_n_32n d14_sel_lo_n_32p d14_sel_lo_n_4n
+ d14_sel_lo_n_4p d14_sel_lo_n_64n d14_sel_lo_n_64p d14_sel_lo_n_8n
+ d14_sel_lo_n_8p d14_rel_n_128n d14_rel_n_128p d14_rel_n_16n
+ d14_rel_n_16p d14_rel_n_1n d14_rel_n_1p d14_rel_n_256n d14_rel_n_256p
+ d14_rel_n_2n d14_rel_n_2p d14_rel_n_32n d14_rel_n_32p d14_rel_n_4n
+ d14_rel_n_4p d14_rel_n_64n d14_rel_n_64p d14_rel_n_8n d14_rel_n_8p
+ d14_sel_in_n a0_topn a0_topp d14_samp_tp_n vcmn vddd vrefn 0 a0_pinp
+ a0_pinn ADC_TOP
ia0b vddc a0_ib dc {ibias}
Xa0cmp a0_topp a0_topn cmpstrobe a0_ib a0_do a0_dob vddc 0 comparator
.nodeset v(a0_do)=0 v(a0_dob)={vdd_val}
ba0dp a0_dp 0 V = (v(a0_topp)-vcm)/lsb
ba0dn a0_dn 0 V = (v(a0_topn)-vcm)/lsb
ba0dd a0_dd 0 V = (v(a0_topp)-v(a0_topn))/lsb

* ---- pair a1: differential input f = -0.450 x V_cm
va1srcp a1_srcp 0 dc {vcm*0.55}
Ra1sp a1_srcp a1_pinp 25
Ca1xp a1_pinp 0 1n
va1srcn a1_srcn 0 dc {vcm*1.45}
Ra1sn a1_srcn a1_pinn 25
Ca1xn a1_pinn 0 1n
Xa1dut d14_sel_hi_n_128n d14_sel_hi_n_128p d14_sel_hi_n_16n
+ d14_sel_hi_n_16p d14_sel_hi_n_1n d14_sel_hi_n_1p d14_sel_hi_n_256n
+ d14_sel_hi_n_256p d14_sel_hi_n_2n d14_sel_hi_n_2p d14_sel_hi_n_32n
+ d14_sel_hi_n_32p d14_sel_hi_n_4n d14_sel_hi_n_4p d14_sel_hi_n_64n
+ d14_sel_hi_n_64p d14_sel_hi_n_8n d14_sel_hi_n_8p d14_sel_lo_n_128n
+ d14_sel_lo_n_128p d14_sel_lo_n_16n d14_sel_lo_n_16p d14_sel_lo_n_1n
+ d14_sel_lo_n_1p d14_sel_lo_n_256n d14_sel_lo_n_256p d14_sel_lo_n_2n
+ d14_sel_lo_n_2p d14_sel_lo_n_32n d14_sel_lo_n_32p d14_sel_lo_n_4n
+ d14_sel_lo_n_4p d14_sel_lo_n_64n d14_sel_lo_n_64p d14_sel_lo_n_8n
+ d14_sel_lo_n_8p d14_rel_n_128n d14_rel_n_128p d14_rel_n_16n
+ d14_rel_n_16p d14_rel_n_1n d14_rel_n_1p d14_rel_n_256n d14_rel_n_256p
+ d14_rel_n_2n d14_rel_n_2p d14_rel_n_32n d14_rel_n_32p d14_rel_n_4n
+ d14_rel_n_4p d14_rel_n_64n d14_rel_n_64p d14_rel_n_8n d14_rel_n_8p
+ d14_sel_in_n a1_topn a1_topp d14_samp_tp_n vcmn vddd vrefn 0 a1_pinp
+ a1_pinn ADC_TOP
ia1b vddc a1_ib dc {ibias}
Xa1cmp a1_topp a1_topn cmpstrobe a1_ib a1_do a1_dob vddc 0 comparator
.nodeset v(a1_do)=0 v(a1_dob)={vdd_val}
ba1dp a1_dp 0 V = (v(a1_topp)-vcm)/lsb
ba1dn a1_dn 0 V = (v(a1_topn)-vcm)/lsb
ba1dd a1_dd 0 V = (v(a1_topp)-v(a1_topn))/lsb

* ---- pair a2: differential input f = +0.000 x V_cm
va2srcp a2_srcp 0 dc {vcm*1.0}
Ra2sp a2_srcp a2_pinp 25
Ca2xp a2_pinp 0 1n
va2srcn a2_srcn 0 dc {vcm*1.0}
Ra2sn a2_srcn a2_pinn 25
Ca2xn a2_pinn 0 1n
Xa2dut d14_sel_hi_n_128n d14_sel_hi_n_128p d14_sel_hi_n_16n
+ d14_sel_hi_n_16p d14_sel_hi_n_1n d14_sel_hi_n_1p d14_sel_hi_n_256n
+ d14_sel_hi_n_256p d14_sel_hi_n_2n d14_sel_hi_n_2p d14_sel_hi_n_32n
+ d14_sel_hi_n_32p d14_sel_hi_n_4n d14_sel_hi_n_4p d14_sel_hi_n_64n
+ d14_sel_hi_n_64p d14_sel_hi_n_8n d14_sel_hi_n_8p d14_sel_lo_n_128n
+ d14_sel_lo_n_128p d14_sel_lo_n_16n d14_sel_lo_n_16p d14_sel_lo_n_1n
+ d14_sel_lo_n_1p d14_sel_lo_n_256n d14_sel_lo_n_256p d14_sel_lo_n_2n
+ d14_sel_lo_n_2p d14_sel_lo_n_32n d14_sel_lo_n_32p d14_sel_lo_n_4n
+ d14_sel_lo_n_4p d14_sel_lo_n_64n d14_sel_lo_n_64p d14_sel_lo_n_8n
+ d14_sel_lo_n_8p d14_rel_n_128n d14_rel_n_128p d14_rel_n_16n
+ d14_rel_n_16p d14_rel_n_1n d14_rel_n_1p d14_rel_n_256n d14_rel_n_256p
+ d14_rel_n_2n d14_rel_n_2p d14_rel_n_32n d14_rel_n_32p d14_rel_n_4n
+ d14_rel_n_4p d14_rel_n_64n d14_rel_n_64p d14_rel_n_8n d14_rel_n_8p
+ d14_sel_in_n a2_topn a2_topp d14_samp_tp_n vcmn vddd vrefn 0 a2_pinp
+ a2_pinn ADC_TOP
ia2b vddc a2_ib dc {ibias}
Xa2cmp a2_topp a2_topn cmpstrobe a2_ib a2_do a2_dob vddc 0 comparator
.nodeset v(a2_do)=0 v(a2_dob)={vdd_val}
ba2dp a2_dp 0 V = (v(a2_topp)-vcm)/lsb
ba2dn a2_dn 0 V = (v(a2_topn)-vcm)/lsb
ba2dd a2_dd 0 V = (v(a2_topp)-v(a2_topn))/lsb

* ---- pair a3: differential input f = +0.450 x V_cm
va3srcp a3_srcp 0 dc {vcm*1.45}
Ra3sp a3_srcp a3_pinp 25
Ca3xp a3_pinp 0 1n
va3srcn a3_srcn 0 dc {vcm*0.55}
Ra3sn a3_srcn a3_pinn 25
Ca3xn a3_pinn 0 1n
Xa3dut d14_sel_hi_n_128n d14_sel_hi_n_128p d14_sel_hi_n_16n
+ d14_sel_hi_n_16p d14_sel_hi_n_1n d14_sel_hi_n_1p d14_sel_hi_n_256n
+ d14_sel_hi_n_256p d14_sel_hi_n_2n d14_sel_hi_n_2p d14_sel_hi_n_32n
+ d14_sel_hi_n_32p d14_sel_hi_n_4n d14_sel_hi_n_4p d14_sel_hi_n_64n
+ d14_sel_hi_n_64p d14_sel_hi_n_8n d14_sel_hi_n_8p d14_sel_lo_n_128n
+ d14_sel_lo_n_128p d14_sel_lo_n_16n d14_sel_lo_n_16p d14_sel_lo_n_1n
+ d14_sel_lo_n_1p d14_sel_lo_n_256n d14_sel_lo_n_256p d14_sel_lo_n_2n
+ d14_sel_lo_n_2p d14_sel_lo_n_32n d14_sel_lo_n_32p d14_sel_lo_n_4n
+ d14_sel_lo_n_4p d14_sel_lo_n_64n d14_sel_lo_n_64p d14_sel_lo_n_8n
+ d14_sel_lo_n_8p d14_rel_n_128n d14_rel_n_128p d14_rel_n_16n
+ d14_rel_n_16p d14_rel_n_1n d14_rel_n_1p d14_rel_n_256n d14_rel_n_256p
+ d14_rel_n_2n d14_rel_n_2p d14_rel_n_32n d14_rel_n_32p d14_rel_n_4n
+ d14_rel_n_4p d14_rel_n_64n d14_rel_n_64p d14_rel_n_8n d14_rel_n_8p
+ d14_sel_in_n a3_topn a3_topp d14_samp_tp_n vcmn vddd vrefn 0 a3_pinp
+ a3_pinn ADC_TOP
ia3b vddc a3_ib dc {ibias}
Xa3cmp a3_topp a3_topn cmpstrobe a3_ib a3_do a3_dob vddc 0 comparator
.nodeset v(a3_do)=0 v(a3_dob)={vdd_val}
ba3dp a3_dp 0 V = (v(a3_topp)-vcm)/lsb
ba3dn a3_dn 0 V = (v(a3_topn)-vcm)/lsb
ba3dd a3_dd 0 V = (v(a3_topp)-v(a3_topn))/lsb

* ---- pair a4: differential input f = +0.900 x V_cm
va4srcp a4_srcp 0 dc {vcm*1.9}
Ra4sp a4_srcp a4_pinp 25
Ca4xp a4_pinp 0 1n
va4srcn a4_srcn 0 dc {vcm*0.09999999999999998}
Ra4sn a4_srcn a4_pinn 25
Ca4xn a4_pinn 0 1n
Xa4dut d14_sel_hi_n_128n d14_sel_hi_n_128p d14_sel_hi_n_16n
+ d14_sel_hi_n_16p d14_sel_hi_n_1n d14_sel_hi_n_1p d14_sel_hi_n_256n
+ d14_sel_hi_n_256p d14_sel_hi_n_2n d14_sel_hi_n_2p d14_sel_hi_n_32n
+ d14_sel_hi_n_32p d14_sel_hi_n_4n d14_sel_hi_n_4p d14_sel_hi_n_64n
+ d14_sel_hi_n_64p d14_sel_hi_n_8n d14_sel_hi_n_8p d14_sel_lo_n_128n
+ d14_sel_lo_n_128p d14_sel_lo_n_16n d14_sel_lo_n_16p d14_sel_lo_n_1n
+ d14_sel_lo_n_1p d14_sel_lo_n_256n d14_sel_lo_n_256p d14_sel_lo_n_2n
+ d14_sel_lo_n_2p d14_sel_lo_n_32n d14_sel_lo_n_32p d14_sel_lo_n_4n
+ d14_sel_lo_n_4p d14_sel_lo_n_64n d14_sel_lo_n_64p d14_sel_lo_n_8n
+ d14_sel_lo_n_8p d14_rel_n_128n d14_rel_n_128p d14_rel_n_16n
+ d14_rel_n_16p d14_rel_n_1n d14_rel_n_1p d14_rel_n_256n d14_rel_n_256p
+ d14_rel_n_2n d14_rel_n_2p d14_rel_n_32n d14_rel_n_32p d14_rel_n_4n
+ d14_rel_n_4p d14_rel_n_64n d14_rel_n_64p d14_rel_n_8n d14_rel_n_8p
+ d14_sel_in_n a4_topn a4_topp d14_samp_tp_n vcmn vddd vrefn 0 a4_pinp
+ a4_pinn ADC_TOP
ia4b vddc a4_ib dc {ibias}
Xa4cmp a4_topp a4_topn cmpstrobe a4_ib a4_do a4_dob vddc 0 comparator
.nodeset v(a4_do)=0 v(a4_dob)={vdd_val}
ba4dp a4_dp 0 V = (v(a4_topp)-vcm)/lsb
ba4dn a4_dn 0 V = (v(a4_topn)-vcm)/lsb
ba4dd a4_dd 0 V = (v(a4_topp)-v(a4_topn))/lsb

* ==================================================================
* GROUP C -- term 4, C_par-mismatch residue at Group A's level 3 (f = +0.450);
* a3 above is the matched reference -- same input,
* same schedule, same deck.
* ==================================================================
* ---- pair c0: differential input f = +0.450 x V_cm, +10 fF on the p top plate
vc0srcp c0_srcp 0 dc {vcm*1.45}
Rc0sp c0_srcp c0_pinp 25
Cc0xp c0_pinp 0 1n
vc0srcn c0_srcn 0 dc {vcm*0.55}
Rc0sn c0_srcn c0_pinn 25
Cc0xn c0_pinn 0 1n
Xc0dut d14_sel_hi_n_128n d14_sel_hi_n_128p d14_sel_hi_n_16n
+ d14_sel_hi_n_16p d14_sel_hi_n_1n d14_sel_hi_n_1p d14_sel_hi_n_256n
+ d14_sel_hi_n_256p d14_sel_hi_n_2n d14_sel_hi_n_2p d14_sel_hi_n_32n
+ d14_sel_hi_n_32p d14_sel_hi_n_4n d14_sel_hi_n_4p d14_sel_hi_n_64n
+ d14_sel_hi_n_64p d14_sel_hi_n_8n d14_sel_hi_n_8p d14_sel_lo_n_128n
+ d14_sel_lo_n_128p d14_sel_lo_n_16n d14_sel_lo_n_16p d14_sel_lo_n_1n
+ d14_sel_lo_n_1p d14_sel_lo_n_256n d14_sel_lo_n_256p d14_sel_lo_n_2n
+ d14_sel_lo_n_2p d14_sel_lo_n_32n d14_sel_lo_n_32p d14_sel_lo_n_4n
+ d14_sel_lo_n_4p d14_sel_lo_n_64n d14_sel_lo_n_64p d14_sel_lo_n_8n
+ d14_sel_lo_n_8p d14_rel_n_128n d14_rel_n_128p d14_rel_n_16n
+ d14_rel_n_16p d14_rel_n_1n d14_rel_n_1p d14_rel_n_256n d14_rel_n_256p
+ d14_rel_n_2n d14_rel_n_2p d14_rel_n_32n d14_rel_n_32p d14_rel_n_4n
+ d14_rel_n_4p d14_rel_n_64n d14_rel_n_64p d14_rel_n_8n d14_rel_n_8p
+ d14_sel_in_n c0_topn c0_topp d14_samp_tp_n vcmn vddd vrefn 0 c0_pinp
+ c0_pinn ADC_TOP
Cc0dcpar c0_topp 0 10f
ic0b vddc c0_ib dc {ibias}
Xc0cmp c0_topp c0_topn cmpstrobe c0_ib c0_do c0_dob vddc 0 comparator
.nodeset v(c0_do)=0 v(c0_dob)={vdd_val}
bc0dp c0_dp 0 V = (v(c0_topp)-vcm)/lsb
bc0dn c0_dn 0 V = (v(c0_topn)-vcm)/lsb
bc0dd c0_dd 0 V = (v(c0_topp)-v(c0_topn))/lsb

* ---- pair c1: differential input f = +0.450 x V_cm, +30 fF on the p top plate
vc1srcp c1_srcp 0 dc {vcm*1.45}
Rc1sp c1_srcp c1_pinp 25
Cc1xp c1_pinp 0 1n
vc1srcn c1_srcn 0 dc {vcm*0.55}
Rc1sn c1_srcn c1_pinn 25
Cc1xn c1_pinn 0 1n
Xc1dut d14_sel_hi_n_128n d14_sel_hi_n_128p d14_sel_hi_n_16n
+ d14_sel_hi_n_16p d14_sel_hi_n_1n d14_sel_hi_n_1p d14_sel_hi_n_256n
+ d14_sel_hi_n_256p d14_sel_hi_n_2n d14_sel_hi_n_2p d14_sel_hi_n_32n
+ d14_sel_hi_n_32p d14_sel_hi_n_4n d14_sel_hi_n_4p d14_sel_hi_n_64n
+ d14_sel_hi_n_64p d14_sel_hi_n_8n d14_sel_hi_n_8p d14_sel_lo_n_128n
+ d14_sel_lo_n_128p d14_sel_lo_n_16n d14_sel_lo_n_16p d14_sel_lo_n_1n
+ d14_sel_lo_n_1p d14_sel_lo_n_256n d14_sel_lo_n_256p d14_sel_lo_n_2n
+ d14_sel_lo_n_2p d14_sel_lo_n_32n d14_sel_lo_n_32p d14_sel_lo_n_4n
+ d14_sel_lo_n_4p d14_sel_lo_n_64n d14_sel_lo_n_64p d14_sel_lo_n_8n
+ d14_sel_lo_n_8p d14_rel_n_128n d14_rel_n_128p d14_rel_n_16n
+ d14_rel_n_16p d14_rel_n_1n d14_rel_n_1p d14_rel_n_256n d14_rel_n_256p
+ d14_rel_n_2n d14_rel_n_2p d14_rel_n_32n d14_rel_n_32p d14_rel_n_4n
+ d14_rel_n_4p d14_rel_n_64n d14_rel_n_64p d14_rel_n_8n d14_rel_n_8p
+ d14_sel_in_n c1_topn c1_topp d14_samp_tp_n vcmn vddd vrefn 0 c1_pinp
+ c1_pinn ADC_TOP
Cc1dcpar c1_topp 0 30f
ic1b vddc c1_ib dc {ibias}
Xc1cmp c1_topp c1_topn cmpstrobe c1_ib c1_do c1_dob vddc 0 comparator
.nodeset v(c1_do)=0 v(c1_dob)={vdd_val}
bc1dp c1_dp 0 V = (v(c1_topp)-vcm)/lsb
bc1dn c1_dn 0 V = (v(c1_topn)-vcm)/lsb
bc1dd c1_dd 0 V = (v(c1_topp)-v(c1_topn))/lsb

* ---- pair c2: differential input f = +0.450 x V_cm, +100 fF on the p top plate
vc2srcp c2_srcp 0 dc {vcm*1.45}
Rc2sp c2_srcp c2_pinp 25
Cc2xp c2_pinp 0 1n
vc2srcn c2_srcn 0 dc {vcm*0.55}
Rc2sn c2_srcn c2_pinn 25
Cc2xn c2_pinn 0 1n
Xc2dut d14_sel_hi_n_128n d14_sel_hi_n_128p d14_sel_hi_n_16n
+ d14_sel_hi_n_16p d14_sel_hi_n_1n d14_sel_hi_n_1p d14_sel_hi_n_256n
+ d14_sel_hi_n_256p d14_sel_hi_n_2n d14_sel_hi_n_2p d14_sel_hi_n_32n
+ d14_sel_hi_n_32p d14_sel_hi_n_4n d14_sel_hi_n_4p d14_sel_hi_n_64n
+ d14_sel_hi_n_64p d14_sel_hi_n_8n d14_sel_hi_n_8p d14_sel_lo_n_128n
+ d14_sel_lo_n_128p d14_sel_lo_n_16n d14_sel_lo_n_16p d14_sel_lo_n_1n
+ d14_sel_lo_n_1p d14_sel_lo_n_256n d14_sel_lo_n_256p d14_sel_lo_n_2n
+ d14_sel_lo_n_2p d14_sel_lo_n_32n d14_sel_lo_n_32p d14_sel_lo_n_4n
+ d14_sel_lo_n_4p d14_sel_lo_n_64n d14_sel_lo_n_64p d14_sel_lo_n_8n
+ d14_sel_lo_n_8p d14_rel_n_128n d14_rel_n_128p d14_rel_n_16n
+ d14_rel_n_16p d14_rel_n_1n d14_rel_n_1p d14_rel_n_256n d14_rel_n_256p
+ d14_rel_n_2n d14_rel_n_2p d14_rel_n_32n d14_rel_n_32p d14_rel_n_4n
+ d14_rel_n_4p d14_rel_n_64n d14_rel_n_64p d14_rel_n_8n d14_rel_n_8p
+ d14_sel_in_n c2_topn c2_topp d14_samp_tp_n vcmn vddd vrefn 0 c2_pinp
+ c2_pinn ADC_TOP
Cc2dcpar c2_topp 0 100f
ic2b vddc c2_ib dc {ibias}
Xc2cmp c2_topp c2_topn cmpstrobe c2_ib c2_do c2_dob vddc 0 comparator
.nodeset v(c2_do)=0 v(c2_dob)={vdd_val}
bc2dp c2_dp 0 V = (v(c2_topp)-vcm)/lsb
bc2dn c2_dn 0 V = (v(c2_topn)-vcm)/lsb
bc2dd c2_dd 0 V = (v(c2_topp)-v(c2_topn))/lsb
