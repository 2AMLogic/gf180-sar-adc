* Flat LVS reference for ADC_TGATE_DUM.
*
* GENERATED by layout/adc-top/cells/gen_adc_cells.py from
* design/adc-top/adc_top.spice's `.subckt adc_tgate_dum` -- do not
* edit. See layout/adc-top/lib/netlist.py for why the layout and this
* reference are derived from the same parsed design netlist, and what
* that does and does not let LVS prove.
*
* Deliberate, documented differences from the schematic, each forced by
* `klt extract`'s gf180mcu ExtractionDeck and restated in
* layout/adc-top/README.md:
*   - every NMOS body is on the deck's `vsubs` global, not on the
*     schematic's `0`/`vss`: the curated deck has no tap layer, so a
*     drawn substrate tie cannot name that net;
*   - every PMOS body is on the Nwell island's own (unnamed) net, not
*     on `vdd`: the deck never connects `nwell` to `contact`;
*   - the MiM capacitors are absent: they are drawn without the
*     CAP_MK/MIM_L_MK marker layers the deck recognises a device
*     by, so `klt extract` reports none (layout/adc-top/README.md).
*
* Runnable by hand:  klt lvs layout/adc-top/cells/adc_tgate_dum.lvs.json --format json
.SUBCKT ADC_TGATE_DUM clk clkb vin vout vsubs
MXDN vout clkb vout vsubs nfet L=0.28U W=17.5U
MXN vin clk vout vsubs nfet L=0.28U W=40U
MXP vin clkb vout nw pfet L=0.28U W=80U
MXDP vout clk vout nw pfet L=0.28U W=35U
.ENDS ADC_TGATE_DUM
