* ==================================================================
* tb_sar_logic_timing -- what the synchronous choice actually buys,
* measured rather than asserted (issue #11, DR-0008).
*
* GENERATED by design/sar-logic/flow/gen_sar_ctrl_gates_tb.py -- do not edit.
*
* ISSUE #311: this deck instantiates ONE loop of the five-loop
* family above (ok/lt/xl/bad/tie), not all five. ngspice advances
* one GLOBAL timestep for a whole deck, so five clock-sharing
* sar_ctrl_a instances sharing one file force each other's step
* down to the union of their switching activity -- measured at up
* to ~100x the cost per simulated ns of running one loop alone
* (sim/sar-logic-timing-gates/investigations/
* 20260917-issue-303-five-loop-composition-cost.md). The loops
* are electrically independent -- each has its own sar_ctrl_a
* instance, CDAC/comparator and stimulus, sharing only the `clk`
* stimulus and the `vdd_gate` supply -- so splitting them changes
* NOTHING about what is measured, only how many loops share one
* deck. The measurement definitions, bounds and 8.5 us duration
* are UNCHANGED from the five-loop composition.
*
* `ok`: 0 ns delay -- the reference point. No delay is
* inserted between the comparator's analog decision and
* the controller sampling it, so with no added decision
* delay every conversion must come out exact.
*
* ==================================================================

.param vref={vdd_val}
.param vcm={vdd_val/2}
.param vth={vdd_val/2}
.param lsbse={vdd_val/1024}
.model sarl_sw sw(vt={vdd_val/2} vh=0 ron=1 roff=1e12)

vclk clk 0 pulse(0 {vdd_val} 0 100p 100p 31.25n 62.5n)

* ---- loop ok ----
vokstart ok_start 0 pwl(0 {vdd_val} 125n {vdd_val} 125.1n 0)
vokmode ok_mode 0 dc 0
xok clk ok_start ok_mode ok_cmpo ok_samp_tp_n ok_sel_in_n ok_drdy ok_c9
+ ok_c8 ok_c7 ok_c6 ok_c5 ok_c4 ok_c3 ok_c2 ok_c1 ok_c0 ok_rel_n_256p
+ ok_sel_hi_n_256p ok_sel_lo_n_256p ok_rel_n_128p ok_sel_hi_n_128p
+ ok_sel_lo_n_128p ok_rel_n_64p ok_sel_hi_n_64p ok_sel_lo_n_64p
+ ok_rel_n_32p ok_sel_hi_n_32p ok_sel_lo_n_32p ok_rel_n_16p
+ ok_sel_hi_n_16p ok_sel_lo_n_16p ok_rel_n_8p ok_sel_hi_n_8p
+ ok_sel_lo_n_8p ok_rel_n_4p ok_sel_hi_n_4p ok_sel_lo_n_4p ok_rel_n_2p
+ ok_sel_hi_n_2p ok_sel_lo_n_2p ok_rel_n_1p ok_sel_hi_n_1p ok_sel_lo_n_1p
+ ok_rel_n_256n ok_sel_hi_n_256n ok_sel_lo_n_256n ok_rel_n_128n
+ ok_sel_hi_n_128n ok_sel_lo_n_128n ok_rel_n_64n ok_sel_hi_n_64n
+ ok_sel_lo_n_64n ok_rel_n_32n ok_sel_hi_n_32n ok_sel_lo_n_32n
+ ok_rel_n_16n ok_sel_hi_n_16n ok_sel_lo_n_16n ok_rel_n_8n ok_sel_hi_n_8n
+ ok_sel_lo_n_8n ok_rel_n_4n ok_sel_hi_n_4n ok_sel_lo_n_4n ok_rel_n_2n
+ ok_sel_hi_n_2n ok_sel_lo_n_2n ok_rel_n_1n ok_sel_hi_n_1n ok_sel_lo_n_1n
+ sar_ctrl_a
sokp ok_vinp ok_shp ok_samp_tp_n 0 sarl_sw
sokn ok_vinn ok_shn ok_samp_tp_n 0 sarl_sw
cokp ok_shp 0 1p
cokn ok_shn 0 1p
roksd ok_samp_tp_n ok_sampd 10k
coksd ok_sampd 0 1p
sokxp ok_vinp ok_shxp ok_sampd 0 sarl_sw
sokxn ok_vinn ok_shxn ok_sampd 0 sarl_sw
cokxp ok_shxp 0 1p
cokxn ok_shxn 0 1p
boktopp ok_topip 0 V = 2*vcm-v(ok_shp)+(1.0/512)*(
+ 256*((v(ok_rel_n_256p)*vcm+v(ok_sel_hi_n_256p)*vref+v(ok_sel_in_n)*v(ok_vinp))/vdd_val-vcm) + 128*((v(ok_rel_n_128p)*vcm+v(ok_sel_hi_n_128p)*vref+v(ok_sel_in_n)*v(ok_vinp))/vdd_val-vcm) + 64*((v(ok_rel_n_64p)*vcm+v(ok_sel_hi_n_64p)*vref+v(ok_sel_in_n)*v(ok_vinp))/vdd_val-vcm) + 32*((v(ok_rel_n_32p)*vcm+v(ok_sel_hi_n_32p)*vref+v(ok_sel_in_n)*v(ok_vinp))/vdd_val-vcm) + 16*((v(ok_rel_n_16p)*vcm+v(ok_sel_hi_n_16p)*vref+v(ok_sel_in_n)*v(ok_vinp))/vdd_val-vcm) + 8*((v(ok_rel_n_8p)*vcm+v(ok_sel_hi_n_8p)*vref+v(ok_sel_in_n)*v(ok_vinp))/vdd_val-vcm) + 4*((v(ok_rel_n_4p)*vcm+v(ok_sel_hi_n_4p)*vref+v(ok_sel_in_n)*v(ok_vinp))/vdd_val-vcm) + 2*((v(ok_rel_n_2p)*vcm+v(ok_sel_hi_n_2p)*vref+v(ok_sel_in_n)*v(ok_vinp))/vdd_val-vcm) + 1*((v(ok_rel_n_1p)*vcm+v(ok_sel_hi_n_1p)*vref+v(ok_sel_in_n)*v(ok_vinp))/vdd_val-vcm) )
boktopn ok_topin 0 V = 2*vcm-v(ok_shn)+(1.0/512)*(
+ 256*((v(ok_rel_n_256n)*vcm+v(ok_sel_hi_n_256n)*vref+v(ok_sel_in_n)*v(ok_vinn))/vdd_val-vcm) + 128*((v(ok_rel_n_128n)*vcm+v(ok_sel_hi_n_128n)*vref+v(ok_sel_in_n)*v(ok_vinn))/vdd_val-vcm) + 64*((v(ok_rel_n_64n)*vcm+v(ok_sel_hi_n_64n)*vref+v(ok_sel_in_n)*v(ok_vinn))/vdd_val-vcm) + 32*((v(ok_rel_n_32n)*vcm+v(ok_sel_hi_n_32n)*vref+v(ok_sel_in_n)*v(ok_vinn))/vdd_val-vcm) + 16*((v(ok_rel_n_16n)*vcm+v(ok_sel_hi_n_16n)*vref+v(ok_sel_in_n)*v(ok_vinn))/vdd_val-vcm) + 8*((v(ok_rel_n_8n)*vcm+v(ok_sel_hi_n_8n)*vref+v(ok_sel_in_n)*v(ok_vinn))/vdd_val-vcm) + 4*((v(ok_rel_n_4n)*vcm+v(ok_sel_hi_n_4n)*vref+v(ok_sel_in_n)*v(ok_vinn))/vdd_val-vcm) + 2*((v(ok_rel_n_2n)*vcm+v(ok_sel_hi_n_2n)*vref+v(ok_sel_in_n)*v(ok_vinn))/vdd_val-vcm) + 1*((v(ok_rel_n_1n)*vcm+v(ok_sel_hi_n_1n)*vref+v(ok_sel_in_n)*v(ok_vinn))/vdd_val-vcm) )
rokp ok_topip ok_topp 1k
rokn ok_topin ok_topn 1k
coktp ok_topp 0 2.56p
coktn ok_topn 0 2.56p
bokcmp ok_cmpd 0 V = v(ok_topp) > v(ok_topn) ? vdd_val : 0
rokcmps ok_cmpd ok_cmpo 1k
cokcmpl ok_cmpo 0 100f
bokcode ok_code 0 V =
+ (512)*(v(ok_c9)>vth ? 1 : 0) + (256)*(v(ok_c8)>vth ? 1 : 0) + (128)*(v(ok_c7)>vth ? 1 : 0) + (64)*(v(ok_c6)>vth ? 1 : 0) + (32)*(v(ok_c5)>vth ? 1 : 0) + (16)*(v(ok_c4)>vth ? 1 : 0) + (8)*(v(ok_c3)>vth ? 1 : 0) + (4)*(v(ok_c2)>vth ? 1 : 0) + (2)*(v(ok_c1)>vth ? 1 : 0) + (1)*(v(ok_c0)>vth ? 1 : 0)
bokconf ok_conf 0 V = (
+ abs(v(ok_sel_in_n)+v(ok_rel_n_256p)+v(ok_sel_hi_n_256p)+v(ok_sel_lo_n_256p)-vdd_val) + abs(v(ok_sel_in_n)+v(ok_rel_n_128p)+v(ok_sel_hi_n_128p)+v(ok_sel_lo_n_128p)-vdd_val) + abs(v(ok_sel_in_n)+v(ok_rel_n_64p)+v(ok_sel_hi_n_64p)+v(ok_sel_lo_n_64p)-vdd_val) + abs(v(ok_sel_in_n)+v(ok_rel_n_32p)+v(ok_sel_hi_n_32p)+v(ok_sel_lo_n_32p)-vdd_val) + abs(v(ok_sel_in_n)+v(ok_rel_n_16p)+v(ok_sel_hi_n_16p)+v(ok_sel_lo_n_16p)-vdd_val) + abs(v(ok_sel_in_n)+v(ok_rel_n_8p)+v(ok_sel_hi_n_8p)+v(ok_sel_lo_n_8p)-vdd_val) + abs(v(ok_sel_in_n)+v(ok_rel_n_4p)+v(ok_sel_hi_n_4p)+v(ok_sel_lo_n_4p)-vdd_val) + abs(v(ok_sel_in_n)+v(ok_rel_n_2p)+v(ok_sel_hi_n_2p)+v(ok_sel_lo_n_2p)-vdd_val) + abs(v(ok_sel_in_n)+v(ok_rel_n_1p)+v(ok_sel_hi_n_1p)+v(ok_sel_lo_n_1p)-vdd_val) + abs(v(ok_sel_in_n)+v(ok_rel_n_256n)+v(ok_sel_hi_n_256n)+v(ok_sel_lo_n_256n)-vdd_val) + abs(v(ok_sel_in_n)+v(ok_rel_n_128n)+v(ok_sel_hi_n_128n)+v(ok_sel_lo_n_128n)-vdd_val) + abs(v(ok_sel_in_n)+v(ok_rel_n_64n)+v(ok_sel_hi_n_64n)+v(ok_sel_lo_n_64n)-vdd_val) + abs(v(ok_sel_in_n)+v(ok_rel_n_32n)+v(ok_sel_hi_n_32n)+v(ok_sel_lo_n_32n)-vdd_val) + abs(v(ok_sel_in_n)+v(ok_rel_n_16n)+v(ok_sel_hi_n_16n)+v(ok_sel_lo_n_16n)-vdd_val) + abs(v(ok_sel_in_n)+v(ok_rel_n_8n)+v(ok_sel_hi_n_8n)+v(ok_sel_lo_n_8n)-vdd_val) + abs(v(ok_sel_in_n)+v(ok_rel_n_4n)+v(ok_sel_hi_n_4n)+v(ok_sel_lo_n_4n)-vdd_val) + abs(v(ok_sel_in_n)+v(ok_rel_n_2n)+v(ok_sel_hi_n_2n)+v(ok_sel_lo_n_2n)-vdd_val) + abs(v(ok_sel_in_n)+v(ok_rel_n_1n)+v(ok_sel_hi_n_1n)+v(ok_sel_lo_n_1n)-vdd_val))/vdd_val
boknside ok_nside 0 V = (
+ v(ok_sel_hi_n_256n)+v(ok_sel_lo_n_256n) + v(ok_sel_hi_n_128n)+v(ok_sel_lo_n_128n) + v(ok_sel_hi_n_64n)+v(ok_sel_lo_n_64n) + v(ok_sel_hi_n_32n)+v(ok_sel_lo_n_32n) + v(ok_sel_hi_n_16n)+v(ok_sel_lo_n_16n) + v(ok_sel_hi_n_8n)+v(ok_sel_lo_n_8n) + v(ok_sel_hi_n_4n)+v(ok_sel_lo_n_4n) + v(ok_sel_hi_n_2n)+v(ok_sel_lo_n_2n) + v(ok_sel_hi_n_1n)+v(ok_sel_lo_n_1n))/vdd_val
bokacq ok_acq 0 V = v(ok_samp_tp_n)/vdd_val
bokiso ok_iso 0 V = (v(ok_sel_in_n)-v(ok_samp_tp_n))/vdd_val
* ok: input ramps one LSB per conversion THROUGH mid-scale
* (codes 507..515), so the run crosses the major carry where every
* bit changes at once -- the worst case for a late decision -- and
* exercises both branches of the free-MSB trial.
vokin ok_vinp 0 pwl(0 {vcm-4.75*lsbse} 8u {vcm+3.25*lsbse})
vokcm ok_vinn 0 dc {vcm}
bokexp ok_exp 0 V = min(max(floor(v(ok_shxp)/lsbse),0),1023)
bokerr ok_err 0 V = v(ok_drdy)>vth ? v(ok_code)-v(ok_exp) : 0
bokaerr ok_aerr 0 V = abs(v(ok_err))

* Externally-supplied net(s) this subckt's cells bind but nothing
* inside it drives. Without .global, SPICE scopes these LOCALLY to
* each instance -- the DUT would sit unpowered at ~0 V and every
* symptom would read as a solver/power-up problem (issue #282).
.global vdd_gate

.subckt sar_ctrl_a clk start mode cmp samp_tp_n sel_in_n drdy c9 c8 c7 c6 c5 c4 c3 c2 c1 c0 rel_n_256p sel_hi_n_256p sel_lo_n_256p rel_n_128p sel_hi_n_128p sel_lo_n_128p rel_n_64p sel_hi_n_64p sel_lo_n_64p rel_n_32p sel_hi_n_32p sel_lo_n_32p rel_n_16p sel_hi_n_16p sel_lo_n_16p rel_n_8p sel_hi_n_8p sel_lo_n_8p rel_n_4p sel_hi_n_4p sel_lo_n_4p rel_n_2p sel_hi_n_2p sel_lo_n_2p rel_n_1p sel_hi_n_1p sel_lo_n_1p rel_n_256n sel_hi_n_256n sel_lo_n_256n rel_n_128n sel_hi_n_128n sel_lo_n_128n rel_n_64n sel_hi_n_64n sel_lo_n_64n rel_n_32n sel_hi_n_32n sel_lo_n_32n rel_n_16n sel_hi_n_16n sel_lo_n_16n rel_n_8n sel_hi_n_8n sel_lo_n_8n rel_n_4n sel_hi_n_4n sel_lo_n_4n rel_n_2n sel_hi_n_2n sel_lo_n_2n rel_n_1n sel_hi_n_1n sel_lo_n_1n
X_065_ eng3 _030_ vdd_gate vdd_gate 0 0 gf180mcu_fd_sc_mcu7t5v0__clkinv_1
X_066_ mode _031_ vdd_gate vdd_gate 0 0 gf180mcu_fd_sc_mcu7t5v0__clkinv_1
X_067_ ph_2 _032_ vdd_gate vdd_gate 0 0 gf180mcu_fd_sc_mcu7t5v0__clkinv_1
X_068_ ph_0 _033_ vdd_gate vdd_gate 0 0 gf180mcu_fd_sc_mcu7t5v0__clkinv_1
X_069_ ph_1 _034_ vdd_gate vdd_gate 0 0 gf180mcu_fd_sc_mcu7t5v0__clkinv_1
X_070_ ph_3 _035_ vdd_gate vdd_gate 0 0 gf180mcu_fd_sc_mcu7t5v0__clkinv_1
X_071_ eng4 _036_ vdd_gate vdd_gate 0 0 gf180mcu_fd_sc_mcu7t5v0__clkinv_1
X_072_ eng5 _037_ vdd_gate vdd_gate 0 0 gf180mcu_fd_sc_mcu7t5v0__clkinv_1
X_073_ eng6 _038_ vdd_gate vdd_gate 0 0 gf180mcu_fd_sc_mcu7t5v0__clkinv_1
X_074_ eng7 _039_ vdd_gate vdd_gate 0 0 gf180mcu_fd_sc_mcu7t5v0__clkinv_1
X_075_ eng8 _040_ vdd_gate vdd_gate 0 0 gf180mcu_fd_sc_mcu7t5v0__clkinv_1
X_076_ eng9 _041_ vdd_gate vdd_gate 0 0 gf180mcu_fd_sc_mcu7t5v0__clkinv_1
X_077_ eng2 _042_ vdd_gate vdd_gate 0 0 gf180mcu_fd_sc_mcu7t5v0__clkinv_1
X_078_ ph_12 _043_ vdd_gate vdd_gate 0 0 gf180mcu_fd_sc_mcu7t5v0__clkinv_1
X_079_ eng1 _044_ vdd_gate vdd_gate 0 0 gf180mcu_fd_sc_mcu7t5v0__clkinv_1
X_080_ ph_13 _045_ vdd_gate vdd_gate 0 0 gf180mcu_fd_sc_mcu7t5v0__clkinv_1
X_081_ ph_11 _046_ vdd_gate vdd_gate 0 0 gf180mcu_fd_sc_mcu7t5v0__clkinv_1
X_082_ ph_10 _047_ vdd_gate vdd_gate 0 0 gf180mcu_fd_sc_mcu7t5v0__clkinv_1
X_083_ ph_9 _048_ vdd_gate vdd_gate 0 0 gf180mcu_fd_sc_mcu7t5v0__clkinv_1
X_084_ ph_8 _049_ vdd_gate vdd_gate 0 0 gf180mcu_fd_sc_mcu7t5v0__clkinv_1
X_085_ ph_7 _050_ vdd_gate vdd_gate 0 0 gf180mcu_fd_sc_mcu7t5v0__clkinv_1
X_086_ ph_6 _051_ vdd_gate vdd_gate 0 0 gf180mcu_fd_sc_mcu7t5v0__clkinv_1
X_087_ ph_5 _052_ vdd_gate vdd_gate 0 0 gf180mcu_fd_sc_mcu7t5v0__clkinv_1
X_088_ ph_4 _053_ vdd_gate vdd_gate 0 0 gf180mcu_fd_sc_mcu7t5v0__clkinv_1
X_089_ ph_14 _054_ vdd_gate vdd_gate 0 0 gf180mcu_fd_sc_mcu7t5v0__clkinv_1
X_090_ _030_ q3 sel_lo_n_4p vdd_gate vdd_gate 0 0 gf180mcu_fd_sc_mcu7t5v0__nor2_1
X_091_ _030_ _031_ q3 sel_hi_n_4n vdd_gate vdd_gate 0 0 gf180mcu_fd_sc_mcu7t5v0__nor3_1
X_092_ _032_ _033_ _034_ samp_tp_n vdd_gate vdd_gate 0 0 gf180mcu_fd_sc_mcu7t5v0__nand3_1
X_093_ ph_2 ph_0 ph_1 ph_3 sel_in_n vdd_gate vdd_gate 0 0 gf180mcu_fd_sc_mcu7t5v0__or4_1
X_094_ eng3 sel_in_n rel_n_4p vdd_gate vdd_gate 0 0 gf180mcu_fd_sc_mcu7t5v0__nor2_1
X_095_ eng3 mode sel_in_n rel_n_4n vdd_gate vdd_gate 0 0 gf180mcu_fd_sc_mcu7t5v0__aoi21_1
X_096_ eng3 q3 sel_hi_n_4p vdd_gate vdd_gate 0 0 gf180mcu_fd_sc_mcu7t5v0__and2_1
X_097_ q4 eng4 sel_hi_n_8p vdd_gate vdd_gate 0 0 gf180mcu_fd_sc_mcu7t5v0__and2_1
X_098_ mode sel_hi_n_8p sel_lo_n_8n vdd_gate vdd_gate 0 0 gf180mcu_fd_sc_mcu7t5v0__and2_1
X_099_ q4 _036_ sel_lo_n_8p vdd_gate vdd_gate 0 0 gf180mcu_fd_sc_mcu7t5v0__nor2_1
X_100_ _031_ q4 _036_ sel_hi_n_8n vdd_gate vdd_gate 0 0 gf180mcu_fd_sc_mcu7t5v0__nor3_1
X_101_ eng4 sel_in_n rel_n_8p vdd_gate vdd_gate 0 0 gf180mcu_fd_sc_mcu7t5v0__nor2_1
X_102_ mode eng4 sel_in_n rel_n_8n vdd_gate vdd_gate 0 0 gf180mcu_fd_sc_mcu7t5v0__aoi21_1
X_103_ q5 eng5 sel_hi_n_16p vdd_gate vdd_gate 0 0 gf180mcu_fd_sc_mcu7t5v0__and2_1
X_104_ mode sel_hi_n_16p sel_lo_n_16n vdd_gate vdd_gate 0 0 gf180mcu_fd_sc_mcu7t5v0__and2_1
X_105_ q5 _037_ sel_lo_n_16p vdd_gate vdd_gate 0 0 gf180mcu_fd_sc_mcu7t5v0__nor2_1
X_106_ _031_ q5 _037_ sel_hi_n_16n vdd_gate vdd_gate 0 0 gf180mcu_fd_sc_mcu7t5v0__nor3_1
X_107_ eng5 sel_in_n rel_n_16p vdd_gate vdd_gate 0 0 gf180mcu_fd_sc_mcu7t5v0__nor2_1
X_108_ mode eng5 sel_in_n rel_n_16n vdd_gate vdd_gate 0 0 gf180mcu_fd_sc_mcu7t5v0__aoi21_1
X_109_ q6 eng6 sel_hi_n_32p vdd_gate vdd_gate 0 0 gf180mcu_fd_sc_mcu7t5v0__and2_1
X_110_ mode sel_hi_n_32p sel_lo_n_32n vdd_gate vdd_gate 0 0 gf180mcu_fd_sc_mcu7t5v0__and2_1
X_111_ q6 _038_ sel_lo_n_32p vdd_gate vdd_gate 0 0 gf180mcu_fd_sc_mcu7t5v0__nor2_1
X_112_ _031_ q6 _038_ sel_hi_n_32n vdd_gate vdd_gate 0 0 gf180mcu_fd_sc_mcu7t5v0__nor3_1
X_113_ eng6 sel_in_n rel_n_32p vdd_gate vdd_gate 0 0 gf180mcu_fd_sc_mcu7t5v0__nor2_1
X_114_ mode eng6 sel_in_n rel_n_32n vdd_gate vdd_gate 0 0 gf180mcu_fd_sc_mcu7t5v0__aoi21_1
X_115_ q7 eng7 sel_hi_n_64p vdd_gate vdd_gate 0 0 gf180mcu_fd_sc_mcu7t5v0__and2_1
X_116_ mode sel_hi_n_64p sel_lo_n_64n vdd_gate vdd_gate 0 0 gf180mcu_fd_sc_mcu7t5v0__and2_1
X_117_ q7 _039_ sel_lo_n_64p vdd_gate vdd_gate 0 0 gf180mcu_fd_sc_mcu7t5v0__nor2_1
X_118_ _031_ q7 _039_ sel_hi_n_64n vdd_gate vdd_gate 0 0 gf180mcu_fd_sc_mcu7t5v0__nor3_1
X_119_ eng7 sel_in_n rel_n_64p vdd_gate vdd_gate 0 0 gf180mcu_fd_sc_mcu7t5v0__nor2_1
X_120_ mode eng7 sel_in_n rel_n_64n vdd_gate vdd_gate 0 0 gf180mcu_fd_sc_mcu7t5v0__aoi21_1
X_121_ q8 eng8 sel_hi_n_128p vdd_gate vdd_gate 0 0 gf180mcu_fd_sc_mcu7t5v0__and2_1
X_122_ mode sel_hi_n_128p sel_lo_n_128n vdd_gate vdd_gate 0 0 gf180mcu_fd_sc_mcu7t5v0__and2_1
X_123_ q8 _040_ sel_lo_n_128p vdd_gate vdd_gate 0 0 gf180mcu_fd_sc_mcu7t5v0__nor2_1
X_124_ _031_ q8 _040_ sel_hi_n_128n vdd_gate vdd_gate 0 0 gf180mcu_fd_sc_mcu7t5v0__nor3_1
X_125_ eng8 sel_in_n rel_n_128p vdd_gate vdd_gate 0 0 gf180mcu_fd_sc_mcu7t5v0__nor2_1
X_126_ mode eng8 sel_in_n rel_n_128n vdd_gate vdd_gate 0 0 gf180mcu_fd_sc_mcu7t5v0__aoi21_1
X_127_ mode sel_hi_n_4p sel_lo_n_4n vdd_gate vdd_gate 0 0 gf180mcu_fd_sc_mcu7t5v0__and2_1
X_128_ q9 eng9 sel_hi_n_256p vdd_gate vdd_gate 0 0 gf180mcu_fd_sc_mcu7t5v0__and2_1
X_129_ mode sel_hi_n_256p sel_lo_n_256n vdd_gate vdd_gate 0 0 gf180mcu_fd_sc_mcu7t5v0__and2_1
X_130_ q9 _041_ sel_lo_n_256p vdd_gate vdd_gate 0 0 gf180mcu_fd_sc_mcu7t5v0__nor2_1
X_131_ _031_ q9 _041_ sel_hi_n_256n vdd_gate vdd_gate 0 0 gf180mcu_fd_sc_mcu7t5v0__nor3_1
X_132_ eng9 sel_in_n rel_n_256p vdd_gate vdd_gate 0 0 gf180mcu_fd_sc_mcu7t5v0__nor2_1
X_133_ mode eng9 sel_in_n rel_n_256n vdd_gate vdd_gate 0 0 gf180mcu_fd_sc_mcu7t5v0__aoi21_1
X_134_ eng2 sel_in_n rel_n_2p vdd_gate vdd_gate 0 0 gf180mcu_fd_sc_mcu7t5v0__nor2_1
X_135_ eng2 q2 sel_hi_n_2p vdd_gate vdd_gate 0 0 gf180mcu_fd_sc_mcu7t5v0__and2_1
X_136_ _043_ _044_ ph_13 _000_ vdd_gate vdd_gate 0 0 gf180mcu_fd_sc_mcu7t5v0__aoi21_1
X_137_ _042_ _046_ ph_13 _001_ vdd_gate vdd_gate 0 0 gf180mcu_fd_sc_mcu7t5v0__aoi21_1
X_138_ _042_ q2 sel_lo_n_2p vdd_gate vdd_gate 0 0 gf180mcu_fd_sc_mcu7t5v0__nor2_1
X_139_ _030_ _047_ ph_13 _002_ vdd_gate vdd_gate 0 0 gf180mcu_fd_sc_mcu7t5v0__aoi21_1
X_140_ _036_ _048_ ph_13 _003_ vdd_gate vdd_gate 0 0 gf180mcu_fd_sc_mcu7t5v0__aoi21_1
X_141_ _037_ _049_ ph_13 _004_ vdd_gate vdd_gate 0 0 gf180mcu_fd_sc_mcu7t5v0__aoi21_1
X_142_ _038_ _050_ ph_13 _005_ vdd_gate vdd_gate 0 0 gf180mcu_fd_sc_mcu7t5v0__aoi21_1
X_143_ mode eng2 sel_in_n rel_n_2n vdd_gate vdd_gate 0 0 gf180mcu_fd_sc_mcu7t5v0__aoi21_1
X_144_ _039_ _051_ ph_13 _006_ vdd_gate vdd_gate 0 0 gf180mcu_fd_sc_mcu7t5v0__aoi21_1
X_145_ _040_ _052_ ph_13 _007_ vdd_gate vdd_gate 0 0 gf180mcu_fd_sc_mcu7t5v0__aoi21_1
X_146_ _041_ _053_ ph_13 _008_ vdd_gate vdd_gate 0 0 gf180mcu_fd_sc_mcu7t5v0__aoi21_1
X_147_ _031_ _042_ q2 sel_hi_n_2n vdd_gate vdd_gate 0 0 gf180mcu_fd_sc_mcu7t5v0__nor3_1
X_148_ _054_ start _009__15 vdd_gate vdd_gate 0 0 gf180mcu_fd_sc_mcu7t5v0__nor2_1
X_149_ _045_ start _009__14 vdd_gate vdd_gate 0 0 gf180mcu_fd_sc_mcu7t5v0__nor2_1
X_150_ mode sel_hi_n_2p sel_lo_n_2n vdd_gate vdd_gate 0 0 gf180mcu_fd_sc_mcu7t5v0__and2_1
X_151_ _043_ start _009__13 vdd_gate vdd_gate 0 0 gf180mcu_fd_sc_mcu7t5v0__nor2_1
X_152_ _046_ start _009__12 vdd_gate vdd_gate 0 0 gf180mcu_fd_sc_mcu7t5v0__nor2_1
X_153_ eng1 sel_in_n rel_n_1p vdd_gate vdd_gate 0 0 gf180mcu_fd_sc_mcu7t5v0__nor2_1
X_154_ _047_ start _009__11 vdd_gate vdd_gate 0 0 gf180mcu_fd_sc_mcu7t5v0__nor2_1
X_155_ eng1 q1 sel_hi_n_1p vdd_gate vdd_gate 0 0 gf180mcu_fd_sc_mcu7t5v0__and2_1
X_156_ _048_ start _009__10 vdd_gate vdd_gate 0 0 gf180mcu_fd_sc_mcu7t5v0__nor2_1
X_157_ _049_ start _009__9 vdd_gate vdd_gate 0 0 gf180mcu_fd_sc_mcu7t5v0__nor2_1
X_158_ _044_ q1 sel_lo_n_1p vdd_gate vdd_gate 0 0 gf180mcu_fd_sc_mcu7t5v0__nor2_1
X_159_ _050_ start _009__8 vdd_gate vdd_gate 0 0 gf180mcu_fd_sc_mcu7t5v0__nor2_1
X_160_ mode sel_hi_n_1p sel_lo_n_1n vdd_gate vdd_gate 0 0 gf180mcu_fd_sc_mcu7t5v0__and2_1
X_161_ _051_ start _009__7 vdd_gate vdd_gate 0 0 gf180mcu_fd_sc_mcu7t5v0__nor2_1
X_162_ _052_ start _009__6 vdd_gate vdd_gate 0 0 gf180mcu_fd_sc_mcu7t5v0__nor2_1
X_163_ _031_ _044_ q1 sel_hi_n_1n vdd_gate vdd_gate 0 0 gf180mcu_fd_sc_mcu7t5v0__nor3_1
X_164_ _053_ start _009__5 vdd_gate vdd_gate 0 0 gf180mcu_fd_sc_mcu7t5v0__nor2_1
X_165_ _035_ start _009__4 vdd_gate vdd_gate 0 0 gf180mcu_fd_sc_mcu7t5v0__nor2_1
X_166_ _032_ start _009__3 vdd_gate vdd_gate 0 0 gf180mcu_fd_sc_mcu7t5v0__nor2_1
X_167_ mode eng1 sel_in_n rel_n_1n vdd_gate vdd_gate 0 0 gf180mcu_fd_sc_mcu7t5v0__aoi21_1
X_168_ _034_ start _009__2 vdd_gate vdd_gate 0 0 gf180mcu_fd_sc_mcu7t5v0__nor2_1
X_169_ _033_ start _009__1 vdd_gate vdd_gate 0 0 gf180mcu_fd_sc_mcu7t5v0__nor2_1
X_170_ start drdy _009__0 vdd_gate vdd_gate 0 0 gf180mcu_fd_sc_mcu7t5v0__or2_1
X_171_ c8 q8 ph_14 _010_ vdd_gate vdd_gate 0 0 gf180mcu_fd_sc_mcu7t5v0__mux2_1
X_172_ c9 q9 ph_14 _011_ vdd_gate vdd_gate 0 0 gf180mcu_fd_sc_mcu7t5v0__mux2_1
X_173_ ph_13 q0 _055_ vdd_gate vdd_gate 0 0 gf180mcu_fd_sc_mcu7t5v0__nor2_1
X_174_ ph_13 cmp _055_ _012_ vdd_gate vdd_gate 0 0 gf180mcu_fd_sc_mcu7t5v0__aoi21_1
X_175_ c0 q0 ph_14 _013_ vdd_gate vdd_gate 0 0 gf180mcu_fd_sc_mcu7t5v0__mux2_1
X_176_ q6 ph_7 _056_ vdd_gate vdd_gate 0 0 gf180mcu_fd_sc_mcu7t5v0__nor2_1
X_177_ ph_7 cmp _056_ _014_ vdd_gate vdd_gate 0 0 gf180mcu_fd_sc_mcu7t5v0__aoi21_1
X_178_ c1 q1 ph_14 _015_ vdd_gate vdd_gate 0 0 gf180mcu_fd_sc_mcu7t5v0__mux2_1
X_179_ c2 q2 ph_14 _016_ vdd_gate vdd_gate 0 0 gf180mcu_fd_sc_mcu7t5v0__mux2_1
X_180_ q2 ph_11 _057_ vdd_gate vdd_gate 0 0 gf180mcu_fd_sc_mcu7t5v0__nor2_1
X_181_ ph_11 cmp _057_ _017_ vdd_gate vdd_gate 0 0 gf180mcu_fd_sc_mcu7t5v0__aoi21_1
X_182_ q7 ph_6 _058_ vdd_gate vdd_gate 0 0 gf180mcu_fd_sc_mcu7t5v0__nor2_1
X_183_ ph_6 cmp _058_ _018_ vdd_gate vdd_gate 0 0 gf180mcu_fd_sc_mcu7t5v0__aoi21_1
X_184_ q5 ph_8 _059_ vdd_gate vdd_gate 0 0 gf180mcu_fd_sc_mcu7t5v0__nor2_1
X_185_ ph_8 cmp _059_ _019_ vdd_gate vdd_gate 0 0 gf180mcu_fd_sc_mcu7t5v0__aoi21_1
X_186_ ph_12 q1 _060_ vdd_gate vdd_gate 0 0 gf180mcu_fd_sc_mcu7t5v0__nor2_1
X_187_ ph_12 cmp _060_ _020_ vdd_gate vdd_gate 0 0 gf180mcu_fd_sc_mcu7t5v0__aoi21_1
X_188_ c3 q3 ph_14 _021_ vdd_gate vdd_gate 0 0 gf180mcu_fd_sc_mcu7t5v0__mux2_1
X_189_ q8 ph_5 _061_ vdd_gate vdd_gate 0 0 gf180mcu_fd_sc_mcu7t5v0__nor2_1
X_190_ ph_5 cmp _061_ _022_ vdd_gate vdd_gate 0 0 gf180mcu_fd_sc_mcu7t5v0__aoi21_1
X_191_ c4 q4 ph_14 _023_ vdd_gate vdd_gate 0 0 gf180mcu_fd_sc_mcu7t5v0__mux2_1
X_192_ c5 q5 ph_14 _024_ vdd_gate vdd_gate 0 0 gf180mcu_fd_sc_mcu7t5v0__mux2_1
X_193_ q4 ph_9 _062_ vdd_gate vdd_gate 0 0 gf180mcu_fd_sc_mcu7t5v0__nor2_1
X_194_ ph_9 cmp _062_ _025_ vdd_gate vdd_gate 0 0 gf180mcu_fd_sc_mcu7t5v0__aoi21_1
X_195_ q9 ph_4 _063_ vdd_gate vdd_gate 0 0 gf180mcu_fd_sc_mcu7t5v0__nor2_1
X_196_ ph_4 cmp _063_ _026_ vdd_gate vdd_gate 0 0 gf180mcu_fd_sc_mcu7t5v0__aoi21_1
X_197_ c6 q6 ph_14 _027_ vdd_gate vdd_gate 0 0 gf180mcu_fd_sc_mcu7t5v0__mux2_1
X_198_ c7 q7 ph_14 _028_ vdd_gate vdd_gate 0 0 gf180mcu_fd_sc_mcu7t5v0__mux2_1
X_199_ q3 ph_10 _064_ vdd_gate vdd_gate 0 0 gf180mcu_fd_sc_mcu7t5v0__nor2_1
X_200_ ph_10 cmp _064_ _029_ vdd_gate vdd_gate 0 0 gf180mcu_fd_sc_mcu7t5v0__aoi21_1
X_201_ _020_ clk q1 vdd_gate vdd_gate 0 0 gf180mcu_fd_sc_mcu7t5v0__dffq_1
X_202_ _017_ clk q2 vdd_gate vdd_gate 0 0 gf180mcu_fd_sc_mcu7t5v0__dffq_1
X_203_ _029_ clk q3 vdd_gate vdd_gate 0 0 gf180mcu_fd_sc_mcu7t5v0__dffq_1
X_204_ _025_ clk q4 vdd_gate vdd_gate 0 0 gf180mcu_fd_sc_mcu7t5v0__dffq_1
X_205_ _019_ clk q5 vdd_gate vdd_gate 0 0 gf180mcu_fd_sc_mcu7t5v0__dffq_1
X_206_ _014_ clk q6 vdd_gate vdd_gate 0 0 gf180mcu_fd_sc_mcu7t5v0__dffq_1
X_207_ _018_ clk q7 vdd_gate vdd_gate 0 0 gf180mcu_fd_sc_mcu7t5v0__dffq_1
X_208_ _022_ clk q8 vdd_gate vdd_gate 0 0 gf180mcu_fd_sc_mcu7t5v0__dffq_1
X_209_ _026_ clk q9 vdd_gate vdd_gate 0 0 gf180mcu_fd_sc_mcu7t5v0__dffq_1
X_210_ _012_ clk q0 vdd_gate vdd_gate 0 0 gf180mcu_fd_sc_mcu7t5v0__dffq_1
X_211_ _013_ clk c0 vdd_gate vdd_gate 0 0 gf180mcu_fd_sc_mcu7t5v0__dffq_1
X_212_ _015_ clk c1 vdd_gate vdd_gate 0 0 gf180mcu_fd_sc_mcu7t5v0__dffq_1
X_213_ _016_ clk c2 vdd_gate vdd_gate 0 0 gf180mcu_fd_sc_mcu7t5v0__dffq_1
X_214_ _021_ clk c3 vdd_gate vdd_gate 0 0 gf180mcu_fd_sc_mcu7t5v0__dffq_1
X_215_ _023_ clk c4 vdd_gate vdd_gate 0 0 gf180mcu_fd_sc_mcu7t5v0__dffq_1
X_216_ _024_ clk c5 vdd_gate vdd_gate 0 0 gf180mcu_fd_sc_mcu7t5v0__dffq_1
X_217_ _027_ clk c6 vdd_gate vdd_gate 0 0 gf180mcu_fd_sc_mcu7t5v0__dffq_1
X_218_ _028_ clk c7 vdd_gate vdd_gate 0 0 gf180mcu_fd_sc_mcu7t5v0__dffq_1
X_219_ _010_ clk c8 vdd_gate vdd_gate 0 0 gf180mcu_fd_sc_mcu7t5v0__dffq_1
X_220_ _011_ clk c9 vdd_gate vdd_gate 0 0 gf180mcu_fd_sc_mcu7t5v0__dffq_1
X_221_ _008_ clk eng9 vdd_gate vdd_gate 0 0 gf180mcu_fd_sc_mcu7t5v0__dffq_1
X_222_ _007_ clk eng8 vdd_gate vdd_gate 0 0 gf180mcu_fd_sc_mcu7t5v0__dffq_1
X_223_ _006_ clk eng7 vdd_gate vdd_gate 0 0 gf180mcu_fd_sc_mcu7t5v0__dffq_1
X_224_ _005_ clk eng6 vdd_gate vdd_gate 0 0 gf180mcu_fd_sc_mcu7t5v0__dffq_1
X_225_ _004_ clk eng5 vdd_gate vdd_gate 0 0 gf180mcu_fd_sc_mcu7t5v0__dffq_1
X_226_ _003_ clk eng4 vdd_gate vdd_gate 0 0 gf180mcu_fd_sc_mcu7t5v0__dffq_1
X_227_ _002_ clk eng3 vdd_gate vdd_gate 0 0 gf180mcu_fd_sc_mcu7t5v0__dffq_1
X_228_ _001_ clk eng2 vdd_gate vdd_gate 0 0 gf180mcu_fd_sc_mcu7t5v0__dffq_1
X_229_ _000_ clk eng1 vdd_gate vdd_gate 0 0 gf180mcu_fd_sc_mcu7t5v0__dffq_1
X_230_ _009__0 clk ph_0 vdd_gate vdd_gate 0 0 gf180mcu_fd_sc_mcu7t5v0__dffq_1
X_231_ _009__1 clk ph_1 vdd_gate vdd_gate 0 0 gf180mcu_fd_sc_mcu7t5v0__dffq_1
X_232_ _009__2 clk ph_2 vdd_gate vdd_gate 0 0 gf180mcu_fd_sc_mcu7t5v0__dffq_1
X_233_ _009__3 clk ph_3 vdd_gate vdd_gate 0 0 gf180mcu_fd_sc_mcu7t5v0__dffq_1
X_234_ _009__4 clk ph_4 vdd_gate vdd_gate 0 0 gf180mcu_fd_sc_mcu7t5v0__dffq_1
X_235_ _009__5 clk ph_5 vdd_gate vdd_gate 0 0 gf180mcu_fd_sc_mcu7t5v0__dffq_1
X_236_ _009__6 clk ph_6 vdd_gate vdd_gate 0 0 gf180mcu_fd_sc_mcu7t5v0__dffq_1
X_237_ _009__7 clk ph_7 vdd_gate vdd_gate 0 0 gf180mcu_fd_sc_mcu7t5v0__dffq_1
X_238_ _009__8 clk ph_8 vdd_gate vdd_gate 0 0 gf180mcu_fd_sc_mcu7t5v0__dffq_1
X_239_ _009__9 clk ph_9 vdd_gate vdd_gate 0 0 gf180mcu_fd_sc_mcu7t5v0__dffq_1
X_240_ _009__10 clk ph_10 vdd_gate vdd_gate 0 0 gf180mcu_fd_sc_mcu7t5v0__dffq_1
X_241_ _009__11 clk ph_11 vdd_gate vdd_gate 0 0 gf180mcu_fd_sc_mcu7t5v0__dffq_1
X_242_ _009__12 clk ph_12 vdd_gate vdd_gate 0 0 gf180mcu_fd_sc_mcu7t5v0__dffq_1
X_243_ _009__13 clk ph_13 vdd_gate vdd_gate 0 0 gf180mcu_fd_sc_mcu7t5v0__dffq_1
X_244_ _009__14 clk ph_14 vdd_gate vdd_gate 0 0 gf180mcu_fd_sc_mcu7t5v0__dffq_1
X_245_ _009__15 clk drdy vdd_gate vdd_gate 0 0 gf180mcu_fd_sc_mcu7t5v0__dffq_1
.ends

.SUBCKT gf180mcu_fd_sc_mcu7t5v0__and2_1 A1 A2 Z VDD VNW VPW VSS
X_i_2 net_0 A1 Z_neg VPW nfet_06v0 W=3.65e-07 L=6e-07
X_i_3 VSS A2 net_0 VPW nfet_06v0 W=3.65e-07 L=6e-07
X_i_0 Z Z_neg VSS VPW nfet_06v0 W=8.15e-07 L=6e-07
X_i_4 Z_neg A1 VDD VNW pfet_06v0 W=6e-07 L=5e-07
X_i_5 VDD A2 Z_neg VNW pfet_06v0 W=6e-07 L=5e-07
X_i_1 Z Z_neg VDD VNW pfet_06v0 W=1.215e-06 L=5e-07
.ENDS

.SUBCKT gf180mcu_fd_sc_mcu7t5v0__aoi21_1 A1 A2 B ZN VDD VNW VPW VSS
X_i_1 net_0 A2 VSS VPW nfet_06v0 W=8.2e-07 L=6e-07
X_i_0 ZN A1 net_0 VPW nfet_06v0 W=8.2e-07 L=6e-07
X_i_2 VSS B ZN VPW nfet_06v0 W=5.1e-07 L=6e-07
X_i_4 ZN A2 net_1 VNW pfet_06v0 W=1.215e-06 L=5e-07
X_i_3 net_1 A1 ZN VNW pfet_06v0 W=1.215e-06 L=5e-07
X_i_5 VDD B net_1 VNW pfet_06v0 W=1.215e-06 L=5e-07
.ENDS

.SUBCKT gf180mcu_fd_sc_mcu7t5v0__clkinv_1 I ZN VDD VNW VPW VSS
X_i_0 ZN I VSS VPW nfet_06v0 W=4.8e-07 L=6e-07
X_i_1 ZN I VDD VNW pfet_06v0 W=1.22e-06 L=5e-07
.ENDS

.SUBCKT gf180mcu_fd_sc_mcu7t5v0__dffq_1 D CLK Q VDD VNW VPW VSS
X_tn3 VSS CLK ncki VPW nfet_06v0 W=4.05e-07 L=6e-07
X_tn4 cki ncki VSS VPW nfet_06v0 W=4.05e-07 L=6e-07
X_tn5 net5 ncki VSS VPW nfet_06v0 W=3.6e-07 L=6e-07
X_tn8 net4 D net5 VPW nfet_06v0 W=3.6e-07 L=6e-07
X_tn6 net6 cki net4 VPW nfet_06v0 W=3.6e-07 L=6e-07
X_tn7 VSS net0 net6 VPW nfet_06v0 W=3.6e-07 L=6e-07
X_tn0 net0 net4 VSS VPW nfet_06v0 W=3.6e-07 L=6e-07
X_tn9 net2 cki net0 VPW nfet_06v0 W=3.6e-07 L=6e-07
X_tn11 net1 ncki net2 VPW nfet_06v0 W=3.6e-07 L=6e-07
X_tn12 VSS net3 net1 VPW nfet_06v0 W=3.6e-07 L=6e-07
X_tn10 net3 net2 VSS VPW nfet_06v0 W=4e-07 L=6e-07
X_tn1 Q net3 VSS VPW nfet_06v0 W=8.2e-07 L=6e-07
X_tp3 VDD CLK ncki VNW pfet_06v0 W=8.65e-07 L=5e-07
X_tp4 cki ncki VDD VNW pfet_06v0 W=8.65e-07 L=5e-07
X_tp12 net7 cki VDD VNW pfet_06v0 W=3.6e-07 L=5e-07
X_tp11 net4 D net7 VNW pfet_06v0 W=3.6e-07 L=5e-07
X_tp6 net8 ncki net4 VNW pfet_06v0 W=3.6e-07 L=5e-07
X_tp5 VDD net0 net8 VNW pfet_06v0 W=3.6e-07 L=5e-07
X_tp0 net0 net4 VDD VNW pfet_06v0 W=3.6e-07 L=5e-07
X_tp7 net2 ncki net0 VNW pfet_06v0 W=3.6e-07 L=5e-07
X_tp9 net1x cki net2 VNW pfet_06v0 W=3.6e-07 L=5e-07
X_tp10 VDD net3 net1x VNW pfet_06v0 W=3.6e-07 L=5e-07
X_tp8 net3 net2 VDD VNW pfet_06v0 W=8e-07 L=5e-07
X_tp1 Q net3 VDD VNW pfet_06v0 W=1.22e-06 L=5e-07
.ENDS

.SUBCKT gf180mcu_fd_sc_mcu7t5v0__mux2_1 I0 I1 S Z VDD VNW VPW VSS
X_MN2 VSS int04 Z VPW nfet_06v0 W=8.2e-07 L=6e-07
X_MN4 net_1 I1 VSS VPW nfet_06v0 W=3.6e-07 L=6e-07
X_MN8 int04 S net_1 VPW nfet_06v0 W=3.6e-07 L=6e-07
X_MN7 net_3 sel1_n int04 VPW nfet_06v0 W=3.6e-07 L=6e-07
X_MN3 VSS I0 net_3 VPW nfet_06v0 W=3.6e-07 L=6e-07
X_MN1 sel1_n S VSS VPW nfet_06v0 W=3.6e-07 L=6e-07
X_MP5 VDD int04 Z VNW pfet_06v0 W=1.22e-06 L=5e-07
X_MP4 net_0 I1 VDD VNW pfet_06v0 W=6.15e-07 L=5e-07
X_MP8 int04 sel1_n net_0 VNW pfet_06v0 W=6.15e-07 L=5e-07
X_MP7 net_2 S int04 VNW pfet_06v0 W=6.15e-07 L=5e-07
X_MP3 VDD I0 net_2 VNW pfet_06v0 W=6.15e-07 L=5e-07
X_MP1 sel1_n S VDD VNW pfet_06v0 W=6.15e-07 L=5e-07
.ENDS

.SUBCKT gf180mcu_fd_sc_mcu7t5v0__nand3_1 A1 A2 A3 ZN VDD VNW VPW VSS
X_i_2 net_1 A3 VSS VPW nfet_06v0 W=8.2e-07 L=6e-07
X_i_1 net_0 A2 net_1 VPW nfet_06v0 W=8.2e-07 L=6e-07
X_i_0 ZN A1 net_0 VPW nfet_06v0 W=8.2e-07 L=6e-07
X_i_5 ZN A3 VDD VNW pfet_06v0 W=9.85e-07 L=5e-07
X_i_4 VDD A2 ZN VNW pfet_06v0 W=9.85e-07 L=5e-07
X_i_3 ZN A1 VDD VNW pfet_06v0 W=9.85e-07 L=5e-07
.ENDS

.SUBCKT gf180mcu_fd_sc_mcu7t5v0__nor2_1 A1 A2 ZN VDD VNW VPW VSS
X_i_1 ZN A2 VSS VPW nfet_06v0 W=5.65e-07 L=6e-07
X_i_0 VSS A1 ZN VPW nfet_06v0 W=5.65e-07 L=6e-07
X_i_3 net_0 A2 VDD VNW pfet_06v0 W=1.22e-06 L=5e-07
X_i_2 ZN A1 net_0 VNW pfet_06v0 W=1.22e-06 L=5e-07
.ENDS

.SUBCKT gf180mcu_fd_sc_mcu7t5v0__nor3_1 A1 A2 A3 ZN VDD VNW VPW VSS
X_i_2 ZN A3 VSS VPW nfet_06v0 W=4.65e-07 L=6e-07
X_i_1 VSS A2 ZN VPW nfet_06v0 W=4.65e-07 L=6e-07
X_i_0 ZN A1 VSS VPW nfet_06v0 W=4.65e-07 L=6e-07
X_i_5 net_1 A3 VDD VNW pfet_06v0 W=1.22e-06 L=5e-07
X_i_4 net_0 A2 net_1 VNW pfet_06v0 W=1.22e-06 L=5e-07
X_i_3 ZN A1 net_0 VNW pfet_06v0 W=1.22e-06 L=5e-07
.ENDS

.SUBCKT gf180mcu_fd_sc_mcu7t5v0__or2_1 A1 A2 Z VDD VNW VPW VSS
X_i_2 Z_neg A1 VSS VPW nfet_06v0 W=3.6e-07 L=6e-07
X_i_3 VSS A2 Z_neg VPW nfet_06v0 W=3.6e-07 L=6e-07
X_i_0 Z Z_neg VSS VPW nfet_06v0 W=8.2e-07 L=6e-07
X_i_4 net_0 A1 Z_neg VNW pfet_06v0 W=5.65e-07 L=5e-07
X_i_5 VDD A2 net_0 VNW pfet_06v0 W=5.65e-07 L=5e-07
X_i_1 Z Z_neg VDD VNW pfet_06v0 W=1.22e-06 L=5e-07
.ENDS

.SUBCKT gf180mcu_fd_sc_mcu7t5v0__or4_1 A1 A2 A3 A4 Z VDD VNW VPW VSS
X_i_2 Z_neg A1 VSS VPW nfet_06v0 W=3.6e-07 L=6e-07
X_i_3 VSS A2 Z_neg VPW nfet_06v0 W=3.6e-07 L=6e-07
X_i_4 Z_neg A3 VSS VPW nfet_06v0 W=3.6e-07 L=6e-07
X_i_5 VSS A4 Z_neg VPW nfet_06v0 W=3.6e-07 L=6e-07
X_i_0 Z Z_neg VSS VPW nfet_06v0 W=8.2e-07 L=6e-07
X_i_6 net_0 A1 Z_neg VNW pfet_06v0 W=5.6e-07 L=5e-07
X_i_7 net_1 A2 net_0 VNW pfet_06v0 W=5.6e-07 L=5e-07
X_i_8 net_2 A3 net_1 VNW pfet_06v0 W=5.6e-07 L=5e-07
X_i_9 VDD A4 net_2 VNW pfet_06v0 W=5.6e-07 L=5e-07
X_i_1 Z Z_neg VDD VNW pfet_06v0 W=1.22e-06 L=5e-07
.ENDS

vvdd_gate vdd_gate 0 dc {vdd_val}
