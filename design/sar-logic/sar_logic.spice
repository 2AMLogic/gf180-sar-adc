* GENERATED by design/sar-logic/generate.py from sar_logic.py -- do not edit.
* Regenerate after any change; sim/tests/test_sar_logic.py fails on drift.
*
* SAR control logic -- bit-cycle sequencing, CDAC switch drivers and the
* 10-bit parallel output register, at transistor level in gf180mcu 3.3 V
* devices. This netlist IS the layout/LVS reference for #15: no synthesis,
* no standard-cell library, nothing between it and the schematic-level
* verification in sim/sar-logic/.
*
* Records this implements: DR-0003 (external clock, M = 16), DR-0004
* (3.3 V devices throughout), DR-0005 (parallel output register only; SPI
* deferred), DR-0006-cdac-switching-scheme (MCS / Vcm switching,
* mode-dependent sequence), DR-0007 (synchronous logic, custom 3.3 V cells),
* DR-0009 (no redundancy, so the output word is the decisions themselves).
*
* Ports: clk rstb mode cmp | switch drives | d1..d10 eoc | vdd vss
*   mode = 1 -> differential (both sides switch each trial)
*   mode = 0 -> single-ended (only the p side switches;
*                             DR-0006-cdac-switching-scheme)

* ---- primitive cells (custom 3.3 V, DR-0004; see module docstring) ----

.subckt sl_inv a z vdd vss
Xmp z a vdd vdd pfet_03v3 w=2u l=0.28u
Xmn z a vss vss nfet_03v3 w=1u l=0.28u
.ends

.subckt sl_inv4 a z vdd vss
Xmp z a vdd vdd pfet_03v3 w=8u l=0.28u
Xmn z a vss vss nfet_03v3 w=4u l=0.28u
.ends

.subckt sl_inv8 a z vdd vss
Xmp z a vdd vdd pfet_03v3 w=16u l=0.28u
Xmn z a vss vss nfet_03v3 w=8u l=0.28u
.ends

.subckt sl_inv48 a z vdd vss
Xmp z a vdd vdd pfet_03v3 w=96u l=0.28u
Xmn z a vss vss nfet_03v3 w=48u l=0.28u
.ends

* Transmission gate. gn is the NMOS gate (active high), gp the PMOS
* gate (active low). Series devices are 1x; a T-gate passes both rails.
.subckt sl_tg a z gn gp vdd vss
Xmn a gn z vss nfet_03v3 w=1u l=0.28u
Xmp a gp z vdd pfet_03v3 w=2u l=0.28u
.ends

* NAND2. Series NMOS stack is doubled so pull-down strength matches 1x.
.subckt sl_nand2 a b z vdd vss
Xmp1 z a vdd vdd pfet_03v3 w=2u l=0.28u
Xmp2 z b vdd vdd pfet_03v3 w=2u l=0.28u
Xmn1 z a nmid vss nfet_03v3 w=2u l=0.28u
Xmn2 nmid b vss vss nfet_03v3 w=2u l=0.28u
.ends

* NOR2. Series PMOS stack is doubled so pull-up strength matches 1x.
.subckt sl_nor2 a b z vdd vss
Xmp1 pmid a vdd vdd pfet_03v3 w=4u l=0.28u
Xmp2 z b pmid vdd pfet_03v3 w=4u l=0.28u
Xmn1 z a vss vss nfet_03v3 w=1u l=0.28u
Xmn2 z b vss vss nfet_03v3 w=1u l=0.28u
.ends

* 2:1 mux, z = s ? a : b. Buffered output: a bare T-gate pair leaves
* the node undriven for the few tens of ps around an s transition.
.subckt sl_mux2 a b s z vdd vss
Xisb s sb vdd vss sl_inv
Xta a zi s sb vdd vss sl_tg
Xtb b zi sb s vdd vss sl_tg
Xb1 zi zn vdd vss sl_inv
Xb2 zn z vdd vss sl_inv
.ends

* Positive-edge D flip-flop, transmission-gate master-slave, with an
* ASYNCHRONOUS active-low clear. The clear is inside both latches (the
* forward inverter of each is a NAND2 against rstb), so q is forced low
* regardless of the clock phase -- which is what gives the sequencer a
* defined state at t = 0 instead of whatever the DC operating point
* happens to find.
.subckt sl_dffr d clk clkb rstb q qb vdd vss
Xtm d mi clkb clk vdd vss sl_tg
Xnm mi rstb mb vdd vss sl_nand2
Xim mb mq vdd vss sl_inv
Xtmfb mq mi clk clkb vdd vss sl_tg
Xts mq si clk clkb vdd vss sl_tg
Xns si rstb qb vdd vss sl_nand2
Xis qb q vdd vss sl_inv
Xtsfb q si clkb clk vdd vss sl_tg
.ends

* Same flip-flop with an ASYNCHRONOUS active-high preset (NOR2 in place
* of NAND2). Exactly one instance exists: sequencer stage 0. The
* one-hot ring needs precisely one stage that resets to 1, or reset
* would leave the ring empty and no conversion would ever start.
.subckt sl_dffs d clk clkb rst q qb vdd vss
Xtm d mi clkb clk vdd vss sl_tg
Xnm mi rst mb vdd vss sl_nor2
Xim mb mq vdd vss sl_inv
Xtmfb mq mi clk clkb vdd vss sl_tg
Xts mq si clk clkb vdd vss sl_tg
Xns si rst qb vdd vss sl_nor2
Xis qb q vdd vss sl_inv
Xtsfb q si clkb clk vdd vss sl_tg
.ends

* ---- controller ------------------------------------------------------
.subckt sar_logic clk rstb mode cmp samp_n samp_p rel_n_256p rel_p_256p
+ sel_hi_n_256p sel_hi_p_256p sel_lo_n_256p sel_lo_p_256p rel_n_128p
+ rel_p_128p sel_hi_n_128p sel_hi_p_128p sel_lo_n_128p sel_lo_p_128p rel_n_64p
+ rel_p_64p sel_hi_n_64p sel_hi_p_64p sel_lo_n_64p sel_lo_p_64p rel_n_32p
+ rel_p_32p sel_hi_n_32p sel_hi_p_32p sel_lo_n_32p sel_lo_p_32p rel_n_16p
+ rel_p_16p sel_hi_n_16p sel_hi_p_16p sel_lo_n_16p sel_lo_p_16p rel_n_8p
+ rel_p_8p sel_hi_n_8p sel_hi_p_8p sel_lo_n_8p sel_lo_p_8p rel_n_4p rel_p_4p
+ sel_hi_n_4p sel_hi_p_4p sel_lo_n_4p sel_lo_p_4p rel_n_2p rel_p_2p
+ sel_hi_n_2p sel_hi_p_2p sel_lo_n_2p sel_lo_p_2p rel_n_1p rel_p_1p
+ sel_hi_n_1p sel_hi_p_1p sel_lo_n_1p sel_lo_p_1p rel_n_256n rel_p_256n
+ sel_hi_n_256n sel_hi_p_256n sel_lo_n_256n sel_lo_p_256n rel_n_128n
+ rel_p_128n sel_hi_n_128n sel_hi_p_128n sel_lo_n_128n sel_lo_p_128n rel_n_64n
+ rel_p_64n sel_hi_n_64n sel_hi_p_64n sel_lo_n_64n sel_lo_p_64n rel_n_32n
+ rel_p_32n sel_hi_n_32n sel_hi_p_32n sel_lo_n_32n sel_lo_p_32n rel_n_16n
+ rel_p_16n sel_hi_n_16n sel_hi_p_16n sel_lo_n_16n sel_lo_p_16n rel_n_8n
+ rel_p_8n sel_hi_n_8n sel_hi_p_8n sel_lo_n_8n sel_lo_p_8n rel_n_4n rel_p_4n
+ sel_hi_n_4n sel_hi_p_4n sel_lo_n_4n sel_lo_p_4n rel_n_2n rel_p_2n
+ sel_hi_n_2n sel_hi_p_2n sel_lo_n_2n sel_lo_p_2n rel_n_1n rel_p_1n
+ sel_hi_n_1n sel_hi_p_1n sel_lo_n_1n sel_lo_p_1n d1 d2 d3 d4 d5 d6 d7 d8 d9
+ d10 eoc vdd vss
Xck0 clk ck_a vdd vss sl_inv
Xck1 ck_a ck_b vdd vss sl_inv8
Xck2 ck_b clkb vdd vss sl_inv48
Xck3 clkb clki vdd vss sl_inv48
Xrs0 rstb rs_a vdd vss sl_inv
Xrs1 rs_a rstbi vdd vss sl_inv8
Xrs2 rstbi rsti vdd vss sl_inv8
Xring0 s15 clki clkb rsti s0 s0b vdd vss sl_dffs
Xring1 s0 clki clkb rstbi s1 s1b vdd vss sl_dffr
Xring2 s1 clki clkb rstbi s2 s2b vdd vss sl_dffr
Xring3 s2 clki clkb rstbi s3 s3b vdd vss sl_dffr
Xring4 s3 clki clkb rstbi s4 s4b vdd vss sl_dffr
Xring5 s4 clki clkb rstbi s5 s5b vdd vss sl_dffr
Xring6 s5 clki clkb rstbi s6 s6b vdd vss sl_dffr
Xring7 s6 clki clkb rstbi s7 s7b vdd vss sl_dffr
Xring8 s7 clki clkb rstbi s8 s8b vdd vss sl_dffr
Xring9 s8 clki clkb rstbi s9 s9b vdd vss sl_dffr
Xring10 s9 clki clkb rstbi s10 s10b vdd vss sl_dffr
Xring11 s10 clki clkb rstbi s11 s11b vdd vss sl_dffr
Xring12 s11 clki clkb rstbi s12 s12b vdd vss sl_dffr
Xring13 s12 clki clkb rstbi s13 s13b vdd vss sl_dffr
Xring14 s13 clki clkb rstbi s14 s14b vdd vss sl_dffr
Xring15 s14 clki clkb rstbi s15 s15b vdd vss sl_dffr
Xsmpa_n s0 s1 smp_01_b vdd vss sl_nor2
Xsmpa_i smp_01_b smp_01 vdd vss sl_inv
Xsmpb_n s2 s3 smp_23_b vdd vss sl_nor2
Xsmpb_i smp_23_b smp_23 vdd vss sl_inv
Xsmpc_n s4 s5 smp_45_b vdd vss sl_nor2
Xsmpc_i smp_45_b smp_45 vdd vss sl_inv
Xsmpd_n smp_01 smp_23 smp_0123_b vdd vss sl_nor2
Xsmpd_i smp_0123_b smp_0123 vdd vss sl_inv
Xsmpe smp_0123 smp_45 smp_off vdd vss sl_nor2
Xsmpf smp_off samp_n vdd vss sl_inv8
Xsmpg samp_n samp_p vdd vss sl_inv8
Xbmux1 cmp b1 s6 bd1 vdd vss sl_mux2
Xbff1 bd1 clki clkb rstbi b1 b1b vdd vss sl_dffr
Xbmux2 cmp b2 s7 bd2 vdd vss sl_mux2
Xbff2 bd2 clki clkb rstbi b2 b2b vdd vss sl_dffr
Xbmux3 cmp b3 s8 bd3 vdd vss sl_mux2
Xbff3 bd3 clki clkb rstbi b3 b3b vdd vss sl_dffr
Xbmux4 cmp b4 s9 bd4 vdd vss sl_mux2
Xbff4 bd4 clki clkb rstbi b4 b4b vdd vss sl_dffr
Xbmux5 cmp b5 s10 bd5 vdd vss sl_mux2
Xbff5 bd5 clki clkb rstbi b5 b5b vdd vss sl_dffr
Xbmux6 cmp b6 s11 bd6 vdd vss sl_mux2
Xbff6 bd6 clki clkb rstbi b6 b6b vdd vss sl_dffr
Xbmux7 cmp b7 s12 bd7 vdd vss sl_mux2
Xbff7 bd7 clki clkb rstbi b7 b7b vdd vss sl_dffr
Xbmux8 cmp b8 s13 bd8 vdd vss sl_mux2
Xbff8 bd8 clki clkb rstbi b8 b8b vdd vss sl_dffr
Xbmux9 cmp b9 s14 bd9 vdd vss sl_mux2
Xbff9 bd9 clki clkb rstbi b9 b9b vdd vss sl_dffr
Xbmux10 cmp b10 s15 bd10 vdd vss sl_mux2
Xbff10 bd10 clki clkb rstbi b10 b10b vdd vss sl_dffr
Xengor1_n eng1 s6 engo1_b vdd vss sl_nor2
Xengor1_i engo1_b engo1 vdd vss sl_inv
Xengcl1_n engo1 s15b engd1_b vdd vss sl_nand2
Xengcl1_i engd1_b engd1 vdd vss sl_inv
Xengff1 engd1 clki clkb rstbi eng1 eng1b vdd vss sl_dffr
Xengor2_n eng2 s7 engo2_b vdd vss sl_nor2
Xengor2_i engo2_b engo2 vdd vss sl_inv
Xengcl2_n engo2 s15b engd2_b vdd vss sl_nand2
Xengcl2_i engd2_b engd2 vdd vss sl_inv
Xengff2 engd2 clki clkb rstbi eng2 eng2b vdd vss sl_dffr
Xengor3_n eng3 s8 engo3_b vdd vss sl_nor2
Xengor3_i engo3_b engo3 vdd vss sl_inv
Xengcl3_n engo3 s15b engd3_b vdd vss sl_nand2
Xengcl3_i engd3_b engd3 vdd vss sl_inv
Xengff3 engd3 clki clkb rstbi eng3 eng3b vdd vss sl_dffr
Xengor4_n eng4 s9 engo4_b vdd vss sl_nor2
Xengor4_i engo4_b engo4 vdd vss sl_inv
Xengcl4_n engo4 s15b engd4_b vdd vss sl_nand2
Xengcl4_i engd4_b engd4 vdd vss sl_inv
Xengff4 engd4 clki clkb rstbi eng4 eng4b vdd vss sl_dffr
Xengor5_n eng5 s10 engo5_b vdd vss sl_nor2
Xengor5_i engo5_b engo5 vdd vss sl_inv
Xengcl5_n engo5 s15b engd5_b vdd vss sl_nand2
Xengcl5_i engd5_b engd5 vdd vss sl_inv
Xengff5 engd5 clki clkb rstbi eng5 eng5b vdd vss sl_dffr
Xengor6_n eng6 s11 engo6_b vdd vss sl_nor2
Xengor6_i engo6_b engo6 vdd vss sl_inv
Xengcl6_n engo6 s15b engd6_b vdd vss sl_nand2
Xengcl6_i engd6_b engd6 vdd vss sl_inv
Xengff6 engd6 clki clkb rstbi eng6 eng6b vdd vss sl_dffr
Xengor7_n eng7 s12 engo7_b vdd vss sl_nor2
Xengor7_i engo7_b engo7 vdd vss sl_inv
Xengcl7_n engo7 s15b engd7_b vdd vss sl_nand2
Xengcl7_i engd7_b engd7 vdd vss sl_inv
Xengff7 engd7 clki clkb rstbi eng7 eng7b vdd vss sl_dffr
Xengor8_n eng8 s13 engo8_b vdd vss sl_nor2
Xengor8_i engo8_b engo8 vdd vss sl_inv
Xengcl8_n engo8 s15b engd8_b vdd vss sl_nand2
Xengcl8_i engd8_b engd8 vdd vss sl_inv
Xengff8 engd8 clki clkb rstbi eng8 eng8b vdd vss sl_dffr
Xengor9_n eng9 s14 engo9_b vdd vss sl_nor2
Xengor9_i engo9_b engo9 vdd vss sl_inv
Xengcl9_n engo9 s15b engd9_b vdd vss sl_nand2
Xengcl9_i engd9_b engd9 vdd vss sl_inv
Xengff9 engd9 clki clkb rstbi eng9 eng9b vdd vss sl_dffr
Xdmux1 bd1 d1 s15 dd1 vdd vss sl_mux2
Xdff1 dd1 clki clkb rstbi d1 d1b vdd vss sl_dffr
Xdmux2 bd2 d2 s15 dd2 vdd vss sl_mux2
Xdff2 dd2 clki clkb rstbi d2 d2b vdd vss sl_dffr
Xdmux3 bd3 d3 s15 dd3 vdd vss sl_mux2
Xdff3 dd3 clki clkb rstbi d3 d3b vdd vss sl_dffr
Xdmux4 bd4 d4 s15 dd4 vdd vss sl_mux2
Xdff4 dd4 clki clkb rstbi d4 d4b vdd vss sl_dffr
Xdmux5 bd5 d5 s15 dd5 vdd vss sl_mux2
Xdff5 dd5 clki clkb rstbi d5 d5b vdd vss sl_dffr
Xdmux6 bd6 d6 s15 dd6 vdd vss sl_mux2
Xdff6 dd6 clki clkb rstbi d6 d6b vdd vss sl_dffr
Xdmux7 bd7 d7 s15 dd7 vdd vss sl_mux2
Xdff7 dd7 clki clkb rstbi d7 d7b vdd vss sl_dffr
Xdmux8 bd8 d8 s15 dd8 vdd vss sl_mux2
Xdff8 dd8 clki clkb rstbi d8 d8b vdd vss sl_dffr
Xdmux9 bd9 d9 s15 dd9 vdd vss sl_mux2
Xdff9 dd9 clki clkb rstbi d9 d9b vdd vss sl_dffr
Xdmux10 bd10 d10 s15 dd10 vdd vss sl_mux2
Xdff10 dd10 clki clkb rstbi d10 d10b vdd vss sl_dffr
Xeocb s0b eoc vdd vss sl_inv4
Xrelp1a eng1 rel_n_256p vdd vss sl_inv4
Xrelp1b rel_n_256p rel_p_256p vdd vss sl_inv4
Xhip1 eng1 b1b sel_hi_p_256p vdd vss sl_nand2
Xhip1b sel_hi_p_256p sel_hi_n_256p vdd vss sl_inv4
Xlop1 eng1 b1 sel_lo_p_256p vdd vss sl_nand2
Xlop1b sel_lo_p_256p sel_lo_n_256p vdd vss sl_inv4
Xenn1 eng1 mode enn1b vdd vss sl_nand2
Xenn1i enn1b enn1 vdd vss sl_inv
Xreln1a enn1 rel_n_256n vdd vss sl_inv4
Xreln1b rel_n_256n rel_p_256n vdd vss sl_inv4
Xhin1 enn1 b1 sel_hi_p_256n vdd vss sl_nand2
Xhin1b sel_hi_p_256n sel_hi_n_256n vdd vss sl_inv4
Xlon1 enn1 b1b sel_lo_p_256n vdd vss sl_nand2
Xlon1b sel_lo_p_256n sel_lo_n_256n vdd vss sl_inv4
Xrelp2a eng2 rel_n_128p vdd vss sl_inv4
Xrelp2b rel_n_128p rel_p_128p vdd vss sl_inv4
Xhip2 eng2 b2b sel_hi_p_128p vdd vss sl_nand2
Xhip2b sel_hi_p_128p sel_hi_n_128p vdd vss sl_inv4
Xlop2 eng2 b2 sel_lo_p_128p vdd vss sl_nand2
Xlop2b sel_lo_p_128p sel_lo_n_128p vdd vss sl_inv4
Xenn2 eng2 mode enn2b vdd vss sl_nand2
Xenn2i enn2b enn2 vdd vss sl_inv
Xreln2a enn2 rel_n_128n vdd vss sl_inv4
Xreln2b rel_n_128n rel_p_128n vdd vss sl_inv4
Xhin2 enn2 b2 sel_hi_p_128n vdd vss sl_nand2
Xhin2b sel_hi_p_128n sel_hi_n_128n vdd vss sl_inv4
Xlon2 enn2 b2b sel_lo_p_128n vdd vss sl_nand2
Xlon2b sel_lo_p_128n sel_lo_n_128n vdd vss sl_inv4
Xrelp3a eng3 rel_n_64p vdd vss sl_inv4
Xrelp3b rel_n_64p rel_p_64p vdd vss sl_inv4
Xhip3 eng3 b3b sel_hi_p_64p vdd vss sl_nand2
Xhip3b sel_hi_p_64p sel_hi_n_64p vdd vss sl_inv4
Xlop3 eng3 b3 sel_lo_p_64p vdd vss sl_nand2
Xlop3b sel_lo_p_64p sel_lo_n_64p vdd vss sl_inv4
Xenn3 eng3 mode enn3b vdd vss sl_nand2
Xenn3i enn3b enn3 vdd vss sl_inv
Xreln3a enn3 rel_n_64n vdd vss sl_inv4
Xreln3b rel_n_64n rel_p_64n vdd vss sl_inv4
Xhin3 enn3 b3 sel_hi_p_64n vdd vss sl_nand2
Xhin3b sel_hi_p_64n sel_hi_n_64n vdd vss sl_inv4
Xlon3 enn3 b3b sel_lo_p_64n vdd vss sl_nand2
Xlon3b sel_lo_p_64n sel_lo_n_64n vdd vss sl_inv4
Xrelp4a eng4 rel_n_32p vdd vss sl_inv4
Xrelp4b rel_n_32p rel_p_32p vdd vss sl_inv4
Xhip4 eng4 b4b sel_hi_p_32p vdd vss sl_nand2
Xhip4b sel_hi_p_32p sel_hi_n_32p vdd vss sl_inv4
Xlop4 eng4 b4 sel_lo_p_32p vdd vss sl_nand2
Xlop4b sel_lo_p_32p sel_lo_n_32p vdd vss sl_inv4
Xenn4 eng4 mode enn4b vdd vss sl_nand2
Xenn4i enn4b enn4 vdd vss sl_inv
Xreln4a enn4 rel_n_32n vdd vss sl_inv4
Xreln4b rel_n_32n rel_p_32n vdd vss sl_inv4
Xhin4 enn4 b4 sel_hi_p_32n vdd vss sl_nand2
Xhin4b sel_hi_p_32n sel_hi_n_32n vdd vss sl_inv4
Xlon4 enn4 b4b sel_lo_p_32n vdd vss sl_nand2
Xlon4b sel_lo_p_32n sel_lo_n_32n vdd vss sl_inv4
Xrelp5a eng5 rel_n_16p vdd vss sl_inv4
Xrelp5b rel_n_16p rel_p_16p vdd vss sl_inv4
Xhip5 eng5 b5b sel_hi_p_16p vdd vss sl_nand2
Xhip5b sel_hi_p_16p sel_hi_n_16p vdd vss sl_inv4
Xlop5 eng5 b5 sel_lo_p_16p vdd vss sl_nand2
Xlop5b sel_lo_p_16p sel_lo_n_16p vdd vss sl_inv4
Xenn5 eng5 mode enn5b vdd vss sl_nand2
Xenn5i enn5b enn5 vdd vss sl_inv
Xreln5a enn5 rel_n_16n vdd vss sl_inv4
Xreln5b rel_n_16n rel_p_16n vdd vss sl_inv4
Xhin5 enn5 b5 sel_hi_p_16n vdd vss sl_nand2
Xhin5b sel_hi_p_16n sel_hi_n_16n vdd vss sl_inv4
Xlon5 enn5 b5b sel_lo_p_16n vdd vss sl_nand2
Xlon5b sel_lo_p_16n sel_lo_n_16n vdd vss sl_inv4
Xrelp6a eng6 rel_n_8p vdd vss sl_inv4
Xrelp6b rel_n_8p rel_p_8p vdd vss sl_inv4
Xhip6 eng6 b6b sel_hi_p_8p vdd vss sl_nand2
Xhip6b sel_hi_p_8p sel_hi_n_8p vdd vss sl_inv4
Xlop6 eng6 b6 sel_lo_p_8p vdd vss sl_nand2
Xlop6b sel_lo_p_8p sel_lo_n_8p vdd vss sl_inv4
Xenn6 eng6 mode enn6b vdd vss sl_nand2
Xenn6i enn6b enn6 vdd vss sl_inv
Xreln6a enn6 rel_n_8n vdd vss sl_inv4
Xreln6b rel_n_8n rel_p_8n vdd vss sl_inv4
Xhin6 enn6 b6 sel_hi_p_8n vdd vss sl_nand2
Xhin6b sel_hi_p_8n sel_hi_n_8n vdd vss sl_inv4
Xlon6 enn6 b6b sel_lo_p_8n vdd vss sl_nand2
Xlon6b sel_lo_p_8n sel_lo_n_8n vdd vss sl_inv4
Xrelp7a eng7 rel_n_4p vdd vss sl_inv4
Xrelp7b rel_n_4p rel_p_4p vdd vss sl_inv4
Xhip7 eng7 b7b sel_hi_p_4p vdd vss sl_nand2
Xhip7b sel_hi_p_4p sel_hi_n_4p vdd vss sl_inv4
Xlop7 eng7 b7 sel_lo_p_4p vdd vss sl_nand2
Xlop7b sel_lo_p_4p sel_lo_n_4p vdd vss sl_inv4
Xenn7 eng7 mode enn7b vdd vss sl_nand2
Xenn7i enn7b enn7 vdd vss sl_inv
Xreln7a enn7 rel_n_4n vdd vss sl_inv4
Xreln7b rel_n_4n rel_p_4n vdd vss sl_inv4
Xhin7 enn7 b7 sel_hi_p_4n vdd vss sl_nand2
Xhin7b sel_hi_p_4n sel_hi_n_4n vdd vss sl_inv4
Xlon7 enn7 b7b sel_lo_p_4n vdd vss sl_nand2
Xlon7b sel_lo_p_4n sel_lo_n_4n vdd vss sl_inv4
Xrelp8a eng8 rel_n_2p vdd vss sl_inv4
Xrelp8b rel_n_2p rel_p_2p vdd vss sl_inv4
Xhip8 eng8 b8b sel_hi_p_2p vdd vss sl_nand2
Xhip8b sel_hi_p_2p sel_hi_n_2p vdd vss sl_inv4
Xlop8 eng8 b8 sel_lo_p_2p vdd vss sl_nand2
Xlop8b sel_lo_p_2p sel_lo_n_2p vdd vss sl_inv4
Xenn8 eng8 mode enn8b vdd vss sl_nand2
Xenn8i enn8b enn8 vdd vss sl_inv
Xreln8a enn8 rel_n_2n vdd vss sl_inv4
Xreln8b rel_n_2n rel_p_2n vdd vss sl_inv4
Xhin8 enn8 b8 sel_hi_p_2n vdd vss sl_nand2
Xhin8b sel_hi_p_2n sel_hi_n_2n vdd vss sl_inv4
Xlon8 enn8 b8b sel_lo_p_2n vdd vss sl_nand2
Xlon8b sel_lo_p_2n sel_lo_n_2n vdd vss sl_inv4
Xrelp9a eng9 rel_n_1p vdd vss sl_inv4
Xrelp9b rel_n_1p rel_p_1p vdd vss sl_inv4
Xhip9 eng9 b9b sel_hi_p_1p vdd vss sl_nand2
Xhip9b sel_hi_p_1p sel_hi_n_1p vdd vss sl_inv4
Xlop9 eng9 b9 sel_lo_p_1p vdd vss sl_nand2
Xlop9b sel_lo_p_1p sel_lo_n_1p vdd vss sl_inv4
Xenn9 eng9 mode enn9b vdd vss sl_nand2
Xenn9i enn9b enn9 vdd vss sl_inv
Xreln9a enn9 rel_n_1n vdd vss sl_inv4
Xreln9b rel_n_1n rel_p_1n vdd vss sl_inv4
Xhin9 enn9 b9 sel_hi_p_1n vdd vss sl_nand2
Xhin9b sel_hi_p_1n sel_hi_n_1n vdd vss sl_inv4
Xlon9 enn9 b9b sel_lo_p_1n vdd vss sl_nand2
Xlon9b sel_lo_p_1n sel_lo_n_1n vdd vss sl_inv4
.ends sar_logic
