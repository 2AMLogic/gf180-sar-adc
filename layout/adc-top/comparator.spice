* extracted by klt extract --deck gf180mcu

* cell COMPARATOR
* pin clk
* pin dout
* pin doutb
* pin ibias
* pin pon
* pin pop
* pin vdd
* pin vinn
* pin vinp
* pin vss
.SUBCKT COMPARATOR clk dout doutb ibias pon pop vdd vinn vinp vss
* device instance $1 r0 *1 53.125,0.5 nfet
M$1 \$15 \$13 vss vss nfet L=0.35U W=1U AS=1.1P AD=1.1P PS=4.2U PD=4.2U
* device instance $2 r0 *1 60.825,0.5 nfet
M$2 \$16 \$12 vss vss nfet L=0.35U W=1U AS=1.1P AD=1.1P PS=4.2U PD=4.2U
* device instance $3 r0 *1 68.525,2 nfet
M$3 dout \$16 vss vss nfet L=0.35U W=4U AS=4.4P AD=4.4P PS=10.2U PD=10.2U
* device instance $4 r0 *1 71.475,2 nfet
M$4 dout doutb vss vss nfet L=0.35U W=4U AS=4.4P AD=4.4P PS=10.2U PD=10.2U
* device instance $5 r0 *1 82.125,2 nfet
M$5 doutb \$15 vss vss nfet L=0.35U W=4U AS=4.4P AD=4.4P PS=10.2U PD=10.2U
* device instance $6 r0 *1 85.075,2 nfet
M$6 doutb dout vss vss nfet L=0.35U W=4U AS=4.4P AD=4.4P PS=10.2U PD=10.2U
* device instance $7 r0 *1 27.725,3 nfet
M$7 \$13 \$12 \$10 vss nfet L=0.35U W=6U AS=6.6P AD=6.6P PS=14.2U PD=14.2U
* device instance $8 r0 *1 30.675,3 nfet
M$8 \$12 \$13 \$11 vss nfet L=0.35U W=6U AS=6.6P AD=6.6P PS=14.2U PD=14.2U
* device instance $9 r0 *1 21.6,4 nfet
M$9 \$10 pop \$9 vss nfet L=0.5U W=8U AS=8.8P AD=8.8P PS=18.2U PD=18.2U
* device instance $10 r0 *1 24.7,4 nfet
M$10 \$11 pon \$9 vss nfet L=0.5U W=8U AS=8.8P AD=8.8P PS=18.2U PD=18.2U
* device instance $11 r0 *1 18.575,8 nfet
M$11 \$9 clk vss vss nfet L=0.35U W=16U AS=17.6P AD=17.6P PS=34.2U PD=34.2U
* device instance $12 r0 *1 2.1,10 nfet
M$12 ibias ibias vss vss nfet L=2U W=20U AS=22P AD=22P PS=42.2U PD=42.2U
* device instance $13 r0 *1 13.9,10 nfet
M$13 \$3 ibias vss vss nfet L=2U W=20U AS=22P AD=22P PS=42.2U PD=42.2U
* device instance $14 r0 *1 6.2,20 nfet
M$14 pon vinp \$3 vss nfet L=1U W=40U AS=44P AD=44P PS=82.2U PD=82.2U
* device instance $15 r0 *1 9.8,20 nfet
M$15 pop vinn \$3 vss nfet L=1U W=40U AS=44P AD=44P PS=82.2U PD=82.2U
* device instance $16 r0 *1 46.325,1 pfet
M$16 \$10 clk vdd vdd pfet L=0.35U W=2U AS=2.2P AD=2.2P PS=6.2U PD=6.2U
* device instance $17 r0 *1 49.275,1 pfet
M$17 \$11 clk vdd vdd pfet L=0.35U W=2U AS=2.2P AD=2.2P PS=6.2U PD=6.2U
* device instance $18 r0 *1 56.975,1 pfet
M$18 \$15 \$13 vdd vdd pfet L=0.35U W=2U AS=2.2P AD=2.2P PS=6.2U PD=6.2U
* device instance $19 r0 *1 64.675,1 pfet
M$19 \$16 \$12 vdd vdd pfet L=0.35U W=2U AS=2.2P AD=2.2P PS=6.2U PD=6.2U
* device instance $20 r0 *1 40.425,2 pfet
M$20 \$13 clk vdd vdd pfet L=0.35U W=4U AS=4.4P AD=4.4P PS=10.2U PD=10.2U
* device instance $21 r0 *1 43.375,2 pfet
M$21 \$12 clk vdd vdd pfet L=0.35U W=4U AS=4.4P AD=4.4P PS=10.2U PD=10.2U
* device instance $22 r0 *1 34.525,4 pfet
M$22 \$13 \$12 vdd vdd pfet L=0.35U W=8U AS=8.8P AD=8.8P PS=18.2U PD=18.2U
* device instance $23 r0 *1 37.475,4 pfet
M$23 \$12 \$13 vdd vdd pfet L=0.35U W=8U AS=8.8P AD=8.8P PS=18.2U PD=18.2U
* device instance $24 r0 *1 75.325,4 pfet
M$24 \$19 \$16 vdd vdd pfet L=0.35U W=8U AS=8.8P AD=8.8P PS=18.2U PD=18.2U
* device instance $25 r0 *1 78.275,4 pfet
M$25 dout doutb \$19 vdd pfet L=0.35U W=8U AS=8.8P AD=8.8P PS=18.2U PD=18.2U
* device instance $26 r0 *1 88.925,4 pfet
M$26 \$20 \$15 vdd vdd pfet L=0.35U W=8U AS=8.8P AD=8.8P PS=18.2U PD=18.2U
* device instance $27 r0 *1 91.875,4 pfet
M$27 doutb dout \$20 vdd pfet L=0.35U W=8U AS=8.8P AD=8.8P PS=18.2U PD=18.2U
* device instance $28 r0 *1 96.95,19.225 ppolyf_u_1k
R$28 vdd pop vss 150000 ppolyf_u_1k L=150U W=1U
* device instance $29 r0 *1 103.15,19.225 ppolyf_u_1k
R$29 vdd pon vss 150000 ppolyf_u_1k L=150U W=1U
.ENDS COMPARATOR
