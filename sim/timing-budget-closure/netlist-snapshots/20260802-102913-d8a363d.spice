* Frozen netlist snapshot for record 20260802-102913-d8a363d
* source     : sim/timing-budget-closure/testbench/tb_timing_budget_closure.spice
* sha256     : 47d3b2a34e365a8ffd83f2e120d708d98452408e74caf1dee032add11958be5a
* This is a verbatim copy taken at record time. Do not edit.
* ==================================================================
* tb_timing_budget_closure -- issue #12's conversion timing budget,
* composed from #8/#9/#10's real worst-case numbers instead of
* spec/prior-art-survey.md Sec 1.4's placeholder DAC model, at both
* the 1 MS/s target (r1, 62.5 ns bit cycle) and the 2 MS/s stretch
* (r2, 31.25 ns bit cycle).
*
* GENERATED by design/sar-logic/gen_sar_logic.py -- do not edit.
*
* Per rate, four single-ended loops, identical except for the
* candidate logic-propagation delay added on top of the FIXED,
* measured 863 ps comparator regeneration delay (#9):
*   l0    +0 ns    just the two closed, measured/derived terms
*   l10   +10 ns   a generous logic-delay allowance -- still well
*                  inside both rates' margin per
*                  spec/timing-budget-memo.md
*   l25   +25 ns   inside the 1 MS/s margin (~52 ns) but OVER the
*                  2 MS/s stretch margin (~21 ns) -- the illustrative
*                  case the memo reports: the stretch's margin can
*                  go negative before the target's does
*   l55   +55 ns   over BOTH rates' margin -- the negative control
*
* Same PVT-subset justification as sim/sar-logic-timing/: rung-1
* ideal-digital + behavioural analog carries no PDK device models, so
* process/temperature cannot move anything here. The worst-PVT-corner
* claim is carried by the injected component VALUES (R_WORST_BIT_OHM,
* C_WORST_BIT_F, T_COMP_REGEN_NS above), each sourced from a closed,
* full-grid PVT sweep (#8/#9/#10), not by sweeping this deck's own
* corners.
* ==================================================================

.param vref={vdd_val}
.param vcm={vdd_val/2}
.param vth={vdd_val/2}
.param lsbse={vdd_val/1024}
.model sarl_sw sw(vt={vdd_val/2} vh=0 ron=1 roff=1e12)

vclk_r1 clk_r1 0 pulse(0 {vdd_val} 0 100p 100p 31.25n 62.5n)
vclk_r2 clk_r2 0 pulse(0 {vdd_val} 0 100p 100p 15.625n 31.25n)

* ---- loop r1_l0 ----
vr1_l0start r1_l0_start 0 dc 0
vr1_l0mode r1_l0_mode 0 dc 0
xr1_l0 clk_r1 r1_l0_start r1_l0_mode r1_l0_cmpo r1_l0_samp_tp_n
+ r1_l0_sel_in_n r1_l0_drdy r1_l0_c9 r1_l0_c8 r1_l0_c7 r1_l0_c6 r1_l0_c5
+ r1_l0_c4 r1_l0_c3 r1_l0_c2 r1_l0_c1 r1_l0_c0 r1_l0_rel_n_256p
+ r1_l0_sel_hi_n_256p r1_l0_sel_lo_n_256p r1_l0_rel_n_128p
+ r1_l0_sel_hi_n_128p r1_l0_sel_lo_n_128p r1_l0_rel_n_64p
+ r1_l0_sel_hi_n_64p r1_l0_sel_lo_n_64p r1_l0_rel_n_32p r1_l0_sel_hi_n_32p
+ r1_l0_sel_lo_n_32p r1_l0_rel_n_16p r1_l0_sel_hi_n_16p r1_l0_sel_lo_n_16p
+ r1_l0_rel_n_8p r1_l0_sel_hi_n_8p r1_l0_sel_lo_n_8p r1_l0_rel_n_4p
+ r1_l0_sel_hi_n_4p r1_l0_sel_lo_n_4p r1_l0_rel_n_2p r1_l0_sel_hi_n_2p
+ r1_l0_sel_lo_n_2p r1_l0_rel_n_1p r1_l0_sel_hi_n_1p r1_l0_sel_lo_n_1p
+ r1_l0_rel_n_256n r1_l0_sel_hi_n_256n r1_l0_sel_lo_n_256n
+ r1_l0_rel_n_128n r1_l0_sel_hi_n_128n r1_l0_sel_lo_n_128n r1_l0_rel_n_64n
+ r1_l0_sel_hi_n_64n r1_l0_sel_lo_n_64n r1_l0_rel_n_32n r1_l0_sel_hi_n_32n
+ r1_l0_sel_lo_n_32n r1_l0_rel_n_16n r1_l0_sel_hi_n_16n r1_l0_sel_lo_n_16n
+ r1_l0_rel_n_8n r1_l0_sel_hi_n_8n r1_l0_sel_lo_n_8n r1_l0_rel_n_4n
+ r1_l0_sel_hi_n_4n r1_l0_sel_lo_n_4n r1_l0_rel_n_2n r1_l0_sel_hi_n_2n
+ r1_l0_sel_lo_n_2n r1_l0_rel_n_1n r1_l0_sel_hi_n_1n r1_l0_sel_lo_n_1n
+ sar_ctrl_a
sr1_l0p r1_l0_vinp r1_l0_shp r1_l0_samp_tp_n 0 sarl_sw
sr1_l0n r1_l0_vinn r1_l0_shn r1_l0_samp_tp_n 0 sarl_sw
cr1_l0p r1_l0_shp 0 1p
cr1_l0n r1_l0_shn 0 1p
rr1_l0sd r1_l0_samp_tp_n r1_l0_sampd 10k
cr1_l0sd r1_l0_sampd 0 1p
sr1_l0xp r1_l0_vinp r1_l0_shxp r1_l0_sampd 0 sarl_sw
sr1_l0xn r1_l0_vinn r1_l0_shxn r1_l0_sampd 0 sarl_sw
cr1_l0xp r1_l0_shxp 0 1p
cr1_l0xn r1_l0_shxn 0 1p
br1_l0topp r1_l0_topip 0 V = 2*vcm-v(r1_l0_shp)+(1.0/512)*(
+ 256*((v(r1_l0_rel_n_256p)*vcm+v(r1_l0_sel_hi_n_256p)*vref+v(r1_l0_sel_in_n)*v(r1_l0_vinp))/vdd_val-vcm) + 128*((v(r1_l0_rel_n_128p)*vcm+v(r1_l0_sel_hi_n_128p)*vref+v(r1_l0_sel_in_n)*v(r1_l0_vinp))/vdd_val-vcm) + 64*((v(r1_l0_rel_n_64p)*vcm+v(r1_l0_sel_hi_n_64p)*vref+v(r1_l0_sel_in_n)*v(r1_l0_vinp))/vdd_val-vcm) + 32*((v(r1_l0_rel_n_32p)*vcm+v(r1_l0_sel_hi_n_32p)*vref+v(r1_l0_sel_in_n)*v(r1_l0_vinp))/vdd_val-vcm) + 16*((v(r1_l0_rel_n_16p)*vcm+v(r1_l0_sel_hi_n_16p)*vref+v(r1_l0_sel_in_n)*v(r1_l0_vinp))/vdd_val-vcm) + 8*((v(r1_l0_rel_n_8p)*vcm+v(r1_l0_sel_hi_n_8p)*vref+v(r1_l0_sel_in_n)*v(r1_l0_vinp))/vdd_val-vcm) + 4*((v(r1_l0_rel_n_4p)*vcm+v(r1_l0_sel_hi_n_4p)*vref+v(r1_l0_sel_in_n)*v(r1_l0_vinp))/vdd_val-vcm) + 2*((v(r1_l0_rel_n_2p)*vcm+v(r1_l0_sel_hi_n_2p)*vref+v(r1_l0_sel_in_n)*v(r1_l0_vinp))/vdd_val-vcm) + 1*((v(r1_l0_rel_n_1p)*vcm+v(r1_l0_sel_hi_n_1p)*vref+v(r1_l0_sel_in_n)*v(r1_l0_vinp))/vdd_val-vcm) )
br1_l0topn r1_l0_topin 0 V = 2*vcm-v(r1_l0_shn)+(1.0/512)*(
+ 256*((v(r1_l0_rel_n_256n)*vcm+v(r1_l0_sel_hi_n_256n)*vref+v(r1_l0_sel_in_n)*v(r1_l0_vinn))/vdd_val-vcm) + 128*((v(r1_l0_rel_n_128n)*vcm+v(r1_l0_sel_hi_n_128n)*vref+v(r1_l0_sel_in_n)*v(r1_l0_vinn))/vdd_val-vcm) + 64*((v(r1_l0_rel_n_64n)*vcm+v(r1_l0_sel_hi_n_64n)*vref+v(r1_l0_sel_in_n)*v(r1_l0_vinn))/vdd_val-vcm) + 32*((v(r1_l0_rel_n_32n)*vcm+v(r1_l0_sel_hi_n_32n)*vref+v(r1_l0_sel_in_n)*v(r1_l0_vinn))/vdd_val-vcm) + 16*((v(r1_l0_rel_n_16n)*vcm+v(r1_l0_sel_hi_n_16n)*vref+v(r1_l0_sel_in_n)*v(r1_l0_vinn))/vdd_val-vcm) + 8*((v(r1_l0_rel_n_8n)*vcm+v(r1_l0_sel_hi_n_8n)*vref+v(r1_l0_sel_in_n)*v(r1_l0_vinn))/vdd_val-vcm) + 4*((v(r1_l0_rel_n_4n)*vcm+v(r1_l0_sel_hi_n_4n)*vref+v(r1_l0_sel_in_n)*v(r1_l0_vinn))/vdd_val-vcm) + 2*((v(r1_l0_rel_n_2n)*vcm+v(r1_l0_sel_hi_n_2n)*vref+v(r1_l0_sel_in_n)*v(r1_l0_vinn))/vdd_val-vcm) + 1*((v(r1_l0_rel_n_1n)*vcm+v(r1_l0_sel_hi_n_1n)*vref+v(r1_l0_sel_in_n)*v(r1_l0_vinn))/vdd_val-vcm) )
rr1_l0p r1_l0_topip r1_l0_topp 570
rr1_l0n r1_l0_topin r1_l0_topn 570
cr1_l0tp r1_l0_topp 0 2.20672p
cr1_l0tn r1_l0_topn 0 2.20672p
br1_l0cmp r1_l0_cmpi 0 V = v(r1_l0_topp) > v(r1_l0_topn) ? vdd_val : 0
tr1_l0d r1_l0_cmpi 0 r1_l0_cmpo 0 z0=50 td=0.863n
rr1_l0term r1_l0_cmpo 0 50
br1_l0code r1_l0_code 0 V =
+ (512)*(v(r1_l0_c9)>vth ? 1 : 0) + (256)*(v(r1_l0_c8)>vth ? 1 : 0) + (128)*(v(r1_l0_c7)>vth ? 1 : 0) + (64)*(v(r1_l0_c6)>vth ? 1 : 0) + (32)*(v(r1_l0_c5)>vth ? 1 : 0) + (16)*(v(r1_l0_c4)>vth ? 1 : 0) + (8)*(v(r1_l0_c3)>vth ? 1 : 0) + (4)*(v(r1_l0_c2)>vth ? 1 : 0) + (2)*(v(r1_l0_c1)>vth ? 1 : 0) + (1)*(v(r1_l0_c0)>vth ? 1 : 0)
br1_l0conf r1_l0_conf 0 V = (
+ abs(v(r1_l0_sel_in_n)+v(r1_l0_rel_n_256p)+v(r1_l0_sel_hi_n_256p)+v(r1_l0_sel_lo_n_256p)-vdd_val) + abs(v(r1_l0_sel_in_n)+v(r1_l0_rel_n_128p)+v(r1_l0_sel_hi_n_128p)+v(r1_l0_sel_lo_n_128p)-vdd_val) + abs(v(r1_l0_sel_in_n)+v(r1_l0_rel_n_64p)+v(r1_l0_sel_hi_n_64p)+v(r1_l0_sel_lo_n_64p)-vdd_val) + abs(v(r1_l0_sel_in_n)+v(r1_l0_rel_n_32p)+v(r1_l0_sel_hi_n_32p)+v(r1_l0_sel_lo_n_32p)-vdd_val) + abs(v(r1_l0_sel_in_n)+v(r1_l0_rel_n_16p)+v(r1_l0_sel_hi_n_16p)+v(r1_l0_sel_lo_n_16p)-vdd_val) + abs(v(r1_l0_sel_in_n)+v(r1_l0_rel_n_8p)+v(r1_l0_sel_hi_n_8p)+v(r1_l0_sel_lo_n_8p)-vdd_val) + abs(v(r1_l0_sel_in_n)+v(r1_l0_rel_n_4p)+v(r1_l0_sel_hi_n_4p)+v(r1_l0_sel_lo_n_4p)-vdd_val) + abs(v(r1_l0_sel_in_n)+v(r1_l0_rel_n_2p)+v(r1_l0_sel_hi_n_2p)+v(r1_l0_sel_lo_n_2p)-vdd_val) + abs(v(r1_l0_sel_in_n)+v(r1_l0_rel_n_1p)+v(r1_l0_sel_hi_n_1p)+v(r1_l0_sel_lo_n_1p)-vdd_val) + abs(v(r1_l0_sel_in_n)+v(r1_l0_rel_n_256n)+v(r1_l0_sel_hi_n_256n)+v(r1_l0_sel_lo_n_256n)-vdd_val) + abs(v(r1_l0_sel_in_n)+v(r1_l0_rel_n_128n)+v(r1_l0_sel_hi_n_128n)+v(r1_l0_sel_lo_n_128n)-vdd_val) + abs(v(r1_l0_sel_in_n)+v(r1_l0_rel_n_64n)+v(r1_l0_sel_hi_n_64n)+v(r1_l0_sel_lo_n_64n)-vdd_val) + abs(v(r1_l0_sel_in_n)+v(r1_l0_rel_n_32n)+v(r1_l0_sel_hi_n_32n)+v(r1_l0_sel_lo_n_32n)-vdd_val) + abs(v(r1_l0_sel_in_n)+v(r1_l0_rel_n_16n)+v(r1_l0_sel_hi_n_16n)+v(r1_l0_sel_lo_n_16n)-vdd_val) + abs(v(r1_l0_sel_in_n)+v(r1_l0_rel_n_8n)+v(r1_l0_sel_hi_n_8n)+v(r1_l0_sel_lo_n_8n)-vdd_val) + abs(v(r1_l0_sel_in_n)+v(r1_l0_rel_n_4n)+v(r1_l0_sel_hi_n_4n)+v(r1_l0_sel_lo_n_4n)-vdd_val) + abs(v(r1_l0_sel_in_n)+v(r1_l0_rel_n_2n)+v(r1_l0_sel_hi_n_2n)+v(r1_l0_sel_lo_n_2n)-vdd_val) + abs(v(r1_l0_sel_in_n)+v(r1_l0_rel_n_1n)+v(r1_l0_sel_hi_n_1n)+v(r1_l0_sel_lo_n_1n)-vdd_val))/vdd_val
br1_l0nside r1_l0_nside 0 V = (
+ v(r1_l0_sel_hi_n_256n)+v(r1_l0_sel_lo_n_256n) + v(r1_l0_sel_hi_n_128n)+v(r1_l0_sel_lo_n_128n) + v(r1_l0_sel_hi_n_64n)+v(r1_l0_sel_lo_n_64n) + v(r1_l0_sel_hi_n_32n)+v(r1_l0_sel_lo_n_32n) + v(r1_l0_sel_hi_n_16n)+v(r1_l0_sel_lo_n_16n) + v(r1_l0_sel_hi_n_8n)+v(r1_l0_sel_lo_n_8n) + v(r1_l0_sel_hi_n_4n)+v(r1_l0_sel_lo_n_4n) + v(r1_l0_sel_hi_n_2n)+v(r1_l0_sel_lo_n_2n) + v(r1_l0_sel_hi_n_1n)+v(r1_l0_sel_lo_n_1n))/vdd_val
br1_l0acq r1_l0_acq 0 V = v(r1_l0_samp_tp_n)/vdd_val
br1_l0iso r1_l0_iso 0 V = (v(r1_l0_sel_in_n)-v(r1_l0_samp_tp_n))/vdd_val
* r1_l0: 62.5 ns/cycle (1000 ns/conversion); added delay = 863 ps (measured, #9) + 0 ns (candidate logic delay)
* input ramps one LSB per conversion THROUGH mid-scale
* (codes 507..515), the worst case for a late decision.
vr1_l0in r1_l0_vinp 0 pwl(0 {vcm-4.75*lsbse} 8u {vcm+3.25*lsbse})
vr1_l0cm r1_l0_vinn 0 dc {vcm}
br1_l0exp r1_l0_exp 0 V = min(max(floor(v(r1_l0_shxp)/lsbse),0),1023)
br1_l0err r1_l0_err 0 V = v(r1_l0_drdy)>vth ? v(r1_l0_code)-v(r1_l0_exp) : 0
br1_l0aerr r1_l0_aerr 0 V = abs(v(r1_l0_err))

* ---- loop r1_l10 ----
vr1_l10start r1_l10_start 0 dc 0
vr1_l10mode r1_l10_mode 0 dc 0
xr1_l10 clk_r1 r1_l10_start r1_l10_mode r1_l10_cmpo r1_l10_samp_tp_n
+ r1_l10_sel_in_n r1_l10_drdy r1_l10_c9 r1_l10_c8 r1_l10_c7 r1_l10_c6
+ r1_l10_c5 r1_l10_c4 r1_l10_c3 r1_l10_c2 r1_l10_c1 r1_l10_c0
+ r1_l10_rel_n_256p r1_l10_sel_hi_n_256p r1_l10_sel_lo_n_256p
+ r1_l10_rel_n_128p r1_l10_sel_hi_n_128p r1_l10_sel_lo_n_128p
+ r1_l10_rel_n_64p r1_l10_sel_hi_n_64p r1_l10_sel_lo_n_64p
+ r1_l10_rel_n_32p r1_l10_sel_hi_n_32p r1_l10_sel_lo_n_32p
+ r1_l10_rel_n_16p r1_l10_sel_hi_n_16p r1_l10_sel_lo_n_16p r1_l10_rel_n_8p
+ r1_l10_sel_hi_n_8p r1_l10_sel_lo_n_8p r1_l10_rel_n_4p r1_l10_sel_hi_n_4p
+ r1_l10_sel_lo_n_4p r1_l10_rel_n_2p r1_l10_sel_hi_n_2p r1_l10_sel_lo_n_2p
+ r1_l10_rel_n_1p r1_l10_sel_hi_n_1p r1_l10_sel_lo_n_1p r1_l10_rel_n_256n
+ r1_l10_sel_hi_n_256n r1_l10_sel_lo_n_256n r1_l10_rel_n_128n
+ r1_l10_sel_hi_n_128n r1_l10_sel_lo_n_128n r1_l10_rel_n_64n
+ r1_l10_sel_hi_n_64n r1_l10_sel_lo_n_64n r1_l10_rel_n_32n
+ r1_l10_sel_hi_n_32n r1_l10_sel_lo_n_32n r1_l10_rel_n_16n
+ r1_l10_sel_hi_n_16n r1_l10_sel_lo_n_16n r1_l10_rel_n_8n
+ r1_l10_sel_hi_n_8n r1_l10_sel_lo_n_8n r1_l10_rel_n_4n r1_l10_sel_hi_n_4n
+ r1_l10_sel_lo_n_4n r1_l10_rel_n_2n r1_l10_sel_hi_n_2n r1_l10_sel_lo_n_2n
+ r1_l10_rel_n_1n r1_l10_sel_hi_n_1n r1_l10_sel_lo_n_1n sar_ctrl_a
sr1_l10p r1_l10_vinp r1_l10_shp r1_l10_samp_tp_n 0 sarl_sw
sr1_l10n r1_l10_vinn r1_l10_shn r1_l10_samp_tp_n 0 sarl_sw
cr1_l10p r1_l10_shp 0 1p
cr1_l10n r1_l10_shn 0 1p
rr1_l10sd r1_l10_samp_tp_n r1_l10_sampd 10k
cr1_l10sd r1_l10_sampd 0 1p
sr1_l10xp r1_l10_vinp r1_l10_shxp r1_l10_sampd 0 sarl_sw
sr1_l10xn r1_l10_vinn r1_l10_shxn r1_l10_sampd 0 sarl_sw
cr1_l10xp r1_l10_shxp 0 1p
cr1_l10xn r1_l10_shxn 0 1p
br1_l10topp r1_l10_topip 0 V = 2*vcm-v(r1_l10_shp)+(1.0/512)*(
+ 256*((v(r1_l10_rel_n_256p)*vcm+v(r1_l10_sel_hi_n_256p)*vref+v(r1_l10_sel_in_n)*v(r1_l10_vinp))/vdd_val-vcm) + 128*((v(r1_l10_rel_n_128p)*vcm+v(r1_l10_sel_hi_n_128p)*vref+v(r1_l10_sel_in_n)*v(r1_l10_vinp))/vdd_val-vcm) + 64*((v(r1_l10_rel_n_64p)*vcm+v(r1_l10_sel_hi_n_64p)*vref+v(r1_l10_sel_in_n)*v(r1_l10_vinp))/vdd_val-vcm) + 32*((v(r1_l10_rel_n_32p)*vcm+v(r1_l10_sel_hi_n_32p)*vref+v(r1_l10_sel_in_n)*v(r1_l10_vinp))/vdd_val-vcm) + 16*((v(r1_l10_rel_n_16p)*vcm+v(r1_l10_sel_hi_n_16p)*vref+v(r1_l10_sel_in_n)*v(r1_l10_vinp))/vdd_val-vcm) + 8*((v(r1_l10_rel_n_8p)*vcm+v(r1_l10_sel_hi_n_8p)*vref+v(r1_l10_sel_in_n)*v(r1_l10_vinp))/vdd_val-vcm) + 4*((v(r1_l10_rel_n_4p)*vcm+v(r1_l10_sel_hi_n_4p)*vref+v(r1_l10_sel_in_n)*v(r1_l10_vinp))/vdd_val-vcm) + 2*((v(r1_l10_rel_n_2p)*vcm+v(r1_l10_sel_hi_n_2p)*vref+v(r1_l10_sel_in_n)*v(r1_l10_vinp))/vdd_val-vcm) + 1*((v(r1_l10_rel_n_1p)*vcm+v(r1_l10_sel_hi_n_1p)*vref+v(r1_l10_sel_in_n)*v(r1_l10_vinp))/vdd_val-vcm) )
br1_l10topn r1_l10_topin 0 V = 2*vcm-v(r1_l10_shn)+(1.0/512)*(
+ 256*((v(r1_l10_rel_n_256n)*vcm+v(r1_l10_sel_hi_n_256n)*vref+v(r1_l10_sel_in_n)*v(r1_l10_vinn))/vdd_val-vcm) + 128*((v(r1_l10_rel_n_128n)*vcm+v(r1_l10_sel_hi_n_128n)*vref+v(r1_l10_sel_in_n)*v(r1_l10_vinn))/vdd_val-vcm) + 64*((v(r1_l10_rel_n_64n)*vcm+v(r1_l10_sel_hi_n_64n)*vref+v(r1_l10_sel_in_n)*v(r1_l10_vinn))/vdd_val-vcm) + 32*((v(r1_l10_rel_n_32n)*vcm+v(r1_l10_sel_hi_n_32n)*vref+v(r1_l10_sel_in_n)*v(r1_l10_vinn))/vdd_val-vcm) + 16*((v(r1_l10_rel_n_16n)*vcm+v(r1_l10_sel_hi_n_16n)*vref+v(r1_l10_sel_in_n)*v(r1_l10_vinn))/vdd_val-vcm) + 8*((v(r1_l10_rel_n_8n)*vcm+v(r1_l10_sel_hi_n_8n)*vref+v(r1_l10_sel_in_n)*v(r1_l10_vinn))/vdd_val-vcm) + 4*((v(r1_l10_rel_n_4n)*vcm+v(r1_l10_sel_hi_n_4n)*vref+v(r1_l10_sel_in_n)*v(r1_l10_vinn))/vdd_val-vcm) + 2*((v(r1_l10_rel_n_2n)*vcm+v(r1_l10_sel_hi_n_2n)*vref+v(r1_l10_sel_in_n)*v(r1_l10_vinn))/vdd_val-vcm) + 1*((v(r1_l10_rel_n_1n)*vcm+v(r1_l10_sel_hi_n_1n)*vref+v(r1_l10_sel_in_n)*v(r1_l10_vinn))/vdd_val-vcm) )
rr1_l10p r1_l10_topip r1_l10_topp 570
rr1_l10n r1_l10_topin r1_l10_topn 570
cr1_l10tp r1_l10_topp 0 2.20672p
cr1_l10tn r1_l10_topn 0 2.20672p
br1_l10cmp r1_l10_cmpi 0 V = v(r1_l10_topp) > v(r1_l10_topn) ? vdd_val : 0
tr1_l10d r1_l10_cmpi 0 r1_l10_cmpo 0 z0=50 td=10.863n
rr1_l10term r1_l10_cmpo 0 50
br1_l10code r1_l10_code 0 V =
+ (512)*(v(r1_l10_c9)>vth ? 1 : 0) + (256)*(v(r1_l10_c8)>vth ? 1 : 0) + (128)*(v(r1_l10_c7)>vth ? 1 : 0) + (64)*(v(r1_l10_c6)>vth ? 1 : 0) + (32)*(v(r1_l10_c5)>vth ? 1 : 0) + (16)*(v(r1_l10_c4)>vth ? 1 : 0) + (8)*(v(r1_l10_c3)>vth ? 1 : 0) + (4)*(v(r1_l10_c2)>vth ? 1 : 0) + (2)*(v(r1_l10_c1)>vth ? 1 : 0) + (1)*(v(r1_l10_c0)>vth ? 1 : 0)
br1_l10conf r1_l10_conf 0 V = (
+ abs(v(r1_l10_sel_in_n)+v(r1_l10_rel_n_256p)+v(r1_l10_sel_hi_n_256p)+v(r1_l10_sel_lo_n_256p)-vdd_val) + abs(v(r1_l10_sel_in_n)+v(r1_l10_rel_n_128p)+v(r1_l10_sel_hi_n_128p)+v(r1_l10_sel_lo_n_128p)-vdd_val) + abs(v(r1_l10_sel_in_n)+v(r1_l10_rel_n_64p)+v(r1_l10_sel_hi_n_64p)+v(r1_l10_sel_lo_n_64p)-vdd_val) + abs(v(r1_l10_sel_in_n)+v(r1_l10_rel_n_32p)+v(r1_l10_sel_hi_n_32p)+v(r1_l10_sel_lo_n_32p)-vdd_val) + abs(v(r1_l10_sel_in_n)+v(r1_l10_rel_n_16p)+v(r1_l10_sel_hi_n_16p)+v(r1_l10_sel_lo_n_16p)-vdd_val) + abs(v(r1_l10_sel_in_n)+v(r1_l10_rel_n_8p)+v(r1_l10_sel_hi_n_8p)+v(r1_l10_sel_lo_n_8p)-vdd_val) + abs(v(r1_l10_sel_in_n)+v(r1_l10_rel_n_4p)+v(r1_l10_sel_hi_n_4p)+v(r1_l10_sel_lo_n_4p)-vdd_val) + abs(v(r1_l10_sel_in_n)+v(r1_l10_rel_n_2p)+v(r1_l10_sel_hi_n_2p)+v(r1_l10_sel_lo_n_2p)-vdd_val) + abs(v(r1_l10_sel_in_n)+v(r1_l10_rel_n_1p)+v(r1_l10_sel_hi_n_1p)+v(r1_l10_sel_lo_n_1p)-vdd_val) + abs(v(r1_l10_sel_in_n)+v(r1_l10_rel_n_256n)+v(r1_l10_sel_hi_n_256n)+v(r1_l10_sel_lo_n_256n)-vdd_val) + abs(v(r1_l10_sel_in_n)+v(r1_l10_rel_n_128n)+v(r1_l10_sel_hi_n_128n)+v(r1_l10_sel_lo_n_128n)-vdd_val) + abs(v(r1_l10_sel_in_n)+v(r1_l10_rel_n_64n)+v(r1_l10_sel_hi_n_64n)+v(r1_l10_sel_lo_n_64n)-vdd_val) + abs(v(r1_l10_sel_in_n)+v(r1_l10_rel_n_32n)+v(r1_l10_sel_hi_n_32n)+v(r1_l10_sel_lo_n_32n)-vdd_val) + abs(v(r1_l10_sel_in_n)+v(r1_l10_rel_n_16n)+v(r1_l10_sel_hi_n_16n)+v(r1_l10_sel_lo_n_16n)-vdd_val) + abs(v(r1_l10_sel_in_n)+v(r1_l10_rel_n_8n)+v(r1_l10_sel_hi_n_8n)+v(r1_l10_sel_lo_n_8n)-vdd_val) + abs(v(r1_l10_sel_in_n)+v(r1_l10_rel_n_4n)+v(r1_l10_sel_hi_n_4n)+v(r1_l10_sel_lo_n_4n)-vdd_val) + abs(v(r1_l10_sel_in_n)+v(r1_l10_rel_n_2n)+v(r1_l10_sel_hi_n_2n)+v(r1_l10_sel_lo_n_2n)-vdd_val) + abs(v(r1_l10_sel_in_n)+v(r1_l10_rel_n_1n)+v(r1_l10_sel_hi_n_1n)+v(r1_l10_sel_lo_n_1n)-vdd_val))/vdd_val
br1_l10nside r1_l10_nside 0 V = (
+ v(r1_l10_sel_hi_n_256n)+v(r1_l10_sel_lo_n_256n) + v(r1_l10_sel_hi_n_128n)+v(r1_l10_sel_lo_n_128n) + v(r1_l10_sel_hi_n_64n)+v(r1_l10_sel_lo_n_64n) + v(r1_l10_sel_hi_n_32n)+v(r1_l10_sel_lo_n_32n) + v(r1_l10_sel_hi_n_16n)+v(r1_l10_sel_lo_n_16n) + v(r1_l10_sel_hi_n_8n)+v(r1_l10_sel_lo_n_8n) + v(r1_l10_sel_hi_n_4n)+v(r1_l10_sel_lo_n_4n) + v(r1_l10_sel_hi_n_2n)+v(r1_l10_sel_lo_n_2n) + v(r1_l10_sel_hi_n_1n)+v(r1_l10_sel_lo_n_1n))/vdd_val
br1_l10acq r1_l10_acq 0 V = v(r1_l10_samp_tp_n)/vdd_val
br1_l10iso r1_l10_iso 0 V = (v(r1_l10_sel_in_n)-v(r1_l10_samp_tp_n))/vdd_val
* r1_l10: 62.5 ns/cycle (1000 ns/conversion); added delay = 863 ps (measured, #9) + 10 ns (candidate logic delay)
* input ramps one LSB per conversion THROUGH mid-scale
* (codes 507..515), the worst case for a late decision.
vr1_l10in r1_l10_vinp 0 pwl(0 {vcm-4.75*lsbse} 8u {vcm+3.25*lsbse})
vr1_l10cm r1_l10_vinn 0 dc {vcm}
br1_l10exp r1_l10_exp 0 V = min(max(floor(v(r1_l10_shxp)/lsbse),0),1023)
br1_l10err r1_l10_err 0 V = v(r1_l10_drdy)>vth ? v(r1_l10_code)-v(r1_l10_exp) : 0
br1_l10aerr r1_l10_aerr 0 V = abs(v(r1_l10_err))

* ---- loop r1_l25 ----
vr1_l25start r1_l25_start 0 dc 0
vr1_l25mode r1_l25_mode 0 dc 0
xr1_l25 clk_r1 r1_l25_start r1_l25_mode r1_l25_cmpo r1_l25_samp_tp_n
+ r1_l25_sel_in_n r1_l25_drdy r1_l25_c9 r1_l25_c8 r1_l25_c7 r1_l25_c6
+ r1_l25_c5 r1_l25_c4 r1_l25_c3 r1_l25_c2 r1_l25_c1 r1_l25_c0
+ r1_l25_rel_n_256p r1_l25_sel_hi_n_256p r1_l25_sel_lo_n_256p
+ r1_l25_rel_n_128p r1_l25_sel_hi_n_128p r1_l25_sel_lo_n_128p
+ r1_l25_rel_n_64p r1_l25_sel_hi_n_64p r1_l25_sel_lo_n_64p
+ r1_l25_rel_n_32p r1_l25_sel_hi_n_32p r1_l25_sel_lo_n_32p
+ r1_l25_rel_n_16p r1_l25_sel_hi_n_16p r1_l25_sel_lo_n_16p r1_l25_rel_n_8p
+ r1_l25_sel_hi_n_8p r1_l25_sel_lo_n_8p r1_l25_rel_n_4p r1_l25_sel_hi_n_4p
+ r1_l25_sel_lo_n_4p r1_l25_rel_n_2p r1_l25_sel_hi_n_2p r1_l25_sel_lo_n_2p
+ r1_l25_rel_n_1p r1_l25_sel_hi_n_1p r1_l25_sel_lo_n_1p r1_l25_rel_n_256n
+ r1_l25_sel_hi_n_256n r1_l25_sel_lo_n_256n r1_l25_rel_n_128n
+ r1_l25_sel_hi_n_128n r1_l25_sel_lo_n_128n r1_l25_rel_n_64n
+ r1_l25_sel_hi_n_64n r1_l25_sel_lo_n_64n r1_l25_rel_n_32n
+ r1_l25_sel_hi_n_32n r1_l25_sel_lo_n_32n r1_l25_rel_n_16n
+ r1_l25_sel_hi_n_16n r1_l25_sel_lo_n_16n r1_l25_rel_n_8n
+ r1_l25_sel_hi_n_8n r1_l25_sel_lo_n_8n r1_l25_rel_n_4n r1_l25_sel_hi_n_4n
+ r1_l25_sel_lo_n_4n r1_l25_rel_n_2n r1_l25_sel_hi_n_2n r1_l25_sel_lo_n_2n
+ r1_l25_rel_n_1n r1_l25_sel_hi_n_1n r1_l25_sel_lo_n_1n sar_ctrl_a
sr1_l25p r1_l25_vinp r1_l25_shp r1_l25_samp_tp_n 0 sarl_sw
sr1_l25n r1_l25_vinn r1_l25_shn r1_l25_samp_tp_n 0 sarl_sw
cr1_l25p r1_l25_shp 0 1p
cr1_l25n r1_l25_shn 0 1p
rr1_l25sd r1_l25_samp_tp_n r1_l25_sampd 10k
cr1_l25sd r1_l25_sampd 0 1p
sr1_l25xp r1_l25_vinp r1_l25_shxp r1_l25_sampd 0 sarl_sw
sr1_l25xn r1_l25_vinn r1_l25_shxn r1_l25_sampd 0 sarl_sw
cr1_l25xp r1_l25_shxp 0 1p
cr1_l25xn r1_l25_shxn 0 1p
br1_l25topp r1_l25_topip 0 V = 2*vcm-v(r1_l25_shp)+(1.0/512)*(
+ 256*((v(r1_l25_rel_n_256p)*vcm+v(r1_l25_sel_hi_n_256p)*vref+v(r1_l25_sel_in_n)*v(r1_l25_vinp))/vdd_val-vcm) + 128*((v(r1_l25_rel_n_128p)*vcm+v(r1_l25_sel_hi_n_128p)*vref+v(r1_l25_sel_in_n)*v(r1_l25_vinp))/vdd_val-vcm) + 64*((v(r1_l25_rel_n_64p)*vcm+v(r1_l25_sel_hi_n_64p)*vref+v(r1_l25_sel_in_n)*v(r1_l25_vinp))/vdd_val-vcm) + 32*((v(r1_l25_rel_n_32p)*vcm+v(r1_l25_sel_hi_n_32p)*vref+v(r1_l25_sel_in_n)*v(r1_l25_vinp))/vdd_val-vcm) + 16*((v(r1_l25_rel_n_16p)*vcm+v(r1_l25_sel_hi_n_16p)*vref+v(r1_l25_sel_in_n)*v(r1_l25_vinp))/vdd_val-vcm) + 8*((v(r1_l25_rel_n_8p)*vcm+v(r1_l25_sel_hi_n_8p)*vref+v(r1_l25_sel_in_n)*v(r1_l25_vinp))/vdd_val-vcm) + 4*((v(r1_l25_rel_n_4p)*vcm+v(r1_l25_sel_hi_n_4p)*vref+v(r1_l25_sel_in_n)*v(r1_l25_vinp))/vdd_val-vcm) + 2*((v(r1_l25_rel_n_2p)*vcm+v(r1_l25_sel_hi_n_2p)*vref+v(r1_l25_sel_in_n)*v(r1_l25_vinp))/vdd_val-vcm) + 1*((v(r1_l25_rel_n_1p)*vcm+v(r1_l25_sel_hi_n_1p)*vref+v(r1_l25_sel_in_n)*v(r1_l25_vinp))/vdd_val-vcm) )
br1_l25topn r1_l25_topin 0 V = 2*vcm-v(r1_l25_shn)+(1.0/512)*(
+ 256*((v(r1_l25_rel_n_256n)*vcm+v(r1_l25_sel_hi_n_256n)*vref+v(r1_l25_sel_in_n)*v(r1_l25_vinn))/vdd_val-vcm) + 128*((v(r1_l25_rel_n_128n)*vcm+v(r1_l25_sel_hi_n_128n)*vref+v(r1_l25_sel_in_n)*v(r1_l25_vinn))/vdd_val-vcm) + 64*((v(r1_l25_rel_n_64n)*vcm+v(r1_l25_sel_hi_n_64n)*vref+v(r1_l25_sel_in_n)*v(r1_l25_vinn))/vdd_val-vcm) + 32*((v(r1_l25_rel_n_32n)*vcm+v(r1_l25_sel_hi_n_32n)*vref+v(r1_l25_sel_in_n)*v(r1_l25_vinn))/vdd_val-vcm) + 16*((v(r1_l25_rel_n_16n)*vcm+v(r1_l25_sel_hi_n_16n)*vref+v(r1_l25_sel_in_n)*v(r1_l25_vinn))/vdd_val-vcm) + 8*((v(r1_l25_rel_n_8n)*vcm+v(r1_l25_sel_hi_n_8n)*vref+v(r1_l25_sel_in_n)*v(r1_l25_vinn))/vdd_val-vcm) + 4*((v(r1_l25_rel_n_4n)*vcm+v(r1_l25_sel_hi_n_4n)*vref+v(r1_l25_sel_in_n)*v(r1_l25_vinn))/vdd_val-vcm) + 2*((v(r1_l25_rel_n_2n)*vcm+v(r1_l25_sel_hi_n_2n)*vref+v(r1_l25_sel_in_n)*v(r1_l25_vinn))/vdd_val-vcm) + 1*((v(r1_l25_rel_n_1n)*vcm+v(r1_l25_sel_hi_n_1n)*vref+v(r1_l25_sel_in_n)*v(r1_l25_vinn))/vdd_val-vcm) )
rr1_l25p r1_l25_topip r1_l25_topp 570
rr1_l25n r1_l25_topin r1_l25_topn 570
cr1_l25tp r1_l25_topp 0 2.20672p
cr1_l25tn r1_l25_topn 0 2.20672p
br1_l25cmp r1_l25_cmpi 0 V = v(r1_l25_topp) > v(r1_l25_topn) ? vdd_val : 0
tr1_l25d r1_l25_cmpi 0 r1_l25_cmpo 0 z0=50 td=25.863n
rr1_l25term r1_l25_cmpo 0 50
br1_l25code r1_l25_code 0 V =
+ (512)*(v(r1_l25_c9)>vth ? 1 : 0) + (256)*(v(r1_l25_c8)>vth ? 1 : 0) + (128)*(v(r1_l25_c7)>vth ? 1 : 0) + (64)*(v(r1_l25_c6)>vth ? 1 : 0) + (32)*(v(r1_l25_c5)>vth ? 1 : 0) + (16)*(v(r1_l25_c4)>vth ? 1 : 0) + (8)*(v(r1_l25_c3)>vth ? 1 : 0) + (4)*(v(r1_l25_c2)>vth ? 1 : 0) + (2)*(v(r1_l25_c1)>vth ? 1 : 0) + (1)*(v(r1_l25_c0)>vth ? 1 : 0)
br1_l25conf r1_l25_conf 0 V = (
+ abs(v(r1_l25_sel_in_n)+v(r1_l25_rel_n_256p)+v(r1_l25_sel_hi_n_256p)+v(r1_l25_sel_lo_n_256p)-vdd_val) + abs(v(r1_l25_sel_in_n)+v(r1_l25_rel_n_128p)+v(r1_l25_sel_hi_n_128p)+v(r1_l25_sel_lo_n_128p)-vdd_val) + abs(v(r1_l25_sel_in_n)+v(r1_l25_rel_n_64p)+v(r1_l25_sel_hi_n_64p)+v(r1_l25_sel_lo_n_64p)-vdd_val) + abs(v(r1_l25_sel_in_n)+v(r1_l25_rel_n_32p)+v(r1_l25_sel_hi_n_32p)+v(r1_l25_sel_lo_n_32p)-vdd_val) + abs(v(r1_l25_sel_in_n)+v(r1_l25_rel_n_16p)+v(r1_l25_sel_hi_n_16p)+v(r1_l25_sel_lo_n_16p)-vdd_val) + abs(v(r1_l25_sel_in_n)+v(r1_l25_rel_n_8p)+v(r1_l25_sel_hi_n_8p)+v(r1_l25_sel_lo_n_8p)-vdd_val) + abs(v(r1_l25_sel_in_n)+v(r1_l25_rel_n_4p)+v(r1_l25_sel_hi_n_4p)+v(r1_l25_sel_lo_n_4p)-vdd_val) + abs(v(r1_l25_sel_in_n)+v(r1_l25_rel_n_2p)+v(r1_l25_sel_hi_n_2p)+v(r1_l25_sel_lo_n_2p)-vdd_val) + abs(v(r1_l25_sel_in_n)+v(r1_l25_rel_n_1p)+v(r1_l25_sel_hi_n_1p)+v(r1_l25_sel_lo_n_1p)-vdd_val) + abs(v(r1_l25_sel_in_n)+v(r1_l25_rel_n_256n)+v(r1_l25_sel_hi_n_256n)+v(r1_l25_sel_lo_n_256n)-vdd_val) + abs(v(r1_l25_sel_in_n)+v(r1_l25_rel_n_128n)+v(r1_l25_sel_hi_n_128n)+v(r1_l25_sel_lo_n_128n)-vdd_val) + abs(v(r1_l25_sel_in_n)+v(r1_l25_rel_n_64n)+v(r1_l25_sel_hi_n_64n)+v(r1_l25_sel_lo_n_64n)-vdd_val) + abs(v(r1_l25_sel_in_n)+v(r1_l25_rel_n_32n)+v(r1_l25_sel_hi_n_32n)+v(r1_l25_sel_lo_n_32n)-vdd_val) + abs(v(r1_l25_sel_in_n)+v(r1_l25_rel_n_16n)+v(r1_l25_sel_hi_n_16n)+v(r1_l25_sel_lo_n_16n)-vdd_val) + abs(v(r1_l25_sel_in_n)+v(r1_l25_rel_n_8n)+v(r1_l25_sel_hi_n_8n)+v(r1_l25_sel_lo_n_8n)-vdd_val) + abs(v(r1_l25_sel_in_n)+v(r1_l25_rel_n_4n)+v(r1_l25_sel_hi_n_4n)+v(r1_l25_sel_lo_n_4n)-vdd_val) + abs(v(r1_l25_sel_in_n)+v(r1_l25_rel_n_2n)+v(r1_l25_sel_hi_n_2n)+v(r1_l25_sel_lo_n_2n)-vdd_val) + abs(v(r1_l25_sel_in_n)+v(r1_l25_rel_n_1n)+v(r1_l25_sel_hi_n_1n)+v(r1_l25_sel_lo_n_1n)-vdd_val))/vdd_val
br1_l25nside r1_l25_nside 0 V = (
+ v(r1_l25_sel_hi_n_256n)+v(r1_l25_sel_lo_n_256n) + v(r1_l25_sel_hi_n_128n)+v(r1_l25_sel_lo_n_128n) + v(r1_l25_sel_hi_n_64n)+v(r1_l25_sel_lo_n_64n) + v(r1_l25_sel_hi_n_32n)+v(r1_l25_sel_lo_n_32n) + v(r1_l25_sel_hi_n_16n)+v(r1_l25_sel_lo_n_16n) + v(r1_l25_sel_hi_n_8n)+v(r1_l25_sel_lo_n_8n) + v(r1_l25_sel_hi_n_4n)+v(r1_l25_sel_lo_n_4n) + v(r1_l25_sel_hi_n_2n)+v(r1_l25_sel_lo_n_2n) + v(r1_l25_sel_hi_n_1n)+v(r1_l25_sel_lo_n_1n))/vdd_val
br1_l25acq r1_l25_acq 0 V = v(r1_l25_samp_tp_n)/vdd_val
br1_l25iso r1_l25_iso 0 V = (v(r1_l25_sel_in_n)-v(r1_l25_samp_tp_n))/vdd_val
* r1_l25: 62.5 ns/cycle (1000 ns/conversion); added delay = 863 ps (measured, #9) + 25 ns (candidate logic delay)
* input ramps one LSB per conversion THROUGH mid-scale
* (codes 507..515), the worst case for a late decision.
vr1_l25in r1_l25_vinp 0 pwl(0 {vcm-4.75*lsbse} 8u {vcm+3.25*lsbse})
vr1_l25cm r1_l25_vinn 0 dc {vcm}
br1_l25exp r1_l25_exp 0 V = min(max(floor(v(r1_l25_shxp)/lsbse),0),1023)
br1_l25err r1_l25_err 0 V = v(r1_l25_drdy)>vth ? v(r1_l25_code)-v(r1_l25_exp) : 0
br1_l25aerr r1_l25_aerr 0 V = abs(v(r1_l25_err))

* ---- loop r1_l55 ----
vr1_l55start r1_l55_start 0 dc 0
vr1_l55mode r1_l55_mode 0 dc 0
xr1_l55 clk_r1 r1_l55_start r1_l55_mode r1_l55_cmpo r1_l55_samp_tp_n
+ r1_l55_sel_in_n r1_l55_drdy r1_l55_c9 r1_l55_c8 r1_l55_c7 r1_l55_c6
+ r1_l55_c5 r1_l55_c4 r1_l55_c3 r1_l55_c2 r1_l55_c1 r1_l55_c0
+ r1_l55_rel_n_256p r1_l55_sel_hi_n_256p r1_l55_sel_lo_n_256p
+ r1_l55_rel_n_128p r1_l55_sel_hi_n_128p r1_l55_sel_lo_n_128p
+ r1_l55_rel_n_64p r1_l55_sel_hi_n_64p r1_l55_sel_lo_n_64p
+ r1_l55_rel_n_32p r1_l55_sel_hi_n_32p r1_l55_sel_lo_n_32p
+ r1_l55_rel_n_16p r1_l55_sel_hi_n_16p r1_l55_sel_lo_n_16p r1_l55_rel_n_8p
+ r1_l55_sel_hi_n_8p r1_l55_sel_lo_n_8p r1_l55_rel_n_4p r1_l55_sel_hi_n_4p
+ r1_l55_sel_lo_n_4p r1_l55_rel_n_2p r1_l55_sel_hi_n_2p r1_l55_sel_lo_n_2p
+ r1_l55_rel_n_1p r1_l55_sel_hi_n_1p r1_l55_sel_lo_n_1p r1_l55_rel_n_256n
+ r1_l55_sel_hi_n_256n r1_l55_sel_lo_n_256n r1_l55_rel_n_128n
+ r1_l55_sel_hi_n_128n r1_l55_sel_lo_n_128n r1_l55_rel_n_64n
+ r1_l55_sel_hi_n_64n r1_l55_sel_lo_n_64n r1_l55_rel_n_32n
+ r1_l55_sel_hi_n_32n r1_l55_sel_lo_n_32n r1_l55_rel_n_16n
+ r1_l55_sel_hi_n_16n r1_l55_sel_lo_n_16n r1_l55_rel_n_8n
+ r1_l55_sel_hi_n_8n r1_l55_sel_lo_n_8n r1_l55_rel_n_4n r1_l55_sel_hi_n_4n
+ r1_l55_sel_lo_n_4n r1_l55_rel_n_2n r1_l55_sel_hi_n_2n r1_l55_sel_lo_n_2n
+ r1_l55_rel_n_1n r1_l55_sel_hi_n_1n r1_l55_sel_lo_n_1n sar_ctrl_a
sr1_l55p r1_l55_vinp r1_l55_shp r1_l55_samp_tp_n 0 sarl_sw
sr1_l55n r1_l55_vinn r1_l55_shn r1_l55_samp_tp_n 0 sarl_sw
cr1_l55p r1_l55_shp 0 1p
cr1_l55n r1_l55_shn 0 1p
rr1_l55sd r1_l55_samp_tp_n r1_l55_sampd 10k
cr1_l55sd r1_l55_sampd 0 1p
sr1_l55xp r1_l55_vinp r1_l55_shxp r1_l55_sampd 0 sarl_sw
sr1_l55xn r1_l55_vinn r1_l55_shxn r1_l55_sampd 0 sarl_sw
cr1_l55xp r1_l55_shxp 0 1p
cr1_l55xn r1_l55_shxn 0 1p
br1_l55topp r1_l55_topip 0 V = 2*vcm-v(r1_l55_shp)+(1.0/512)*(
+ 256*((v(r1_l55_rel_n_256p)*vcm+v(r1_l55_sel_hi_n_256p)*vref+v(r1_l55_sel_in_n)*v(r1_l55_vinp))/vdd_val-vcm) + 128*((v(r1_l55_rel_n_128p)*vcm+v(r1_l55_sel_hi_n_128p)*vref+v(r1_l55_sel_in_n)*v(r1_l55_vinp))/vdd_val-vcm) + 64*((v(r1_l55_rel_n_64p)*vcm+v(r1_l55_sel_hi_n_64p)*vref+v(r1_l55_sel_in_n)*v(r1_l55_vinp))/vdd_val-vcm) + 32*((v(r1_l55_rel_n_32p)*vcm+v(r1_l55_sel_hi_n_32p)*vref+v(r1_l55_sel_in_n)*v(r1_l55_vinp))/vdd_val-vcm) + 16*((v(r1_l55_rel_n_16p)*vcm+v(r1_l55_sel_hi_n_16p)*vref+v(r1_l55_sel_in_n)*v(r1_l55_vinp))/vdd_val-vcm) + 8*((v(r1_l55_rel_n_8p)*vcm+v(r1_l55_sel_hi_n_8p)*vref+v(r1_l55_sel_in_n)*v(r1_l55_vinp))/vdd_val-vcm) + 4*((v(r1_l55_rel_n_4p)*vcm+v(r1_l55_sel_hi_n_4p)*vref+v(r1_l55_sel_in_n)*v(r1_l55_vinp))/vdd_val-vcm) + 2*((v(r1_l55_rel_n_2p)*vcm+v(r1_l55_sel_hi_n_2p)*vref+v(r1_l55_sel_in_n)*v(r1_l55_vinp))/vdd_val-vcm) + 1*((v(r1_l55_rel_n_1p)*vcm+v(r1_l55_sel_hi_n_1p)*vref+v(r1_l55_sel_in_n)*v(r1_l55_vinp))/vdd_val-vcm) )
br1_l55topn r1_l55_topin 0 V = 2*vcm-v(r1_l55_shn)+(1.0/512)*(
+ 256*((v(r1_l55_rel_n_256n)*vcm+v(r1_l55_sel_hi_n_256n)*vref+v(r1_l55_sel_in_n)*v(r1_l55_vinn))/vdd_val-vcm) + 128*((v(r1_l55_rel_n_128n)*vcm+v(r1_l55_sel_hi_n_128n)*vref+v(r1_l55_sel_in_n)*v(r1_l55_vinn))/vdd_val-vcm) + 64*((v(r1_l55_rel_n_64n)*vcm+v(r1_l55_sel_hi_n_64n)*vref+v(r1_l55_sel_in_n)*v(r1_l55_vinn))/vdd_val-vcm) + 32*((v(r1_l55_rel_n_32n)*vcm+v(r1_l55_sel_hi_n_32n)*vref+v(r1_l55_sel_in_n)*v(r1_l55_vinn))/vdd_val-vcm) + 16*((v(r1_l55_rel_n_16n)*vcm+v(r1_l55_sel_hi_n_16n)*vref+v(r1_l55_sel_in_n)*v(r1_l55_vinn))/vdd_val-vcm) + 8*((v(r1_l55_rel_n_8n)*vcm+v(r1_l55_sel_hi_n_8n)*vref+v(r1_l55_sel_in_n)*v(r1_l55_vinn))/vdd_val-vcm) + 4*((v(r1_l55_rel_n_4n)*vcm+v(r1_l55_sel_hi_n_4n)*vref+v(r1_l55_sel_in_n)*v(r1_l55_vinn))/vdd_val-vcm) + 2*((v(r1_l55_rel_n_2n)*vcm+v(r1_l55_sel_hi_n_2n)*vref+v(r1_l55_sel_in_n)*v(r1_l55_vinn))/vdd_val-vcm) + 1*((v(r1_l55_rel_n_1n)*vcm+v(r1_l55_sel_hi_n_1n)*vref+v(r1_l55_sel_in_n)*v(r1_l55_vinn))/vdd_val-vcm) )
rr1_l55p r1_l55_topip r1_l55_topp 570
rr1_l55n r1_l55_topin r1_l55_topn 570
cr1_l55tp r1_l55_topp 0 2.20672p
cr1_l55tn r1_l55_topn 0 2.20672p
br1_l55cmp r1_l55_cmpi 0 V = v(r1_l55_topp) > v(r1_l55_topn) ? vdd_val : 0
tr1_l55d r1_l55_cmpi 0 r1_l55_cmpo 0 z0=50 td=55.863n
rr1_l55term r1_l55_cmpo 0 50
br1_l55code r1_l55_code 0 V =
+ (512)*(v(r1_l55_c9)>vth ? 1 : 0) + (256)*(v(r1_l55_c8)>vth ? 1 : 0) + (128)*(v(r1_l55_c7)>vth ? 1 : 0) + (64)*(v(r1_l55_c6)>vth ? 1 : 0) + (32)*(v(r1_l55_c5)>vth ? 1 : 0) + (16)*(v(r1_l55_c4)>vth ? 1 : 0) + (8)*(v(r1_l55_c3)>vth ? 1 : 0) + (4)*(v(r1_l55_c2)>vth ? 1 : 0) + (2)*(v(r1_l55_c1)>vth ? 1 : 0) + (1)*(v(r1_l55_c0)>vth ? 1 : 0)
br1_l55conf r1_l55_conf 0 V = (
+ abs(v(r1_l55_sel_in_n)+v(r1_l55_rel_n_256p)+v(r1_l55_sel_hi_n_256p)+v(r1_l55_sel_lo_n_256p)-vdd_val) + abs(v(r1_l55_sel_in_n)+v(r1_l55_rel_n_128p)+v(r1_l55_sel_hi_n_128p)+v(r1_l55_sel_lo_n_128p)-vdd_val) + abs(v(r1_l55_sel_in_n)+v(r1_l55_rel_n_64p)+v(r1_l55_sel_hi_n_64p)+v(r1_l55_sel_lo_n_64p)-vdd_val) + abs(v(r1_l55_sel_in_n)+v(r1_l55_rel_n_32p)+v(r1_l55_sel_hi_n_32p)+v(r1_l55_sel_lo_n_32p)-vdd_val) + abs(v(r1_l55_sel_in_n)+v(r1_l55_rel_n_16p)+v(r1_l55_sel_hi_n_16p)+v(r1_l55_sel_lo_n_16p)-vdd_val) + abs(v(r1_l55_sel_in_n)+v(r1_l55_rel_n_8p)+v(r1_l55_sel_hi_n_8p)+v(r1_l55_sel_lo_n_8p)-vdd_val) + abs(v(r1_l55_sel_in_n)+v(r1_l55_rel_n_4p)+v(r1_l55_sel_hi_n_4p)+v(r1_l55_sel_lo_n_4p)-vdd_val) + abs(v(r1_l55_sel_in_n)+v(r1_l55_rel_n_2p)+v(r1_l55_sel_hi_n_2p)+v(r1_l55_sel_lo_n_2p)-vdd_val) + abs(v(r1_l55_sel_in_n)+v(r1_l55_rel_n_1p)+v(r1_l55_sel_hi_n_1p)+v(r1_l55_sel_lo_n_1p)-vdd_val) + abs(v(r1_l55_sel_in_n)+v(r1_l55_rel_n_256n)+v(r1_l55_sel_hi_n_256n)+v(r1_l55_sel_lo_n_256n)-vdd_val) + abs(v(r1_l55_sel_in_n)+v(r1_l55_rel_n_128n)+v(r1_l55_sel_hi_n_128n)+v(r1_l55_sel_lo_n_128n)-vdd_val) + abs(v(r1_l55_sel_in_n)+v(r1_l55_rel_n_64n)+v(r1_l55_sel_hi_n_64n)+v(r1_l55_sel_lo_n_64n)-vdd_val) + abs(v(r1_l55_sel_in_n)+v(r1_l55_rel_n_32n)+v(r1_l55_sel_hi_n_32n)+v(r1_l55_sel_lo_n_32n)-vdd_val) + abs(v(r1_l55_sel_in_n)+v(r1_l55_rel_n_16n)+v(r1_l55_sel_hi_n_16n)+v(r1_l55_sel_lo_n_16n)-vdd_val) + abs(v(r1_l55_sel_in_n)+v(r1_l55_rel_n_8n)+v(r1_l55_sel_hi_n_8n)+v(r1_l55_sel_lo_n_8n)-vdd_val) + abs(v(r1_l55_sel_in_n)+v(r1_l55_rel_n_4n)+v(r1_l55_sel_hi_n_4n)+v(r1_l55_sel_lo_n_4n)-vdd_val) + abs(v(r1_l55_sel_in_n)+v(r1_l55_rel_n_2n)+v(r1_l55_sel_hi_n_2n)+v(r1_l55_sel_lo_n_2n)-vdd_val) + abs(v(r1_l55_sel_in_n)+v(r1_l55_rel_n_1n)+v(r1_l55_sel_hi_n_1n)+v(r1_l55_sel_lo_n_1n)-vdd_val))/vdd_val
br1_l55nside r1_l55_nside 0 V = (
+ v(r1_l55_sel_hi_n_256n)+v(r1_l55_sel_lo_n_256n) + v(r1_l55_sel_hi_n_128n)+v(r1_l55_sel_lo_n_128n) + v(r1_l55_sel_hi_n_64n)+v(r1_l55_sel_lo_n_64n) + v(r1_l55_sel_hi_n_32n)+v(r1_l55_sel_lo_n_32n) + v(r1_l55_sel_hi_n_16n)+v(r1_l55_sel_lo_n_16n) + v(r1_l55_sel_hi_n_8n)+v(r1_l55_sel_lo_n_8n) + v(r1_l55_sel_hi_n_4n)+v(r1_l55_sel_lo_n_4n) + v(r1_l55_sel_hi_n_2n)+v(r1_l55_sel_lo_n_2n) + v(r1_l55_sel_hi_n_1n)+v(r1_l55_sel_lo_n_1n))/vdd_val
br1_l55acq r1_l55_acq 0 V = v(r1_l55_samp_tp_n)/vdd_val
br1_l55iso r1_l55_iso 0 V = (v(r1_l55_sel_in_n)-v(r1_l55_samp_tp_n))/vdd_val
* r1_l55: 62.5 ns/cycle (1000 ns/conversion); added delay = 863 ps (measured, #9) + 55 ns (candidate logic delay)
* input ramps one LSB per conversion THROUGH mid-scale
* (codes 507..515), the worst case for a late decision.
vr1_l55in r1_l55_vinp 0 pwl(0 {vcm-4.75*lsbse} 8u {vcm+3.25*lsbse})
vr1_l55cm r1_l55_vinn 0 dc {vcm}
br1_l55exp r1_l55_exp 0 V = min(max(floor(v(r1_l55_shxp)/lsbse),0),1023)
br1_l55err r1_l55_err 0 V = v(r1_l55_drdy)>vth ? v(r1_l55_code)-v(r1_l55_exp) : 0
br1_l55aerr r1_l55_aerr 0 V = abs(v(r1_l55_err))

* ---- loop r2_l0 ----
vr2_l0start r2_l0_start 0 dc 0
vr2_l0mode r2_l0_mode 0 dc 0
xr2_l0 clk_r2 r2_l0_start r2_l0_mode r2_l0_cmpo r2_l0_samp_tp_n
+ r2_l0_sel_in_n r2_l0_drdy r2_l0_c9 r2_l0_c8 r2_l0_c7 r2_l0_c6 r2_l0_c5
+ r2_l0_c4 r2_l0_c3 r2_l0_c2 r2_l0_c1 r2_l0_c0 r2_l0_rel_n_256p
+ r2_l0_sel_hi_n_256p r2_l0_sel_lo_n_256p r2_l0_rel_n_128p
+ r2_l0_sel_hi_n_128p r2_l0_sel_lo_n_128p r2_l0_rel_n_64p
+ r2_l0_sel_hi_n_64p r2_l0_sel_lo_n_64p r2_l0_rel_n_32p r2_l0_sel_hi_n_32p
+ r2_l0_sel_lo_n_32p r2_l0_rel_n_16p r2_l0_sel_hi_n_16p r2_l0_sel_lo_n_16p
+ r2_l0_rel_n_8p r2_l0_sel_hi_n_8p r2_l0_sel_lo_n_8p r2_l0_rel_n_4p
+ r2_l0_sel_hi_n_4p r2_l0_sel_lo_n_4p r2_l0_rel_n_2p r2_l0_sel_hi_n_2p
+ r2_l0_sel_lo_n_2p r2_l0_rel_n_1p r2_l0_sel_hi_n_1p r2_l0_sel_lo_n_1p
+ r2_l0_rel_n_256n r2_l0_sel_hi_n_256n r2_l0_sel_lo_n_256n
+ r2_l0_rel_n_128n r2_l0_sel_hi_n_128n r2_l0_sel_lo_n_128n r2_l0_rel_n_64n
+ r2_l0_sel_hi_n_64n r2_l0_sel_lo_n_64n r2_l0_rel_n_32n r2_l0_sel_hi_n_32n
+ r2_l0_sel_lo_n_32n r2_l0_rel_n_16n r2_l0_sel_hi_n_16n r2_l0_sel_lo_n_16n
+ r2_l0_rel_n_8n r2_l0_sel_hi_n_8n r2_l0_sel_lo_n_8n r2_l0_rel_n_4n
+ r2_l0_sel_hi_n_4n r2_l0_sel_lo_n_4n r2_l0_rel_n_2n r2_l0_sel_hi_n_2n
+ r2_l0_sel_lo_n_2n r2_l0_rel_n_1n r2_l0_sel_hi_n_1n r2_l0_sel_lo_n_1n
+ sar_ctrl_a
sr2_l0p r2_l0_vinp r2_l0_shp r2_l0_samp_tp_n 0 sarl_sw
sr2_l0n r2_l0_vinn r2_l0_shn r2_l0_samp_tp_n 0 sarl_sw
cr2_l0p r2_l0_shp 0 1p
cr2_l0n r2_l0_shn 0 1p
rr2_l0sd r2_l0_samp_tp_n r2_l0_sampd 10k
cr2_l0sd r2_l0_sampd 0 1p
sr2_l0xp r2_l0_vinp r2_l0_shxp r2_l0_sampd 0 sarl_sw
sr2_l0xn r2_l0_vinn r2_l0_shxn r2_l0_sampd 0 sarl_sw
cr2_l0xp r2_l0_shxp 0 1p
cr2_l0xn r2_l0_shxn 0 1p
br2_l0topp r2_l0_topip 0 V = 2*vcm-v(r2_l0_shp)+(1.0/512)*(
+ 256*((v(r2_l0_rel_n_256p)*vcm+v(r2_l0_sel_hi_n_256p)*vref+v(r2_l0_sel_in_n)*v(r2_l0_vinp))/vdd_val-vcm) + 128*((v(r2_l0_rel_n_128p)*vcm+v(r2_l0_sel_hi_n_128p)*vref+v(r2_l0_sel_in_n)*v(r2_l0_vinp))/vdd_val-vcm) + 64*((v(r2_l0_rel_n_64p)*vcm+v(r2_l0_sel_hi_n_64p)*vref+v(r2_l0_sel_in_n)*v(r2_l0_vinp))/vdd_val-vcm) + 32*((v(r2_l0_rel_n_32p)*vcm+v(r2_l0_sel_hi_n_32p)*vref+v(r2_l0_sel_in_n)*v(r2_l0_vinp))/vdd_val-vcm) + 16*((v(r2_l0_rel_n_16p)*vcm+v(r2_l0_sel_hi_n_16p)*vref+v(r2_l0_sel_in_n)*v(r2_l0_vinp))/vdd_val-vcm) + 8*((v(r2_l0_rel_n_8p)*vcm+v(r2_l0_sel_hi_n_8p)*vref+v(r2_l0_sel_in_n)*v(r2_l0_vinp))/vdd_val-vcm) + 4*((v(r2_l0_rel_n_4p)*vcm+v(r2_l0_sel_hi_n_4p)*vref+v(r2_l0_sel_in_n)*v(r2_l0_vinp))/vdd_val-vcm) + 2*((v(r2_l0_rel_n_2p)*vcm+v(r2_l0_sel_hi_n_2p)*vref+v(r2_l0_sel_in_n)*v(r2_l0_vinp))/vdd_val-vcm) + 1*((v(r2_l0_rel_n_1p)*vcm+v(r2_l0_sel_hi_n_1p)*vref+v(r2_l0_sel_in_n)*v(r2_l0_vinp))/vdd_val-vcm) )
br2_l0topn r2_l0_topin 0 V = 2*vcm-v(r2_l0_shn)+(1.0/512)*(
+ 256*((v(r2_l0_rel_n_256n)*vcm+v(r2_l0_sel_hi_n_256n)*vref+v(r2_l0_sel_in_n)*v(r2_l0_vinn))/vdd_val-vcm) + 128*((v(r2_l0_rel_n_128n)*vcm+v(r2_l0_sel_hi_n_128n)*vref+v(r2_l0_sel_in_n)*v(r2_l0_vinn))/vdd_val-vcm) + 64*((v(r2_l0_rel_n_64n)*vcm+v(r2_l0_sel_hi_n_64n)*vref+v(r2_l0_sel_in_n)*v(r2_l0_vinn))/vdd_val-vcm) + 32*((v(r2_l0_rel_n_32n)*vcm+v(r2_l0_sel_hi_n_32n)*vref+v(r2_l0_sel_in_n)*v(r2_l0_vinn))/vdd_val-vcm) + 16*((v(r2_l0_rel_n_16n)*vcm+v(r2_l0_sel_hi_n_16n)*vref+v(r2_l0_sel_in_n)*v(r2_l0_vinn))/vdd_val-vcm) + 8*((v(r2_l0_rel_n_8n)*vcm+v(r2_l0_sel_hi_n_8n)*vref+v(r2_l0_sel_in_n)*v(r2_l0_vinn))/vdd_val-vcm) + 4*((v(r2_l0_rel_n_4n)*vcm+v(r2_l0_sel_hi_n_4n)*vref+v(r2_l0_sel_in_n)*v(r2_l0_vinn))/vdd_val-vcm) + 2*((v(r2_l0_rel_n_2n)*vcm+v(r2_l0_sel_hi_n_2n)*vref+v(r2_l0_sel_in_n)*v(r2_l0_vinn))/vdd_val-vcm) + 1*((v(r2_l0_rel_n_1n)*vcm+v(r2_l0_sel_hi_n_1n)*vref+v(r2_l0_sel_in_n)*v(r2_l0_vinn))/vdd_val-vcm) )
rr2_l0p r2_l0_topip r2_l0_topp 570
rr2_l0n r2_l0_topin r2_l0_topn 570
cr2_l0tp r2_l0_topp 0 2.20672p
cr2_l0tn r2_l0_topn 0 2.20672p
br2_l0cmp r2_l0_cmpi 0 V = v(r2_l0_topp) > v(r2_l0_topn) ? vdd_val : 0
tr2_l0d r2_l0_cmpi 0 r2_l0_cmpo 0 z0=50 td=0.863n
rr2_l0term r2_l0_cmpo 0 50
br2_l0code r2_l0_code 0 V =
+ (512)*(v(r2_l0_c9)>vth ? 1 : 0) + (256)*(v(r2_l0_c8)>vth ? 1 : 0) + (128)*(v(r2_l0_c7)>vth ? 1 : 0) + (64)*(v(r2_l0_c6)>vth ? 1 : 0) + (32)*(v(r2_l0_c5)>vth ? 1 : 0) + (16)*(v(r2_l0_c4)>vth ? 1 : 0) + (8)*(v(r2_l0_c3)>vth ? 1 : 0) + (4)*(v(r2_l0_c2)>vth ? 1 : 0) + (2)*(v(r2_l0_c1)>vth ? 1 : 0) + (1)*(v(r2_l0_c0)>vth ? 1 : 0)
br2_l0conf r2_l0_conf 0 V = (
+ abs(v(r2_l0_sel_in_n)+v(r2_l0_rel_n_256p)+v(r2_l0_sel_hi_n_256p)+v(r2_l0_sel_lo_n_256p)-vdd_val) + abs(v(r2_l0_sel_in_n)+v(r2_l0_rel_n_128p)+v(r2_l0_sel_hi_n_128p)+v(r2_l0_sel_lo_n_128p)-vdd_val) + abs(v(r2_l0_sel_in_n)+v(r2_l0_rel_n_64p)+v(r2_l0_sel_hi_n_64p)+v(r2_l0_sel_lo_n_64p)-vdd_val) + abs(v(r2_l0_sel_in_n)+v(r2_l0_rel_n_32p)+v(r2_l0_sel_hi_n_32p)+v(r2_l0_sel_lo_n_32p)-vdd_val) + abs(v(r2_l0_sel_in_n)+v(r2_l0_rel_n_16p)+v(r2_l0_sel_hi_n_16p)+v(r2_l0_sel_lo_n_16p)-vdd_val) + abs(v(r2_l0_sel_in_n)+v(r2_l0_rel_n_8p)+v(r2_l0_sel_hi_n_8p)+v(r2_l0_sel_lo_n_8p)-vdd_val) + abs(v(r2_l0_sel_in_n)+v(r2_l0_rel_n_4p)+v(r2_l0_sel_hi_n_4p)+v(r2_l0_sel_lo_n_4p)-vdd_val) + abs(v(r2_l0_sel_in_n)+v(r2_l0_rel_n_2p)+v(r2_l0_sel_hi_n_2p)+v(r2_l0_sel_lo_n_2p)-vdd_val) + abs(v(r2_l0_sel_in_n)+v(r2_l0_rel_n_1p)+v(r2_l0_sel_hi_n_1p)+v(r2_l0_sel_lo_n_1p)-vdd_val) + abs(v(r2_l0_sel_in_n)+v(r2_l0_rel_n_256n)+v(r2_l0_sel_hi_n_256n)+v(r2_l0_sel_lo_n_256n)-vdd_val) + abs(v(r2_l0_sel_in_n)+v(r2_l0_rel_n_128n)+v(r2_l0_sel_hi_n_128n)+v(r2_l0_sel_lo_n_128n)-vdd_val) + abs(v(r2_l0_sel_in_n)+v(r2_l0_rel_n_64n)+v(r2_l0_sel_hi_n_64n)+v(r2_l0_sel_lo_n_64n)-vdd_val) + abs(v(r2_l0_sel_in_n)+v(r2_l0_rel_n_32n)+v(r2_l0_sel_hi_n_32n)+v(r2_l0_sel_lo_n_32n)-vdd_val) + abs(v(r2_l0_sel_in_n)+v(r2_l0_rel_n_16n)+v(r2_l0_sel_hi_n_16n)+v(r2_l0_sel_lo_n_16n)-vdd_val) + abs(v(r2_l0_sel_in_n)+v(r2_l0_rel_n_8n)+v(r2_l0_sel_hi_n_8n)+v(r2_l0_sel_lo_n_8n)-vdd_val) + abs(v(r2_l0_sel_in_n)+v(r2_l0_rel_n_4n)+v(r2_l0_sel_hi_n_4n)+v(r2_l0_sel_lo_n_4n)-vdd_val) + abs(v(r2_l0_sel_in_n)+v(r2_l0_rel_n_2n)+v(r2_l0_sel_hi_n_2n)+v(r2_l0_sel_lo_n_2n)-vdd_val) + abs(v(r2_l0_sel_in_n)+v(r2_l0_rel_n_1n)+v(r2_l0_sel_hi_n_1n)+v(r2_l0_sel_lo_n_1n)-vdd_val))/vdd_val
br2_l0nside r2_l0_nside 0 V = (
+ v(r2_l0_sel_hi_n_256n)+v(r2_l0_sel_lo_n_256n) + v(r2_l0_sel_hi_n_128n)+v(r2_l0_sel_lo_n_128n) + v(r2_l0_sel_hi_n_64n)+v(r2_l0_sel_lo_n_64n) + v(r2_l0_sel_hi_n_32n)+v(r2_l0_sel_lo_n_32n) + v(r2_l0_sel_hi_n_16n)+v(r2_l0_sel_lo_n_16n) + v(r2_l0_sel_hi_n_8n)+v(r2_l0_sel_lo_n_8n) + v(r2_l0_sel_hi_n_4n)+v(r2_l0_sel_lo_n_4n) + v(r2_l0_sel_hi_n_2n)+v(r2_l0_sel_lo_n_2n) + v(r2_l0_sel_hi_n_1n)+v(r2_l0_sel_lo_n_1n))/vdd_val
br2_l0acq r2_l0_acq 0 V = v(r2_l0_samp_tp_n)/vdd_val
br2_l0iso r2_l0_iso 0 V = (v(r2_l0_sel_in_n)-v(r2_l0_samp_tp_n))/vdd_val
* r2_l0: 31.25 ns/cycle (500 ns/conversion); added delay = 863 ps (measured, #9) + 0 ns (candidate logic delay)
* input ramps one LSB per conversion THROUGH mid-scale
* (codes 507..515), the worst case for a late decision.
vr2_l0in r2_l0_vinp 0 pwl(0 {vcm-4.75*lsbse} 8u {vcm+3.25*lsbse})
vr2_l0cm r2_l0_vinn 0 dc {vcm}
br2_l0exp r2_l0_exp 0 V = min(max(floor(v(r2_l0_shxp)/lsbse),0),1023)
br2_l0err r2_l0_err 0 V = v(r2_l0_drdy)>vth ? v(r2_l0_code)-v(r2_l0_exp) : 0
br2_l0aerr r2_l0_aerr 0 V = abs(v(r2_l0_err))

* ---- loop r2_l10 ----
vr2_l10start r2_l10_start 0 dc 0
vr2_l10mode r2_l10_mode 0 dc 0
xr2_l10 clk_r2 r2_l10_start r2_l10_mode r2_l10_cmpo r2_l10_samp_tp_n
+ r2_l10_sel_in_n r2_l10_drdy r2_l10_c9 r2_l10_c8 r2_l10_c7 r2_l10_c6
+ r2_l10_c5 r2_l10_c4 r2_l10_c3 r2_l10_c2 r2_l10_c1 r2_l10_c0
+ r2_l10_rel_n_256p r2_l10_sel_hi_n_256p r2_l10_sel_lo_n_256p
+ r2_l10_rel_n_128p r2_l10_sel_hi_n_128p r2_l10_sel_lo_n_128p
+ r2_l10_rel_n_64p r2_l10_sel_hi_n_64p r2_l10_sel_lo_n_64p
+ r2_l10_rel_n_32p r2_l10_sel_hi_n_32p r2_l10_sel_lo_n_32p
+ r2_l10_rel_n_16p r2_l10_sel_hi_n_16p r2_l10_sel_lo_n_16p r2_l10_rel_n_8p
+ r2_l10_sel_hi_n_8p r2_l10_sel_lo_n_8p r2_l10_rel_n_4p r2_l10_sel_hi_n_4p
+ r2_l10_sel_lo_n_4p r2_l10_rel_n_2p r2_l10_sel_hi_n_2p r2_l10_sel_lo_n_2p
+ r2_l10_rel_n_1p r2_l10_sel_hi_n_1p r2_l10_sel_lo_n_1p r2_l10_rel_n_256n
+ r2_l10_sel_hi_n_256n r2_l10_sel_lo_n_256n r2_l10_rel_n_128n
+ r2_l10_sel_hi_n_128n r2_l10_sel_lo_n_128n r2_l10_rel_n_64n
+ r2_l10_sel_hi_n_64n r2_l10_sel_lo_n_64n r2_l10_rel_n_32n
+ r2_l10_sel_hi_n_32n r2_l10_sel_lo_n_32n r2_l10_rel_n_16n
+ r2_l10_sel_hi_n_16n r2_l10_sel_lo_n_16n r2_l10_rel_n_8n
+ r2_l10_sel_hi_n_8n r2_l10_sel_lo_n_8n r2_l10_rel_n_4n r2_l10_sel_hi_n_4n
+ r2_l10_sel_lo_n_4n r2_l10_rel_n_2n r2_l10_sel_hi_n_2n r2_l10_sel_lo_n_2n
+ r2_l10_rel_n_1n r2_l10_sel_hi_n_1n r2_l10_sel_lo_n_1n sar_ctrl_a
sr2_l10p r2_l10_vinp r2_l10_shp r2_l10_samp_tp_n 0 sarl_sw
sr2_l10n r2_l10_vinn r2_l10_shn r2_l10_samp_tp_n 0 sarl_sw
cr2_l10p r2_l10_shp 0 1p
cr2_l10n r2_l10_shn 0 1p
rr2_l10sd r2_l10_samp_tp_n r2_l10_sampd 10k
cr2_l10sd r2_l10_sampd 0 1p
sr2_l10xp r2_l10_vinp r2_l10_shxp r2_l10_sampd 0 sarl_sw
sr2_l10xn r2_l10_vinn r2_l10_shxn r2_l10_sampd 0 sarl_sw
cr2_l10xp r2_l10_shxp 0 1p
cr2_l10xn r2_l10_shxn 0 1p
br2_l10topp r2_l10_topip 0 V = 2*vcm-v(r2_l10_shp)+(1.0/512)*(
+ 256*((v(r2_l10_rel_n_256p)*vcm+v(r2_l10_sel_hi_n_256p)*vref+v(r2_l10_sel_in_n)*v(r2_l10_vinp))/vdd_val-vcm) + 128*((v(r2_l10_rel_n_128p)*vcm+v(r2_l10_sel_hi_n_128p)*vref+v(r2_l10_sel_in_n)*v(r2_l10_vinp))/vdd_val-vcm) + 64*((v(r2_l10_rel_n_64p)*vcm+v(r2_l10_sel_hi_n_64p)*vref+v(r2_l10_sel_in_n)*v(r2_l10_vinp))/vdd_val-vcm) + 32*((v(r2_l10_rel_n_32p)*vcm+v(r2_l10_sel_hi_n_32p)*vref+v(r2_l10_sel_in_n)*v(r2_l10_vinp))/vdd_val-vcm) + 16*((v(r2_l10_rel_n_16p)*vcm+v(r2_l10_sel_hi_n_16p)*vref+v(r2_l10_sel_in_n)*v(r2_l10_vinp))/vdd_val-vcm) + 8*((v(r2_l10_rel_n_8p)*vcm+v(r2_l10_sel_hi_n_8p)*vref+v(r2_l10_sel_in_n)*v(r2_l10_vinp))/vdd_val-vcm) + 4*((v(r2_l10_rel_n_4p)*vcm+v(r2_l10_sel_hi_n_4p)*vref+v(r2_l10_sel_in_n)*v(r2_l10_vinp))/vdd_val-vcm) + 2*((v(r2_l10_rel_n_2p)*vcm+v(r2_l10_sel_hi_n_2p)*vref+v(r2_l10_sel_in_n)*v(r2_l10_vinp))/vdd_val-vcm) + 1*((v(r2_l10_rel_n_1p)*vcm+v(r2_l10_sel_hi_n_1p)*vref+v(r2_l10_sel_in_n)*v(r2_l10_vinp))/vdd_val-vcm) )
br2_l10topn r2_l10_topin 0 V = 2*vcm-v(r2_l10_shn)+(1.0/512)*(
+ 256*((v(r2_l10_rel_n_256n)*vcm+v(r2_l10_sel_hi_n_256n)*vref+v(r2_l10_sel_in_n)*v(r2_l10_vinn))/vdd_val-vcm) + 128*((v(r2_l10_rel_n_128n)*vcm+v(r2_l10_sel_hi_n_128n)*vref+v(r2_l10_sel_in_n)*v(r2_l10_vinn))/vdd_val-vcm) + 64*((v(r2_l10_rel_n_64n)*vcm+v(r2_l10_sel_hi_n_64n)*vref+v(r2_l10_sel_in_n)*v(r2_l10_vinn))/vdd_val-vcm) + 32*((v(r2_l10_rel_n_32n)*vcm+v(r2_l10_sel_hi_n_32n)*vref+v(r2_l10_sel_in_n)*v(r2_l10_vinn))/vdd_val-vcm) + 16*((v(r2_l10_rel_n_16n)*vcm+v(r2_l10_sel_hi_n_16n)*vref+v(r2_l10_sel_in_n)*v(r2_l10_vinn))/vdd_val-vcm) + 8*((v(r2_l10_rel_n_8n)*vcm+v(r2_l10_sel_hi_n_8n)*vref+v(r2_l10_sel_in_n)*v(r2_l10_vinn))/vdd_val-vcm) + 4*((v(r2_l10_rel_n_4n)*vcm+v(r2_l10_sel_hi_n_4n)*vref+v(r2_l10_sel_in_n)*v(r2_l10_vinn))/vdd_val-vcm) + 2*((v(r2_l10_rel_n_2n)*vcm+v(r2_l10_sel_hi_n_2n)*vref+v(r2_l10_sel_in_n)*v(r2_l10_vinn))/vdd_val-vcm) + 1*((v(r2_l10_rel_n_1n)*vcm+v(r2_l10_sel_hi_n_1n)*vref+v(r2_l10_sel_in_n)*v(r2_l10_vinn))/vdd_val-vcm) )
rr2_l10p r2_l10_topip r2_l10_topp 570
rr2_l10n r2_l10_topin r2_l10_topn 570
cr2_l10tp r2_l10_topp 0 2.20672p
cr2_l10tn r2_l10_topn 0 2.20672p
br2_l10cmp r2_l10_cmpi 0 V = v(r2_l10_topp) > v(r2_l10_topn) ? vdd_val : 0
tr2_l10d r2_l10_cmpi 0 r2_l10_cmpo 0 z0=50 td=10.863n
rr2_l10term r2_l10_cmpo 0 50
br2_l10code r2_l10_code 0 V =
+ (512)*(v(r2_l10_c9)>vth ? 1 : 0) + (256)*(v(r2_l10_c8)>vth ? 1 : 0) + (128)*(v(r2_l10_c7)>vth ? 1 : 0) + (64)*(v(r2_l10_c6)>vth ? 1 : 0) + (32)*(v(r2_l10_c5)>vth ? 1 : 0) + (16)*(v(r2_l10_c4)>vth ? 1 : 0) + (8)*(v(r2_l10_c3)>vth ? 1 : 0) + (4)*(v(r2_l10_c2)>vth ? 1 : 0) + (2)*(v(r2_l10_c1)>vth ? 1 : 0) + (1)*(v(r2_l10_c0)>vth ? 1 : 0)
br2_l10conf r2_l10_conf 0 V = (
+ abs(v(r2_l10_sel_in_n)+v(r2_l10_rel_n_256p)+v(r2_l10_sel_hi_n_256p)+v(r2_l10_sel_lo_n_256p)-vdd_val) + abs(v(r2_l10_sel_in_n)+v(r2_l10_rel_n_128p)+v(r2_l10_sel_hi_n_128p)+v(r2_l10_sel_lo_n_128p)-vdd_val) + abs(v(r2_l10_sel_in_n)+v(r2_l10_rel_n_64p)+v(r2_l10_sel_hi_n_64p)+v(r2_l10_sel_lo_n_64p)-vdd_val) + abs(v(r2_l10_sel_in_n)+v(r2_l10_rel_n_32p)+v(r2_l10_sel_hi_n_32p)+v(r2_l10_sel_lo_n_32p)-vdd_val) + abs(v(r2_l10_sel_in_n)+v(r2_l10_rel_n_16p)+v(r2_l10_sel_hi_n_16p)+v(r2_l10_sel_lo_n_16p)-vdd_val) + abs(v(r2_l10_sel_in_n)+v(r2_l10_rel_n_8p)+v(r2_l10_sel_hi_n_8p)+v(r2_l10_sel_lo_n_8p)-vdd_val) + abs(v(r2_l10_sel_in_n)+v(r2_l10_rel_n_4p)+v(r2_l10_sel_hi_n_4p)+v(r2_l10_sel_lo_n_4p)-vdd_val) + abs(v(r2_l10_sel_in_n)+v(r2_l10_rel_n_2p)+v(r2_l10_sel_hi_n_2p)+v(r2_l10_sel_lo_n_2p)-vdd_val) + abs(v(r2_l10_sel_in_n)+v(r2_l10_rel_n_1p)+v(r2_l10_sel_hi_n_1p)+v(r2_l10_sel_lo_n_1p)-vdd_val) + abs(v(r2_l10_sel_in_n)+v(r2_l10_rel_n_256n)+v(r2_l10_sel_hi_n_256n)+v(r2_l10_sel_lo_n_256n)-vdd_val) + abs(v(r2_l10_sel_in_n)+v(r2_l10_rel_n_128n)+v(r2_l10_sel_hi_n_128n)+v(r2_l10_sel_lo_n_128n)-vdd_val) + abs(v(r2_l10_sel_in_n)+v(r2_l10_rel_n_64n)+v(r2_l10_sel_hi_n_64n)+v(r2_l10_sel_lo_n_64n)-vdd_val) + abs(v(r2_l10_sel_in_n)+v(r2_l10_rel_n_32n)+v(r2_l10_sel_hi_n_32n)+v(r2_l10_sel_lo_n_32n)-vdd_val) + abs(v(r2_l10_sel_in_n)+v(r2_l10_rel_n_16n)+v(r2_l10_sel_hi_n_16n)+v(r2_l10_sel_lo_n_16n)-vdd_val) + abs(v(r2_l10_sel_in_n)+v(r2_l10_rel_n_8n)+v(r2_l10_sel_hi_n_8n)+v(r2_l10_sel_lo_n_8n)-vdd_val) + abs(v(r2_l10_sel_in_n)+v(r2_l10_rel_n_4n)+v(r2_l10_sel_hi_n_4n)+v(r2_l10_sel_lo_n_4n)-vdd_val) + abs(v(r2_l10_sel_in_n)+v(r2_l10_rel_n_2n)+v(r2_l10_sel_hi_n_2n)+v(r2_l10_sel_lo_n_2n)-vdd_val) + abs(v(r2_l10_sel_in_n)+v(r2_l10_rel_n_1n)+v(r2_l10_sel_hi_n_1n)+v(r2_l10_sel_lo_n_1n)-vdd_val))/vdd_val
br2_l10nside r2_l10_nside 0 V = (
+ v(r2_l10_sel_hi_n_256n)+v(r2_l10_sel_lo_n_256n) + v(r2_l10_sel_hi_n_128n)+v(r2_l10_sel_lo_n_128n) + v(r2_l10_sel_hi_n_64n)+v(r2_l10_sel_lo_n_64n) + v(r2_l10_sel_hi_n_32n)+v(r2_l10_sel_lo_n_32n) + v(r2_l10_sel_hi_n_16n)+v(r2_l10_sel_lo_n_16n) + v(r2_l10_sel_hi_n_8n)+v(r2_l10_sel_lo_n_8n) + v(r2_l10_sel_hi_n_4n)+v(r2_l10_sel_lo_n_4n) + v(r2_l10_sel_hi_n_2n)+v(r2_l10_sel_lo_n_2n) + v(r2_l10_sel_hi_n_1n)+v(r2_l10_sel_lo_n_1n))/vdd_val
br2_l10acq r2_l10_acq 0 V = v(r2_l10_samp_tp_n)/vdd_val
br2_l10iso r2_l10_iso 0 V = (v(r2_l10_sel_in_n)-v(r2_l10_samp_tp_n))/vdd_val
* r2_l10: 31.25 ns/cycle (500 ns/conversion); added delay = 863 ps (measured, #9) + 10 ns (candidate logic delay)
* input ramps one LSB per conversion THROUGH mid-scale
* (codes 507..515), the worst case for a late decision.
vr2_l10in r2_l10_vinp 0 pwl(0 {vcm-4.75*lsbse} 8u {vcm+3.25*lsbse})
vr2_l10cm r2_l10_vinn 0 dc {vcm}
br2_l10exp r2_l10_exp 0 V = min(max(floor(v(r2_l10_shxp)/lsbse),0),1023)
br2_l10err r2_l10_err 0 V = v(r2_l10_drdy)>vth ? v(r2_l10_code)-v(r2_l10_exp) : 0
br2_l10aerr r2_l10_aerr 0 V = abs(v(r2_l10_err))

* ---- loop r2_l25 ----
vr2_l25start r2_l25_start 0 dc 0
vr2_l25mode r2_l25_mode 0 dc 0
xr2_l25 clk_r2 r2_l25_start r2_l25_mode r2_l25_cmpo r2_l25_samp_tp_n
+ r2_l25_sel_in_n r2_l25_drdy r2_l25_c9 r2_l25_c8 r2_l25_c7 r2_l25_c6
+ r2_l25_c5 r2_l25_c4 r2_l25_c3 r2_l25_c2 r2_l25_c1 r2_l25_c0
+ r2_l25_rel_n_256p r2_l25_sel_hi_n_256p r2_l25_sel_lo_n_256p
+ r2_l25_rel_n_128p r2_l25_sel_hi_n_128p r2_l25_sel_lo_n_128p
+ r2_l25_rel_n_64p r2_l25_sel_hi_n_64p r2_l25_sel_lo_n_64p
+ r2_l25_rel_n_32p r2_l25_sel_hi_n_32p r2_l25_sel_lo_n_32p
+ r2_l25_rel_n_16p r2_l25_sel_hi_n_16p r2_l25_sel_lo_n_16p r2_l25_rel_n_8p
+ r2_l25_sel_hi_n_8p r2_l25_sel_lo_n_8p r2_l25_rel_n_4p r2_l25_sel_hi_n_4p
+ r2_l25_sel_lo_n_4p r2_l25_rel_n_2p r2_l25_sel_hi_n_2p r2_l25_sel_lo_n_2p
+ r2_l25_rel_n_1p r2_l25_sel_hi_n_1p r2_l25_sel_lo_n_1p r2_l25_rel_n_256n
+ r2_l25_sel_hi_n_256n r2_l25_sel_lo_n_256n r2_l25_rel_n_128n
+ r2_l25_sel_hi_n_128n r2_l25_sel_lo_n_128n r2_l25_rel_n_64n
+ r2_l25_sel_hi_n_64n r2_l25_sel_lo_n_64n r2_l25_rel_n_32n
+ r2_l25_sel_hi_n_32n r2_l25_sel_lo_n_32n r2_l25_rel_n_16n
+ r2_l25_sel_hi_n_16n r2_l25_sel_lo_n_16n r2_l25_rel_n_8n
+ r2_l25_sel_hi_n_8n r2_l25_sel_lo_n_8n r2_l25_rel_n_4n r2_l25_sel_hi_n_4n
+ r2_l25_sel_lo_n_4n r2_l25_rel_n_2n r2_l25_sel_hi_n_2n r2_l25_sel_lo_n_2n
+ r2_l25_rel_n_1n r2_l25_sel_hi_n_1n r2_l25_sel_lo_n_1n sar_ctrl_a
sr2_l25p r2_l25_vinp r2_l25_shp r2_l25_samp_tp_n 0 sarl_sw
sr2_l25n r2_l25_vinn r2_l25_shn r2_l25_samp_tp_n 0 sarl_sw
cr2_l25p r2_l25_shp 0 1p
cr2_l25n r2_l25_shn 0 1p
rr2_l25sd r2_l25_samp_tp_n r2_l25_sampd 10k
cr2_l25sd r2_l25_sampd 0 1p
sr2_l25xp r2_l25_vinp r2_l25_shxp r2_l25_sampd 0 sarl_sw
sr2_l25xn r2_l25_vinn r2_l25_shxn r2_l25_sampd 0 sarl_sw
cr2_l25xp r2_l25_shxp 0 1p
cr2_l25xn r2_l25_shxn 0 1p
br2_l25topp r2_l25_topip 0 V = 2*vcm-v(r2_l25_shp)+(1.0/512)*(
+ 256*((v(r2_l25_rel_n_256p)*vcm+v(r2_l25_sel_hi_n_256p)*vref+v(r2_l25_sel_in_n)*v(r2_l25_vinp))/vdd_val-vcm) + 128*((v(r2_l25_rel_n_128p)*vcm+v(r2_l25_sel_hi_n_128p)*vref+v(r2_l25_sel_in_n)*v(r2_l25_vinp))/vdd_val-vcm) + 64*((v(r2_l25_rel_n_64p)*vcm+v(r2_l25_sel_hi_n_64p)*vref+v(r2_l25_sel_in_n)*v(r2_l25_vinp))/vdd_val-vcm) + 32*((v(r2_l25_rel_n_32p)*vcm+v(r2_l25_sel_hi_n_32p)*vref+v(r2_l25_sel_in_n)*v(r2_l25_vinp))/vdd_val-vcm) + 16*((v(r2_l25_rel_n_16p)*vcm+v(r2_l25_sel_hi_n_16p)*vref+v(r2_l25_sel_in_n)*v(r2_l25_vinp))/vdd_val-vcm) + 8*((v(r2_l25_rel_n_8p)*vcm+v(r2_l25_sel_hi_n_8p)*vref+v(r2_l25_sel_in_n)*v(r2_l25_vinp))/vdd_val-vcm) + 4*((v(r2_l25_rel_n_4p)*vcm+v(r2_l25_sel_hi_n_4p)*vref+v(r2_l25_sel_in_n)*v(r2_l25_vinp))/vdd_val-vcm) + 2*((v(r2_l25_rel_n_2p)*vcm+v(r2_l25_sel_hi_n_2p)*vref+v(r2_l25_sel_in_n)*v(r2_l25_vinp))/vdd_val-vcm) + 1*((v(r2_l25_rel_n_1p)*vcm+v(r2_l25_sel_hi_n_1p)*vref+v(r2_l25_sel_in_n)*v(r2_l25_vinp))/vdd_val-vcm) )
br2_l25topn r2_l25_topin 0 V = 2*vcm-v(r2_l25_shn)+(1.0/512)*(
+ 256*((v(r2_l25_rel_n_256n)*vcm+v(r2_l25_sel_hi_n_256n)*vref+v(r2_l25_sel_in_n)*v(r2_l25_vinn))/vdd_val-vcm) + 128*((v(r2_l25_rel_n_128n)*vcm+v(r2_l25_sel_hi_n_128n)*vref+v(r2_l25_sel_in_n)*v(r2_l25_vinn))/vdd_val-vcm) + 64*((v(r2_l25_rel_n_64n)*vcm+v(r2_l25_sel_hi_n_64n)*vref+v(r2_l25_sel_in_n)*v(r2_l25_vinn))/vdd_val-vcm) + 32*((v(r2_l25_rel_n_32n)*vcm+v(r2_l25_sel_hi_n_32n)*vref+v(r2_l25_sel_in_n)*v(r2_l25_vinn))/vdd_val-vcm) + 16*((v(r2_l25_rel_n_16n)*vcm+v(r2_l25_sel_hi_n_16n)*vref+v(r2_l25_sel_in_n)*v(r2_l25_vinn))/vdd_val-vcm) + 8*((v(r2_l25_rel_n_8n)*vcm+v(r2_l25_sel_hi_n_8n)*vref+v(r2_l25_sel_in_n)*v(r2_l25_vinn))/vdd_val-vcm) + 4*((v(r2_l25_rel_n_4n)*vcm+v(r2_l25_sel_hi_n_4n)*vref+v(r2_l25_sel_in_n)*v(r2_l25_vinn))/vdd_val-vcm) + 2*((v(r2_l25_rel_n_2n)*vcm+v(r2_l25_sel_hi_n_2n)*vref+v(r2_l25_sel_in_n)*v(r2_l25_vinn))/vdd_val-vcm) + 1*((v(r2_l25_rel_n_1n)*vcm+v(r2_l25_sel_hi_n_1n)*vref+v(r2_l25_sel_in_n)*v(r2_l25_vinn))/vdd_val-vcm) )
rr2_l25p r2_l25_topip r2_l25_topp 570
rr2_l25n r2_l25_topin r2_l25_topn 570
cr2_l25tp r2_l25_topp 0 2.20672p
cr2_l25tn r2_l25_topn 0 2.20672p
br2_l25cmp r2_l25_cmpi 0 V = v(r2_l25_topp) > v(r2_l25_topn) ? vdd_val : 0
tr2_l25d r2_l25_cmpi 0 r2_l25_cmpo 0 z0=50 td=25.863n
rr2_l25term r2_l25_cmpo 0 50
br2_l25code r2_l25_code 0 V =
+ (512)*(v(r2_l25_c9)>vth ? 1 : 0) + (256)*(v(r2_l25_c8)>vth ? 1 : 0) + (128)*(v(r2_l25_c7)>vth ? 1 : 0) + (64)*(v(r2_l25_c6)>vth ? 1 : 0) + (32)*(v(r2_l25_c5)>vth ? 1 : 0) + (16)*(v(r2_l25_c4)>vth ? 1 : 0) + (8)*(v(r2_l25_c3)>vth ? 1 : 0) + (4)*(v(r2_l25_c2)>vth ? 1 : 0) + (2)*(v(r2_l25_c1)>vth ? 1 : 0) + (1)*(v(r2_l25_c0)>vth ? 1 : 0)
br2_l25conf r2_l25_conf 0 V = (
+ abs(v(r2_l25_sel_in_n)+v(r2_l25_rel_n_256p)+v(r2_l25_sel_hi_n_256p)+v(r2_l25_sel_lo_n_256p)-vdd_val) + abs(v(r2_l25_sel_in_n)+v(r2_l25_rel_n_128p)+v(r2_l25_sel_hi_n_128p)+v(r2_l25_sel_lo_n_128p)-vdd_val) + abs(v(r2_l25_sel_in_n)+v(r2_l25_rel_n_64p)+v(r2_l25_sel_hi_n_64p)+v(r2_l25_sel_lo_n_64p)-vdd_val) + abs(v(r2_l25_sel_in_n)+v(r2_l25_rel_n_32p)+v(r2_l25_sel_hi_n_32p)+v(r2_l25_sel_lo_n_32p)-vdd_val) + abs(v(r2_l25_sel_in_n)+v(r2_l25_rel_n_16p)+v(r2_l25_sel_hi_n_16p)+v(r2_l25_sel_lo_n_16p)-vdd_val) + abs(v(r2_l25_sel_in_n)+v(r2_l25_rel_n_8p)+v(r2_l25_sel_hi_n_8p)+v(r2_l25_sel_lo_n_8p)-vdd_val) + abs(v(r2_l25_sel_in_n)+v(r2_l25_rel_n_4p)+v(r2_l25_sel_hi_n_4p)+v(r2_l25_sel_lo_n_4p)-vdd_val) + abs(v(r2_l25_sel_in_n)+v(r2_l25_rel_n_2p)+v(r2_l25_sel_hi_n_2p)+v(r2_l25_sel_lo_n_2p)-vdd_val) + abs(v(r2_l25_sel_in_n)+v(r2_l25_rel_n_1p)+v(r2_l25_sel_hi_n_1p)+v(r2_l25_sel_lo_n_1p)-vdd_val) + abs(v(r2_l25_sel_in_n)+v(r2_l25_rel_n_256n)+v(r2_l25_sel_hi_n_256n)+v(r2_l25_sel_lo_n_256n)-vdd_val) + abs(v(r2_l25_sel_in_n)+v(r2_l25_rel_n_128n)+v(r2_l25_sel_hi_n_128n)+v(r2_l25_sel_lo_n_128n)-vdd_val) + abs(v(r2_l25_sel_in_n)+v(r2_l25_rel_n_64n)+v(r2_l25_sel_hi_n_64n)+v(r2_l25_sel_lo_n_64n)-vdd_val) + abs(v(r2_l25_sel_in_n)+v(r2_l25_rel_n_32n)+v(r2_l25_sel_hi_n_32n)+v(r2_l25_sel_lo_n_32n)-vdd_val) + abs(v(r2_l25_sel_in_n)+v(r2_l25_rel_n_16n)+v(r2_l25_sel_hi_n_16n)+v(r2_l25_sel_lo_n_16n)-vdd_val) + abs(v(r2_l25_sel_in_n)+v(r2_l25_rel_n_8n)+v(r2_l25_sel_hi_n_8n)+v(r2_l25_sel_lo_n_8n)-vdd_val) + abs(v(r2_l25_sel_in_n)+v(r2_l25_rel_n_4n)+v(r2_l25_sel_hi_n_4n)+v(r2_l25_sel_lo_n_4n)-vdd_val) + abs(v(r2_l25_sel_in_n)+v(r2_l25_rel_n_2n)+v(r2_l25_sel_hi_n_2n)+v(r2_l25_sel_lo_n_2n)-vdd_val) + abs(v(r2_l25_sel_in_n)+v(r2_l25_rel_n_1n)+v(r2_l25_sel_hi_n_1n)+v(r2_l25_sel_lo_n_1n)-vdd_val))/vdd_val
br2_l25nside r2_l25_nside 0 V = (
+ v(r2_l25_sel_hi_n_256n)+v(r2_l25_sel_lo_n_256n) + v(r2_l25_sel_hi_n_128n)+v(r2_l25_sel_lo_n_128n) + v(r2_l25_sel_hi_n_64n)+v(r2_l25_sel_lo_n_64n) + v(r2_l25_sel_hi_n_32n)+v(r2_l25_sel_lo_n_32n) + v(r2_l25_sel_hi_n_16n)+v(r2_l25_sel_lo_n_16n) + v(r2_l25_sel_hi_n_8n)+v(r2_l25_sel_lo_n_8n) + v(r2_l25_sel_hi_n_4n)+v(r2_l25_sel_lo_n_4n) + v(r2_l25_sel_hi_n_2n)+v(r2_l25_sel_lo_n_2n) + v(r2_l25_sel_hi_n_1n)+v(r2_l25_sel_lo_n_1n))/vdd_val
br2_l25acq r2_l25_acq 0 V = v(r2_l25_samp_tp_n)/vdd_val
br2_l25iso r2_l25_iso 0 V = (v(r2_l25_sel_in_n)-v(r2_l25_samp_tp_n))/vdd_val
* r2_l25: 31.25 ns/cycle (500 ns/conversion); added delay = 863 ps (measured, #9) + 25 ns (candidate logic delay)
* input ramps one LSB per conversion THROUGH mid-scale
* (codes 507..515), the worst case for a late decision.
vr2_l25in r2_l25_vinp 0 pwl(0 {vcm-4.75*lsbse} 8u {vcm+3.25*lsbse})
vr2_l25cm r2_l25_vinn 0 dc {vcm}
br2_l25exp r2_l25_exp 0 V = min(max(floor(v(r2_l25_shxp)/lsbse),0),1023)
br2_l25err r2_l25_err 0 V = v(r2_l25_drdy)>vth ? v(r2_l25_code)-v(r2_l25_exp) : 0
br2_l25aerr r2_l25_aerr 0 V = abs(v(r2_l25_err))

* ---- loop r2_l55 ----
vr2_l55start r2_l55_start 0 dc 0
vr2_l55mode r2_l55_mode 0 dc 0
xr2_l55 clk_r2 r2_l55_start r2_l55_mode r2_l55_cmpo r2_l55_samp_tp_n
+ r2_l55_sel_in_n r2_l55_drdy r2_l55_c9 r2_l55_c8 r2_l55_c7 r2_l55_c6
+ r2_l55_c5 r2_l55_c4 r2_l55_c3 r2_l55_c2 r2_l55_c1 r2_l55_c0
+ r2_l55_rel_n_256p r2_l55_sel_hi_n_256p r2_l55_sel_lo_n_256p
+ r2_l55_rel_n_128p r2_l55_sel_hi_n_128p r2_l55_sel_lo_n_128p
+ r2_l55_rel_n_64p r2_l55_sel_hi_n_64p r2_l55_sel_lo_n_64p
+ r2_l55_rel_n_32p r2_l55_sel_hi_n_32p r2_l55_sel_lo_n_32p
+ r2_l55_rel_n_16p r2_l55_sel_hi_n_16p r2_l55_sel_lo_n_16p r2_l55_rel_n_8p
+ r2_l55_sel_hi_n_8p r2_l55_sel_lo_n_8p r2_l55_rel_n_4p r2_l55_sel_hi_n_4p
+ r2_l55_sel_lo_n_4p r2_l55_rel_n_2p r2_l55_sel_hi_n_2p r2_l55_sel_lo_n_2p
+ r2_l55_rel_n_1p r2_l55_sel_hi_n_1p r2_l55_sel_lo_n_1p r2_l55_rel_n_256n
+ r2_l55_sel_hi_n_256n r2_l55_sel_lo_n_256n r2_l55_rel_n_128n
+ r2_l55_sel_hi_n_128n r2_l55_sel_lo_n_128n r2_l55_rel_n_64n
+ r2_l55_sel_hi_n_64n r2_l55_sel_lo_n_64n r2_l55_rel_n_32n
+ r2_l55_sel_hi_n_32n r2_l55_sel_lo_n_32n r2_l55_rel_n_16n
+ r2_l55_sel_hi_n_16n r2_l55_sel_lo_n_16n r2_l55_rel_n_8n
+ r2_l55_sel_hi_n_8n r2_l55_sel_lo_n_8n r2_l55_rel_n_4n r2_l55_sel_hi_n_4n
+ r2_l55_sel_lo_n_4n r2_l55_rel_n_2n r2_l55_sel_hi_n_2n r2_l55_sel_lo_n_2n
+ r2_l55_rel_n_1n r2_l55_sel_hi_n_1n r2_l55_sel_lo_n_1n sar_ctrl_a
sr2_l55p r2_l55_vinp r2_l55_shp r2_l55_samp_tp_n 0 sarl_sw
sr2_l55n r2_l55_vinn r2_l55_shn r2_l55_samp_tp_n 0 sarl_sw
cr2_l55p r2_l55_shp 0 1p
cr2_l55n r2_l55_shn 0 1p
rr2_l55sd r2_l55_samp_tp_n r2_l55_sampd 10k
cr2_l55sd r2_l55_sampd 0 1p
sr2_l55xp r2_l55_vinp r2_l55_shxp r2_l55_sampd 0 sarl_sw
sr2_l55xn r2_l55_vinn r2_l55_shxn r2_l55_sampd 0 sarl_sw
cr2_l55xp r2_l55_shxp 0 1p
cr2_l55xn r2_l55_shxn 0 1p
br2_l55topp r2_l55_topip 0 V = 2*vcm-v(r2_l55_shp)+(1.0/512)*(
+ 256*((v(r2_l55_rel_n_256p)*vcm+v(r2_l55_sel_hi_n_256p)*vref+v(r2_l55_sel_in_n)*v(r2_l55_vinp))/vdd_val-vcm) + 128*((v(r2_l55_rel_n_128p)*vcm+v(r2_l55_sel_hi_n_128p)*vref+v(r2_l55_sel_in_n)*v(r2_l55_vinp))/vdd_val-vcm) + 64*((v(r2_l55_rel_n_64p)*vcm+v(r2_l55_sel_hi_n_64p)*vref+v(r2_l55_sel_in_n)*v(r2_l55_vinp))/vdd_val-vcm) + 32*((v(r2_l55_rel_n_32p)*vcm+v(r2_l55_sel_hi_n_32p)*vref+v(r2_l55_sel_in_n)*v(r2_l55_vinp))/vdd_val-vcm) + 16*((v(r2_l55_rel_n_16p)*vcm+v(r2_l55_sel_hi_n_16p)*vref+v(r2_l55_sel_in_n)*v(r2_l55_vinp))/vdd_val-vcm) + 8*((v(r2_l55_rel_n_8p)*vcm+v(r2_l55_sel_hi_n_8p)*vref+v(r2_l55_sel_in_n)*v(r2_l55_vinp))/vdd_val-vcm) + 4*((v(r2_l55_rel_n_4p)*vcm+v(r2_l55_sel_hi_n_4p)*vref+v(r2_l55_sel_in_n)*v(r2_l55_vinp))/vdd_val-vcm) + 2*((v(r2_l55_rel_n_2p)*vcm+v(r2_l55_sel_hi_n_2p)*vref+v(r2_l55_sel_in_n)*v(r2_l55_vinp))/vdd_val-vcm) + 1*((v(r2_l55_rel_n_1p)*vcm+v(r2_l55_sel_hi_n_1p)*vref+v(r2_l55_sel_in_n)*v(r2_l55_vinp))/vdd_val-vcm) )
br2_l55topn r2_l55_topin 0 V = 2*vcm-v(r2_l55_shn)+(1.0/512)*(
+ 256*((v(r2_l55_rel_n_256n)*vcm+v(r2_l55_sel_hi_n_256n)*vref+v(r2_l55_sel_in_n)*v(r2_l55_vinn))/vdd_val-vcm) + 128*((v(r2_l55_rel_n_128n)*vcm+v(r2_l55_sel_hi_n_128n)*vref+v(r2_l55_sel_in_n)*v(r2_l55_vinn))/vdd_val-vcm) + 64*((v(r2_l55_rel_n_64n)*vcm+v(r2_l55_sel_hi_n_64n)*vref+v(r2_l55_sel_in_n)*v(r2_l55_vinn))/vdd_val-vcm) + 32*((v(r2_l55_rel_n_32n)*vcm+v(r2_l55_sel_hi_n_32n)*vref+v(r2_l55_sel_in_n)*v(r2_l55_vinn))/vdd_val-vcm) + 16*((v(r2_l55_rel_n_16n)*vcm+v(r2_l55_sel_hi_n_16n)*vref+v(r2_l55_sel_in_n)*v(r2_l55_vinn))/vdd_val-vcm) + 8*((v(r2_l55_rel_n_8n)*vcm+v(r2_l55_sel_hi_n_8n)*vref+v(r2_l55_sel_in_n)*v(r2_l55_vinn))/vdd_val-vcm) + 4*((v(r2_l55_rel_n_4n)*vcm+v(r2_l55_sel_hi_n_4n)*vref+v(r2_l55_sel_in_n)*v(r2_l55_vinn))/vdd_val-vcm) + 2*((v(r2_l55_rel_n_2n)*vcm+v(r2_l55_sel_hi_n_2n)*vref+v(r2_l55_sel_in_n)*v(r2_l55_vinn))/vdd_val-vcm) + 1*((v(r2_l55_rel_n_1n)*vcm+v(r2_l55_sel_hi_n_1n)*vref+v(r2_l55_sel_in_n)*v(r2_l55_vinn))/vdd_val-vcm) )
rr2_l55p r2_l55_topip r2_l55_topp 570
rr2_l55n r2_l55_topin r2_l55_topn 570
cr2_l55tp r2_l55_topp 0 2.20672p
cr2_l55tn r2_l55_topn 0 2.20672p
br2_l55cmp r2_l55_cmpi 0 V = v(r2_l55_topp) > v(r2_l55_topn) ? vdd_val : 0
tr2_l55d r2_l55_cmpi 0 r2_l55_cmpo 0 z0=50 td=55.863n
rr2_l55term r2_l55_cmpo 0 50
br2_l55code r2_l55_code 0 V =
+ (512)*(v(r2_l55_c9)>vth ? 1 : 0) + (256)*(v(r2_l55_c8)>vth ? 1 : 0) + (128)*(v(r2_l55_c7)>vth ? 1 : 0) + (64)*(v(r2_l55_c6)>vth ? 1 : 0) + (32)*(v(r2_l55_c5)>vth ? 1 : 0) + (16)*(v(r2_l55_c4)>vth ? 1 : 0) + (8)*(v(r2_l55_c3)>vth ? 1 : 0) + (4)*(v(r2_l55_c2)>vth ? 1 : 0) + (2)*(v(r2_l55_c1)>vth ? 1 : 0) + (1)*(v(r2_l55_c0)>vth ? 1 : 0)
br2_l55conf r2_l55_conf 0 V = (
+ abs(v(r2_l55_sel_in_n)+v(r2_l55_rel_n_256p)+v(r2_l55_sel_hi_n_256p)+v(r2_l55_sel_lo_n_256p)-vdd_val) + abs(v(r2_l55_sel_in_n)+v(r2_l55_rel_n_128p)+v(r2_l55_sel_hi_n_128p)+v(r2_l55_sel_lo_n_128p)-vdd_val) + abs(v(r2_l55_sel_in_n)+v(r2_l55_rel_n_64p)+v(r2_l55_sel_hi_n_64p)+v(r2_l55_sel_lo_n_64p)-vdd_val) + abs(v(r2_l55_sel_in_n)+v(r2_l55_rel_n_32p)+v(r2_l55_sel_hi_n_32p)+v(r2_l55_sel_lo_n_32p)-vdd_val) + abs(v(r2_l55_sel_in_n)+v(r2_l55_rel_n_16p)+v(r2_l55_sel_hi_n_16p)+v(r2_l55_sel_lo_n_16p)-vdd_val) + abs(v(r2_l55_sel_in_n)+v(r2_l55_rel_n_8p)+v(r2_l55_sel_hi_n_8p)+v(r2_l55_sel_lo_n_8p)-vdd_val) + abs(v(r2_l55_sel_in_n)+v(r2_l55_rel_n_4p)+v(r2_l55_sel_hi_n_4p)+v(r2_l55_sel_lo_n_4p)-vdd_val) + abs(v(r2_l55_sel_in_n)+v(r2_l55_rel_n_2p)+v(r2_l55_sel_hi_n_2p)+v(r2_l55_sel_lo_n_2p)-vdd_val) + abs(v(r2_l55_sel_in_n)+v(r2_l55_rel_n_1p)+v(r2_l55_sel_hi_n_1p)+v(r2_l55_sel_lo_n_1p)-vdd_val) + abs(v(r2_l55_sel_in_n)+v(r2_l55_rel_n_256n)+v(r2_l55_sel_hi_n_256n)+v(r2_l55_sel_lo_n_256n)-vdd_val) + abs(v(r2_l55_sel_in_n)+v(r2_l55_rel_n_128n)+v(r2_l55_sel_hi_n_128n)+v(r2_l55_sel_lo_n_128n)-vdd_val) + abs(v(r2_l55_sel_in_n)+v(r2_l55_rel_n_64n)+v(r2_l55_sel_hi_n_64n)+v(r2_l55_sel_lo_n_64n)-vdd_val) + abs(v(r2_l55_sel_in_n)+v(r2_l55_rel_n_32n)+v(r2_l55_sel_hi_n_32n)+v(r2_l55_sel_lo_n_32n)-vdd_val) + abs(v(r2_l55_sel_in_n)+v(r2_l55_rel_n_16n)+v(r2_l55_sel_hi_n_16n)+v(r2_l55_sel_lo_n_16n)-vdd_val) + abs(v(r2_l55_sel_in_n)+v(r2_l55_rel_n_8n)+v(r2_l55_sel_hi_n_8n)+v(r2_l55_sel_lo_n_8n)-vdd_val) + abs(v(r2_l55_sel_in_n)+v(r2_l55_rel_n_4n)+v(r2_l55_sel_hi_n_4n)+v(r2_l55_sel_lo_n_4n)-vdd_val) + abs(v(r2_l55_sel_in_n)+v(r2_l55_rel_n_2n)+v(r2_l55_sel_hi_n_2n)+v(r2_l55_sel_lo_n_2n)-vdd_val) + abs(v(r2_l55_sel_in_n)+v(r2_l55_rel_n_1n)+v(r2_l55_sel_hi_n_1n)+v(r2_l55_sel_lo_n_1n)-vdd_val))/vdd_val
br2_l55nside r2_l55_nside 0 V = (
+ v(r2_l55_sel_hi_n_256n)+v(r2_l55_sel_lo_n_256n) + v(r2_l55_sel_hi_n_128n)+v(r2_l55_sel_lo_n_128n) + v(r2_l55_sel_hi_n_64n)+v(r2_l55_sel_lo_n_64n) + v(r2_l55_sel_hi_n_32n)+v(r2_l55_sel_lo_n_32n) + v(r2_l55_sel_hi_n_16n)+v(r2_l55_sel_lo_n_16n) + v(r2_l55_sel_hi_n_8n)+v(r2_l55_sel_lo_n_8n) + v(r2_l55_sel_hi_n_4n)+v(r2_l55_sel_lo_n_4n) + v(r2_l55_sel_hi_n_2n)+v(r2_l55_sel_lo_n_2n) + v(r2_l55_sel_hi_n_1n)+v(r2_l55_sel_lo_n_1n))/vdd_val
br2_l55acq r2_l55_acq 0 V = v(r2_l55_samp_tp_n)/vdd_val
br2_l55iso r2_l55_iso 0 V = (v(r2_l55_sel_in_n)-v(r2_l55_samp_tp_n))/vdd_val
* r2_l55: 31.25 ns/cycle (500 ns/conversion); added delay = 863 ps (measured, #9) + 55 ns (candidate logic delay)
* input ramps one LSB per conversion THROUGH mid-scale
* (codes 507..515), the worst case for a late decision.
vr2_l55in r2_l55_vinp 0 pwl(0 {vcm-4.75*lsbse} 8u {vcm+3.25*lsbse})
vr2_l55cm r2_l55_vinn 0 dc {vcm}
br2_l55exp r2_l55_exp 0 V = min(max(floor(v(r2_l55_shxp)/lsbse),0),1023)
br2_l55err r2_l55_err 0 V = v(r2_l55_drdy)>vth ? v(r2_l55_code)-v(r2_l55_exp) : 0
br2_l55aerr r2_l55_aerr 0 V = abs(v(r2_l55_err))

* ------------------------------------------------------------------
* sar_ctrl.spice -- synchronous SAR control logic, rung-1 abstraction
*
* GENERATED by design/sar-logic/gen_sar_logic.py -- do not edit.
*
* Ideal XSPICE event-driven digital primitives (digital.cm: d_dff,
* d_and, d_or, d_inverter) plus adc_bridge/dac_bridge at the analog
* boundary. This is rung 1 of the fidelity ladder in DR-0010: it fixes
* the SEQUENCING and the SWITCH DECODE, and deliberately says nothing
* about gf180mcu gate delay (rung 3 / sim/sar-logic-cell-delay/ owns
* that).
*
* Conversion, M = 16 clocks (DR-0003), with DR-0014's TWO-PHASE
* BOTTOM-PLATE sample laid inside the same 4-clock sample window:
*   ph0..ph2   acquire  samp_tp and samp_bp both asserted: the top
*                       plate is held at Vcm by its own switch and
*                       every bottom plate tracks V_in through the
*                       cell's fourth leg
*   ph2->ph3   THE SAMPLING INSTANT -- samp_tp falls, the top-plate
*                       switch opens and the top node floats
*   ph3        the bottom plates stay on V_in one more clock
*   ph3->ph4   samp_bp falls a full bit cycle after the sampling
*                       instant: the bottom plates leave V_in for Vcm
*                       onto a node that is ALREADY isolated, which
*                       is the whole reason bottom-plate sampling is
*                       worth a fourth leg (DR-0014, README note [d])
*   ph4        trial 1  free MSB -- no array switching at all, the
*                       comparator decides the sign of the sampled
*                       residue (DR-0014 keeps DR-0011's free MSB)
*   ph5..ph13  trials 2..10, weights 256,128,...,1 engaged in turn
*   ph14       output register loads the 10 decisions
*   ph15       drdy asserted; array released back to Vcm
*
* Switch decode per weight w and side s -- FOUR one-hot legs per cell
* now, not three -- from the slice's own engage flag `eng`, the
* direction bit `dir` (= the decision of the PREVIOUS trial, which is
* also that trial's output bit) and the shared sample control `smp`:
*   in  = smp                      bottom plate on V_in (DR-0014)
*   rel = !eng & !smp              bottom plate parked at Vcm
*   p-side:  hi = eng &  dir       -> V_REF      lo = eng & !dir -> GND
*   n-side:  hi = eng & !dir       -> V_REF      lo = eng &  dir -> GND
*   n-side is additionally gated by `mode` (1 = differential): in
*   single-ended mode every n-side cell stays released to Vcm for the
*   whole conversion, per DR-0011 -- driving it too would double every
*   step and cost a bit of resolution. The `in` leg is NOT mode-gated:
*   both sides must acquire their own input pin, and DR-0011's mode
*   rule is about bit trials, not about the sample phase.
*   `eng` is zero for the whole sample window, so exactly one of the
*   four legs conducts at every instant -- the invariant
*   sim/sar-logic-functional/ measures directly as sw_conflict_*.
*
* Sign convention, RE-DERIVED FOR DR-0014 and the one place the
* superseded record's decode could not simply be carried forward.
* Sampling on the bottom plate INVERTS the residue with respect to the
* input: after the sample, top_p - top_n = -k*(V_inp - V_inn). The
* comparator is wired conventionally (cmp = 1 when top_p > top_n), so
* the controller inverts it ONCE at its own boundary --
*
*     dec = !cmp    = 1 when the sampled input is ABOVE the DAC's
*                     current estimate, i.e. 'add this weight'
*
* -- and `dir` therefore still holds the OUTPUT BIT of its position,
* exactly as under DR-0011, at the cost of the hi/lo assignment above
* being the mirror of DR-0011's. Inverting only one of the two would
* either diverge (right code polarity, wrong feedback direction) or
* emit the one's complement of the code (right feedback, wrong bits);
* both were checked against the closed loop before this form was
* chosen, and sim/sar-logic-functional/ falsifies either error on
* every one of the 1024 codes in both modes.
* ------------------------------------------------------------------

* --- ideal digital primitives -------------------------------------
.model sarl_dff d_dff(clk_delay=0.5n set_delay=0.5n
+ reset_delay=0.5n ic=0 rise_delay=0.5n fall_delay=0.5n)
.model sarl_dff1 d_dff(clk_delay=0.5n set_delay=0.5n
+ reset_delay=0.5n ic=1 rise_delay=0.5n fall_delay=0.5n)
.model sarl_and d_and(rise_delay=0.2n fall_delay=0.2n input_load=0)
.model sarl_or d_or(rise_delay=0.2n fall_delay=0.2n input_load=0)
.model sarl_inv d_inverter(rise_delay=0.2n fall_delay=0.2n
+ input_load=0)

* --- enabled bit register -----------------------------------------
* Captures `d` on the clock edge that ENDS the phase in which `en` is
* asserted, and holds otherwise. Written as an explicit D-mux rather
* than a gated clock: gating the clock with a phase signal that itself
* changes one gate delay after the clock edge creates a spurious
* rising edge on the gated clock, which is a real bug in a real
* implementation, not just in this model.
.subckt sar_bitreg clk d en q qb
a_inv en enb sarl_inv
a_sel [en d] dsel sarl_and
a_hold [enb q] dhold sarl_and
a_mux [dsel dhold] dnext sarl_or
a_ff dnext clk NULL NULL q qb sarl_dff
.ends sar_bitreg

* --- one bit slice: engage flag + direction bit + switch decode -----
* `arm`     one-hot phase pulse of the trial BEFORE this slice's own
*           trial: the slice engages on the edge entering its trial,
*           and the direction bit captures the decision made during
*           `arm` (which is also this bit position's output bit).
* `endconv` forces the engage flag low on the edge leaving the last
*           trial, releasing the whole array back to Vcm for the next
*           sample phase.
* `dec`     the comparator decision in OUTPUT-BIT polarity (= !cmp;
*           see the sign-convention note in the header).
* `smpb`    the inverse of the shared bottom-plate sample control,
*           distributed already-inverted so that all four legs of the
*           cell come out at the SAME logic depth. That is not
*           cosmetic: `rel` and the V_in leg are complementary during
*           the sample window, so a one-gate depth difference between
*           them opens a window in which a cell drives V_in and Vcm at
*           once -- which is exactly what the one-hot invariant is
*           there to catch, and it would catch this generator.
.subckt sar_slice clk dec mode arm endconv smpb dir dirb
+ rel_p hi_p lo_p rel_n hi_n lo_n
a_set [arm eng] eng_set sarl_or
a_ninv endconv nend sarl_inv
a_keep [eng_set nend] eng_d sarl_and
a_ff eng_d clk NULL NULL eng engb sarl_dff
xdir clk dec arm dir dirb sar_bitreg
* p side: always driven
a_relp [engb smpb] rel_p sarl_and
a_hip [eng dir] hi_p sarl_and
a_lop [eng dirb] lo_p sarl_and
* n side: driven only in differential mode (DR-0011). `engnb` is built
* as !eng | !mode rather than as an inverter on `engn`, so that it
* lands at the same depth as `engn` and rel_n/hi_n/lo_n switch
* together -- the same delay-balance argument as `smpb` above.
a_engn [eng mode] engn sarl_and
a_modeb mode modeb sarl_inv
a_engnb [engb modeb] engnb sarl_or
a_reln [engnb smpb] rel_n sarl_and
a_hin [engn dirb] hi_n sarl_and
a_lon [engn dir] lo_n sarl_and
.ends sar_slice

* --- 16-phase one-hot sequencer ------------------------------------
* A one-hot ring, seeded by ph15's ic=1 so the very first clock edge
* enters ph0 (sample) with exactly one token in the ring. `start`
* forces a synchronous restart: it sets stage 0 and clears every other
* stage on the same edge, so an asserted `start` cannot inject a
* SECOND token alongside the circulating one.
.subckt sar_seq clk start ph0 ph1 ph2 ph3 ph4 ph5 ph6 ph7 ph8 ph9 ph10 ph11 ph12 ph13 ph14 ph15
a_nstart start nstart sarl_inv
a_d0 [ph15 start] d0 sarl_or
a_ff0 d0 clk NULL NULL ph0 ph0b sarl_dff
a_d1 [ph0 nstart] d1 sarl_and
a_ff1 d1 clk NULL NULL ph1 ph1b sarl_dff
a_d2 [ph1 nstart] d2 sarl_and
a_ff2 d2 clk NULL NULL ph2 ph2b sarl_dff
a_d3 [ph2 nstart] d3 sarl_and
a_ff3 d3 clk NULL NULL ph3 ph3b sarl_dff
a_d4 [ph3 nstart] d4 sarl_and
a_ff4 d4 clk NULL NULL ph4 ph4b sarl_dff
a_d5 [ph4 nstart] d5 sarl_and
a_ff5 d5 clk NULL NULL ph5 ph5b sarl_dff
a_d6 [ph5 nstart] d6 sarl_and
a_ff6 d6 clk NULL NULL ph6 ph6b sarl_dff
a_d7 [ph6 nstart] d7 sarl_and
a_ff7 d7 clk NULL NULL ph7 ph7b sarl_dff
a_d8 [ph7 nstart] d8 sarl_and
a_ff8 d8 clk NULL NULL ph8 ph8b sarl_dff
a_d9 [ph8 nstart] d9 sarl_and
a_ff9 d9 clk NULL NULL ph9 ph9b sarl_dff
a_d10 [ph9 nstart] d10 sarl_and
a_ff10 d10 clk NULL NULL ph10 ph10b sarl_dff
a_d11 [ph10 nstart] d11 sarl_and
a_ff11 d11 clk NULL NULL ph11 ph11b sarl_dff
a_d12 [ph11 nstart] d12 sarl_and
a_ff12 d12 clk NULL NULL ph12 ph12b sarl_dff
a_d13 [ph12 nstart] d13 sarl_and
a_ff13 d13 clk NULL NULL ph13 ph13b sarl_dff
a_d14 [ph13 nstart] d14 sarl_and
a_ff14 d14 clk NULL NULL ph14 ph14b sarl_dff
a_d15 [ph14 nstart] d15 sarl_and
a_ff15 d15 clk NULL NULL ph15 ph15b sarl_dff1
.ends sar_seq

* --- digital top ----------------------------------------------------
.subckt sar_ctrl clk start mode cmp samp_tp samp_bp drdy b9 b8 b7 b6 b5 b4
+ b3 b2 b1 b0 rel_256p hi_256p lo_256p rel_128p hi_128p lo_128p rel_64p
+ hi_64p lo_64p rel_32p hi_32p lo_32p rel_16p hi_16p lo_16p rel_8p hi_8p
+ lo_8p rel_4p hi_4p lo_4p rel_2p hi_2p lo_2p rel_1p hi_1p lo_1p rel_256n
+ hi_256n lo_256n rel_128n hi_128n lo_128n rel_64n hi_64n lo_64n rel_32n
+ hi_32n lo_32n rel_16n hi_16n lo_16n rel_8n hi_8n lo_8n rel_4n hi_4n
+ lo_4n rel_2n hi_2n lo_2n rel_1n hi_1n lo_1n
xseq clk start ph0 ph1 ph2 ph3 ph4 ph5 ph6 ph7 ph8 ph9 ph10 ph11 ph12 ph13 ph14 ph15 sar_seq
* ---- DR-0014's two-phase sample ----------------------------------
* `samp_tp` closes the top-plate switch for ph0..ph2 and opens it on
* the edge into ph3: THAT edge is the sampling instant. `samp_bp`
* keeps every bottom plate on V_in for the whole 4-clock window, so
* the input legs turn off one full clock LATER, onto a top node that
* is already floating. Both are one-hot phase ORs off the same ring:
* one external clock, rising edges only (DR-0008), no gated or
* inverted clock anywhere in the sample path.
* `samp_bp` is emitted through smpb -> inverter rather than straight
* off the OR so that it lands at the SAME logic depth as each cell's
* `rel`, which is AND(engb, smpb). Those two legs are complementary
* across the sample boundary, so a one-gate depth difference would
* leave every cell driving V_in and V_cm together for 0.2 ns.
a_samp4 [ph0 ph1 ph2 ph3] samp4 sarl_or
a_samptp [ph0 ph1 ph2] samp_tp sarl_or
a_smpb samp4 smpb sarl_inv
a_sampbp smpb samp_bp sarl_inv
* The comparator decision, inverted once here into output-bit
* polarity: bottom-plate sampling inverts the residue with respect to
* the input (DR-0014). See the header's sign-convention note.
a_dec cmp dec sarl_inv
a_drdy ph15 drdy_n sarl_inv
a_drdy2 drdy_n drdy sarl_inv
xs256 clk dec mode ph4 ph13 smpb q9 q9b rel_256p hi_256p lo_256p rel_256n hi_256n lo_256n sar_slice
xs128 clk dec mode ph5 ph13 smpb q8 q8b rel_128p hi_128p lo_128p rel_128n hi_128n lo_128n sar_slice
xs64 clk dec mode ph6 ph13 smpb q7 q7b rel_64p hi_64p lo_64p rel_64n hi_64n lo_64n sar_slice
xs32 clk dec mode ph7 ph13 smpb q6 q6b rel_32p hi_32p lo_32p rel_32n hi_32n lo_32n sar_slice
xs16 clk dec mode ph8 ph13 smpb q5 q5b rel_16p hi_16p lo_16p rel_16n hi_16n lo_16n sar_slice
xs8 clk dec mode ph9 ph13 smpb q4 q4b rel_8p hi_8p lo_8p rel_8n hi_8n lo_8n sar_slice
xs4 clk dec mode ph10 ph13 smpb q3 q3b rel_4p hi_4p lo_4p rel_4n hi_4n lo_4n sar_slice
xs2 clk dec mode ph11 ph13 smpb q2 q2b rel_2p hi_2p lo_2p rel_2n hi_2n lo_2n sar_slice
xs1 clk dec mode ph12 ph13 smpb q1 q1b rel_1p hi_1p lo_1p rel_1n hi_1n lo_1n sar_slice
xb0 clk dec ph13 q0 q0b sar_bitreg
* 10-bit parallel output register (DR-0005: in scope, SPI deferred)
xo9 clk q9 ph14 b9 b9b sar_bitreg
xo8 clk q8 ph14 b8 b8b sar_bitreg
xo7 clk q7 ph14 b7 b7b sar_bitreg
xo6 clk q6 ph14 b6 b6b sar_bitreg
xo5 clk q5 ph14 b5 b5b sar_bitreg
xo4 clk q4 ph14 b4 b4b sar_bitreg
xo3 clk q3 ph14 b3 b3b sar_bitreg
xo2 clk q2 ph14 b2 b2b sar_bitreg
xo1 clk q1 ph14 b1 b1b sar_bitreg
xo0 clk q0 ph14 b0 b0b sar_bitreg
.ends sar_ctrl

* --- analog-boundary wrapper ----------------------------------------
* Presents the controller at the analog boundary with the port names
* design/cdac/cdac_array.sch uses, so the two connect directly. Only
* the NMOS-gate (active-high) half of each T-gate leg is routed out of
* the controller; `sar_tgate_drv` below makes the PMOS gate locally at
* the cell. Bridges are VECTOR instances on purpose: 54 scalar
* dac_bridges would put 54 separate sources in the analog matrix.
* DR-0014's two additions ride on the SCALAR bridge group with drdy
* and the code bits, not on the 54-wide array bus: `sel_in_n` is one
* broadcast net feeding every cell's fourth leg and `samp_tp_n` is the
* per-side top-plate switch, so the array control bus grows from 54 to
* 55 wires, not to 72.
.subckt sar_ctrl_a clk start mode cmp samp_tp_n sel_in_n drdy c9 c8 c7 c6
+ c5 c4 c3 c2 c1 c0 rel_n_256p sel_hi_n_256p sel_lo_n_256p rel_n_128p
+ sel_hi_n_128p sel_lo_n_128p rel_n_64p sel_hi_n_64p sel_lo_n_64p
+ rel_n_32p sel_hi_n_32p sel_lo_n_32p rel_n_16p sel_hi_n_16p sel_lo_n_16p
+ rel_n_8p sel_hi_n_8p sel_lo_n_8p rel_n_4p sel_hi_n_4p sel_lo_n_4p
+ rel_n_2p sel_hi_n_2p sel_lo_n_2p rel_n_1p sel_hi_n_1p sel_lo_n_1p
+ rel_n_256n sel_hi_n_256n sel_lo_n_256n rel_n_128n sel_hi_n_128n
+ sel_lo_n_128n rel_n_64n sel_hi_n_64n sel_lo_n_64n rel_n_32n sel_hi_n_32n
+ sel_lo_n_32n rel_n_16n sel_hi_n_16n sel_lo_n_16n rel_n_8n sel_hi_n_8n
+ sel_lo_n_8n rel_n_4n sel_hi_n_4n sel_lo_n_4n rel_n_2n sel_hi_n_2n
+ sel_lo_n_2n rel_n_1n sel_hi_n_1n sel_lo_n_1n
a_in [clk start mode cmp] [dclk dstart dmode dcmp] sarl_adc
xctrl dclk dstart dmode dcmp dsamp_tp dsamp_bp ddrdy db9 db8 db7 db6 db5
+ db4 db3 db2 db1 db0 drel_256p dhi_256p dlo_256p drel_128p dhi_128p
+ dlo_128p drel_64p dhi_64p dlo_64p drel_32p dhi_32p dlo_32p drel_16p
+ dhi_16p dlo_16p drel_8p dhi_8p dlo_8p drel_4p dhi_4p dlo_4p drel_2p
+ dhi_2p dlo_2p drel_1p dhi_1p dlo_1p drel_256n dhi_256n dlo_256n
+ drel_128n dhi_128n dlo_128n drel_64n dhi_64n dlo_64n drel_32n dhi_32n
+ dlo_32n drel_16n dhi_16n dlo_16n drel_8n dhi_8n dlo_8n drel_4n dhi_4n
+ dlo_4n drel_2n dhi_2n dlo_2n drel_1n dhi_1n dlo_1n sar_ctrl
a_dout [dsamp_tp dsamp_bp ddrdy db9 db8 db7 db6 db5 db4 db3 db2 db1 db0]
+ [samp_tp_n sel_in_n drdy c9 c8 c7 c6 c5 c4 c3 c2 c1 c0] sarl_dac
a_gn [drel_256p dhi_256p dlo_256p drel_128p dhi_128p dlo_128p drel_64p dhi_64p dlo_64p drel_32p dhi_32p dlo_32p drel_16p dhi_16p dlo_16p drel_8p dhi_8p dlo_8p drel_4p dhi_4p dlo_4p drel_2p dhi_2p dlo_2p drel_1p dhi_1p dlo_1p drel_256n dhi_256n dlo_256n drel_128n dhi_128n dlo_128n drel_64n dhi_64n dlo_64n drel_32n dhi_32n dlo_32n drel_16n dhi_16n dlo_16n drel_8n dhi_8n dlo_8n drel_4n dhi_4n dlo_4n drel_2n dhi_2n dlo_2n drel_1n dhi_1n dlo_1n]
+ [rel_n_256p sel_hi_n_256p sel_lo_n_256p rel_n_128p sel_hi_n_128p sel_lo_n_128p rel_n_64p sel_hi_n_64p sel_lo_n_64p rel_n_32p sel_hi_n_32p sel_lo_n_32p rel_n_16p sel_hi_n_16p sel_lo_n_16p rel_n_8p sel_hi_n_8p sel_lo_n_8p rel_n_4p sel_hi_n_4p sel_lo_n_4p rel_n_2p sel_hi_n_2p sel_lo_n_2p rel_n_1p sel_hi_n_1p sel_lo_n_1p rel_n_256n sel_hi_n_256n sel_lo_n_256n rel_n_128n sel_hi_n_128n sel_lo_n_128n rel_n_64n sel_hi_n_64n sel_lo_n_64n rel_n_32n sel_hi_n_32n sel_lo_n_32n rel_n_16n sel_hi_n_16n sel_lo_n_16n rel_n_8n sel_hi_n_8n sel_lo_n_8n rel_n_4n sel_hi_n_4n sel_lo_n_4n rel_n_2n sel_hi_n_2n sel_lo_n_2n rel_n_1n sel_hi_n_1n sel_lo_n_1n] sarl_dac
.ends sar_ctrl_a

* --- local T-gate driver -------------------------------------------
* One per T-gate leg, placed with the CDAC cell (#15/#16), not with
* the controller: `gn` is the controller's active-high control and
* `gp` the complementary PMOS gate. Modelled as an ideal inverter at
* rung 1; at rung 3 it is one standard-cell inverter.
.subckt sar_tgate_drv gn gp
a_adc gn dgn sarl_adc
a_inv dgn dgp sarl_inv
a_dac dgp gp sarl_dac
.ends sar_tgate_drv

* Bridge models. Thresholds and rails track the PVT point's supply, so
* the supply axis of the corner grid actually moves something in this
* otherwise PVT-invariant model.
.model sarl_adc adc_bridge(in_low={vdd_val*0.4} in_high={vdd_val*0.6})
.model sarl_dac dac_bridge(out_low=0 out_high={vdd_val}
+ out_undef={vdd_val/2} t_rise=0.3n t_fall=0.3n)
