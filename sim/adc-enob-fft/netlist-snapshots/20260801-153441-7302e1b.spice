* Frozen netlist snapshot for record 20260801-153441-7302e1b
* source     : sim/adc-enob-fft/testbench/tb_adc_enob_fft.spice
* sha256     : 08ea875124fae38957a20dc82b3e4f024ecc0e8e81398ddf99290f8a26a92f85
* This is a verbatim copy taken at record time. Do not edit.
* ==================================================================
* tb_adc_enob_fft -- dynamic performance near Nyquist, by coherently
* sampled FFT (issue #13).
*
* GENERATED by design/adc-top/gen_adc_top.py -- do not edit.
*
* Same converter as sim/adc-inl-dnl/ -- same generator, same core
* function -- driven by a full-scale sine instead of a code ladder.
*
* COHERENT SAMPLING. f_in = (M / N) * f_s with
*     N = 64 samples (a power of two: no zero padding, which
*         would destroy the coherence it is supposed to preserve)
*     M = 31 input cycles captured, prime and therefore
*         coprime to N
*     f_s = 1 MS/s  ->  f_in = 484.3750 kHz
*         = 0.9688 x Nyquist (f_s/2 = 500 kHz),
*         i.e. 'near Nyquist' as the ratified ENOB and SFDR rows
*         specify
* Because gcd(M, N) = 1 the N samples fall on N distinct phases of the
* input and the capture contains a whole number of input periods, so
* the signal lands entirely in bin M with no leakage into its
* neighbours. THAT is why the window is `none`: a window is a repair
* for the discontinuity a non-integer number of periods leaves at the
* record boundary, and coherent sampling leaves none. Applying one
* here would spread the signal over three bins and understate SFDR.
*
* WHAT AN FFT OF THIS DECK DOES AND DOES NOT MEASURE. ngspice injects
* NO device noise into a transient analysis -- noise enters only
* through explicit trnoise/trrandom sources. So the non-signal bins
* of this FFT contain distortion, settling error and quantization,
* and NOT thermal or flicker noise. The ENOB claim is therefore
* composed in the record: this deck's measured distortion terms plus
* the separately measured noise terms (sim/comparator-preamp-noise/'s
* ac-based .noise result, and the kT/C term
* spec/cdac-sizing-memo.md Sec 1 sizes the array against). Reporting
* an ENOB straight off this FFT alone would overstate it by omitting
* every noise term in the budget -- see spec/testbench-suite-memo.md.
*
* The deck exports the code sequence as one `meas` per sample, so the
* FFT itself is done by sim/adc-enob-fft/testbench/analyze_fft.py over
* the runner's own raw per-corner logs -- the same post-processing
* pattern sim/comparator-offset-gof/ uses. Nothing is hand-entered:
* the script reads the logs the corner runner wrote.
* ==================================================================

* ---- ratiometric rails --------------------------------------------
* V_REF = V_DD. README.md note [c] makes V_REF <= V_DD a hard
* condition of the ratified spec, so a fixed 3.3 V reference is not
* legal at the 2.97 V corner; taking V_REF = V_DD keeps the deck legal
* at every point of the supply axis, and every figure below is in LSB
* of whatever full scale that point has.
.param vref={vdd_val}
.param vcm={vdd_val/2}
.param vth={vdd_val/2}
.param lsb={vdd_val/1024}

* ---- clocks --------------------------------------------------------
* DR-0003: one external clock pin at 16 x f_s. The comparator strobe
* is the same clock shifted half a bit cycle, so the CDAC settles in
* the first 31.25 ns and the comparator decides in the second -- the
* split spec/prior-art-survey.md Sec 1.4 allocates and
* sim/comparator-regeneration/ measured 863 ps of worst-case decision
* delay against.
vclk clk 0 pulse(0 {vdd_val} 0 100p 100p 31.25n 62.5n)
vcmpclk cmpclk 0 pulse(0 {vdd_val} 31.25n 100p 100p 31.25n 62.5n)
vcmpclkb cmpclkb 0 pulse({vdd_val} 0 31.25n 100p 100p 31.25n 62.5n)

* ---- supplies, split per block so power is attributable -----------
vddt vddt 0 dc {vdd_val}
vddd vddd 0 dc {vdd_val}
vddc vddc 0 dc {vdd_val}

* ---- reference network, DR-0002 -----------------------------------
* DR-0002 specifies an EXTERNAL V_REF pin with an effective source
* impedance <= 240 ohm IN THE SWITCHING BAND and >= 40 nF of external
* decoupling. Both halves of that sentence are modelled: the inductor
* in parallel with the 240 ohm makes the network 240 ohm at the
* switching band and DC-accurate below it, which is what an external
* reference buffer behind a decoupling capacitor actually is. A bare
* 240 ohm series resistor would instead assert a DC offset DR-0002
* never specified -- and, with 40 nF, a 9.6 us settling tail that
* would dominate any run shorter than ~50 us.
vrefs vrefs 0 dc {vref}
rref vrefs vrefn 240
lref vrefs vrefn 2.3873u
cref vrefn 0 40n
* V_cm generation is explicitly unbudgeted work (DR-0011
* Consequences: 'a new, currently-unbudgeted deliverable for a future
* issue'), so there is no ratified envelope to model it against and it
* is an IDEAL source here. That is a stated assumption of every record
* this deck produces, not a measured result -- see the known-
* limitations section of spec/testbench-suite-memo.md.
vcms vcmn 0 dc {vcm}

* ---- near-full-scale sine -----------------------------------------
* Amplitude is 0.94 x half full scale, i.e. -0.54 dBFS. The backoff is
* for a MEASURED reason, not out of habit: sim/adc-inl-dnl/ finds a
* converter-level gain error of ~3 % of full scale, dominated by top-
* plate parasitic loading of the array by the comparator input
* capacitance. A true rail-to-rail drive would therefore CLIP at both
* ends, and the FFT would report the clipping as distortion the block
* does not have. analyze_fft.py reports the resulting dBFS shortfall
* per corner, so a reader sees the backoff rather than assuming it.
vsein se_vinp 0 sin({vcm} {vref/2*0.94} 484375.000000 0.000002000 0 0)
vsevinn se_vinn 0 dc {vcm}

* ================= core se (single-ended) ==
vsestart se_start 0 dc 0
vsemode se_mode 0 dc 0
xsectrl clk se_start se_mode se_cmp se_samp se_drdy se_c9 se_c8 se_c7
+ se_c6 se_c5 se_c4 se_c3 se_c2 se_c1 se_c0 se_rel_n_256p se_sel_hi_n_256p
+ se_sel_lo_n_256p se_rel_n_128p se_sel_hi_n_128p se_sel_lo_n_128p
+ se_rel_n_64p se_sel_hi_n_64p se_sel_lo_n_64p se_rel_n_32p
+ se_sel_hi_n_32p se_sel_lo_n_32p se_rel_n_16p se_sel_hi_n_16p
+ se_sel_lo_n_16p se_rel_n_8p se_sel_hi_n_8p se_sel_lo_n_8p se_rel_n_4p
+ se_sel_hi_n_4p se_sel_lo_n_4p se_rel_n_2p se_sel_hi_n_2p se_sel_lo_n_2p
+ se_rel_n_1p se_sel_hi_n_1p se_sel_lo_n_1p se_rel_n_256n se_sel_hi_n_256n
+ se_sel_lo_n_256n se_rel_n_128n se_sel_hi_n_128n se_sel_lo_n_128n
+ se_rel_n_64n se_sel_hi_n_64n se_sel_lo_n_64n se_rel_n_32n
+ se_sel_hi_n_32n se_sel_lo_n_32n se_rel_n_16n se_sel_hi_n_16n
+ se_sel_lo_n_16n se_rel_n_8n se_sel_hi_n_8n se_sel_lo_n_8n se_rel_n_4n
+ se_sel_hi_n_4n se_sel_lo_n_4n se_rel_n_2n se_sel_hi_n_2n se_sel_lo_n_2n
+ se_rel_n_1n se_sel_hi_n_1n se_sel_lo_n_1n sar_ctrl_a
* Input drive network, DR-0013: series source resistance and a pin
* capacitor, at the compliant point sim/track-switch-sampling/
* measured the ratified gain-error number at (25 ohm, 1n).
Rsesp se_vinp se_pinp 25
Csexp se_pinp 0 1n
Xseswp se_pinp se_topp se_samp se_sampb vddt adc_tgate_dum wn=40u wp=80u rd=0.4375
Rsesn se_vinn se_pinn 25
Csexn se_pinn 0 1n
Xseswn se_pinn se_topn se_samp se_sampb vddt adc_tgate_dum wn=40u wp=80u rd=0.4375
* The complementary sampling-clock phase is generated at rung 1 (an
* ideal inverter + dac_bridge) rather than by a real inverter, so the
* NMOS/PMOS turn-off skew is identical to the one the ratified
* DR-0013 charge-split measurement was taken with. A real driver's
* own skew would change that split -- i.e. it would silently re-open
* a closed decision -- so the sampling-switch DRIVER is carried as an
* analytic power term instead (see the power record), not simulated.
asesb [se_samp] [se_dsamp] sarl_adc
asesi se_dsamp se_dsampb sarl_inv
asesd [se_dsampb] [se_sampb] sarl_dac
Xsearrp se_topp vrefn vcmn 0 vddd se_rel_n_256p se_sel_hi_n_256p
+ se_sel_lo_n_256p se_rel_n_128p se_sel_hi_n_128p se_sel_lo_n_128p
+ se_rel_n_64p se_sel_hi_n_64p se_sel_lo_n_64p se_rel_n_32p
+ se_sel_hi_n_32p se_sel_lo_n_32p se_rel_n_16p se_sel_hi_n_16p
+ se_sel_lo_n_16p se_rel_n_8p se_sel_hi_n_8p se_sel_lo_n_8p se_rel_n_4p
+ se_sel_hi_n_4p se_sel_lo_n_4p se_rel_n_2p se_sel_hi_n_2p se_sel_lo_n_2p
+ se_rel_n_1p se_sel_hi_n_1p se_sel_lo_n_1p adc_cdac_side
Xsearrn se_topn vrefn vcmn 0 vddd se_rel_n_256n se_sel_hi_n_256n
+ se_sel_lo_n_256n se_rel_n_128n se_sel_hi_n_128n se_sel_lo_n_128n
+ se_rel_n_64n se_sel_hi_n_64n se_sel_lo_n_64n se_rel_n_32n
+ se_sel_hi_n_32n se_sel_lo_n_32n se_rel_n_16n se_sel_hi_n_16n
+ se_sel_lo_n_16n se_rel_n_8n se_sel_hi_n_8n se_sel_lo_n_8n se_rel_n_4n
+ se_sel_hi_n_4n se_sel_lo_n_4n se_rel_n_2n se_sel_hi_n_2n se_sel_lo_n_2n
+ se_rel_n_1n se_sel_hi_n_1n se_sel_lo_n_1n adc_cdac_side
* Comparator, DR-0007: static preamp + StrongARM latch. Its inputs
* ARE the CDAC top plates, so its input capacitance and its kickback
* are inside every number this deck reports, not bolted on after.
iseb vddc se_ibias dc 10u
Xsecmp se_topp se_topn cmpclk se_ibias se_cmp se_cmpb vddc 0 comparator
* ---- the ideal shadow --------------------------------------------
* The reference this deck measures against is NOT a second simulation:
* it is the exact charge-domain result of THE DECISIONS THE REAL
* CONVERTER JUST MADE, computed from the controller's own switch-
* driver outputs. So the error node below isolates the analog error
* mechanisms (acquisition, charge injection, incomplete settling,
* reference movement, comparator kickback, top-plate parasitic
* attenuation) from decision errors, which the code check catches
* separately.
bsedacp se_dacp 0 V = (1.0/512)*(
+ 256*((v(se_rel_n_256p)*vcm+v(se_sel_hi_n_256p)*vref)/vdd_val-vcm) + 128*((v(se_rel_n_128p)*vcm+v(se_sel_hi_n_128p)*vref)/vdd_val-vcm) + 64*((v(se_rel_n_64p)*vcm+v(se_sel_hi_n_64p)*vref)/vdd_val-vcm) + 32*((v(se_rel_n_32p)*vcm+v(se_sel_hi_n_32p)*vref)/vdd_val-vcm) + 16*((v(se_rel_n_16p)*vcm+v(se_sel_hi_n_16p)*vref)/vdd_val-vcm) + 8*((v(se_rel_n_8p)*vcm+v(se_sel_hi_n_8p)*vref)/vdd_val-vcm) + 4*((v(se_rel_n_4p)*vcm+v(se_sel_hi_n_4p)*vref)/vdd_val-vcm) + 2*((v(se_rel_n_2p)*vcm+v(se_sel_hi_n_2p)*vref)/vdd_val-vcm) + 1*((v(se_rel_n_1p)*vcm+v(se_sel_hi_n_1p)*vref)/vdd_val-vcm) )
bsedacn se_dacn 0 V = (1.0/512)*(
+ 256*((v(se_rel_n_256n)*vcm+v(se_sel_hi_n_256n)*vref)/vdd_val-vcm) + 128*((v(se_rel_n_128n)*vcm+v(se_sel_hi_n_128n)*vref)/vdd_val-vcm) + 64*((v(se_rel_n_64n)*vcm+v(se_sel_hi_n_64n)*vref)/vdd_val-vcm) + 32*((v(se_rel_n_32n)*vcm+v(se_sel_hi_n_32n)*vref)/vdd_val-vcm) + 16*((v(se_rel_n_16n)*vcm+v(se_sel_hi_n_16n)*vref)/vdd_val-vcm) + 8*((v(se_rel_n_8n)*vcm+v(se_sel_hi_n_8n)*vref)/vdd_val-vcm) + 4*((v(se_rel_n_4n)*vcm+v(se_sel_hi_n_4n)*vref)/vdd_val-vcm) + 2*((v(se_rel_n_2n)*vcm+v(se_sel_hi_n_2n)*vref)/vdd_val-vcm) + 1*((v(se_rel_n_1n)*vcm+v(se_sel_hi_n_1n)*vref)/vdd_val-vcm) )
bsedi se_di 0 V = v(se_vinp)-v(se_vinn)+v(se_dacp)-v(se_dacn)
* Error, in LSB of this deck's own mode. Referenced to zero, not to a
* mid-rail level, so the ~1 uV `meas` result-precision floor
* (sim/harness/README.md) lands 3 decades below one LSB instead of on
* top of the quantity being measured.
bsee se_err 0 V = (v(se_topp)-v(se_topn)-v(se_di))/lsb
* The error, GATED TO THE DECIDE PHASES ONLY. A comparator decides on
* the strobe, so the only instants at which the input-referred error
* matters are the ten strobe-high windows; in between, the residue is
* still settling and its excursion is a transient nobody samples. So
* this node is |err| while cmpclk is high and zero otherwise, and MAX
* over a conversion's trial window is that conversion's WORST DECISION
* ERROR -- one number instead of ten.
*
* An earlier draft used a track-and-hold switched by cmpclkb instead.
* That was wrong in a way worth recording: the T/H TRACKS during the
* settling half of each bit cycle, so a MAX over the same window picked
* up the settling transient it was supposed to blank -- reporting ~300
* LSB where the decisions were actually taken within a few LSB. Gating
* is the correct primitive here; holding is not.
bseea se_aerrh 0 V = abs(v(se_err))*(v(cmpclk)>vth ? 1 : 0)
* Decoded output code (the parallel register, DR-0005).
bsecode se_code 0 V =
+ (512)*(v(se_c9)>vth ? 1 : 0) + (256)*(v(se_c8)>vth ? 1 : 0) + (128)*(v(se_c7)>vth ? 1 : 0) + (64)*(v(se_c6)>vth ? 1 : 0) + (32)*(v(se_c5)>vth ? 1 : 0) + (16)*(v(se_c4)>vth ? 1 : 0) + (8)*(v(se_c3)>vth ? 1 : 0) + (4)*(v(se_c2)>vth ? 1 : 0) + (2)*(v(se_c1)>vth ? 1 : 0) + (1)*(v(se_c0)>vth ? 1 : 0)

* Sample-and-hold on the output code, opened at the end of each
* conversion's drdy phase, so one `meas ... FIND` per conversion
* period recovers the code sequence unambiguously.
bseph seph 0 V = v(se_drdy)

* ==================================================================
* The three netlists below are COPIES, kept honest by unit tests:
*   design/comparator/comparator.spice   (test_comparator_netlist)
*   design/sar-logic/sar_ctrl.spice      (test_sar_logic_netlist)
*   design/adc-top/adc_top.spice         (test_adc_top_netlist)
* sim/harness/testbench.py rejects .include in a fragment, so a
* testbench has to carry its DUT inline; generating the copies is
* what stops them drifting from the design they claim to verify.
* ==================================================================

* --- COMPARATOR-NETLIST-BEGIN (verbatim-copied into every testbench) ---
.subckt preamp vinp vinn ibias pop pon vdd vss
* 1:1 NMOS current mirror; ibias is forced into the diode branch.
Xmb  ibias ibias vss vss nfet_03v3 w=20u l=2u
Xmt  ptail ibias vss vss nfet_03v3 w=20u l=2u
* Input pair. The device whose gate is vinp drives the INVERTING node
* pon, so v(pop) - v(pon) = +A_v * (v(vinp) - v(vinn)).
Xmip pon vinp ptail vss nfet_03v3 w=40u l=1u
Xmin pop vinn ptail vss nfet_03v3 w=40u l=1u
* Unsalicided 2 kohm/sq p+ poly loads, 75 squares = 150 kohm nominal.
* Third terminal is the substrate/body contact.
Xrlp vdd pop vss ppolyf_u_2k r_width=1u r_length=75u
Xrln vdd pon vss ppolyf_u_2k r_width=1u r_length=75u
.ends preamp

.subckt sarlatch inp inn clk outp outn vdd vss
* clk low  -> tail off; outp/outn/dip/din precharged to vdd
* clk high -> tail on; the input pair discharges dip/din at rates set by
*             v(inp)/v(inn), then the cross-coupled pairs regenerate.
Xmlt ltail clk   vss   vss nfet_03v3 w=16u l=0.35u
Xmlp dip   inp   ltail vss nfet_03v3 w=8u  l=0.5u
Xmln din   inn   ltail vss nfet_03v3 w=8u  l=0.5u
Xmnp outn  outp  dip   vss nfet_03v3 w=6u  l=0.35u
Xmnn outp  outn  din   vss nfet_03v3 w=6u  l=0.35u
Xmpp outn  outp  vdd   vdd pfet_03v3 w=8u  l=0.35u
Xmpn outp  outn  vdd   vdd pfet_03v3 w=8u  l=0.35u
Xmrp outn  clk   vdd   vdd pfet_03v3 w=4u  l=0.35u
Xmrn outp  clk   vdd   vdd pfet_03v3 w=4u  l=0.35u
Xmrd dip   clk   vdd   vdd pfet_03v3 w=2u  l=0.35u
Xmre din   clk   vdd   vdd pfet_03v3 w=2u  l=0.35u
.ends sarlatch

* Minimum-ish isolation inverter. Deliberately small: it is the only
* thing the regeneration nodes drive, so its gate capacitance is added
* directly to the latch's own output nodes and shows up as regeneration
* time.
.subckt inv a y vdd vss
Xp y a vdd vdd pfet_03v3 w=2u   l=0.35u
Xn y a vss vss nfet_03v3 w=1u   l=0.35u
.ends inv

.subckt nor2 a b y vdd vss
Xp1 ps a vdd vdd pfet_03v3 w=8u l=0.35u
Xp2 y  b ps  vdd pfet_03v3 w=8u l=0.35u
Xn1 y  a vss vss nfet_03v3 w=4u l=0.35u
Xn2 y  b vss vss nfet_03v3 w=4u l=0.35u
.ends nor2

.subckt comparator vinp vinn clk ibias dout doutb vdd vss
Xpre preamp_in1 preamp_in2 ibias pop pon vdd vss preamp
Xlat pop pon clk outp outn vdd vss sarlatch
* THE ISOLATION INVERTERS ARE NOT OPTIONAL -- they fix a measured
* hysteresis defect. Both StrongARM outputs precharge HIGH, so the
* decision arrives as an active-low pulse on exactly one of them, and
* the obvious way to hold it is a NAND SR latch wired straight to
* outp/outn. That circuit was built first and MEASURED: after deciding
* one way it would not flip back until the input reached ~10 mV of the
* opposite polarity -- about 3 LSB of hysteresis, which in a SAR (where
* the same comparator makes ten successive decisions on a shrinking
* residue) is a code-dependent error, not an offset.
*
* The cause is that a NAND SR latch's HELD STATE loads the two
* regeneration nodes asymmetrically. Wired directly, the node driving
* the NAND whose output is LOW sees that output swing when it falls
* (Miller-multiplied C_gd, ~26 fF against a regeneration node of a few
* tens of fF), while its twin drives a NAND whose output is already
* HIGH and stays there. The latch is therefore biased toward keeping
* the answer it already holds.
*
* Interposing one small inverter per side removes the coupling: the
* inverters are identical, both of their inputs precharge to V_DD, and
* neither loading depends on what the SR latch is holding. The SR latch
* becomes NOR-type because the inverters make the decision pulses
* active-HIGH. dout goes HIGH when outn falls, i.e. when
* v(vinp) > v(vinn), exactly as before.
Xis outn sset vdd vss inv
Xir outp srst vdd vss inv
Xno1 srst doutb dout  vdd vss nor2
Xno2 sset dout  doutb vdd vss nor2
* Input pass-through (zero-volt sources) so a testbench can probe the
* current the comparator draws from each CDAC top plate directly.
Vpp preamp_in1 vinp dc 0
Vpn preamp_in2 vinn dc 0
.ends comparator
* --- COMPARATOR-NETLIST-END ---

* ------------------------------------------------------------------
* sar_ctrl.spice -- synchronous SAR control logic, rung-1 abstraction
*
* GENERATED by design/sar-logic/gen_sar_logic.py -- do not edit.
*
* Ideal XSPICE event-driven digital primitives (digital.cm: d_dff,
* d_and, d_or, d_inverter) plus adc_bridge/dac_bridge at the analog
* boundary. This is rung 1 of the fidelity ladder in DR-0010: it fixes
* the SEQUENCING and the SWITCH DECODE, and deliberately says nothing
* about gf180mcu gate delay (rung 3 / sim/sar-logic-cell-delay/ owns
* that).
*
* Conversion, M = 16 clocks (DR-0003):
*   ph0..ph3   sample   (samp asserted; every bottom plate at Vcm)
*   ph4        trial 1  free MSB -- no array switching at all, the
*                       comparator decides the sign of the sampled
*                       residue (DR-0011 top-plate sampling)
*   ph5..ph13  trials 2..10, weights 256,128,...,1 engaged in turn
*   ph14       output register loads the 10 decisions
*   ph15       drdy asserted; array released back to Vcm
*
* Switch decode per weight w and side s, from the slice's own engage
* flag `eng` and direction bit `dir` (= the decision of the PREVIOUS
* trial, which is also that trial's output bit):
*   rel = !eng                     bottom plate parked at Vcm
*   p-side:  hi = eng & !dir       -> V_REF      lo = eng & dir  -> GND
*   n-side:  hi = eng &  dir       -> V_REF      lo = eng & !dir -> GND
*   n-side is additionally gated by `mode` (1 = differential): in
*   single-ended mode every n-side cell stays released to Vcm for the
*   whole conversion, per DR-0011 -- driving it too would double every
*   step and cost a bit of resolution.
*
* Sign convention: cmp = 1 when top_p > top_n. dir = 1 therefore means
* 'residue positive, subtract this weight', i.e. p-side down / n-side
* up, which is the `p-side lo` / `n-side hi` decode above.
* ------------------------------------------------------------------

* --- ideal digital primitives -------------------------------------
.model sarl_dff d_dff(clk_delay=0.5n set_delay=0.5n
+ reset_delay=0.5n ic=0 rise_delay=0.5n fall_delay=0.5n)
.model sarl_dff1 d_dff(clk_delay=0.5n set_delay=0.5n
+ reset_delay=0.5n ic=1 rise_delay=0.5n fall_delay=0.5n)
.model sarl_and d_and(rise_delay=0.2n fall_delay=0.2n input_load=0)
.model sarl_or d_or(rise_delay=0.2n fall_delay=0.2n input_load=0)
.model sarl_inv d_inverter(rise_delay=0.2n fall_delay=0.2n
+ input_load=0)

* --- enabled bit register -----------------------------------------
* Captures `d` on the clock edge that ENDS the phase in which `en` is
* asserted, and holds otherwise. Written as an explicit D-mux rather
* than a gated clock: gating the clock with a phase signal that itself
* changes one gate delay after the clock edge creates a spurious
* rising edge on the gated clock, which is a real bug in a real
* implementation, not just in this model.
.subckt sar_bitreg clk d en q qb
a_inv en enb sarl_inv
a_sel [en d] dsel sarl_and
a_hold [enb q] dhold sarl_and
a_mux [dsel dhold] dnext sarl_or
a_ff dnext clk NULL NULL q qb sarl_dff
.ends sar_bitreg

* --- one bit slice: engage flag + direction bit + switch decode -----
* `arm`     one-hot phase pulse of the trial BEFORE this slice's own
*           trial: the slice engages on the edge entering its trial,
*           and the direction bit captures the decision made during
*           `arm` (which is also this bit position's output bit).
* `endconv` forces the engage flag low on the edge leaving the last
*           trial, releasing the whole array back to Vcm for the next
*           sample phase.
.subckt sar_slice clk cmp mode arm endconv dir dirb
+ rel_p hi_p lo_p rel_n hi_n lo_n
a_set [arm eng] eng_set sarl_or
a_ninv endconv nend sarl_inv
a_keep [eng_set nend] eng_d sarl_and
a_ff eng_d clk NULL NULL eng engb sarl_dff
xdir clk cmp arm dir dirb sar_bitreg
* p side: always driven
a_relp eng rel_p sarl_inv
a_hip [eng dirb] hi_p sarl_and
a_lop [eng dir] lo_p sarl_and
* n side: driven only in differential mode (DR-0011)
a_engn [eng mode] engn sarl_and
a_reln engn rel_n sarl_inv
a_hin [engn dir] hi_n sarl_and
a_lon [engn dirb] lo_n sarl_and
.ends sar_slice

* --- 16-phase one-hot sequencer ------------------------------------
* A one-hot ring, seeded by ph15's ic=1 so the very first clock edge
* enters ph0 (sample) with exactly one token in the ring. `start`
* forces a synchronous restart: it sets stage 0 and clears every other
* stage on the same edge, so an asserted `start` cannot inject a
* SECOND token alongside the circulating one.
.subckt sar_seq clk start ph0 ph1 ph2 ph3 ph4 ph5 ph6 ph7 ph8 ph9 ph10 ph11 ph12 ph13 ph14 ph15
a_nstart start nstart sarl_inv
a_d0 [ph15 start] d0 sarl_or
a_ff0 d0 clk NULL NULL ph0 ph0b sarl_dff
a_d1 [ph0 nstart] d1 sarl_and
a_ff1 d1 clk NULL NULL ph1 ph1b sarl_dff
a_d2 [ph1 nstart] d2 sarl_and
a_ff2 d2 clk NULL NULL ph2 ph2b sarl_dff
a_d3 [ph2 nstart] d3 sarl_and
a_ff3 d3 clk NULL NULL ph3 ph3b sarl_dff
a_d4 [ph3 nstart] d4 sarl_and
a_ff4 d4 clk NULL NULL ph4 ph4b sarl_dff
a_d5 [ph4 nstart] d5 sarl_and
a_ff5 d5 clk NULL NULL ph5 ph5b sarl_dff
a_d6 [ph5 nstart] d6 sarl_and
a_ff6 d6 clk NULL NULL ph6 ph6b sarl_dff
a_d7 [ph6 nstart] d7 sarl_and
a_ff7 d7 clk NULL NULL ph7 ph7b sarl_dff
a_d8 [ph7 nstart] d8 sarl_and
a_ff8 d8 clk NULL NULL ph8 ph8b sarl_dff
a_d9 [ph8 nstart] d9 sarl_and
a_ff9 d9 clk NULL NULL ph9 ph9b sarl_dff
a_d10 [ph9 nstart] d10 sarl_and
a_ff10 d10 clk NULL NULL ph10 ph10b sarl_dff
a_d11 [ph10 nstart] d11 sarl_and
a_ff11 d11 clk NULL NULL ph11 ph11b sarl_dff
a_d12 [ph11 nstart] d12 sarl_and
a_ff12 d12 clk NULL NULL ph12 ph12b sarl_dff
a_d13 [ph12 nstart] d13 sarl_and
a_ff13 d13 clk NULL NULL ph13 ph13b sarl_dff
a_d14 [ph13 nstart] d14 sarl_and
a_ff14 d14 clk NULL NULL ph14 ph14b sarl_dff
a_d15 [ph14 nstart] d15 sarl_and
a_ff15 d15 clk NULL NULL ph15 ph15b sarl_dff1
.ends sar_seq

* --- digital top ----------------------------------------------------
.subckt sar_ctrl clk start mode cmp samp drdy b9 b8 b7 b6 b5 b4 b3 b2 b1
+ b0 rel_256p hi_256p lo_256p rel_128p hi_128p lo_128p rel_64p hi_64p
+ lo_64p rel_32p hi_32p lo_32p rel_16p hi_16p lo_16p rel_8p hi_8p lo_8p
+ rel_4p hi_4p lo_4p rel_2p hi_2p lo_2p rel_1p hi_1p lo_1p rel_256n
+ hi_256n lo_256n rel_128n hi_128n lo_128n rel_64n hi_64n lo_64n rel_32n
+ hi_32n lo_32n rel_16n hi_16n lo_16n rel_8n hi_8n lo_8n rel_4n hi_4n
+ lo_4n rel_2n hi_2n lo_2n rel_1n hi_1n lo_1n
xseq clk start ph0 ph1 ph2 ph3 ph4 ph5 ph6 ph7 ph8 ph9 ph10 ph11 ph12 ph13 ph14 ph15 sar_seq
a_samp [ph0 ph1 ph2 ph3] samp sarl_or
a_drdy ph15 drdy_n sarl_inv
a_drdy2 drdy_n drdy sarl_inv
xs256 clk cmp mode ph4 ph13 q9 q9b rel_256p hi_256p lo_256p rel_256n hi_256n lo_256n sar_slice
xs128 clk cmp mode ph5 ph13 q8 q8b rel_128p hi_128p lo_128p rel_128n hi_128n lo_128n sar_slice
xs64 clk cmp mode ph6 ph13 q7 q7b rel_64p hi_64p lo_64p rel_64n hi_64n lo_64n sar_slice
xs32 clk cmp mode ph7 ph13 q6 q6b rel_32p hi_32p lo_32p rel_32n hi_32n lo_32n sar_slice
xs16 clk cmp mode ph8 ph13 q5 q5b rel_16p hi_16p lo_16p rel_16n hi_16n lo_16n sar_slice
xs8 clk cmp mode ph9 ph13 q4 q4b rel_8p hi_8p lo_8p rel_8n hi_8n lo_8n sar_slice
xs4 clk cmp mode ph10 ph13 q3 q3b rel_4p hi_4p lo_4p rel_4n hi_4n lo_4n sar_slice
xs2 clk cmp mode ph11 ph13 q2 q2b rel_2p hi_2p lo_2p rel_2n hi_2n lo_2n sar_slice
xs1 clk cmp mode ph12 ph13 q1 q1b rel_1p hi_1p lo_1p rel_1n hi_1n lo_1n sar_slice
xb0 clk cmp ph13 q0 q0b sar_bitreg
* 10-bit parallel output register (DR-0005: in scope, SPI deferred)
xo9 clk q9 ph14 b9 b9b sar_bitreg
xo8 clk q8 ph14 b8 b8b sar_bitreg
xo7 clk q7 ph14 b7 b7b sar_bitreg
xo6 clk q6 ph14 b6 b6b sar_bitreg
xo5 clk q5 ph14 b5 b5b sar_bitreg
xo4 clk q4 ph14 b4 b4b sar_bitreg
xo3 clk q3 ph14 b3 b3b sar_bitreg
xo2 clk q2 ph14 b2 b2b sar_bitreg
xo1 clk q1 ph14 b1 b1b sar_bitreg
xo0 clk q0 ph14 b0 b0b sar_bitreg
.ends sar_ctrl

* --- analog-boundary wrapper ----------------------------------------
* Presents the controller at the analog boundary with the port names
* design/cdac/cdac_array.sch uses, so the two connect directly. Only
* the NMOS-gate (active-high) half of each T-gate leg is routed out of
* the controller; `sar_tgate_drv` below makes the PMOS gate locally at
* the cell. Bridges are VECTOR instances on purpose: 54 scalar
* dac_bridges would put 54 separate sources in the analog matrix.
.subckt sar_ctrl_a clk start mode cmp samp drdy c9 c8 c7 c6 c5 c4 c3 c2 c1
+ c0 rel_n_256p sel_hi_n_256p sel_lo_n_256p rel_n_128p sel_hi_n_128p
+ sel_lo_n_128p rel_n_64p sel_hi_n_64p sel_lo_n_64p rel_n_32p sel_hi_n_32p
+ sel_lo_n_32p rel_n_16p sel_hi_n_16p sel_lo_n_16p rel_n_8p sel_hi_n_8p
+ sel_lo_n_8p rel_n_4p sel_hi_n_4p sel_lo_n_4p rel_n_2p sel_hi_n_2p
+ sel_lo_n_2p rel_n_1p sel_hi_n_1p sel_lo_n_1p rel_n_256n sel_hi_n_256n
+ sel_lo_n_256n rel_n_128n sel_hi_n_128n sel_lo_n_128n rel_n_64n
+ sel_hi_n_64n sel_lo_n_64n rel_n_32n sel_hi_n_32n sel_lo_n_32n rel_n_16n
+ sel_hi_n_16n sel_lo_n_16n rel_n_8n sel_hi_n_8n sel_lo_n_8n rel_n_4n
+ sel_hi_n_4n sel_lo_n_4n rel_n_2n sel_hi_n_2n sel_lo_n_2n rel_n_1n
+ sel_hi_n_1n sel_lo_n_1n
a_in [clk start mode cmp] [dclk dstart dmode dcmp] sarl_adc
xctrl dclk dstart dmode dcmp dsamp ddrdy db9 db8 db7 db6 db5 db4 db3 db2
+ db1 db0 drel_256p dhi_256p dlo_256p drel_128p dhi_128p dlo_128p drel_64p
+ dhi_64p dlo_64p drel_32p dhi_32p dlo_32p drel_16p dhi_16p dlo_16p
+ drel_8p dhi_8p dlo_8p drel_4p dhi_4p dlo_4p drel_2p dhi_2p dlo_2p
+ drel_1p dhi_1p dlo_1p drel_256n dhi_256n dlo_256n drel_128n dhi_128n
+ dlo_128n drel_64n dhi_64n dlo_64n drel_32n dhi_32n dlo_32n drel_16n
+ dhi_16n dlo_16n drel_8n dhi_8n dlo_8n drel_4n dhi_4n dlo_4n drel_2n
+ dhi_2n dlo_2n drel_1n dhi_1n dlo_1n sar_ctrl
a_dout [dsamp ddrdy db9 db8 db7 db6 db5 db4 db3 db2 db1 db0]
+ [samp drdy c9 c8 c7 c6 c5 c4 c3 c2 c1 c0] sarl_dac
a_gn [drel_256p dhi_256p dlo_256p drel_128p dhi_128p dlo_128p drel_64p dhi_64p dlo_64p drel_32p dhi_32p dlo_32p drel_16p dhi_16p dlo_16p drel_8p dhi_8p dlo_8p drel_4p dhi_4p dlo_4p drel_2p dhi_2p dlo_2p drel_1p dhi_1p dlo_1p drel_256n dhi_256n dlo_256n drel_128n dhi_128n dlo_128n drel_64n dhi_64n dlo_64n drel_32n dhi_32n dlo_32n drel_16n dhi_16n dlo_16n drel_8n dhi_8n dlo_8n drel_4n dhi_4n dlo_4n drel_2n dhi_2n dlo_2n drel_1n dhi_1n dlo_1n]
+ [rel_n_256p sel_hi_n_256p sel_lo_n_256p rel_n_128p sel_hi_n_128p sel_lo_n_128p rel_n_64p sel_hi_n_64p sel_lo_n_64p rel_n_32p sel_hi_n_32p sel_lo_n_32p rel_n_16p sel_hi_n_16p sel_lo_n_16p rel_n_8p sel_hi_n_8p sel_lo_n_8p rel_n_4p sel_hi_n_4p sel_lo_n_4p rel_n_2p sel_hi_n_2p sel_lo_n_2p rel_n_1p sel_hi_n_1p sel_lo_n_1p rel_n_256n sel_hi_n_256n sel_lo_n_256n rel_n_128n sel_hi_n_128n sel_lo_n_128n rel_n_64n sel_hi_n_64n sel_lo_n_64n rel_n_32n sel_hi_n_32n sel_lo_n_32n rel_n_16n sel_hi_n_16n sel_lo_n_16n rel_n_8n sel_hi_n_8n sel_lo_n_8n rel_n_4n sel_hi_n_4n sel_lo_n_4n rel_n_2n sel_hi_n_2n sel_lo_n_2n rel_n_1n sel_hi_n_1n sel_lo_n_1n] sarl_dac
.ends sar_ctrl_a

* --- local T-gate driver -------------------------------------------
* One per T-gate leg, placed with the CDAC cell (#15/#16), not with
* the controller: `gn` is the controller's active-high control and
* `gp` the complementary PMOS gate. Modelled as an ideal inverter at
* rung 1; at rung 3 it is one standard-cell inverter.
.subckt sar_tgate_drv gn gp
a_adc gn dgn sarl_adc
a_inv dgn dgp sarl_inv
a_dac dgp gp sarl_dac
.ends sar_tgate_drv

* Bridge models. Thresholds and rails track the PVT point's supply, so
* the supply axis of the corner grid actually moves something in this
* otherwise PVT-invariant model.
.model sarl_adc adc_bridge(in_low={vdd_val*0.4} in_high={vdd_val*0.6})
.model sarl_dac dac_bridge(out_low=0 out_high={vdd_val}
+ out_undef={vdd_val/2} t_rise=0.3n t_fall=0.3n)

* ==================================================================
* adc_top.spice -- the SAR ADC analog core: CDAC array, its bottom-
* plate switches and their local drivers, and the input sampling
* switch.
*
* GENERATED by design/adc-top/gen_adc_top.py -- do not edit.
*
* This library holds ONLY what is not already owned by another
* canonical file. The comparator lives in design/comparator/
* comparator.spice and the SAR controller in design/sar-logic/
* sar_ctrl.spice; the testbenches under sim/adc-*/ inline all three.
*
* Fidelity (DR-0010): everything here is transistor level. The
* sequencer and the output register stay at rung 1 (ideal XSPICE
* primitives) because the open gf180mcu PDK ships no 3.3 V standard-
* cell library -- the gap DR-0010 names as an open precondition of
* rung 3. The T-gate DRIVERS are transistor level even so: they are
* custom cells placed with the CDAC (design/sar-logic/README.md), not
* standard cells, so the library gap does not apply to them, and they
* are the dominant digital load in a SAR ADC.
* ==================================================================

* --- ADC-TOP-NETLIST-BEGIN (verbatim-copied into every testbench) ---
* ---- switches ----------------------------------------------------
* CDAC bottom-plate T-gate. Same geometry as sim/device-switch-ron/
* and sim/cdac-bit-settling/, so R_on carries the corner sensitivity
* those records already characterised.
.subckt adc_tgate vin vout gn gp vdd wn=10u wp=20u
XN vin gn vout 0   nfet_03v3 w='wn' l=0.28u
XP vin gp vout vdd pfet_03v3 w='wp' l=0.28u
.ends adc_tgate

* Input sampling switch: dummy-compensated T-gate, DR-0007 (track
* switch) / DR-0013. Identical device text to the `tgate_dum` subckt
* sim/track-switch-sampling/ measured the ratified gain-error number
* with, at the same default rd = 7/16.
.subckt adc_tgate_dum vin vout clk clkb vdd wn=40u wp=80u rd=0.4375
XN  vin  clk  vout 0   nfet_03v3 w='wn' l=0.28u
XP  vin  clkb vout vdd pfet_03v3 w='wp' l=0.28u
XDN vout clkb vout 0   nfet_03v3 w='wn*rd' l=0.28u
XDP vout clk  vout vdd pfet_03v3 w='wp*rd' l=0.28u
.ends adc_tgate_dum

* Local T-gate driver -- one per leg, placed with the CDAC cell. This
* is design/sar-logic/sar_ctrl.spice's `sar_tgate_drv` promoted from
* its rung-1 ideal inverter to real devices: the controller routes
* only the active-high (NMOS gate) half of each leg, and the
* complementary PMOS gate is made here.
.subckt adc_drv a y vdd vss
Xp y a vdd vdd pfet_03v3 w=8u l=0.35u
Xn y a vss vss nfet_03v3 w=4u l=0.35u
.ends adc_drv

* ---- one CDAC cell ------------------------------------------------
* A weight-w block of unit capacitors and its three-way bottom-plate
* switch (DR-0011): released to V_cm, or engaged to V_REF or GND.
* Exactly one leg conducts at a time -- the one-hot invariant
* sim/sar-logic-functional/ checks on the control side.
.subckt adc_cdac_cell top vref vcm vss vdd gn_rel gn_hi gn_lo
+ cw=10u cl=10u
Xc  top bp mim_cap_2f0 c_width='cw' c_length='cl'
Xdr gn_rel gp_rel vdd vss adc_drv
Xdh gn_hi  gp_hi  vdd vss adc_drv
Xdl gn_lo  gp_lo  vdd vss adc_drv
Xsr vcm  bp gn_rel gp_rel vdd adc_tgate wn=10u wp=20u
Xsh vref bp gn_hi  gp_hi  vdd adc_tgate wn=10u wp=20u
Xsl vss  bp gn_lo  gp_lo  vdd adc_tgate wn=10u wp=20u
.ends adc_cdac_cell

* ---- one array side -----------------------------------------------
* DR-0011: 2^(N-1) = 512 unit positions per side -- nine binary
* weighted blocks (256..1, 511 units) plus one terminating unit fixed
* to V_cm. C_u = 17.24 fF (spec/cdac-sizing-memo.md Sec 4), so the
* per-side track-mode capacitance is 512 * C_u = 8.827 pF, which is
* the C_in the ratified Input-structure row publishes.
*
* Each block is drawn as ONE capacitor of the block's total area, not
* as w separate unit cells. That is exact for this campaign and it is
* deliberate: these records verify the NOMINAL design over PVT, where
* unit-to-unit mismatch is zero by construction, and the statistical
* spread of the same array is sim/mc-cdac-mismatch/'s claim, taken at
* nominal PVT with a behavioural model because the open PDK ships no
* local capacitor mismatch model at all. Drawing 1022 unit cells here
* would multiply simulation cost by ~50x and change no number.
*
* Areas from the measured MiM density law (devchar Sec 1.2),
* C(s) = 1.99*s^2 + 0.9532*s fF for a square of side s um:
*   w=256  C =   4413.44 fF  ->  s = 46.8547 um
*   w=128  C =   2206.72 fF  ->  s = 33.0616 um
*   w= 64  C =   1103.36 fF  ->  s = 23.3085 um
*   w= 32  C =    551.68 fF  ->  s = 16.4123 um
*   w= 16  C =    275.84 fF  ->  s = 11.5363 um
*   w=  8  C =    137.92 fF  ->  s = 8.0890 um
*   w=  4  C =     68.96 fF  ->  s = 5.6521 um
*   w=  2  C =     34.48 fF  ->  s = 3.9299 um
*   w=  1  C =     17.24 fF  ->  s = 2.7136 um
.subckt adc_cdac_side top vref vcm vss vdd rel_256 hi_256 lo_256 rel_128
+ hi_128 lo_128 rel_64 hi_64 lo_64 rel_32 hi_32 lo_32 rel_16 hi_16 lo_16
+ rel_8 hi_8 lo_8 rel_4 hi_4 lo_4 rel_2 hi_2 lo_2 rel_1 hi_1 lo_1
X256 top vref vcm vss vdd rel_256 hi_256 lo_256 adc_cdac_cell cw=46.8547u cl=46.8547u
X128 top vref vcm vss vdd rel_128 hi_128 lo_128 adc_cdac_cell cw=33.0616u cl=33.0616u
X64 top vref vcm vss vdd rel_64 hi_64 lo_64 adc_cdac_cell cw=23.3085u cl=23.3085u
X32 top vref vcm vss vdd rel_32 hi_32 lo_32 adc_cdac_cell cw=16.4123u cl=16.4123u
X16 top vref vcm vss vdd rel_16 hi_16 lo_16 adc_cdac_cell cw=11.5363u cl=11.5363u
X8 top vref vcm vss vdd rel_8 hi_8 lo_8 adc_cdac_cell cw=8.0890u cl=8.0890u
X4 top vref vcm vss vdd rel_4 hi_4 lo_4 adc_cdac_cell cw=5.6521u cl=5.6521u
X2 top vref vcm vss vdd rel_2 hi_2 lo_2 adc_cdac_cell cw=3.9299u cl=3.9299u
X1 top vref vcm vss vdd rel_1 hi_1 lo_1 adc_cdac_cell cw=2.7136u cl=2.7136u
* terminating unit: DR-0011's 512th position, fixed to V_cm, never
* switched -- it is what makes the weight-1 trial resolve exactly one
* LSB of full scale rather than one part in 511.
Xterm top vcm mim_cap_2f0 c_width=2.7136u c_length=2.7136u
.ends adc_cdac_side
* --- ADC-TOP-NETLIST-END ---
