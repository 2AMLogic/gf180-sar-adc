* Frozen netlist snapshot for record 20260814-191138-f613571
* source     : sim/device-switch-ron/testbench/tb_switch_ron_extracted.spice
* sha256     : 926cd29abd9e5654b72a7fa9064b29ded6b2da85a6f7e71c04d50b35392e620f
* This is a verbatim copy taken at record time. Do not edit.
* ==================================================================
* tb_switch_ron_extracted -- the switch-R_on testbench with its
* transmission-gate branch wired against the EXTRACTED, PMOS-body-
* remediated `adc_tgate` leaf cell (sim/extracted-delta-summary.md
* SS6.3's Input-structure R_on re-take). GENERATED by
* layout/adc-top/parasitics/gen_extracted_switch_ron_tb.py -- do not
* edit.
*
* Runs sim/device-switch-ron/testbench/tb.json UNMODIFIED, via
* `run_corners.py device-switch-ron --netlist <this file>`. Everything
* above the transmission-gate section below -- the supply, the seven
* supply-tracking input points, and the whole NMOS-only and PMOS-only
* branches -- is copied VERBATIM from tb_switch_ron.spice, so ron_n_*
* and ron_p_* are a built-in control (they must come back bit-
* identical) and ron_t_* is the only measurement that can move.
* ==================================================================
* tb_switch_ron -- sampling-switch on-resistance vs input voltage
*
* Netlist FRAGMENT. The harness supplies the models, the corner .lib
* sections, .temp, the .control block and .end. Parameters provided by the
* harness: vdd_val, vdd_nom, temp_c.
*
* Question this answers (feeds #10, switch topology): how flat is R_on across
* the input range for an NMOS-only, a PMOS-only and a transmission-gate
* sampling switch, and which PVT corner is worst?
*
* Method. Each branch holds the switch source at a fixed input voltage and
* forces V_ds = 10 mV across the channel -- deep triode, small enough that
* R_on = 10 mV / |I| is the small-signal channel resistance rather than a
* large-signal average. One 10 mV source per branch means its current IS the
* channel current, with no divider or probe to correct for.
*
* WHY THE INPUT POINTS TRACK THE SUPPLY. The input is swept as a fraction of
* vdd_val, not as a fixed 0-3.3 V ladder. At the low-supply corner (2.97 V) a
* 3.3 V input would sit 330 mV above the rail: the PMOS source-body junction
* forward-biases and the "R_on" measured there is a forward-biased diode, not
* a switch. Sweeping f * vdd_val characterises each supply corner across its
* own rail-to-rail range, which is the physically meaningful comparison.
* (That a 0-3.3 V input range is NOT samplable at a drooped 2.97 V supply is
* itself a finding for #1/#10; see the characterization report.)
*
* Body connections are the single-well reality: NMOS body to ground, PMOS
* body to vdd. R_on therefore carries the body effect, which is most of the
* reason the NMOS degrades toward the top of the range.
*
* Device sizing. W is a free variable for #10 -- R_on scales as 1/W to first
* order -- so this testbench pins one geometry and reports the resistance for
* it: NMOS W = 10 um, PMOS W = 20 um (2:1 for the mobility ratio), both at
* L = 0.28 um (the 3.3 V minimum). The transmission gate is exactly those two
* devices in parallel. Scale by 10 um / W_actual to re-use these numbers.

vsup vdd 0 dc {vdd_val}

* ---- input ladder: 7 points from rail to rail ----------------------------
vin_f00  nf00  0 dc 0
vin_f17  nf17  0 dc {vdd_val/6}
vin_f33  nf33  0 dc {vdd_val/3}
vin_f50  nf50  0 dc {vdd_val/2}
vin_f67  nf67  0 dc {2*vdd_val/3}
vin_f83  nf83  0 dc {5*vdd_val/6}
vin_f100 nf100 0 dc {vdd_val}

* ===========================================================================
* NMOS-only switch, gate hard on at vdd
vdn_f00  ndn_f00  nf00  dc 10m
XN_f00   ndn_f00  vdd nf00  0 nfet_03v3 w=10u l=0.28u
vdn_f17  ndn_f17  nf17  dc 10m
XN_f17   ndn_f17  vdd nf17  0 nfet_03v3 w=10u l=0.28u
vdn_f33  ndn_f33  nf33  dc 10m
XN_f33   ndn_f33  vdd nf33  0 nfet_03v3 w=10u l=0.28u
vdn_f50  ndn_f50  nf50  dc 10m
XN_f50   ndn_f50  vdd nf50  0 nfet_03v3 w=10u l=0.28u
vdn_f67  ndn_f67  nf67  dc 10m
XN_f67   ndn_f67  vdd nf67  0 nfet_03v3 w=10u l=0.28u
vdn_f83  ndn_f83  nf83  dc 10m
XN_f83   ndn_f83  vdd nf83  0 nfet_03v3 w=10u l=0.28u
vdn_f100 ndn_f100 nf100 dc 10m
XN_f100  ndn_f100 vdd nf100 0 nfet_03v3 w=10u l=0.28u

* ===========================================================================
* PMOS-only switch, gate hard on at 0
vdp_f00  ndp_f00  nf00  dc 10m
XP_f00   ndp_f00  0 nf00  vdd pfet_03v3 w=20u l=0.28u
vdp_f17  ndp_f17  nf17  dc 10m
XP_f17   ndp_f17  0 nf17  vdd pfet_03v3 w=20u l=0.28u
vdp_f33  ndp_f33  nf33  dc 10m
XP_f33   ndp_f33  0 nf33  vdd pfet_03v3 w=20u l=0.28u
vdp_f50  ndp_f50  nf50  dc 10m
XP_f50   ndp_f50  0 nf50  vdd pfet_03v3 w=20u l=0.28u
vdp_f67  ndp_f67  nf67  dc 10m
XP_f67   ndp_f67  0 nf67  vdd pfet_03v3 w=20u l=0.28u
vdp_f83  ndp_f83  nf83  dc 10m
XP_f83   ndp_f83  0 nf83  vdd pfet_03v3 w=20u l=0.28u
vdp_f100 ndp_f100 nf100 dc 10m
XP_f100  ndp_f100 0 nf100 vdd pfet_03v3 w=20u l=0.28u

* ===========================================================================
* The DRAWN transmission gate, extracted with its parasitics.
*
* Source: layout/adc-top/parasitics/reports/20260806-230838-56be937/adc_tgate.para.spice
* (`klt extract --deck gf180mcu --parasitics --pdk`, asserted against
* layout/adc-top/parasitics/cells.json by run_extract_parasitics.py),
* post-processed by remediate_extracted.py --leaf, which promotes the
* anonymous Nwell net every PMOS body lands on to a `vnw` pin instead
* of tying it inside the cell. This deck wires that pin to vdd below --
* the single-well convention tb_switch_ron.spice's own header states.
*
* Device geometry is asserted equal on both sides before this file is
* written: nfet_03v3 W=10.0u L=0.28u, pfet_03v3 W=20.0u L=0.28u.
* ===========================================================================
* REMEDIATED extracted leaf cell -- NOT raw `klt extract` output.
* Produced by layout/adc-top/parasitics/remediate_extracted.py
* (remediate_leaf):
*   - 1 PMOS body terminal(s) on 1 anonymous Nwell net(s) promoted to a new
*     .SUBCKT pin 'vnw', so the instantiating testbench supplies the
*     well bias explicitly (local remediation of the klt PMOS-body gap;
*     upstream klayout-tools#555). No net is tied inside the cell.
*   - device geometry, connectivity and the parasitic RC ladder are untouched.
* See remediate_extracted.py's remediate_leaf() for provenance.
* cell ADC_TGATE
* pin gn
* pin gp
* pin vin
* pin vout
* pin vsubs
.SUBCKT ADC_TGATE gn gp vin vout vsubs vnw
* device instance $1 r0 *1 1.24,5 nfet
X$1 vin__t0 gn__t0 vout__t0 vsubs nfet_03v3 L=0.28U W=10U
* device instance $2 r0 *1 5.02,10 pfet
X$2 vin__t1 gp__t0 vout__t1 vnw pfet_03v3 L=0.28U W=20U
* device instance gn_t0 r0 *1 0,0
Rgn_t0 gn__t0 gn 53.1159
* device instance gn r0 *1 0,0
Cgn gn vsubs 5.87527e-16
* device instance gp_t0 r0 *1 0,0
Rgp_t0 gp__t0 gp 53.1159
* device instance gp r0 *1 0,0
Cgp gp vsubs 5.87527e-16
* device instance vin_t0 r0 *1 0,0
Rvin_t0 vin__t0 vin 60.0163
* device instance vin_t1 r0 *1 0,0
Rvin_t1 vin__t1 vin 60.0163
* device instance vin r0 *1 0,0
Cvin vin vsubs 4.208827e-15
* device instance vout_t0 r0 *1 0,0
Rvout_t0 vout__t0 vout 38.2668
* device instance vout_t1 r0 *1 0,0
Rvout_t1 vout__t1 vout 38.2668
* device instance vout r0 *1 0,0
Cvout vout vsubs 3.851043e-15
.ENDS ADC_TGATE

* ===========================================================================
* Transmission gate: one extracted-cell instance per input point.
* Same forcing method as the schematic branch it replaces -- a 10 mV
* source from the forced node to the input point, so its current IS the
* channel current and R_on = 10 mV / |I| at that input.
* Pin order: gn gp vin vout vsubs vnw  (gn = vdd, gp = 0: both devices hard on;
* vin = the forced node, vout = the input point, vsubs = 0, vnw = vdd.)
vdt_f00  ndt_f00  nf00  dc 10m
Xtg_f00  vdd 0 ndt_f00 nf00 0 vdd ADC_TGATE
vdt_f17  ndt_f17  nf17  dc 10m
Xtg_f17  vdd 0 ndt_f17 nf17 0 vdd ADC_TGATE
vdt_f33  ndt_f33  nf33  dc 10m
Xtg_f33  vdd 0 ndt_f33 nf33 0 vdd ADC_TGATE
vdt_f50  ndt_f50  nf50  dc 10m
Xtg_f50  vdd 0 ndt_f50 nf50 0 vdd ADC_TGATE
vdt_f67  ndt_f67  nf67  dc 10m
Xtg_f67  vdd 0 ndt_f67 nf67 0 vdd ADC_TGATE
vdt_f83  ndt_f83  nf83  dc 10m
Xtg_f83  vdd 0 ndt_f83 nf83 0 vdd ADC_TGATE
vdt_f100  ndt_f100  nf100  dc 10m
Xtg_f100  vdd 0 ndt_f100 nf100 0 vdd ADC_TGATE
