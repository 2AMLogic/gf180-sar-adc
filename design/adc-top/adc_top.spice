* ==================================================================
* adc_top.spice -- the SAR ADC analog core: CDAC array, its bottom-
* plate switches and their local drivers, and the input sampling
* switch.
*
* GENERATED by design/adc-top/gen_adc_top.py -- do not edit.
*
* This library holds ONLY what is not already owned by another
* canonical file. The comparator lives in design/comparator/
* comparator.spice and the SAR controller in design/sar-logic/
* sar_ctrl.spice; the testbenches under sim/adc-*/ inline all three.
*
* Fidelity (DR-0010): everything here is transistor level. The
* sequencer and the output register stay at rung 1 (ideal XSPICE
* primitives) because the open gf180mcu PDK ships no 3.3 V standard-
* cell library -- the gap DR-0010 names as an open precondition of
* rung 3. The T-gate DRIVERS are transistor level even so: they are
* custom cells placed with the CDAC (design/sar-logic/README.md), not
* standard cells, so the library gap does not apply to them, and they
* are the dominant digital load in a SAR ADC.
* ==================================================================

* --- ADC-TOP-NETLIST-BEGIN (verbatim-copied into every testbench) ---
* ---- switches ----------------------------------------------------
* CDAC bottom-plate T-gate. Same geometry as sim/device-switch-ron/
* and sim/cdac-bit-settling/, so R_on carries the corner sensitivity
* those records already characterised.
.subckt adc_tgate vin vout gn gp vdd wn=10u wp=20u
XN vin gn vout 0   nfet_03v3 w='wn' l=0.28u
XP vin gp vout vdd pfet_03v3 w='wp' l=0.28u
.ends adc_tgate

* Input sampling switch: dummy-compensated T-gate, DR-0007 (track
* switch) / DR-0013. Identical device text to the `tgate_dum` subckt
* sim/track-switch-sampling/ measured the ratified gain-error number
* with, at the same default rd = 7/16.
.subckt adc_tgate_dum vin vout clk clkb vdd wn=40u wp=80u rd=0.4375
XN  vin  clk  vout 0   nfet_03v3 w='wn' l=0.28u
XP  vin  clkb vout vdd pfet_03v3 w='wp' l=0.28u
XDN vout clkb vout 0   nfet_03v3 w='wn*rd' l=0.28u
XDP vout clk  vout vdd pfet_03v3 w='wp*rd' l=0.28u
.ends adc_tgate_dum

* Local T-gate driver -- one per leg, placed with the CDAC cell. This
* is design/sar-logic/sar_ctrl.spice's `sar_tgate_drv` promoted from
* its rung-1 ideal inverter to real devices: the controller routes
* only the active-high (NMOS gate) half of each leg, and the
* complementary PMOS gate is made here.
.subckt adc_drv a y vdd vss
Xp y a vdd vdd pfet_03v3 w=8u l=0.35u
Xn y a vss vss nfet_03v3 w=4u l=0.35u
.ends adc_drv

* ---- one CDAC cell ------------------------------------------------
* A weight-w block of unit capacitors and its three-way bottom-plate
* switch (DR-0011): released to V_cm, or engaged to V_REF or GND.
* Exactly one leg conducts at a time -- the one-hot invariant
* sim/sar-logic-functional/ checks on the control side.
.subckt adc_cdac_cell top vref vcm vss vdd gn_rel gn_hi gn_lo
+ cw=10u cl=10u
Xc  top bp mim_cap_2f0 c_width='cw' c_length='cl'
Xdr gn_rel gp_rel vdd vss adc_drv
Xdh gn_hi  gp_hi  vdd vss adc_drv
Xdl gn_lo  gp_lo  vdd vss adc_drv
Xsr vcm  bp gn_rel gp_rel vdd adc_tgate wn=10u wp=20u
Xsh vref bp gn_hi  gp_hi  vdd adc_tgate wn=10u wp=20u
Xsl vss  bp gn_lo  gp_lo  vdd adc_tgate wn=10u wp=20u
.ends adc_cdac_cell

* ---- one array side -----------------------------------------------
* DR-0011: 2^(N-1) = 512 unit positions per side -- nine binary
* weighted blocks (256..1, 511 units) plus one terminating unit fixed
* to V_cm. C_u = 17.24 fF (spec/cdac-sizing-memo.md Sec 4), so the
* per-side track-mode capacitance is 512 * C_u = 8.827 pF, which is
* the C_in the ratified Input-structure row publishes.
*
* Each block is drawn as ONE capacitor of the block's total area, not
* as w separate unit cells. That is exact for this campaign and it is
* deliberate: these records verify the NOMINAL design over PVT, where
* unit-to-unit mismatch is zero by construction, and the statistical
* spread of the same array is sim/mc-cdac-mismatch/'s claim, taken at
* nominal PVT with a behavioural model because the open PDK ships no
* local capacitor mismatch model at all. Drawing 1022 unit cells here
* would multiply simulation cost by ~50x and change no number.
*
* Areas from the measured MiM density law (devchar Sec 1.2),
* C(s) = 1.99*s^2 + 0.9532*s fF for a square of side s um:
*   w=256  C =   4413.44 fF  ->  s = 46.8547 um
*   w=128  C =   2206.72 fF  ->  s = 33.0616 um
*   w= 64  C =   1103.36 fF  ->  s = 23.3085 um
*   w= 32  C =    551.68 fF  ->  s = 16.4123 um
*   w= 16  C =    275.84 fF  ->  s = 11.5363 um
*   w=  8  C =    137.92 fF  ->  s = 8.0890 um
*   w=  4  C =     68.96 fF  ->  s = 5.6521 um
*   w=  2  C =     34.48 fF  ->  s = 3.9299 um
*   w=  1  C =     17.24 fF  ->  s = 2.7136 um
.subckt adc_cdac_side top vref vcm vss vdd rel_256 hi_256 lo_256 rel_128
+ hi_128 lo_128 rel_64 hi_64 lo_64 rel_32 hi_32 lo_32 rel_16 hi_16 lo_16
+ rel_8 hi_8 lo_8 rel_4 hi_4 lo_4 rel_2 hi_2 lo_2 rel_1 hi_1 lo_1
X256 top vref vcm vss vdd rel_256 hi_256 lo_256 adc_cdac_cell cw=46.8547u cl=46.8547u
X128 top vref vcm vss vdd rel_128 hi_128 lo_128 adc_cdac_cell cw=33.0616u cl=33.0616u
X64 top vref vcm vss vdd rel_64 hi_64 lo_64 adc_cdac_cell cw=23.3085u cl=23.3085u
X32 top vref vcm vss vdd rel_32 hi_32 lo_32 adc_cdac_cell cw=16.4123u cl=16.4123u
X16 top vref vcm vss vdd rel_16 hi_16 lo_16 adc_cdac_cell cw=11.5363u cl=11.5363u
X8 top vref vcm vss vdd rel_8 hi_8 lo_8 adc_cdac_cell cw=8.0890u cl=8.0890u
X4 top vref vcm vss vdd rel_4 hi_4 lo_4 adc_cdac_cell cw=5.6521u cl=5.6521u
X2 top vref vcm vss vdd rel_2 hi_2 lo_2 adc_cdac_cell cw=3.9299u cl=3.9299u
X1 top vref vcm vss vdd rel_1 hi_1 lo_1 adc_cdac_cell cw=2.7136u cl=2.7136u
* terminating unit: DR-0011's 512th position, fixed to V_cm, never
* switched -- it is what makes the weight-1 trial resolve exactly one
* LSB of full scale rather than one part in 511.
Xterm top vcm mim_cap_2f0 c_width=2.7136u c_length=2.7136u
.ends adc_cdac_side
* --- ADC-TOP-NETLIST-END ---
