* extracted by klt extract --deck gf180mcu

* cell sar_ctrl_a
* pin VDD
* pin VDD
* pin VDD
* pin VDD
* pin VDD
* pin VSS
* pin c0_r
* pin c1_r
* pin c2_r
* pin c3_r
* pin c4_r
* pin c5_r
* pin c6_r
* pin c7_r
* pin c8_r
* pin c9_r
* pin clk
* pin cmp
* pin mode
* pin ph[15]
* pin rel_n_128n
* pin rel_n_128p
* pin rel_n_16n
* pin rel_n_16p
* pin rel_n_1n
* pin rel_n_1p
* pin rel_n_256n
* pin rel_n_256p
* pin rel_n_2n
* pin rel_n_2p
* pin rel_n_32n
* pin rel_n_32p
* pin rel_n_4n
* pin rel_n_4p
* pin rel_n_64n
* pin rel_n_64p
* pin rel_n_8n
* pin rel_n_8p
* pin samp_tp_n
* pin sel_hi_n_128n
* pin sel_hi_n_128p
* pin sel_hi_n_16n
* pin sel_hi_n_16p
* pin sel_hi_n_1n
* pin sel_hi_n_1p
* pin sel_hi_n_256n
* pin sel_hi_n_256p
* pin sel_hi_n_2n
* pin sel_hi_n_2p
* pin sel_hi_n_32n
* pin sel_hi_n_32p
* pin sel_hi_n_4n
* pin sel_hi_n_4p
* pin sel_hi_n_64n
* pin sel_hi_n_64p
* pin sel_hi_n_8n
* pin sel_hi_n_8p
* pin sel_in_n
* pin sel_lo_n_128n
* pin sel_lo_n_128p
* pin sel_lo_n_16n
* pin sel_lo_n_16p
* pin sel_lo_n_1n
* pin sel_lo_n_1p
* pin sel_lo_n_256n
* pin sel_lo_n_256p
* pin sel_lo_n_2n
* pin sel_lo_n_2p
* pin sel_lo_n_32n
* pin sel_lo_n_32p
* pin sel_lo_n_4n
* pin sel_lo_n_4p
* pin sel_lo_n_64n
* pin sel_lo_n_64p
* pin sel_lo_n_8n
* pin sel_lo_n_8p
* pin start
.SUBCKT sar_ctrl_a VDD VDD$1 VDD$2 VDD$3 VDD$4 VSS c0_r c1_r c2_r c3_r c4_r
+ c5_r c6_r c7_r c8_r c9_r clk cmp mode ph[15] rel_n_128n rel_n_128p rel_n_16n
+ rel_n_16p rel_n_1n rel_n_1p rel_n_256n rel_n_256p rel_n_2n rel_n_2p rel_n_32n
+ rel_n_32p rel_n_4n rel_n_4p rel_n_64n rel_n_64p rel_n_8n rel_n_8p samp_tp_n
+ sel_hi_n_128n sel_hi_n_128p sel_hi_n_16n sel_hi_n_16p sel_hi_n_1n sel_hi_n_1p
+ sel_hi_n_256n sel_hi_n_256p sel_hi_n_2n sel_hi_n_2p sel_hi_n_32n sel_hi_n_32p
+ sel_hi_n_4n sel_hi_n_4p sel_hi_n_64n sel_hi_n_64p sel_hi_n_8n sel_hi_n_8p
+ sel_in_n sel_lo_n_128n sel_lo_n_128p sel_lo_n_16n sel_lo_n_16p sel_lo_n_1n
+ sel_lo_n_1p sel_lo_n_256n sel_lo_n_256p sel_lo_n_2n sel_lo_n_2p sel_lo_n_32n
+ sel_lo_n_32p sel_lo_n_4n sel_lo_n_4p sel_lo_n_64n sel_lo_n_64p sel_lo_n_8n
+ sel_lo_n_8p start
* device instance $1 r0 *1 17.34,0.75 nfet
M$1 ph[11] \$42 VSS VSS nfet L=0.6U W=0.82U AS=0.3608P AD=0.3608P PS=2.52U
+ PD=2.52U
* device instance $2 r0 *1 45.9,0.75 nfet
M$2 eng2 \$52 VSS VSS nfet L=0.6U W=0.82U AS=0.3608P AD=0.3608P PS=2.52U
+ PD=2.52U
* device instance $3 r0 *1 78.78,0.595 nfet
M$3 VSS sel_in_n rel_n_8n VSS nfet L=0.6U W=0.51U AS=0.2569P AD=0.2244P
+ PS=1.56U PD=1.9U
* device instance $4 r0 *1 76.52,0.75 nfet
M$4 \$93 eng4 VSS VSS nfet L=0.6U W=0.82U AS=0.3608P AD=0.1312P PS=2.52U
+ PD=1.14U
* device instance $5 r0 *1 77.44,0.75 nfet
M$5 rel_n_8n mode \$93 VSS nfet L=0.6U W=0.82U AS=0.1312P AD=0.2569P PS=1.14U
+ PD=1.56U
* device instance $6 r0 *1 89.98,0.595 nfet
M$6 VSS sel_in_n rel_n_128n VSS nfet L=0.6U W=0.51U AS=0.2569P AD=0.2244P
+ PS=1.56U PD=1.9U
* device instance $7 r0 *1 87.72,0.75 nfet
M$7 \$94 eng8 VSS VSS nfet L=0.6U W=0.82U AS=0.3608P AD=0.1312P PS=2.52U
+ PD=1.14U
* device instance $8 r0 *1 88.64,0.75 nfet
M$8 rel_n_128n mode \$94 VSS nfet L=0.6U W=0.82U AS=0.1312P AD=0.2569P PS=1.14U
+ PD=1.56U
* device instance $9 r0 *1 124.7,0.595 nfet
M$9 VSS sel_in_n rel_n_1n VSS nfet L=0.6U W=0.51U AS=0.2569P AD=0.2244P
+ PS=1.56U PD=1.9U
* device instance $10 r0 *1 122.44,0.75 nfet
M$10 \$96 eng1 VSS VSS nfet L=0.6U W=0.82U AS=0.3608P AD=0.1312P PS=2.52U
+ PD=1.14U
* device instance $11 r0 *1 123.36,0.75 nfet
M$11 rel_n_1n mode \$96 VSS nfet L=0.6U W=0.82U AS=0.1312P AD=0.2569P PS=1.14U
+ PD=1.56U
* device instance $12 r0 *1 144.28,0.75 nfet
M$12 ZN clknet_2_2__leaf_clk VSS VSS nfet L=0.6U W=0.82U AS=0.3608P AD=0.2132P
+ PS=2.52U PD=1.34U
* device instance $13 r0 *1 145.4,0.75 nfet
M$13 VSS clknet_2_2__leaf_clk ZN VSS nfet L=0.6U W=0.82U AS=0.2132P AD=0.2132P
+ PS=1.34U PD=1.34U
* device instance $14 r0 *1 146.52,0.75 nfet
M$14 ZN clknet_2_2__leaf_clk VSS VSS nfet L=0.6U W=0.82U AS=0.2132P AD=0.3608P
+ PS=1.34U PD=2.52U
* device instance $15 r0 *1 166.3,0.75 nfet
M$15 ph[7] \$72 VSS VSS nfet L=0.6U W=0.82U AS=0.3608P AD=0.3608P PS=2.52U
+ PD=2.52U
* device instance $16 r0 *1 191.5,0.75 nfet
M$16 ph[1] \$79 VSS VSS nfet L=0.6U W=0.82U AS=0.3608P AD=0.3608P PS=2.52U
+ PD=2.52U
* device instance $17 r0 *1 19.4,0.92 nfet
M$17 \_047_ ph[10] VSS VSS nfet L=0.6U W=0.48U AS=0.2112P AD=0.2112P PS=1.84U
+ PD=1.84U
* device instance $18 r0 *1 54.68,0.8075 nfet
M$18 sel_lo_n_2p q2 VSS VSS nfet L=0.6U W=0.565U AS=0.2486P AD=0.1469P PS=2.01U
+ PD=1.085U
* device instance $19 r0 *1 55.8,0.8075 nfet
M$19 VSS \_042_ sel_lo_n_2p VSS nfet L=0.6U W=0.565U AS=0.1469P AD=0.2486P
+ PS=1.085U PD=2.01U
* device instance $20 r0 *1 58.04,0.8075 nfet
M$20 sel_lo_n_4p q3 VSS VSS nfet L=0.6U W=0.565U AS=0.2486P AD=0.1469P PS=2.01U
+ PD=1.085U
* device instance $21 r0 *1 59.16,0.8075 nfet
M$21 VSS \_030_ sel_lo_n_4p VSS nfet L=0.6U W=0.565U AS=0.1469P AD=0.2486P
+ PS=1.085U PD=2.01U
* device instance $22 r0 *1 84.36,0.8075 nfet
M$22 rel_n_32p sel_in_n VSS VSS nfet L=0.6U W=0.565U AS=0.2486P AD=0.1469P
+ PS=2.01U PD=1.085U
* device instance $23 r0 *1 85.48,0.8075 nfet
M$23 VSS eng6 rel_n_32p VSS nfet L=0.6U W=0.565U AS=0.1469P AD=0.2486P
+ PS=1.085U PD=2.01U
* device instance $24 r0 *1 93.32,0.92 nfet
M$24 \_031_ mode VSS VSS nfet L=0.6U W=0.48U AS=0.2112P AD=0.2112P PS=1.84U
+ PD=1.84U
* device instance $25 r0 *1 97.24,0.8075 nfet
M$25 rel_n_128p sel_in_n VSS VSS nfet L=0.6U W=0.565U AS=0.2486P AD=0.1469P
+ PS=2.01U PD=1.085U
* device instance $26 r0 *1 98.36,0.8075 nfet
M$26 VSS eng8 rel_n_128p VSS nfet L=0.6U W=0.565U AS=0.1469P AD=0.2486P
+ PS=1.085U PD=2.01U
* device instance $27 r0 *1 113.48,0.7575 nfet
M$27 sel_hi_n_1n q1 VSS VSS nfet L=0.6U W=0.465U AS=0.2046P AD=0.1209P PS=1.81U
+ PD=0.985U
* device instance $28 r0 *1 114.6,0.7575 nfet
M$28 VSS \_044_ sel_hi_n_1n VSS nfet L=0.6U W=0.465U AS=0.1209P AD=0.1209P
+ PS=0.985U PD=0.985U
* device instance $29 r0 *1 115.72,0.7575 nfet
M$29 sel_hi_n_1n \_031_ VSS VSS nfet L=0.6U W=0.465U AS=0.1209P AD=0.2046P
+ PS=0.985U PD=1.81U
* device instance $30 r0 *1 134.2,0.7575 nfet
M$30 sel_hi_n_32n \_038_ VSS VSS nfet L=0.6U W=0.465U AS=0.2046P AD=0.1209P
+ PS=1.81U PD=0.985U
* device instance $31 r0 *1 135.32,0.7575 nfet
M$31 VSS q6 sel_hi_n_32n VSS nfet L=0.6U W=0.465U AS=0.1209P AD=0.1209P
+ PS=0.985U PD=0.985U
* device instance $32 r0 *1 136.44,0.7575 nfet
M$32 sel_hi_n_32n \_031_ VSS VSS nfet L=0.6U W=0.465U AS=0.1209P AD=0.2046P
+ PS=0.985U PD=1.81U
* device instance $33 r0 *1 140.92,0.92 nfet
M$33 \_038_ eng6 VSS VSS nfet L=0.6U W=0.48U AS=0.2112P AD=0.2112P PS=1.84U
+ PD=1.84U
* device instance $34 r0 *1 3.16,0.9575 nfet
M$34 VSS clknet_2_0__leaf_clk \$35 VSS nfet L=0.6U W=0.405U AS=0.1782P
+ AD=0.1053P PS=1.69U PD=0.925U
* device instance $35 r0 *1 4.28,0.9575 nfet
M$35 \$37 \$35 VSS VSS nfet L=0.6U W=0.405U AS=0.1053P AD=0.1782P PS=0.925U
+ PD=1.69U
* device instance $36 r0 *1 6.12,0.975 nfet
M$36 \$80 \$35 VSS VSS nfet L=0.6U W=0.36U AS=0.1584P AD=0.0432P PS=1.6U PD=0.6U
* device instance $37 r0 *1 6.96,0.975 nfet
M$37 \$39 \_009_[11] \$80 VSS nfet L=0.6U W=0.36U AS=0.0432P AD=0.207P PS=0.6U
+ PD=1.51U
* device instance $38 r0 *1 8.58,0.975 nfet
M$38 \$81 \$37 \$39 VSS nfet L=0.6U W=0.36U AS=0.207P AD=0.0432P PS=1.51U
+ PD=0.6U
* device instance $39 r0 *1 9.42,0.975 nfet
M$39 \$81 \$40 VSS VSS nfet L=0.6U W=0.36U AS=0.2637P AD=0.0432P PS=1.825U
+ PD=0.6U
* device instance $40 r0 *1 10.98,0.975 nfet
M$40 \$40 \$39 VSS VSS nfet L=0.6U W=0.36U AS=0.2637P AD=0.0936P PS=1.825U
+ PD=0.88U
* device instance $41 r0 *1 12.1,0.975 nfet
M$41 \$41 \$37 \$40 VSS nfet L=0.6U W=0.36U AS=0.0936P AD=0.0936P PS=0.88U
+ PD=0.88U
* device instance $42 r0 *1 13.22,0.975 nfet
M$42 \$83 \$35 \$41 VSS nfet L=0.6U W=0.36U AS=0.0936P AD=0.0432P PS=0.88U
+ PD=0.6U
* device instance $43 r0 *1 14.06,0.975 nfet
M$43 \$83 \$42 VSS VSS nfet L=0.6U W=0.36U AS=0.142P AD=0.0432P PS=1.14U PD=0.6U
* device instance $44 r0 *1 15.4,0.955 nfet
M$44 \$42 \$41 VSS VSS nfet L=0.6U W=0.4U AS=0.142P AD=0.176P PS=1.14U PD=1.68U
* device instance $45 r0 *1 31.72,0.9575 nfet
M$45 VSS clknet_2_0__leaf_clk \$46 VSS nfet L=0.6U W=0.405U AS=0.1782P
+ AD=0.1053P PS=1.69U PD=0.925U
* device instance $46 r0 *1 32.84,0.9575 nfet
M$46 \$47 \$46 VSS VSS nfet L=0.6U W=0.405U AS=0.1053P AD=0.1782P PS=0.925U
+ PD=1.69U
* device instance $47 r0 *1 34.68,0.975 nfet
M$47 \$86 \$46 VSS VSS nfet L=0.6U W=0.36U AS=0.1584P AD=0.0432P PS=1.6U PD=0.6U
* device instance $48 r0 *1 35.52,0.975 nfet
M$48 \$49 \_001_ \$86 VSS nfet L=0.6U W=0.36U AS=0.0432P AD=0.207P PS=0.6U
+ PD=1.51U
* device instance $49 r0 *1 37.14,0.975 nfet
M$49 \$87 \$47 \$49 VSS nfet L=0.6U W=0.36U AS=0.207P AD=0.0432P PS=1.51U
+ PD=0.6U
* device instance $50 r0 *1 37.98,0.975 nfet
M$50 \$87 \$50 VSS VSS nfet L=0.6U W=0.36U AS=0.2637P AD=0.0432P PS=1.825U
+ PD=0.6U
* device instance $51 r0 *1 39.54,0.975 nfet
M$51 \$50 \$49 VSS VSS nfet L=0.6U W=0.36U AS=0.2637P AD=0.0936P PS=1.825U
+ PD=0.88U
* device instance $52 r0 *1 40.66,0.975 nfet
M$52 \$51 \$47 \$50 VSS nfet L=0.6U W=0.36U AS=0.0936P AD=0.0936P PS=0.88U
+ PD=0.88U
* device instance $53 r0 *1 41.78,0.975 nfet
M$53 \$88 \$46 \$51 VSS nfet L=0.6U W=0.36U AS=0.0936P AD=0.0432P PS=0.88U
+ PD=0.6U
* device instance $54 r0 *1 42.62,0.975 nfet
M$54 \$88 \$52 VSS VSS nfet L=0.6U W=0.36U AS=0.142P AD=0.0432P PS=1.14U PD=0.6U
* device instance $55 r0 *1 43.96,0.955 nfet
M$55 \$52 \$51 VSS VSS nfet L=0.6U W=0.4U AS=0.142P AD=0.176P PS=1.14U PD=1.68U
* device instance $56 r0 *1 61.4,0.9775 nfet
M$56 \$92 mode \$55 VSS nfet L=0.6U W=0.365U AS=0.1606P AD=0.0584P PS=1.61U
+ PD=0.685U
* device instance $57 r0 *1 62.32,0.9775 nfet
M$57 \$92 sel_hi_n_64p VSS VSS nfet L=0.6U W=0.365U AS=0.23405P AD=0.0584P
+ PS=1.555U PD=0.685U
* device instance $58 r0 *1 63.66,0.7525 nfet
M$58 sel_lo_n_64n \$55 VSS VSS nfet L=0.6U W=0.815U AS=0.23405P AD=0.3586P
+ PS=1.555U PD=2.51U
* device instance $59 r0 *1 101.72,0.9775 nfet
M$59 \$95 mode \$59 VSS nfet L=0.6U W=0.365U AS=0.1606P AD=0.0584P PS=1.61U
+ PD=0.685U
* device instance $60 r0 *1 102.64,0.9775 nfet
M$60 \$95 sel_hi_n_2p VSS VSS nfet L=0.6U W=0.365U AS=0.23405P AD=0.0584P
+ PS=1.555U PD=0.685U
* device instance $61 r0 *1 103.98,0.7525 nfet
M$61 sel_lo_n_2n \$59 VSS VSS nfet L=0.6U W=0.815U AS=0.23405P AD=0.3586P
+ PS=1.555U PD=2.51U
* device instance $62 r0 *1 109,0.9775 nfet
M$62 \$97 q6 \$60 VSS nfet L=0.6U W=0.365U AS=0.1606P AD=0.0584P PS=1.61U
+ PD=0.685U
* device instance $63 r0 *1 109.92,0.9775 nfet
M$63 \$97 eng6 VSS VSS nfet L=0.6U W=0.365U AS=0.23405P AD=0.0584P PS=1.555U
+ PD=0.685U
* device instance $64 r0 *1 111.26,0.7525 nfet
M$64 sel_hi_n_32p \$60 VSS VSS nfet L=0.6U W=0.815U AS=0.23405P AD=0.3586P
+ PS=1.555U PD=2.51U
* device instance $65 r0 *1 152.12,0.9575 nfet
M$65 VSS clknet_2_2__leaf_clk \$66 VSS nfet L=0.6U W=0.405U AS=0.1782P
+ AD=0.1053P PS=1.69U PD=0.925U
* device instance $66 r0 *1 153.24,0.9575 nfet
M$66 \$67 \$66 VSS VSS nfet L=0.6U W=0.405U AS=0.1053P AD=0.1782P PS=0.925U
+ PD=1.69U
* device instance $67 r0 *1 155.08,0.975 nfet
M$67 \$91 \$66 VSS VSS nfet L=0.6U W=0.36U AS=0.1584P AD=0.0432P PS=1.6U PD=0.6U
* device instance $68 r0 *1 155.92,0.975 nfet
M$68 \$69 \_009_[7] \$91 VSS nfet L=0.6U W=0.36U AS=0.0432P AD=0.207P PS=0.6U
+ PD=1.51U
* device instance $69 r0 *1 157.54,0.975 nfet
M$69 \$90 \$67 \$69 VSS nfet L=0.6U W=0.36U AS=0.207P AD=0.0432P PS=1.51U
+ PD=0.6U
* device instance $70 r0 *1 158.38,0.975 nfet
M$70 \$90 \$70 VSS VSS nfet L=0.6U W=0.36U AS=0.2637P AD=0.0432P PS=1.825U
+ PD=0.6U
* device instance $71 r0 *1 159.94,0.975 nfet
M$71 \$70 \$69 VSS VSS nfet L=0.6U W=0.36U AS=0.2637P AD=0.0936P PS=1.825U
+ PD=0.88U
* device instance $72 r0 *1 161.06,0.975 nfet
M$72 \$71 \$67 \$70 VSS nfet L=0.6U W=0.36U AS=0.0936P AD=0.0936P PS=0.88U
+ PD=0.88U
* device instance $73 r0 *1 162.18,0.975 nfet
M$73 \$89 \$66 \$71 VSS nfet L=0.6U W=0.36U AS=0.0936P AD=0.0432P PS=0.88U
+ PD=0.6U
* device instance $74 r0 *1 163.02,0.975 nfet
M$74 \$89 \$72 VSS VSS nfet L=0.6U W=0.36U AS=0.142P AD=0.0432P PS=1.14U PD=0.6U
* device instance $75 r0 *1 164.36,0.955 nfet
M$75 \$72 \$71 VSS VSS nfet L=0.6U W=0.4U AS=0.142P AD=0.176P PS=1.14U PD=1.68U
* device instance $76 r0 *1 177.32,0.9575 nfet
M$76 VSS clknet_2_2__leaf_clk \$73 VSS nfet L=0.6U W=0.405U AS=0.1782P
+ AD=0.1053P PS=1.69U PD=0.925U
* device instance $77 r0 *1 178.44,0.9575 nfet
M$77 \$74 \$73 VSS VSS nfet L=0.6U W=0.405U AS=0.1053P AD=0.1782P PS=0.925U
+ PD=1.69U
* device instance $78 r0 *1 180.28,0.975 nfet
M$78 \$85 \$73 VSS VSS nfet L=0.6U W=0.36U AS=0.1584P AD=0.0432P PS=1.6U PD=0.6U
* device instance $79 r0 *1 181.12,0.975 nfet
M$79 \$76 \_009_[1] \$85 VSS nfet L=0.6U W=0.36U AS=0.0432P AD=0.207P PS=0.6U
+ PD=1.51U
* device instance $80 r0 *1 182.74,0.975 nfet
M$80 \$84 \$74 \$76 VSS nfet L=0.6U W=0.36U AS=0.207P AD=0.0432P PS=1.51U
+ PD=0.6U
* device instance $81 r0 *1 183.58,0.975 nfet
M$81 \$84 \$77 VSS VSS nfet L=0.6U W=0.36U AS=0.2637P AD=0.0432P PS=1.825U
+ PD=0.6U
* device instance $82 r0 *1 185.14,0.975 nfet
M$82 \$77 \$76 VSS VSS nfet L=0.6U W=0.36U AS=0.2637P AD=0.0936P PS=1.825U
+ PD=0.88U
* device instance $83 r0 *1 186.26,0.975 nfet
M$83 \$78 \$74 \$77 VSS nfet L=0.6U W=0.36U AS=0.0936P AD=0.0936P PS=0.88U
+ PD=0.88U
* device instance $84 r0 *1 187.38,0.975 nfet
M$84 \$82 \$73 \$78 VSS nfet L=0.6U W=0.36U AS=0.0936P AD=0.0432P PS=0.88U
+ PD=0.6U
* device instance $85 r0 *1 188.22,0.975 nfet
M$85 \$82 \$79 VSS VSS nfet L=0.6U W=0.36U AS=0.142P AD=0.0432P PS=1.14U PD=0.6U
* device instance $86 r0 *1 189.56,0.955 nfet
M$86 \$79 \$78 VSS VSS nfet L=0.6U W=0.4U AS=0.142P AD=0.176P PS=1.14U PD=1.68U
* device instance $87 r0 *1 8.2,6.8825 nfet
M$87 VSS clknet_2_0__leaf_clk \$129 VSS nfet L=0.6U W=0.405U AS=0.1782P
+ AD=0.1053P PS=1.69U PD=0.925U
* device instance $88 r0 *1 9.32,6.8825 nfet
M$88 \$131 \$129 VSS VSS nfet L=0.6U W=0.405U AS=0.1053P AD=0.1782P PS=0.925U
+ PD=1.69U
* device instance $89 r0 *1 11.16,6.865 nfet
M$89 \$210 \$129 VSS VSS nfet L=0.6U W=0.36U AS=0.1584P AD=0.0432P PS=1.6U
+ PD=0.6U
* device instance $90 r0 *1 12,6.865 nfet
M$90 \$210 \_029_ \$157 VSS nfet L=0.6U W=0.36U AS=0.207P AD=0.0432P PS=1.51U
+ PD=0.6U
* device instance $91 r0 *1 13.62,6.865 nfet
M$91 \$211 \$131 \$157 VSS nfet L=0.6U W=0.36U AS=0.207P AD=0.0432P PS=1.51U
+ PD=0.6U
* device instance $92 r0 *1 14.46,6.865 nfet
M$92 VSS \$130 \$211 VSS nfet L=0.6U W=0.36U AS=0.0432P AD=0.2637P PS=0.6U
+ PD=1.825U
* device instance $93 r0 *1 16.02,6.865 nfet
M$93 \$130 \$157 VSS VSS nfet L=0.6U W=0.36U AS=0.2637P AD=0.0936P PS=1.825U
+ PD=0.88U
* device instance $94 r0 *1 17.14,6.865 nfet
M$94 \$158 \$131 \$130 VSS nfet L=0.6U W=0.36U AS=0.0936P AD=0.0936P PS=0.88U
+ PD=0.88U
* device instance $95 r0 *1 18.26,6.865 nfet
M$95 \$212 \$129 \$158 VSS nfet L=0.6U W=0.36U AS=0.0936P AD=0.0432P PS=0.88U
+ PD=0.6U
* device instance $96 r0 *1 19.1,6.865 nfet
M$96 VSS \$132 \$212 VSS nfet L=0.6U W=0.36U AS=0.0432P AD=0.142P PS=0.6U
+ PD=1.14U
* device instance $97 r0 *1 20.44,6.885 nfet
M$97 \$132 \$158 VSS VSS nfet L=0.6U W=0.4U AS=0.142P AD=0.176P PS=1.14U
+ PD=1.68U
* device instance $98 r0 *1 22.38,7.09 nfet
M$98 q3 \$132 VSS VSS nfet L=0.6U W=0.82U AS=0.3608P AD=0.3608P PS=2.52U
+ PD=2.52U
* device instance $99 r0 *1 29.48,6.8825 nfet
M$99 VSS clknet_2_0__leaf_clk \$133 VSS nfet L=0.6U W=0.405U AS=0.1782P
+ AD=0.1053P PS=1.69U PD=0.925U
* device instance $100 r0 *1 30.6,6.8825 nfet
M$100 \$135 \$133 VSS VSS nfet L=0.6U W=0.405U AS=0.1053P AD=0.1782P PS=0.925U
+ PD=1.69U
* device instance $101 r0 *1 32.44,6.865 nfet
M$101 \$213 \$133 VSS VSS nfet L=0.6U W=0.36U AS=0.1584P AD=0.0432P PS=1.6U
+ PD=0.6U
* device instance $102 r0 *1 33.28,6.865 nfet
M$102 \$213 \_002_ \$159 VSS nfet L=0.6U W=0.36U AS=0.207P AD=0.0432P PS=1.51U
+ PD=0.6U
* device instance $103 r0 *1 34.9,6.865 nfet
M$103 \$214 \$135 \$159 VSS nfet L=0.6U W=0.36U AS=0.207P AD=0.0432P PS=1.51U
+ PD=0.6U
* device instance $104 r0 *1 35.74,6.865 nfet
M$104 VSS \$134 \$214 VSS nfet L=0.6U W=0.36U AS=0.0432P AD=0.2637P PS=0.6U
+ PD=1.825U
* device instance $105 r0 *1 37.3,6.865 nfet
M$105 \$134 \$159 VSS VSS nfet L=0.6U W=0.36U AS=0.2637P AD=0.0936P PS=1.825U
+ PD=0.88U
* device instance $106 r0 *1 38.42,6.865 nfet
M$106 \$160 \$135 \$134 VSS nfet L=0.6U W=0.36U AS=0.0936P AD=0.0936P PS=0.88U
+ PD=0.88U
* device instance $107 r0 *1 39.54,6.865 nfet
M$107 \$216 \$133 \$160 VSS nfet L=0.6U W=0.36U AS=0.0936P AD=0.0432P PS=0.88U
+ PD=0.6U
* device instance $108 r0 *1 40.38,6.865 nfet
M$108 VSS \$136 \$216 VSS nfet L=0.6U W=0.36U AS=0.0432P AD=0.142P PS=0.6U
+ PD=1.14U
* device instance $109 r0 *1 41.72,6.885 nfet
M$109 \$136 \$160 VSS VSS nfet L=0.6U W=0.4U AS=0.142P AD=0.176P PS=1.14U
+ PD=1.68U
* device instance $110 r0 *1 43.66,7.09 nfet
M$110 eng3 \$136 VSS VSS nfet L=0.6U W=0.82U AS=0.3608P AD=0.3608P PS=2.52U
+ PD=2.52U
* device instance $111 r0 *1 45.72,6.92 nfet
M$111 \_030_ eng3 VSS VSS nfet L=0.6U W=0.48U AS=0.2112P AD=0.2112P PS=1.84U
+ PD=1.84U
* device instance $112 r0 *1 61.4,6.8625 nfet
M$112 \$218 q4 \$137 VSS nfet L=0.6U W=0.365U AS=0.1606P AD=0.0584P PS=1.61U
+ PD=0.685U
* device instance $113 r0 *1 62.32,6.8625 nfet
M$113 VSS eng4 \$218 VSS nfet L=0.6U W=0.365U AS=0.0584P AD=0.23405P PS=0.685U
+ PD=1.555U
* device instance $114 r0 *1 63.66,7.0875 nfet
M$114 sel_hi_n_8p \$137 VSS VSS nfet L=0.6U W=0.815U AS=0.23405P AD=0.3586P
+ PS=1.555U PD=2.51U
* device instance $115 r0 *1 68.12,6.8625 nfet
M$115 \$219 mode \$139 VSS nfet L=0.6U W=0.365U AS=0.1606P AD=0.0584P PS=1.61U
+ PD=0.685U
* device instance $116 r0 *1 69.04,6.8625 nfet
M$116 VSS sel_hi_n_8p \$219 VSS nfet L=0.6U W=0.365U AS=0.0584P AD=0.23405P
+ PS=0.685U PD=1.555U
* device instance $117 r0 *1 70.38,7.0875 nfet
M$117 sel_lo_n_8n \$139 VSS VSS nfet L=0.6U W=0.815U AS=0.23405P AD=0.3586P
+ PS=1.555U PD=2.51U
* device instance $118 r0 *1 73.16,6.8625 nfet
M$118 \$221 mode \$141 VSS nfet L=0.6U W=0.365U AS=0.1606P AD=0.0584P PS=1.61U
+ PD=0.685U
* device instance $119 r0 *1 74.08,6.8625 nfet
M$119 VSS sel_hi_n_1p \$221 VSS nfet L=0.6U W=0.365U AS=0.0584P AD=0.23405P
+ PS=0.685U PD=1.555U
* device instance $120 r0 *1 75.42,7.0875 nfet
M$120 sel_lo_n_1n \$141 VSS VSS nfet L=0.6U W=0.815U AS=0.23405P AD=0.3586P
+ PS=1.555U PD=2.51U
* device instance $121 r0 *1 80.44,7.09 nfet
M$121 \$223 eng2 VSS VSS nfet L=0.6U W=0.82U AS=0.3608P AD=0.1312P PS=2.52U
+ PD=1.14U
* device instance $122 r0 *1 81.36,7.09 nfet
M$122 rel_n_2n mode \$223 VSS nfet L=0.6U W=0.82U AS=0.1312P AD=0.2569P
+ PS=1.14U PD=1.56U
* device instance $123 r0 *1 82.7,7.245 nfet
M$123 VSS sel_in_n rel_n_2n VSS nfet L=0.6U W=0.51U AS=0.2569P AD=0.2244P
+ PS=1.56U PD=1.9U
* device instance $124 r0 *1 86.6,6.8625 nfet
M$124 \$225 mode \$143 VSS nfet L=0.6U W=0.365U AS=0.1606P AD=0.0584P PS=1.61U
+ PD=0.685U
* device instance $125 r0 *1 87.52,6.8625 nfet
M$125 VSS sel_hi_n_4p \$225 VSS nfet L=0.6U W=0.365U AS=0.0584P AD=0.23405P
+ PS=0.685U PD=1.555U
* device instance $126 r0 *1 88.86,7.0875 nfet
M$126 sel_lo_n_4n \$143 VSS VSS nfet L=0.6U W=0.815U AS=0.23405P AD=0.3586P
+ PS=1.555U PD=2.51U
* device instance $127 r0 *1 92.2,7.0325 nfet
M$127 rel_n_64p sel_in_n VSS VSS nfet L=0.6U W=0.565U AS=0.2486P AD=0.1469P
+ PS=2.01U PD=1.085U
* device instance $128 r0 *1 93.32,7.0325 nfet
M$128 VSS eng7 rel_n_64p VSS nfet L=0.6U W=0.565U AS=0.1469P AD=0.2486P
+ PS=1.085U PD=2.01U
* device instance $129 r0 *1 97.24,7.0325 nfet
M$129 rel_n_2p sel_in_n VSS VSS nfet L=0.6U W=0.565U AS=0.2486P AD=0.1469P
+ PS=2.01U PD=1.085U
* device instance $130 r0 *1 98.36,7.0325 nfet
M$130 VSS eng2 rel_n_2p VSS nfet L=0.6U W=0.565U AS=0.1469P AD=0.2486P
+ PS=1.085U PD=2.01U
* device instance $131 r0 *1 102.28,7.0325 nfet
M$131 rel_n_1p sel_in_n VSS VSS nfet L=0.6U W=0.565U AS=0.2486P AD=0.1469P
+ PS=2.01U PD=1.085U
* device instance $132 r0 *1 103.4,7.0325 nfet
M$132 VSS eng1 rel_n_1p VSS nfet L=0.6U W=0.565U AS=0.1469P AD=0.2486P
+ PS=1.085U PD=2.01U
* device instance $133 r0 *1 105.64,7.0325 nfet
M$133 rel_n_4p sel_in_n VSS VSS nfet L=0.6U W=0.565U AS=0.2486P AD=0.1469P
+ PS=2.01U PD=1.085U
* device instance $134 r0 *1 106.76,7.0325 nfet
M$134 VSS eng3 rel_n_4p VSS nfet L=0.6U W=0.565U AS=0.1469P AD=0.2486P
+ PS=1.085U PD=2.01U
* device instance $135 r0 *1 110.12,7.09 nfet
M$135 \$229 eng7 VSS VSS nfet L=0.6U W=0.82U AS=0.3608P AD=0.1312P PS=2.52U
+ PD=1.14U
* device instance $136 r0 *1 111.04,7.09 nfet
M$136 rel_n_64n mode \$229 VSS nfet L=0.6U W=0.82U AS=0.1312P AD=0.2569P
+ PS=1.14U PD=1.56U
* device instance $137 r0 *1 112.38,7.245 nfet
M$137 VSS sel_in_n rel_n_64n VSS nfet L=0.6U W=0.51U AS=0.2569P AD=0.2244P
+ PS=1.56U PD=1.9U
* device instance $138 r0 *1 114.6,6.8625 nfet
M$138 \$230 mode \$147 VSS nfet L=0.6U W=0.365U AS=0.1606P AD=0.0584P PS=1.61U
+ PD=0.685U
* device instance $139 r0 *1 115.52,6.8625 nfet
M$139 VSS sel_hi_n_32p \$230 VSS nfet L=0.6U W=0.365U AS=0.0584P AD=0.23405P
+ PS=0.685U PD=1.555U
* device instance $140 r0 *1 116.86,7.0875 nfet
M$140 sel_lo_n_32n \$147 VSS VSS nfet L=0.6U W=0.815U AS=0.23405P AD=0.3586P
+ PS=1.555U PD=2.51U
* device instance $141 r0 *1 119.64,7.09 nfet
M$141 \$231 mode VSS VSS nfet L=0.6U W=0.82U AS=0.3608P AD=0.1312P PS=2.52U
+ PD=1.14U
* device instance $142 r0 *1 120.56,7.09 nfet
M$142 rel_n_4n eng3 \$231 VSS nfet L=0.6U W=0.82U AS=0.1312P AD=0.2569P
+ PS=1.14U PD=1.56U
* device instance $143 r0 *1 121.9,7.245 nfet
M$143 VSS sel_in_n rel_n_4n VSS nfet L=0.6U W=0.51U AS=0.2569P AD=0.2244P
+ PS=1.56U PD=1.9U
* device instance $144 r0 *1 124.12,7.0325 nfet
M$144 rel_n_256p sel_in_n VSS VSS nfet L=0.6U W=0.565U AS=0.2486P AD=0.1469P
+ PS=2.01U PD=1.085U
* device instance $145 r0 *1 125.24,7.0325 nfet
M$145 VSS eng9 rel_n_256p VSS nfet L=0.6U W=0.565U AS=0.1469P AD=0.2486P
+ PS=1.085U PD=2.01U
* device instance $146 r0 *1 128.6,7.0325 nfet
M$146 rel_n_8p sel_in_n VSS VSS nfet L=0.6U W=0.565U AS=0.2486P AD=0.1469P
+ PS=2.01U PD=1.085U
* device instance $147 r0 *1 129.72,7.0325 nfet
M$147 VSS eng4 rel_n_8p VSS nfet L=0.6U W=0.565U AS=0.1469P AD=0.2486P
+ PS=1.085U PD=2.01U
* device instance $148 r0 *1 137,7.0325 nfet
M$148 rel_n_16p sel_in_n VSS VSS nfet L=0.6U W=0.565U AS=0.2486P AD=0.1469P
+ PS=2.01U PD=1.085U
* device instance $149 r0 *1 138.12,7.0325 nfet
M$149 VSS eng5 rel_n_16p VSS nfet L=0.6U W=0.565U AS=0.1469P AD=0.2486P
+ PS=1.085U PD=2.01U
* device instance $150 r0 *1 141.48,6.8825 nfet
M$150 VSS clknet_2_2__leaf_clk \$149 VSS nfet L=0.6U W=0.405U AS=0.1782P
+ AD=0.1053P PS=1.69U PD=0.925U
* device instance $151 r0 *1 142.6,6.8825 nfet
M$151 \$151 \$149 VSS VSS nfet L=0.6U W=0.405U AS=0.1053P AD=0.1782P PS=0.925U
+ PD=1.69U
* device instance $152 r0 *1 144.44,6.865 nfet
M$152 \$228 \$149 VSS VSS nfet L=0.6U W=0.36U AS=0.1584P AD=0.0432P PS=1.6U
+ PD=0.6U
* device instance $153 r0 *1 145.28,6.865 nfet
M$153 \$228 \_005_ \$169 VSS nfet L=0.6U W=0.36U AS=0.207P AD=0.0432P PS=1.51U
+ PD=0.6U
* device instance $154 r0 *1 146.9,6.865 nfet
M$154 \$227 \$151 \$169 VSS nfet L=0.6U W=0.36U AS=0.207P AD=0.0432P PS=1.51U
+ PD=0.6U
* device instance $155 r0 *1 147.74,6.865 nfet
M$155 VSS \$150 \$227 VSS nfet L=0.6U W=0.36U AS=0.0432P AD=0.2637P PS=0.6U
+ PD=1.825U
* device instance $156 r0 *1 149.3,6.865 nfet
M$156 \$150 \$169 VSS VSS nfet L=0.6U W=0.36U AS=0.2637P AD=0.0936P PS=1.825U
+ PD=0.88U
* device instance $157 r0 *1 150.42,6.865 nfet
M$157 \$170 \$151 \$150 VSS nfet L=0.6U W=0.36U AS=0.0936P AD=0.0936P PS=0.88U
+ PD=0.88U
* device instance $158 r0 *1 151.54,6.865 nfet
M$158 \$226 \$149 \$170 VSS nfet L=0.6U W=0.36U AS=0.0936P AD=0.0432P PS=0.88U
+ PD=0.6U
* device instance $159 r0 *1 152.38,6.865 nfet
M$159 VSS \$152 \$226 VSS nfet L=0.6U W=0.36U AS=0.0432P AD=0.142P PS=0.6U
+ PD=1.14U
* device instance $160 r0 *1 153.72,6.885 nfet
M$160 \$152 \$170 VSS VSS nfet L=0.6U W=0.4U AS=0.142P AD=0.176P PS=1.14U
+ PD=1.68U
* device instance $161 r0 *1 155.66,7.09 nfet
M$161 eng6 \$152 VSS VSS nfet L=0.6U W=0.82U AS=0.3608P AD=0.3608P PS=2.52U
+ PD=2.52U
* device instance $162 r0 *1 161.08,6.8825 nfet
M$162 VSS clknet_2_2__leaf_clk \$153 VSS nfet L=0.6U W=0.405U AS=0.1782P
+ AD=0.1053P PS=1.69U PD=0.925U
* device instance $163 r0 *1 162.2,6.8825 nfet
M$163 \$155 \$153 VSS VSS nfet L=0.6U W=0.405U AS=0.1053P AD=0.1782P PS=0.925U
+ PD=1.69U
* device instance $164 r0 *1 164.04,6.865 nfet
M$164 \$224 \$153 VSS VSS nfet L=0.6U W=0.36U AS=0.1584P AD=0.0432P PS=1.6U
+ PD=0.6U
* device instance $165 r0 *1 164.88,6.865 nfet
M$165 \$224 \_009_[0] \$171 VSS nfet L=0.6U W=0.36U AS=0.207P AD=0.0432P
+ PS=1.51U PD=0.6U
* device instance $166 r0 *1 166.5,6.865 nfet
M$166 \$222 \$155 \$171 VSS nfet L=0.6U W=0.36U AS=0.207P AD=0.0432P PS=1.51U
+ PD=0.6U
* device instance $167 r0 *1 167.34,6.865 nfet
M$167 VSS \$154 \$222 VSS nfet L=0.6U W=0.36U AS=0.0432P AD=0.2637P PS=0.6U
+ PD=1.825U
* device instance $168 r0 *1 168.9,6.865 nfet
M$168 \$154 \$171 VSS VSS nfet L=0.6U W=0.36U AS=0.2637P AD=0.0936P PS=1.825U
+ PD=0.88U
* device instance $169 r0 *1 170.02,6.865 nfet
M$169 \$172 \$155 \$154 VSS nfet L=0.6U W=0.36U AS=0.0936P AD=0.0936P PS=0.88U
+ PD=0.88U
* device instance $170 r0 *1 171.14,6.865 nfet
M$170 \$220 \$153 \$172 VSS nfet L=0.6U W=0.36U AS=0.0936P AD=0.0432P PS=0.88U
+ PD=0.6U
* device instance $171 r0 *1 171.98,6.865 nfet
M$171 VSS \$156 \$220 VSS nfet L=0.6U W=0.36U AS=0.0432P AD=0.142P PS=0.6U
+ PD=1.14U
* device instance $172 r0 *1 173.32,6.885 nfet
M$172 \$156 \$172 VSS VSS nfet L=0.6U W=0.4U AS=0.142P AD=0.176P PS=1.14U
+ PD=1.68U
* device instance $173 r0 *1 175.26,7.09 nfet
M$173 ph[0] \$156 VSS VSS nfet L=0.6U W=0.82U AS=0.3608P AD=0.3608P PS=2.52U
+ PD=2.52U
* device instance $174 r0 *1 177.88,6.92 nfet
M$174 \_033_ ph[0] VSS VSS nfet L=0.6U W=0.48U AS=0.2112P AD=0.2112P PS=1.84U
+ PD=1.84U
* device instance $175 r0 *1 181.935,7.09 nfet
M$175 \$217 \_034_ VSS VSS nfet L=0.6U W=0.82U AS=0.3608P AD=0.1312P PS=2.52U
+ PD=1.14U
* device instance $176 r0 *1 182.855,7.09 nfet
M$176 \$215 \_033_ \$217 VSS nfet L=0.6U W=0.82U AS=0.1312P AD=0.1722P PS=1.14U
+ PD=1.24U
* device instance $177 r0 *1 183.875,7.09 nfet
M$177 samp_tp_n \_032_ \$215 VSS nfet L=0.6U W=0.82U AS=0.1722P AD=0.3608P
+ PS=1.24U PD=2.52U
* device instance $178 r0 *1 185.72,6.92 nfet
M$178 \_034_ ph[1] VSS VSS nfet L=0.6U W=0.48U AS=0.2112P AD=0.2112P PS=1.84U
+ PD=1.84U
* device instance $179 r0 *1 187.96,6.92 nfet
M$179 \_032_ ph[2] VSS VSS nfet L=0.6U W=0.48U AS=0.2112P AD=0.2112P PS=1.84U
+ PD=1.84U
* device instance $180 r0 *1 8.76,8.6475 nfet
M$180 \_009_[11] start VSS VSS nfet L=0.6U W=0.565U AS=0.2486P AD=0.1469P
+ PS=2.01U PD=1.085U
* device instance $181 r0 *1 9.88,8.6475 nfet
M$181 VSS \_047_ \_009_[11] VSS nfet L=0.6U W=0.565U AS=0.1469P AD=0.2486P
+ PS=1.085U PD=2.01U
* device instance $182 r0 *1 14.38,8.435 nfet
M$182 VSS \_064_ \_029_ VSS nfet L=0.6U W=0.51U AS=0.2569P AD=0.2244P PS=1.56U
+ PD=1.9U
* device instance $183 r0 *1 12.12,8.59 nfet
M$183 \$273 cmp VSS VSS nfet L=0.6U W=0.82U AS=0.3608P AD=0.1312P PS=2.52U
+ PD=1.14U
* device instance $184 r0 *1 13.04,8.59 nfet
M$184 \_029_ ph[10] \$273 VSS nfet L=0.6U W=0.82U AS=0.1312P AD=0.2569P
+ PS=1.14U PD=1.56U
* device instance $185 r0 *1 16.6,8.6475 nfet
M$185 \_064_ ph[10] VSS VSS nfet L=0.6U W=0.565U AS=0.2486P AD=0.1469P PS=2.01U
+ PD=1.085U
* device instance $186 r0 *1 17.72,8.6475 nfet
M$186 VSS q3 \_064_ VSS nfet L=0.6U W=0.565U AS=0.1469P AD=0.2486P PS=1.085U
+ PD=2.01U
* device instance $187 r0 *1 19.96,8.6475 nfet
M$187 \_057_ ph[11] VSS VSS nfet L=0.6U W=0.565U AS=0.2486P AD=0.1469P PS=2.01U
+ PD=1.085U
* device instance $188 r0 *1 21.08,8.6475 nfet
M$188 VSS q2 \_057_ VSS nfet L=0.6U W=0.565U AS=0.1469P AD=0.2486P PS=1.085U
+ PD=2.01U
* device instance $189 r0 *1 35.1,8.435 nfet
M$189 VSS ph[13] \_002_ VSS nfet L=0.6U W=0.51U AS=0.2569P AD=0.2244P PS=1.56U
+ PD=1.9U
* device instance $190 r0 *1 32.84,8.59 nfet
M$190 \$274 \_047_ VSS VSS nfet L=0.6U W=0.82U AS=0.3608P AD=0.1312P PS=2.52U
+ PD=1.14U
* device instance $191 r0 *1 33.76,8.59 nfet
M$191 \_002_ \_030_ \$274 VSS nfet L=0.6U W=0.82U AS=0.1312P AD=0.2569P
+ PS=1.14U PD=1.56U
* device instance $192 r0 *1 39.58,8.435 nfet
M$192 VSS ph[13] \_000_ VSS nfet L=0.6U W=0.51U AS=0.2569P AD=0.2244P PS=1.56U
+ PD=1.9U
* device instance $193 r0 *1 37.32,8.59 nfet
M$193 \$275 \_044_ VSS VSS nfet L=0.6U W=0.82U AS=0.3608P AD=0.1312P PS=2.52U
+ PD=1.14U
* device instance $194 r0 *1 38.24,8.59 nfet
M$194 \_000_ \_043_ \$275 VSS nfet L=0.6U W=0.82U AS=0.1312P AD=0.2569P
+ PS=1.14U PD=1.56U
* device instance $195 r0 *1 45.72,8.76 nfet
M$195 \_036_ eng4 VSS VSS nfet L=0.6U W=0.48U AS=0.2112P AD=0.2112P PS=1.84U
+ PD=1.84U
* device instance $196 r0 *1 47.96,8.76 nfet
M$196 \_042_ eng2 VSS VSS nfet L=0.6U W=0.48U AS=0.2112P AD=0.2112P PS=1.84U
+ PD=1.84U
* device instance $197 r0 *1 56.36,8.5975 nfet
M$197 sel_hi_n_8n \_036_ VSS VSS nfet L=0.6U W=0.465U AS=0.2046P AD=0.1209P
+ PS=1.81U PD=0.985U
* device instance $198 r0 *1 57.48,8.5975 nfet
M$198 VSS q4 sel_hi_n_8n VSS nfet L=0.6U W=0.465U AS=0.1209P AD=0.1209P
+ PS=0.985U PD=0.985U
* device instance $199 r0 *1 58.6,8.5975 nfet
M$199 sel_hi_n_8n \_031_ VSS VSS nfet L=0.6U W=0.465U AS=0.1209P AD=0.2046P
+ PS=0.985U PD=1.81U
* device instance $200 r0 *1 56.92,7.0825 nfet
M$200 sel_hi_n_2n q2 VSS VSS nfet L=0.6U W=0.465U AS=0.2046P AD=0.1209P
+ PS=1.81U PD=0.985U
* device instance $201 r0 *1 58.04,7.0825 nfet
M$201 VSS \_042_ sel_hi_n_2n VSS nfet L=0.6U W=0.465U AS=0.1209P AD=0.1209P
+ PS=0.985U PD=0.985U
* device instance $202 r0 *1 59.16,7.0825 nfet
M$202 sel_hi_n_2n \_031_ VSS VSS nfet L=0.6U W=0.465U AS=0.1209P AD=0.2046P
+ PS=0.985U PD=1.81U
* device instance $203 r0 *1 60.84,8.8175 nfet
M$203 \$278 eng3 \$248 VSS nfet L=0.6U W=0.365U AS=0.1606P AD=0.0584P PS=1.61U
+ PD=0.685U
* device instance $204 r0 *1 61.76,8.8175 nfet
M$204 \$278 q3 VSS VSS nfet L=0.6U W=0.365U AS=0.23405P AD=0.0584P PS=1.555U
+ PD=0.685U
* device instance $205 r0 *1 63.1,8.5925 nfet
M$205 sel_hi_n_4p \$248 VSS VSS nfet L=0.6U W=0.815U AS=0.23405P AD=0.3586P
+ PS=1.555U PD=2.51U
* device instance $206 r0 *1 65.32,8.8175 nfet
M$206 \$280 mode \$249 VSS nfet L=0.6U W=0.365U AS=0.1606P AD=0.0584P PS=1.61U
+ PD=0.685U
* device instance $207 r0 *1 66.24,8.8175 nfet
M$207 \$280 sel_hi_n_128p VSS VSS nfet L=0.6U W=0.365U AS=0.23405P AD=0.0584P
+ PS=1.555U PD=0.685U
* device instance $208 r0 *1 67.58,8.5925 nfet
M$208 sel_lo_n_128n \$249 VSS VSS nfet L=0.6U W=0.815U AS=0.23405P AD=0.3586P
+ PS=1.555U PD=2.51U
* device instance $209 r0 *1 74.28,8.8175 nfet
M$209 \$281 eng1 \$250 VSS nfet L=0.6U W=0.365U AS=0.1606P AD=0.0584P PS=1.61U
+ PD=0.685U
* device instance $210 r0 *1 75.2,8.8175 nfet
M$210 \$281 q1 VSS VSS nfet L=0.6U W=0.365U AS=0.23405P AD=0.0584P PS=1.555U
+ PD=0.685U
* device instance $211 r0 *1 76.54,8.5925 nfet
M$211 sel_hi_n_1p \$250 VSS VSS nfet L=0.6U W=0.815U AS=0.23405P AD=0.3586P
+ PS=1.555U PD=2.51U
* device instance $212 r0 *1 82.14,8.435 nfet
M$212 VSS sel_in_n rel_n_32n VSS nfet L=0.6U W=0.51U AS=0.2569P AD=0.2244P
+ PS=1.56U PD=1.9U
* device instance $213 r0 *1 79.88,8.59 nfet
M$213 \$283 eng6 VSS VSS nfet L=0.6U W=0.82U AS=0.3608P AD=0.1312P PS=2.52U
+ PD=1.14U
* device instance $214 r0 *1 80.8,8.59 nfet
M$214 rel_n_32n mode \$283 VSS nfet L=0.6U W=0.82U AS=0.1312P AD=0.2569P
+ PS=1.14U PD=1.56U
* device instance $215 r0 *1 86.62,8.435 nfet
M$215 VSS sel_in_n rel_n_256n VSS nfet L=0.6U W=0.51U AS=0.2569P AD=0.2244P
+ PS=1.56U PD=1.9U
* device instance $216 r0 *1 84.36,8.59 nfet
M$216 \$284 eng9 VSS VSS nfet L=0.6U W=0.82U AS=0.3608P AD=0.1312P PS=2.52U
+ PD=1.14U
* device instance $217 r0 *1 85.28,8.59 nfet
M$217 rel_n_256n mode \$284 VSS nfet L=0.6U W=0.82U AS=0.1312P AD=0.2569P
+ PS=1.14U PD=1.56U
* device instance $218 r0 *1 93.32,8.8175 nfet
M$218 \$285 eng2 \$251 VSS nfet L=0.6U W=0.365U AS=0.1606P AD=0.0584P PS=1.61U
+ PD=0.685U
* device instance $219 r0 *1 94.24,8.8175 nfet
M$219 \$285 q2 VSS VSS nfet L=0.6U W=0.365U AS=0.23405P AD=0.0584P PS=1.555U
+ PD=0.685U
* device instance $220 r0 *1 95.58,8.5925 nfet
M$220 sel_hi_n_2p \$251 VSS VSS nfet L=0.6U W=0.815U AS=0.23405P AD=0.3586P
+ PS=1.555U PD=2.51U
* device instance $221 r0 *1 101.72,8.8175 nfet
M$221 \$286 q7 \$252 VSS nfet L=0.6U W=0.365U AS=0.1606P AD=0.0584P PS=1.61U
+ PD=0.685U
* device instance $222 r0 *1 102.64,8.8175 nfet
M$222 \$286 eng7 VSS VSS nfet L=0.6U W=0.365U AS=0.23405P AD=0.0584P PS=1.555U
+ PD=0.685U
* device instance $223 r0 *1 103.98,8.5925 nfet
M$223 sel_hi_n_64p \$252 VSS VSS nfet L=0.6U W=0.815U AS=0.23405P AD=0.3586P
+ PS=1.555U PD=2.51U
* device instance $224 r0 *1 107.32,8.8175 nfet
M$224 \$288 q5 \$253 VSS nfet L=0.6U W=0.365U AS=0.1606P AD=0.0584P PS=1.61U
+ PD=0.685U
* device instance $225 r0 *1 108.24,8.8175 nfet
M$225 \$288 eng5 VSS VSS nfet L=0.6U W=0.365U AS=0.23405P AD=0.0584P PS=1.555U
+ PD=0.685U
* device instance $226 r0 *1 109.58,8.5925 nfet
M$226 sel_hi_n_16p \$253 VSS VSS nfet L=0.6U W=0.815U AS=0.23405P AD=0.3586P
+ PS=1.555U PD=2.51U
* device instance $227 r0 *1 111.8,8.6475 nfet
M$227 sel_lo_n_1p q1 VSS VSS nfet L=0.6U W=0.565U AS=0.2486P AD=0.1469P
+ PS=2.01U PD=1.085U
* device instance $228 r0 *1 112.92,8.6475 nfet
M$228 VSS \_044_ sel_lo_n_1p VSS nfet L=0.6U W=0.565U AS=0.1469P AD=0.2486P
+ PS=1.085U PD=2.01U
* device instance $229 r0 *1 115.16,8.5975 nfet
M$229 sel_hi_n_16n \_037_ VSS VSS nfet L=0.6U W=0.465U AS=0.2046P AD=0.1209P
+ PS=1.81U PD=0.985U
* device instance $230 r0 *1 116.28,8.5975 nfet
M$230 VSS q5 sel_hi_n_16n VSS nfet L=0.6U W=0.465U AS=0.1209P AD=0.1209P
+ PS=0.985U PD=0.985U
* device instance $231 r0 *1 117.4,8.5975 nfet
M$231 sel_hi_n_16n \_031_ VSS VSS nfet L=0.6U W=0.465U AS=0.1209P AD=0.2046P
+ PS=0.985U PD=1.81U
* device instance $232 r0 *1 123.02,8.435 nfet
M$232 VSS sel_in_n rel_n_16n VSS nfet L=0.6U W=0.51U AS=0.2569P AD=0.2244P
+ PS=1.56U PD=1.9U
* device instance $233 r0 *1 120.76,8.59 nfet
M$233 \$287 eng5 VSS VSS nfet L=0.6U W=0.82U AS=0.3608P AD=0.1312P PS=2.52U
+ PD=1.14U
* device instance $234 r0 *1 121.68,8.59 nfet
M$234 rel_n_16n mode \$287 VSS nfet L=0.6U W=0.82U AS=0.1312P AD=0.2569P
+ PS=1.14U PD=1.56U
* device instance $235 r0 *1 127.48,8.6475 nfet
M$235 sel_lo_n_16p \_037_ VSS VSS nfet L=0.6U W=0.565U AS=0.2486P AD=0.1469P
+ PS=2.01U PD=1.085U
* device instance $236 r0 *1 128.6,8.6475 nfet
M$236 VSS q5 sel_lo_n_16p VSS nfet L=0.6U W=0.565U AS=0.1469P AD=0.2486P
+ PS=1.085U PD=2.01U
* device instance $237 r0 *1 132.52,7.0825 nfet
M$237 sel_hi_n_64n \_039_ VSS VSS nfet L=0.6U W=0.465U AS=0.2046P AD=0.1209P
+ PS=1.81U PD=0.985U
* device instance $238 r0 *1 133.64,7.0825 nfet
M$238 VSS q7 sel_hi_n_64n VSS nfet L=0.6U W=0.465U AS=0.1209P AD=0.1209P
+ PS=0.985U PD=0.985U
* device instance $239 r0 *1 134.76,7.0825 nfet
M$239 sel_hi_n_64n \_031_ VSS VSS nfet L=0.6U W=0.465U AS=0.1209P AD=0.2046P
+ PS=0.985U PD=1.81U
* device instance $240 r0 *1 132.52,8.5975 nfet
M$240 sel_hi_n_128n \_040_ VSS VSS nfet L=0.6U W=0.465U AS=0.2046P AD=0.1209P
+ PS=1.81U PD=0.985U
* device instance $241 r0 *1 133.64,8.5975 nfet
M$241 VSS q8 sel_hi_n_128n VSS nfet L=0.6U W=0.465U AS=0.1209P AD=0.1209P
+ PS=0.985U PD=0.985U
* device instance $242 r0 *1 134.76,8.5975 nfet
M$242 sel_hi_n_128n \_031_ VSS VSS nfet L=0.6U W=0.465U AS=0.1209P AD=0.2046P
+ PS=0.985U PD=1.81U
* device instance $243 r0 *1 140.92,8.76 nfet
M$243 \_039_ eng7 VSS VSS nfet L=0.6U W=0.48U AS=0.2112P AD=0.2112P PS=1.84U
+ PD=1.84U
* device instance $244 r0 *1 145.42,8.435 nfet
M$244 VSS ph[13] \_006_ VSS nfet L=0.6U W=0.51U AS=0.2569P AD=0.2244P PS=1.56U
+ PD=1.9U
* device instance $245 r0 *1 143.16,8.59 nfet
M$245 \$282 \_051_ VSS VSS nfet L=0.6U W=0.82U AS=0.3608P AD=0.1312P PS=2.52U
+ PD=1.14U
* device instance $246 r0 *1 144.08,8.59 nfet
M$246 \_006_ \_039_ \$282 VSS nfet L=0.6U W=0.82U AS=0.1312P AD=0.2569P
+ PS=1.14U PD=1.56U
* device instance $247 r0 *1 153.855,8.485 nfet
M$247 \$261 start VSS VSS nfet L=0.6U W=0.36U AS=0.1584P AD=0.0936P PS=1.6U
+ PD=0.88U
* device instance $248 r0 *1 154.975,8.485 nfet
M$248 \$261 ph[15] VSS VSS nfet L=0.6U W=0.36U AS=0.2288P AD=0.0936P PS=1.58U
+ PD=0.88U
* device instance $249 r0 *1 156.335,8.59 nfet
M$249 \_009_[0] \$261 VSS VSS nfet L=0.6U W=0.82U AS=0.2288P AD=0.3608P
+ PS=1.58U PD=2.52U
* device instance $250 r0 *1 158.28,8.7975 nfet
M$250 VSS clknet_2_2__leaf_clk \$262 VSS nfet L=0.6U W=0.405U AS=0.1782P
+ AD=0.1053P PS=1.69U PD=0.925U
* device instance $251 r0 *1 159.4,8.7975 nfet
M$251 \$263 \$262 VSS VSS nfet L=0.6U W=0.405U AS=0.1053P AD=0.1782P PS=0.925U
+ PD=1.69U
* device instance $252 r0 *1 161.24,8.815 nfet
M$252 \$279 \$262 VSS VSS nfet L=0.6U W=0.36U AS=0.1584P AD=0.0432P PS=1.6U
+ PD=0.6U
* device instance $253 r0 *1 162.08,8.815 nfet
M$253 \$265 \_014_ \$279 VSS nfet L=0.6U W=0.36U AS=0.0432P AD=0.207P PS=0.6U
+ PD=1.51U
* device instance $254 r0 *1 163.7,8.815 nfet
M$254 \$277 \$263 \$265 VSS nfet L=0.6U W=0.36U AS=0.207P AD=0.0432P PS=1.51U
+ PD=0.6U
* device instance $255 r0 *1 164.54,8.815 nfet
M$255 \$277 \$266 VSS VSS nfet L=0.6U W=0.36U AS=0.2637P AD=0.0432P PS=1.825U
+ PD=0.6U
* device instance $256 r0 *1 166.1,8.815 nfet
M$256 \$266 \$265 VSS VSS nfet L=0.6U W=0.36U AS=0.2637P AD=0.0936P PS=1.825U
+ PD=0.88U
* device instance $257 r0 *1 167.22,8.815 nfet
M$257 \$267 \$263 \$266 VSS nfet L=0.6U W=0.36U AS=0.0936P AD=0.0936P PS=0.88U
+ PD=0.88U
* device instance $258 r0 *1 168.34,8.815 nfet
M$258 \$276 \$262 \$267 VSS nfet L=0.6U W=0.36U AS=0.0936P AD=0.0432P PS=0.88U
+ PD=0.6U
* device instance $259 r0 *1 169.18,8.815 nfet
M$259 \$276 \$268 VSS VSS nfet L=0.6U W=0.36U AS=0.142P AD=0.0432P PS=1.14U
+ PD=0.6U
* device instance $260 r0 *1 170.52,8.795 nfet
M$260 \$268 \$267 VSS VSS nfet L=0.6U W=0.4U AS=0.142P AD=0.176P PS=1.14U
+ PD=1.68U
* device instance $261 r0 *1 172.46,8.59 nfet
M$261 q6 \$268 VSS VSS nfet L=0.6U W=0.82U AS=0.3608P AD=0.3608P PS=2.52U
+ PD=2.52U
* device instance $262 r0 *1 175.64,8.6475 nfet
M$262 \_009_[2] start VSS VSS nfet L=0.6U W=0.565U AS=0.2486P AD=0.1469P
+ PS=2.01U PD=1.085U
* device instance $263 r0 *1 176.76,8.6475 nfet
M$263 VSS \_034_ \_009_[2] VSS nfet L=0.6U W=0.565U AS=0.1469P AD=0.2486P
+ PS=1.085U PD=2.01U
* device instance $264 r0 *1 179,8.6475 nfet
M$264 \_061_ ph[5] VSS VSS nfet L=0.6U W=0.565U AS=0.2486P AD=0.1469P PS=2.01U
+ PD=1.085U
* device instance $265 r0 *1 180.12,8.6475 nfet
M$265 VSS q8 \_061_ VSS nfet L=0.6U W=0.565U AS=0.1469P AD=0.2486P PS=1.085U
+ PD=2.01U
* device instance $266 r0 *1 182.36,8.6475 nfet
M$266 \_009_[3] start VSS VSS nfet L=0.6U W=0.565U AS=0.2486P AD=0.1469P
+ PS=2.01U PD=1.085U
* device instance $267 r0 *1 183.48,8.6475 nfet
M$267 VSS \_032_ \_009_[3] VSS nfet L=0.6U W=0.565U AS=0.1469P AD=0.2486P
+ PS=1.085U PD=2.01U
* device instance $268 r0 *1 185.72,8.485 nfet
M$268 \$272 ph[2] VSS VSS nfet L=0.6U W=0.36U AS=0.1584P AD=0.126P PS=1.6U
+ PD=1.06U
* device instance $269 r0 *1 187.02,8.485 nfet
M$269 VSS ph[0] \$272 VSS nfet L=0.6U W=0.36U AS=0.126P AD=0.0936P PS=1.06U
+ PD=0.88U
* device instance $270 r0 *1 188.14,8.485 nfet
M$270 \$272 ph[1] VSS VSS nfet L=0.6U W=0.36U AS=0.0936P AD=0.0936P PS=0.88U
+ PD=0.88U
* device instance $271 r0 *1 189.26,8.485 nfet
M$271 \$272 ph[3] VSS VSS nfet L=0.6U W=0.36U AS=0.218P AD=0.0936P PS=1.52U
+ PD=0.88U
* device instance $272 r0 *1 190.56,8.59 nfet
M$272 sel_in_n \$272 VSS VSS nfet L=0.6U W=0.82U AS=0.218P AD=0.3608P PS=1.52U
+ PD=2.52U
* device instance $273 r0 *1 2.04,14.7225 nfet
M$273 VSS clknet_2_0__leaf_clk \$324 VSS nfet L=0.6U W=0.405U AS=0.1782P
+ AD=0.1053P PS=1.69U PD=0.925U
* device instance $274 r0 *1 3.16,14.7225 nfet
M$274 \$327 \$324 VSS VSS nfet L=0.6U W=0.405U AS=0.1053P AD=0.1782P PS=0.925U
+ PD=1.69U
* device instance $275 r0 *1 5,14.705 nfet
M$275 \$385 \$324 VSS VSS nfet L=0.6U W=0.36U AS=0.1584P AD=0.0432P PS=1.6U
+ PD=0.6U
* device instance $276 r0 *1 5.84,14.705 nfet
M$276 \$385 \_009_[10] \$325 VSS nfet L=0.6U W=0.36U AS=0.207P AD=0.0432P
+ PS=1.51U PD=0.6U
* device instance $277 r0 *1 7.46,14.705 nfet
M$277 \$386 \$327 \$325 VSS nfet L=0.6U W=0.36U AS=0.207P AD=0.0432P PS=1.51U
+ PD=0.6U
* device instance $278 r0 *1 8.3,14.705 nfet
M$278 VSS \$326 \$386 VSS nfet L=0.6U W=0.36U AS=0.0432P AD=0.2637P PS=0.6U
+ PD=1.825U
* device instance $279 r0 *1 9.86,14.705 nfet
M$279 \$326 \$325 VSS VSS nfet L=0.6U W=0.36U AS=0.2637P AD=0.0936P PS=1.825U
+ PD=0.88U
* device instance $280 r0 *1 10.98,14.705 nfet
M$280 \$328 \$327 \$326 VSS nfet L=0.6U W=0.36U AS=0.0936P AD=0.0936P PS=0.88U
+ PD=0.88U
* device instance $281 r0 *1 12.1,14.705 nfet
M$281 \$387 \$324 \$328 VSS nfet L=0.6U W=0.36U AS=0.0936P AD=0.0432P PS=0.88U
+ PD=0.6U
* device instance $282 r0 *1 12.94,14.705 nfet
M$282 VSS \$329 \$387 VSS nfet L=0.6U W=0.36U AS=0.0432P AD=0.142P PS=0.6U
+ PD=1.14U
* device instance $283 r0 *1 14.28,14.725 nfet
M$283 \$329 \$328 VSS VSS nfet L=0.6U W=0.4U AS=0.142P AD=0.176P PS=1.14U
+ PD=1.68U
* device instance $284 r0 *1 16.22,14.93 nfet
M$284 ph[10] \$329 VSS VSS nfet L=0.6U W=0.82U AS=0.3608P AD=0.3608P PS=2.52U
+ PD=2.52U
* device instance $285 r0 *1 19.4,14.76 nfet
M$285 \_046_ ph[11] VSS VSS nfet L=0.6U W=0.48U AS=0.2112P AD=0.2112P PS=1.84U
+ PD=1.84U
* device instance $286 r0 *1 23.5,16.43 nfet
M$286 q2 \$415 VSS VSS nfet L=0.6U W=0.82U AS=0.3608P AD=0.3608P PS=2.52U
+ PD=2.52U
* device instance $287 r0 *1 33.4,14.93 nfet
M$287 \$389 \_048_ VSS VSS nfet L=0.6U W=0.82U AS=0.3608P AD=0.1312P PS=2.52U
+ PD=1.14U
* device instance $288 r0 *1 34.32,14.93 nfet
M$288 \_003_ \_036_ \$389 VSS nfet L=0.6U W=0.82U AS=0.1312P AD=0.2569P
+ PS=1.14U PD=1.56U
* device instance $289 r0 *1 35.66,15.085 nfet
M$289 VSS ph[13] \_003_ VSS nfet L=0.6U W=0.51U AS=0.2569P AD=0.2244P PS=1.56U
+ PD=1.9U
* device instance $290 r0 *1 37.88,14.93 nfet
M$290 \$390 \_046_ VSS VSS nfet L=0.6U W=0.82U AS=0.3608P AD=0.1312P PS=2.52U
+ PD=1.14U
* device instance $291 r0 *1 38.8,14.93 nfet
M$291 \_001_ \_042_ \$390 VSS nfet L=0.6U W=0.82U AS=0.1312P AD=0.2569P
+ PS=1.14U PD=1.56U
* device instance $292 r0 *1 40.14,15.085 nfet
M$292 VSS ph[13] \_001_ VSS nfet L=0.6U W=0.51U AS=0.2569P AD=0.2244P PS=1.56U
+ PD=1.9U
* device instance $293 r0 *1 42.36,14.93 nfet
M$293 \$332 clknet_0_clk VSS VSS nfet L=0.6U W=0.82U AS=0.3608P AD=0.2132P
+ PS=2.52U PD=1.34U
* device instance $294 r0 *1 43.48,14.93 nfet
M$294 VSS clknet_0_clk \$332 VSS nfet L=0.6U W=0.82U AS=0.2132P AD=0.2132P
+ PS=1.34U PD=1.34U
* device instance $295 r0 *1 44.6,14.93 nfet
M$295 clknet_2_0__leaf_clk \$332 VSS VSS nfet L=0.6U W=0.82U AS=0.2132P
+ AD=0.2132P PS=1.34U PD=1.34U
* device instance $296 r0 *1 45.72,14.93 nfet
M$296 VSS \$332 clknet_2_0__leaf_clk VSS nfet L=0.6U W=0.82U AS=0.2132P
+ AD=0.2132P PS=1.34U PD=1.34U
* device instance $297 r0 *1 46.84,14.93 nfet
M$297 clknet_2_0__leaf_clk \$332 VSS VSS nfet L=0.6U W=0.82U AS=0.2132P
+ AD=0.2132P PS=1.34U PD=1.34U
* device instance $298 r0 *1 47.96,14.93 nfet
M$298 VSS \$332 clknet_2_0__leaf_clk VSS nfet L=0.6U W=0.82U AS=0.2132P
+ AD=0.3608P PS=1.34U PD=2.52U
* device instance $299 r0 *1 49.26,16.43 nfet
M$299 eng1 \$422 VSS VSS nfet L=0.6U W=0.82U AS=0.3608P AD=0.3608P PS=2.52U
+ PD=2.52U
* device instance $300 r0 *1 50.76,14.76 nfet
M$300 \_044_ eng1 VSS VSS nfet L=0.6U W=0.48U AS=0.2112P AD=0.2112P PS=1.84U
+ PD=1.84U
* device instance $301 r0 *1 54.68,14.8725 nfet
M$301 sel_lo_n_8p \_036_ VSS VSS nfet L=0.6U W=0.565U AS=0.2486P AD=0.1469P
+ PS=2.01U PD=1.085U
* device instance $302 r0 *1 55.8,14.8725 nfet
M$302 VSS q4 sel_lo_n_8p VSS nfet L=0.6U W=0.565U AS=0.1469P AD=0.2486P
+ PS=1.085U PD=2.01U
* device instance $303 r0 *1 57.66,16.38 nfet
M$303 \$467 q0 VSS VSS nfet L=0.6U W=0.36U AS=0.218P AD=0.0432P PS=1.52U PD=0.6U
* device instance $304 r0 *1 58.5,16.38 nfet
M$304 \$400 ph[14] \$467 VSS nfet L=0.6U W=0.36U AS=0.0432P AD=0.0936P PS=0.6U
+ PD=0.88U
* device instance $305 r0 *1 59.62,16.38 nfet
M$305 \$468 \$401 \$400 VSS nfet L=0.6U W=0.36U AS=0.0936P AD=0.0432P PS=0.88U
+ PD=0.6U
* device instance $306 r0 *1 60.46,16.38 nfet
M$306 VSS c0_r \$468 VSS nfet L=0.6U W=0.36U AS=0.0432P AD=0.0936P PS=0.6U
+ PD=0.88U
* device instance $307 r0 *1 61.58,16.38 nfet
M$307 \$401 ph[14] VSS VSS nfet L=0.6U W=0.36U AS=0.0936P AD=0.1584P PS=0.88U
+ PD=1.6U
* device instance $308 r0 *1 56.36,16.43 nfet
M$308 VSS \$400 \_013_ VSS nfet L=0.6U W=0.82U AS=0.3608P AD=0.218P PS=2.52U
+ PD=1.52U
* device instance $309 r0 *1 58.04,14.9225 nfet
M$309 sel_hi_n_4n q3 VSS VSS nfet L=0.6U W=0.465U AS=0.2046P AD=0.1209P
+ PS=1.81U PD=0.985U
* device instance $310 r0 *1 59.16,14.9225 nfet
M$310 VSS \_031_ sel_hi_n_4n VSS nfet L=0.6U W=0.465U AS=0.1209P AD=0.1209P
+ PS=0.985U PD=0.985U
* device instance $311 r0 *1 60.28,14.9225 nfet
M$311 sel_hi_n_4n \_030_ VSS VSS nfet L=0.6U W=0.465U AS=0.1209P AD=0.2046P
+ PS=0.985U PD=1.81U
* device instance $312 r0 *1 62.52,14.7025 nfet
M$312 \$393 mode \$334 VSS nfet L=0.6U W=0.365U AS=0.1606P AD=0.0584P PS=1.61U
+ PD=0.685U
* device instance $313 r0 *1 63.44,14.7025 nfet
M$313 VSS sel_hi_n_256p \$393 VSS nfet L=0.6U W=0.365U AS=0.0584P AD=0.23405P
+ PS=0.685U PD=1.555U
* device instance $314 r0 *1 64.78,14.9275 nfet
M$314 sel_lo_n_256n \$334 VSS VSS nfet L=0.6U W=0.815U AS=0.23405P AD=0.3586P
+ PS=1.555U PD=2.51U
* device instance $315 r0 *1 73.72,14.7025 nfet
M$315 \$394 q8 \$336 VSS nfet L=0.6U W=0.365U AS=0.1606P AD=0.0584P PS=1.61U
+ PD=0.685U
* device instance $316 r0 *1 74.64,14.7025 nfet
M$316 VSS eng8 \$394 VSS nfet L=0.6U W=0.365U AS=0.0584P AD=0.23405P PS=0.685U
+ PD=1.555U
* device instance $317 r0 *1 75.98,14.9275 nfet
M$317 sel_hi_n_128p \$336 VSS VSS nfet L=0.6U W=0.815U AS=0.23405P AD=0.3586P
+ PS=1.555U PD=2.51U
* device instance $318 r0 *1 82.86,16.38 nfet
M$318 \$472 q9 VSS VSS nfet L=0.6U W=0.36U AS=0.218P AD=0.0432P PS=1.52U PD=0.6U
* device instance $319 r0 *1 83.7,16.38 nfet
M$319 \$404 ph[14] \$472 VSS nfet L=0.6U W=0.36U AS=0.0432P AD=0.0936P PS=0.6U
+ PD=0.88U
* device instance $320 r0 *1 84.82,16.38 nfet
M$320 \$474 \$405 \$404 VSS nfet L=0.6U W=0.36U AS=0.0936P AD=0.0432P PS=0.88U
+ PD=0.6U
* device instance $321 r0 *1 85.66,16.38 nfet
M$321 VSS c9_r \$474 VSS nfet L=0.6U W=0.36U AS=0.0432P AD=0.0936P PS=0.6U
+ PD=0.88U
* device instance $322 r0 *1 86.78,16.38 nfet
M$322 \$405 ph[14] VSS VSS nfet L=0.6U W=0.36U AS=0.0936P AD=0.1584P PS=0.88U
+ PD=1.6U
* device instance $323 r0 *1 81.56,16.43 nfet
M$323 VSS \$404 \_011_ VSS nfet L=0.6U W=0.82U AS=0.3608P AD=0.218P PS=2.52U
+ PD=1.52U
* device instance $324 r0 *1 82.68,14.7025 nfet
M$324 \$395 q9 \$337 VSS nfet L=0.6U W=0.365U AS=0.1606P AD=0.0584P PS=1.61U
+ PD=0.685U
* device instance $325 r0 *1 83.6,14.7025 nfet
M$325 VSS eng9 \$395 VSS nfet L=0.6U W=0.365U AS=0.0584P AD=0.23405P PS=0.685U
+ PD=1.555U
* device instance $326 r0 *1 84.94,14.9275 nfet
M$326 sel_hi_n_256p \$337 VSS VSS nfet L=0.6U W=0.815U AS=0.23405P AD=0.3586P
+ PS=1.555U PD=2.51U
* device instance $327 r0 *1 87.72,14.7225 nfet
M$327 VSS clknet_2_0__leaf_clk \$338 VSS nfet L=0.6U W=0.405U AS=0.1782P
+ AD=0.1053P PS=1.69U PD=0.925U
* device instance $328 r0 *1 88.84,14.7225 nfet
M$328 \$341 \$338 VSS VSS nfet L=0.6U W=0.405U AS=0.1053P AD=0.1782P PS=0.925U
+ PD=1.69U
* device instance $329 r0 *1 90.14,16.38 nfet
M$329 \$475 q2 VSS VSS nfet L=0.6U W=0.36U AS=0.218P AD=0.0432P PS=1.52U PD=0.6U
* device instance $330 r0 *1 90.98,16.38 nfet
M$330 \$406 ph[14] \$475 VSS nfet L=0.6U W=0.36U AS=0.0432P AD=0.0936P PS=0.6U
+ PD=0.88U
* device instance $331 r0 *1 92.1,16.38 nfet
M$331 \$476 \$407 \$406 VSS nfet L=0.6U W=0.36U AS=0.0936P AD=0.0432P PS=0.88U
+ PD=0.6U
* device instance $332 r0 *1 92.94,16.38 nfet
M$332 VSS c2_r \$476 VSS nfet L=0.6U W=0.36U AS=0.0432P AD=0.0936P PS=0.6U
+ PD=0.88U
* device instance $333 r0 *1 94.06,16.38 nfet
M$333 \$407 ph[14] VSS VSS nfet L=0.6U W=0.36U AS=0.0936P AD=0.1584P PS=0.88U
+ PD=1.6U
* device instance $334 r0 *1 88.84,16.43 nfet
M$334 VSS \$406 \_016_ VSS nfet L=0.6U W=0.82U AS=0.3608P AD=0.218P PS=2.52U
+ PD=1.52U
* device instance $335 r0 *1 90.68,14.705 nfet
M$335 \$396 \$338 VSS VSS nfet L=0.6U W=0.36U AS=0.1584P AD=0.0432P PS=1.6U
+ PD=0.6U
* device instance $336 r0 *1 91.52,14.705 nfet
M$336 \$396 \_024_ \$339 VSS nfet L=0.6U W=0.36U AS=0.207P AD=0.0432P PS=1.51U
+ PD=0.6U
* device instance $337 r0 *1 93.14,14.705 nfet
M$337 \$397 \$341 \$339 VSS nfet L=0.6U W=0.36U AS=0.207P AD=0.0432P PS=1.51U
+ PD=0.6U
* device instance $338 r0 *1 93.98,14.705 nfet
M$338 VSS \$340 \$397 VSS nfet L=0.6U W=0.36U AS=0.0432P AD=0.2637P PS=0.6U
+ PD=1.825U
* device instance $339 r0 *1 95.54,14.705 nfet
M$339 \$340 \$339 VSS VSS nfet L=0.6U W=0.36U AS=0.2637P AD=0.0936P PS=1.825U
+ PD=0.88U
* device instance $340 r0 *1 96.66,14.705 nfet
M$340 \$342 \$341 \$340 VSS nfet L=0.6U W=0.36U AS=0.0936P AD=0.0936P PS=0.88U
+ PD=0.88U
* device instance $341 r0 *1 97.78,14.705 nfet
M$341 \$398 \$338 \$342 VSS nfet L=0.6U W=0.36U AS=0.0936P AD=0.0432P PS=0.88U
+ PD=0.6U
* device instance $342 r0 *1 98.62,14.705 nfet
M$342 VSS \$343 \$398 VSS nfet L=0.6U W=0.36U AS=0.0432P AD=0.142P PS=0.6U
+ PD=1.14U
* device instance $343 r0 *1 99.96,14.725 nfet
M$343 \$343 \$342 VSS VSS nfet L=0.6U W=0.4U AS=0.142P AD=0.176P PS=1.14U
+ PD=1.68U
* device instance $344 r0 *1 101.9,14.93 nfet
M$344 c5_r \$343 VSS VSS nfet L=0.6U W=0.82U AS=0.3608P AD=0.3608P PS=2.52U
+ PD=2.52U
* device instance $345 r0 *1 112.92,14.9225 nfet
M$345 sel_hi_n_256n \_041_ VSS VSS nfet L=0.6U W=0.465U AS=0.2046P AD=0.1209P
+ PS=1.81U PD=0.985U
* device instance $346 r0 *1 114.04,14.9225 nfet
M$346 VSS q9 sel_hi_n_256n VSS nfet L=0.6U W=0.465U AS=0.1209P AD=0.1209P
+ PS=0.985U PD=0.985U
* device instance $347 r0 *1 115.16,14.9225 nfet
M$347 sel_hi_n_256n \_031_ VSS VSS nfet L=0.6U W=0.465U AS=0.1209P AD=0.2046P
+ PS=0.985U PD=1.81U
* device instance $348 r0 *1 117.4,14.8725 nfet
M$348 sel_lo_n_256p \_041_ VSS VSS nfet L=0.6U W=0.565U AS=0.2486P AD=0.1469P
+ PS=2.01U PD=1.085U
* device instance $349 r0 *1 118.52,14.8725 nfet
M$349 VSS q9 sel_lo_n_256p VSS nfet L=0.6U W=0.565U AS=0.1469P AD=0.2486P
+ PS=1.085U PD=2.01U
* device instance $350 r0 *1 118.14,16.43 nfet
M$350 c1_r \$434 VSS VSS nfet L=0.6U W=0.82U AS=0.3608P AD=0.3608P PS=2.52U
+ PD=2.52U
* device instance $351 r0 *1 131.4,14.8725 nfet
M$351 sel_lo_n_64p \_039_ VSS VSS nfet L=0.6U W=0.565U AS=0.2486P AD=0.1469P
+ PS=2.01U PD=1.085U
* device instance $352 r0 *1 132.52,14.8725 nfet
M$352 VSS q7 sel_lo_n_64p VSS nfet L=0.6U W=0.565U AS=0.1469P AD=0.2486P
+ PS=1.085U PD=2.01U
* device instance $353 r0 *1 134.76,14.8725 nfet
M$353 sel_lo_n_32p \_038_ VSS VSS nfet L=0.6U W=0.565U AS=0.2486P AD=0.1469P
+ PS=2.01U PD=1.085U
* device instance $354 r0 *1 135.88,14.8725 nfet
M$354 VSS q6 sel_lo_n_32p VSS nfet L=0.6U W=0.565U AS=0.1469P AD=0.2486P
+ PS=1.085U PD=2.01U
* device instance $355 r0 *1 142.04,14.93 nfet
M$355 \$399 \_050_ VSS VSS nfet L=0.6U W=0.82U AS=0.3608P AD=0.1312P PS=2.52U
+ PD=1.14U
* device instance $356 r0 *1 142.96,14.93 nfet
M$356 \_005_ \_038_ \$399 VSS nfet L=0.6U W=0.82U AS=0.1312P AD=0.2569P
+ PS=1.14U PD=1.56U
* device instance $357 r0 *1 144.3,15.085 nfet
M$357 VSS ph[13] \_005_ VSS nfet L=0.6U W=0.51U AS=0.2569P AD=0.2244P PS=1.56U
+ PD=1.9U
* device instance $358 r0 *1 142.22,16.43 nfet
M$358 eng5 \$441 VSS VSS nfet L=0.6U W=0.82U AS=0.3608P AD=0.3608P PS=2.52U
+ PD=2.52U
* device instance $359 r0 *1 147.64,14.8725 nfet
M$359 \_009_[6] start VSS VSS nfet L=0.6U W=0.565U AS=0.2486P AD=0.1469P
+ PS=2.01U PD=1.085U
* device instance $360 r0 *1 148.76,14.8725 nfet
M$360 VSS \_052_ \_009_[6] VSS nfet L=0.6U W=0.565U AS=0.1469P AD=0.2486P
+ PS=1.085U PD=2.01U
* device instance $361 r0 *1 152.68,14.8725 nfet
M$361 \_009_[7] start VSS VSS nfet L=0.6U W=0.565U AS=0.2486P AD=0.1469P
+ PS=2.01U PD=1.085U
* device instance $362 r0 *1 153.8,14.8725 nfet
M$362 VSS \_051_ \_009_[7] VSS nfet L=0.6U W=0.565U AS=0.1469P AD=0.2486P
+ PS=1.085U PD=2.01U
* device instance $363 r0 *1 158.28,14.76 nfet
M$363 \_050_ ph[7] VSS VSS nfet L=0.6U W=0.48U AS=0.2112P AD=0.2112P PS=1.84U
+ PD=1.84U
* device instance $364 r0 *1 159.02,16.43 nfet
M$364 ph[6] \$448 VSS VSS nfet L=0.6U W=0.82U AS=0.3608P AD=0.3608P PS=2.52U
+ PD=2.52U
* device instance $365 r0 *1 164.46,16.275 nfet
M$365 VSS \_056_ \_014_ VSS nfet L=0.6U W=0.51U AS=0.2569P AD=0.2244P PS=1.56U
+ PD=1.9U
* device instance $366 r0 *1 162.2,16.43 nfet
M$366 \$466 cmp VSS VSS nfet L=0.6U W=0.82U AS=0.3608P AD=0.1312P PS=2.52U
+ PD=1.14U
* device instance $367 r0 *1 163.12,16.43 nfet
M$367 \_014_ ph[7] \$466 VSS nfet L=0.6U W=0.82U AS=0.1312P AD=0.2569P PS=1.14U
+ PD=1.56U
* device instance $368 r0 *1 163.88,14.8725 nfet
M$368 \_056_ ph[7] VSS VSS nfet L=0.6U W=0.565U AS=0.2486P AD=0.1469P PS=2.01U
+ PD=1.085U
* device instance $369 r0 *1 165,14.8725 nfet
M$369 VSS q6 \_056_ VSS nfet L=0.6U W=0.565U AS=0.1469P AD=0.2486P PS=1.085U
+ PD=2.01U
* device instance $370 r0 *1 176.2,14.7225 nfet
M$370 VSS clknet_2_2__leaf_clk \$349 VSS nfet L=0.6U W=0.405U AS=0.1782P
+ AD=0.1053P PS=1.69U PD=0.925U
* device instance $371 r0 *1 177.32,14.7225 nfet
M$371 \$352 \$349 VSS VSS nfet L=0.6U W=0.405U AS=0.1053P AD=0.1782P PS=0.925U
+ PD=1.69U
* device instance $372 r0 *1 179.16,14.705 nfet
M$372 \$392 \$349 VSS VSS nfet L=0.6U W=0.36U AS=0.1584P AD=0.0432P PS=1.6U
+ PD=0.6U
* device instance $373 r0 *1 180,14.705 nfet
M$373 \$392 \_026_ \$350 VSS nfet L=0.6U W=0.36U AS=0.207P AD=0.0432P PS=1.51U
+ PD=0.6U
* device instance $374 r0 *1 181.62,14.705 nfet
M$374 \$391 \$352 \$350 VSS nfet L=0.6U W=0.36U AS=0.207P AD=0.0432P PS=1.51U
+ PD=0.6U
* device instance $375 r0 *1 182.46,14.705 nfet
M$375 VSS \$351 \$391 VSS nfet L=0.6U W=0.36U AS=0.0432P AD=0.2637P PS=0.6U
+ PD=1.825U
* device instance $376 r0 *1 184.02,14.705 nfet
M$376 \$351 \$350 VSS VSS nfet L=0.6U W=0.36U AS=0.2637P AD=0.0936P PS=1.825U
+ PD=0.88U
* device instance $377 r0 *1 185.14,14.705 nfet
M$377 \$353 \$352 \$351 VSS nfet L=0.6U W=0.36U AS=0.0936P AD=0.0936P PS=0.88U
+ PD=0.88U
* device instance $378 r0 *1 186.26,14.705 nfet
M$378 \$388 \$349 \$353 VSS nfet L=0.6U W=0.36U AS=0.0936P AD=0.0432P PS=0.88U
+ PD=0.6U
* device instance $379 r0 *1 187.1,14.705 nfet
M$379 VSS \$354 \$388 VSS nfet L=0.6U W=0.36U AS=0.0432P AD=0.142P PS=0.6U
+ PD=1.14U
* device instance $380 r0 *1 188.44,14.725 nfet
M$380 \$354 \$353 VSS VSS nfet L=0.6U W=0.4U AS=0.142P AD=0.176P PS=1.14U
+ PD=1.68U
* device instance $381 r0 *1 188.14,16.43 nfet
M$381 q8 \$456 VSS VSS nfet L=0.6U W=0.82U AS=0.3608P AD=0.3608P PS=2.52U
+ PD=2.52U
* device instance $382 r0 *1 190.38,14.93 nfet
M$382 q9 \$354 VSS VSS nfet L=0.6U W=0.82U AS=0.3608P AD=0.3608P PS=2.52U
+ PD=2.52U
* device instance $383 r0 *1 72.6,16.4875 nfet
M$383 sel_lo_n_128p \_040_ VSS VSS nfet L=0.6U W=0.565U AS=0.2486P AD=0.1469P
+ PS=2.01U PD=1.085U
* device instance $384 r0 *1 73.72,16.4875 nfet
M$384 VSS q8 sel_lo_n_128p VSS nfet L=0.6U W=0.565U AS=0.1469P AD=0.2486P
+ PS=1.085U PD=2.01U
* device instance $385 r0 *1 190.2,16.4875 nfet
M$385 \_009_[4] start VSS VSS nfet L=0.6U W=0.565U AS=0.2486P AD=0.1469P
+ PS=2.01U PD=1.085U
* device instance $386 r0 *1 191.32,16.4875 nfet
M$386 VSS \_035_ \_009_[4] VSS nfet L=0.6U W=0.565U AS=0.1469P AD=0.2486P
+ PS=1.085U PD=2.01U
* device instance $387 r0 *1 9.32,16.6375 nfet
M$387 VSS clknet_2_0__leaf_clk \$409 VSS nfet L=0.6U W=0.405U AS=0.1782P
+ AD=0.1053P PS=1.69U PD=0.925U
* device instance $388 r0 *1 10.44,16.6375 nfet
M$388 \$410 \$409 VSS VSS nfet L=0.6U W=0.405U AS=0.1053P AD=0.1782P PS=0.925U
+ PD=1.69U
* device instance $389 r0 *1 12.28,16.655 nfet
M$389 \$457 \$409 VSS VSS nfet L=0.6U W=0.36U AS=0.1584P AD=0.0432P PS=1.6U
+ PD=0.6U
* device instance $390 r0 *1 13.12,16.655 nfet
M$390 \$412 \_017_ \$457 VSS nfet L=0.6U W=0.36U AS=0.0432P AD=0.207P PS=0.6U
+ PD=1.51U
* device instance $391 r0 *1 14.74,16.655 nfet
M$391 \$458 \$410 \$412 VSS nfet L=0.6U W=0.36U AS=0.207P AD=0.0432P PS=1.51U
+ PD=0.6U
* device instance $392 r0 *1 15.58,16.655 nfet
M$392 \$458 \$413 VSS VSS nfet L=0.6U W=0.36U AS=0.2637P AD=0.0432P PS=1.825U
+ PD=0.6U
* device instance $393 r0 *1 17.14,16.655 nfet
M$393 \$413 \$412 VSS VSS nfet L=0.6U W=0.36U AS=0.2637P AD=0.0936P PS=1.825U
+ PD=0.88U
* device instance $394 r0 *1 18.26,16.655 nfet
M$394 \$414 \$410 \$413 VSS nfet L=0.6U W=0.36U AS=0.0936P AD=0.0936P PS=0.88U
+ PD=0.88U
* device instance $395 r0 *1 19.38,16.655 nfet
M$395 \$459 \$409 \$414 VSS nfet L=0.6U W=0.36U AS=0.0936P AD=0.0432P PS=0.88U
+ PD=0.6U
* device instance $396 r0 *1 20.22,16.655 nfet
M$396 \$459 \$415 VSS VSS nfet L=0.6U W=0.36U AS=0.142P AD=0.0432P PS=1.14U
+ PD=0.6U
* device instance $397 r0 *1 21.56,16.635 nfet
M$397 \$415 \$414 VSS VSS nfet L=0.6U W=0.4U AS=0.142P AD=0.176P PS=1.14U
+ PD=1.68U
* device instance $398 r0 *1 31.72,16.6 nfet
M$398 \_043_ ph[12] VSS VSS nfet L=0.6U W=0.48U AS=0.2112P AD=0.2112P PS=1.84U
+ PD=1.84U
* device instance $399 r0 *1 35.08,16.6375 nfet
M$399 VSS clknet_2_0__leaf_clk \$417 VSS nfet L=0.6U W=0.405U AS=0.1782P
+ AD=0.1053P PS=1.69U PD=0.925U
* device instance $400 r0 *1 36.2,16.6375 nfet
M$400 \$418 \$417 VSS VSS nfet L=0.6U W=0.405U AS=0.1053P AD=0.1782P PS=0.925U
+ PD=1.69U
* device instance $401 r0 *1 38.04,16.655 nfet
M$401 \$461 \$417 VSS VSS nfet L=0.6U W=0.36U AS=0.1584P AD=0.0432P PS=1.6U
+ PD=0.6U
* device instance $402 r0 *1 38.88,16.655 nfet
M$402 \$419 \_000_ \$461 VSS nfet L=0.6U W=0.36U AS=0.0432P AD=0.207P PS=0.6U
+ PD=1.51U
* device instance $403 r0 *1 40.5,16.655 nfet
M$403 \$464 \$418 \$419 VSS nfet L=0.6U W=0.36U AS=0.207P AD=0.0432P PS=1.51U
+ PD=0.6U
* device instance $404 r0 *1 41.34,16.655 nfet
M$404 \$464 \$420 VSS VSS nfet L=0.6U W=0.36U AS=0.2637P AD=0.0432P PS=1.825U
+ PD=0.6U
* device instance $405 r0 *1 42.9,16.655 nfet
M$405 \$420 \$419 VSS VSS nfet L=0.6U W=0.36U AS=0.2637P AD=0.0936P PS=1.825U
+ PD=0.88U
* device instance $406 r0 *1 44.02,16.655 nfet
M$406 \$421 \$418 \$420 VSS nfet L=0.6U W=0.36U AS=0.0936P AD=0.0936P PS=0.88U
+ PD=0.88U
* device instance $407 r0 *1 45.14,16.655 nfet
M$407 \$465 \$417 \$421 VSS nfet L=0.6U W=0.36U AS=0.0936P AD=0.0432P PS=0.88U
+ PD=0.6U
* device instance $408 r0 *1 45.98,16.655 nfet
M$408 \$465 \$422 VSS VSS nfet L=0.6U W=0.36U AS=0.142P AD=0.0432P PS=1.14U
+ PD=0.6U
* device instance $409 r0 *1 47.32,16.635 nfet
M$409 \$422 \$421 VSS VSS nfet L=0.6U W=0.4U AS=0.142P AD=0.176P PS=1.14U
+ PD=1.68U
* device instance $410 r0 *1 63.64,16.6575 nfet
M$410 \$469 mode \$424 VSS nfet L=0.6U W=0.365U AS=0.1606P AD=0.0584P PS=1.61U
+ PD=0.685U
* device instance $411 r0 *1 64.56,16.6575 nfet
M$411 \$469 sel_hi_n_16p VSS VSS nfet L=0.6U W=0.365U AS=0.23405P AD=0.0584P
+ PS=1.555U PD=0.685U
* device instance $412 r0 *1 65.9,16.4325 nfet
M$412 sel_lo_n_16n \$424 VSS VSS nfet L=0.6U W=0.815U AS=0.23405P AD=0.3586P
+ PS=1.555U PD=2.51U
* device instance $413 r0 *1 79.32,16.6 nfet
M$413 \_040_ eng8 VSS VSS nfet L=0.6U W=0.48U AS=0.2112P AD=0.2112P PS=1.84U
+ PD=1.84U
* device instance $414 r0 *1 103.96,16.6375 nfet
M$414 VSS clknet_2_2__leaf_clk \$428 VSS nfet L=0.6U W=0.405U AS=0.1782P
+ AD=0.1053P PS=1.69U PD=0.925U
* device instance $415 r0 *1 105.08,16.6375 nfet
M$415 \$429 \$428 VSS VSS nfet L=0.6U W=0.405U AS=0.1053P AD=0.1782P PS=0.925U
+ PD=1.69U
* device instance $416 r0 *1 106.92,16.655 nfet
M$416 \$478 \$428 VSS VSS nfet L=0.6U W=0.36U AS=0.1584P AD=0.0432P PS=1.6U
+ PD=0.6U
* device instance $417 r0 *1 107.76,16.655 nfet
M$417 \$431 \_015_ \$478 VSS nfet L=0.6U W=0.36U AS=0.0432P AD=0.207P PS=0.6U
+ PD=1.51U
* device instance $418 r0 *1 109.38,16.655 nfet
M$418 \$479 \$429 \$431 VSS nfet L=0.6U W=0.36U AS=0.207P AD=0.0432P PS=1.51U
+ PD=0.6U
* device instance $419 r0 *1 110.22,16.655 nfet
M$419 \$479 \$432 VSS VSS nfet L=0.6U W=0.36U AS=0.2637P AD=0.0432P PS=1.825U
+ PD=0.6U
* device instance $420 r0 *1 111.78,16.655 nfet
M$420 \$432 \$431 VSS VSS nfet L=0.6U W=0.36U AS=0.2637P AD=0.0936P PS=1.825U
+ PD=0.88U
* device instance $421 r0 *1 112.9,16.655 nfet
M$421 \$433 \$429 \$432 VSS nfet L=0.6U W=0.36U AS=0.0936P AD=0.0936P PS=0.88U
+ PD=0.88U
* device instance $422 r0 *1 114.02,16.655 nfet
M$422 \$480 \$428 \$433 VSS nfet L=0.6U W=0.36U AS=0.0936P AD=0.0432P PS=0.88U
+ PD=0.6U
* device instance $423 r0 *1 114.86,16.655 nfet
M$423 \$480 \$434 VSS VSS nfet L=0.6U W=0.36U AS=0.142P AD=0.0432P PS=1.14U
+ PD=0.6U
* device instance $424 r0 *1 116.2,16.635 nfet
M$424 \$434 \$433 VSS VSS nfet L=0.6U W=0.4U AS=0.142P AD=0.176P PS=1.14U
+ PD=1.68U
* device instance $425 r0 *1 120.2,16.6 nfet
M$425 \_037_ eng5 VSS VSS nfet L=0.6U W=0.48U AS=0.2112P AD=0.2112P PS=1.84U
+ PD=1.84U
* device instance $426 r0 *1 128.04,16.6375 nfet
M$426 VSS clknet_2_2__leaf_clk \$435 VSS nfet L=0.6U W=0.405U AS=0.1782P
+ AD=0.1053P PS=1.69U PD=0.925U
* device instance $427 r0 *1 129.16,16.6375 nfet
M$427 \$436 \$435 VSS VSS nfet L=0.6U W=0.405U AS=0.1053P AD=0.1782P PS=0.925U
+ PD=1.69U
* device instance $428 r0 *1 131,16.655 nfet
M$428 \$482 \$435 VSS VSS nfet L=0.6U W=0.36U AS=0.1584P AD=0.0432P PS=1.6U
+ PD=0.6U
* device instance $429 r0 *1 131.84,16.655 nfet
M$429 \$438 \_004_ \$482 VSS nfet L=0.6U W=0.36U AS=0.0432P AD=0.207P PS=0.6U
+ PD=1.51U
* device instance $430 r0 *1 133.46,16.655 nfet
M$430 \$481 \$436 \$438 VSS nfet L=0.6U W=0.36U AS=0.207P AD=0.0432P PS=1.51U
+ PD=0.6U
* device instance $431 r0 *1 134.3,16.655 nfet
M$431 \$481 \$439 VSS VSS nfet L=0.6U W=0.36U AS=0.2637P AD=0.0432P PS=1.825U
+ PD=0.6U
* device instance $432 r0 *1 135.86,16.655 nfet
M$432 \$439 \$438 VSS VSS nfet L=0.6U W=0.36U AS=0.2637P AD=0.0936P PS=1.825U
+ PD=0.88U
* device instance $433 r0 *1 136.98,16.655 nfet
M$433 \$440 \$436 \$439 VSS nfet L=0.6U W=0.36U AS=0.0936P AD=0.0936P PS=0.88U
+ PD=0.88U
* device instance $434 r0 *1 138.1,16.655 nfet
M$434 \$477 \$435 \$440 VSS nfet L=0.6U W=0.36U AS=0.0936P AD=0.0432P PS=0.88U
+ PD=0.6U
* device instance $435 r0 *1 138.94,16.655 nfet
M$435 \$477 \$441 VSS VSS nfet L=0.6U W=0.36U AS=0.142P AD=0.0432P PS=1.14U
+ PD=0.6U
* device instance $436 r0 *1 140.28,16.635 nfet
M$436 \$441 \$440 VSS VSS nfet L=0.6U W=0.4U AS=0.142P AD=0.176P PS=1.14U
+ PD=1.68U
* device instance $437 r0 *1 144.84,16.6375 nfet
M$437 VSS clknet_2_3__leaf_clk \$442 VSS nfet L=0.6U W=0.405U AS=0.1782P
+ AD=0.1053P PS=1.69U PD=0.925U
* device instance $438 r0 *1 145.96,16.6375 nfet
M$438 \$444 \$442 VSS VSS nfet L=0.6U W=0.405U AS=0.1053P AD=0.1782P PS=0.925U
+ PD=1.69U
* device instance $439 r0 *1 147.8,16.655 nfet
M$439 \$473 \$442 VSS VSS nfet L=0.6U W=0.36U AS=0.1584P AD=0.0432P PS=1.6U
+ PD=0.6U
* device instance $440 r0 *1 148.64,16.655 nfet
M$440 \$445 \_009_[6] \$473 VSS nfet L=0.6U W=0.36U AS=0.0432P AD=0.207P
+ PS=0.6U PD=1.51U
* device instance $441 r0 *1 150.26,16.655 nfet
M$441 \$471 \$444 \$445 VSS nfet L=0.6U W=0.36U AS=0.207P AD=0.0432P PS=1.51U
+ PD=0.6U
* device instance $442 r0 *1 151.1,16.655 nfet
M$442 \$471 \$446 VSS VSS nfet L=0.6U W=0.36U AS=0.2637P AD=0.0432P PS=1.825U
+ PD=0.6U
* device instance $443 r0 *1 152.66,16.655 nfet
M$443 \$446 \$445 VSS VSS nfet L=0.6U W=0.36U AS=0.2637P AD=0.0936P PS=1.825U
+ PD=0.88U
* device instance $444 r0 *1 153.78,16.655 nfet
M$444 \$447 \$444 \$446 VSS nfet L=0.6U W=0.36U AS=0.0936P AD=0.0936P PS=0.88U
+ PD=0.88U
* device instance $445 r0 *1 154.9,16.655 nfet
M$445 \$470 \$442 \$447 VSS nfet L=0.6U W=0.36U AS=0.0936P AD=0.0432P PS=0.88U
+ PD=0.6U
* device instance $446 r0 *1 155.74,16.655 nfet
M$446 \$470 \$448 VSS VSS nfet L=0.6U W=0.36U AS=0.142P AD=0.0432P PS=1.14U
+ PD=0.6U
* device instance $447 r0 *1 157.08,16.635 nfet
M$447 \$448 \$447 VSS VSS nfet L=0.6U W=0.4U AS=0.142P AD=0.176P PS=1.14U
+ PD=1.68U
* device instance $448 r0 *1 173.96,16.6375 nfet
M$448 VSS clknet_2_2__leaf_clk \$450 VSS nfet L=0.6U W=0.405U AS=0.1782P
+ AD=0.1053P PS=1.69U PD=0.925U
* device instance $449 r0 *1 175.08,16.6375 nfet
M$449 \$451 \$450 VSS VSS nfet L=0.6U W=0.405U AS=0.1053P AD=0.1782P PS=0.925U
+ PD=1.69U
* device instance $450 r0 *1 176.92,16.655 nfet
M$450 \$463 \$450 VSS VSS nfet L=0.6U W=0.36U AS=0.1584P AD=0.0432P PS=1.6U
+ PD=0.6U
* device instance $451 r0 *1 177.76,16.655 nfet
M$451 \$453 \_022_ \$463 VSS nfet L=0.6U W=0.36U AS=0.0432P AD=0.207P PS=0.6U
+ PD=1.51U
* device instance $452 r0 *1 179.38,16.655 nfet
M$452 \$462 \$451 \$453 VSS nfet L=0.6U W=0.36U AS=0.207P AD=0.0432P PS=1.51U
+ PD=0.6U
* device instance $453 r0 *1 180.22,16.655 nfet
M$453 \$462 \$454 VSS VSS nfet L=0.6U W=0.36U AS=0.2637P AD=0.0432P PS=1.825U
+ PD=0.6U
* device instance $454 r0 *1 181.78,16.655 nfet
M$454 \$454 \$453 VSS VSS nfet L=0.6U W=0.36U AS=0.2637P AD=0.0936P PS=1.825U
+ PD=0.88U
* device instance $455 r0 *1 182.9,16.655 nfet
M$455 \$455 \$451 \$454 VSS nfet L=0.6U W=0.36U AS=0.0936P AD=0.0936P PS=0.88U
+ PD=0.88U
* device instance $456 r0 *1 184.02,16.655 nfet
M$456 \$460 \$450 \$455 VSS nfet L=0.6U W=0.36U AS=0.0936P AD=0.0432P PS=0.88U
+ PD=0.6U
* device instance $457 r0 *1 184.86,16.655 nfet
M$457 \$460 \$456 VSS VSS nfet L=0.6U W=0.36U AS=0.142P AD=0.0432P PS=1.14U
+ PD=0.6U
* device instance $458 r0 *1 186.2,16.635 nfet
M$458 \$456 \$455 VSS VSS nfet L=0.6U W=0.4U AS=0.142P AD=0.176P PS=1.14U
+ PD=1.68U
* device instance $459 r0 *1 9.88,22.77 nfet
M$459 \$594 cmp VSS VSS nfet L=0.6U W=0.82U AS=0.3608P AD=0.1312P PS=2.52U
+ PD=1.14U
* device instance $460 r0 *1 10.8,22.77 nfet
M$460 \_025_ ph[9] \$594 VSS nfet L=0.6U W=0.82U AS=0.1312P AD=0.2569P PS=1.14U
+ PD=1.56U
* device instance $461 r0 *1 12.14,22.925 nfet
M$461 VSS \_062_ \_025_ VSS nfet L=0.6U W=0.51U AS=0.2569P AD=0.2244P PS=1.56U
+ PD=1.9U
* device instance $462 r0 *1 14.36,22.6 nfet
M$462 \_048_ ph[9] VSS VSS nfet L=0.6U W=0.48U AS=0.2112P AD=0.2112P PS=1.84U
+ PD=1.84U
* device instance $463 r0 *1 16.6,22.7125 nfet
M$463 \_009_[12] start VSS VSS nfet L=0.6U W=0.565U AS=0.2486P AD=0.1469P
+ PS=2.01U PD=1.085U
* device instance $464 r0 *1 17.72,22.7125 nfet
M$464 VSS \_046_ \_009_[12] VSS nfet L=0.6U W=0.565U AS=0.1469P AD=0.2486P
+ PS=1.085U PD=2.01U
* device instance $465 r0 *1 26.3,24.27 nfet
M$465 ph[12] \$620 VSS VSS nfet L=0.6U W=0.82U AS=0.3608P AD=0.3608P PS=2.52U
+ PD=2.52U
* device instance $466 r0 *1 30.04,22.5625 nfet
M$466 VSS clknet_2_0__leaf_clk \$517 VSS nfet L=0.6U W=0.405U AS=0.1782P
+ AD=0.1053P PS=1.69U PD=0.925U
* device instance $467 r0 *1 31.16,22.5625 nfet
M$467 \$519 \$517 VSS VSS nfet L=0.6U W=0.405U AS=0.1053P AD=0.1782P PS=0.925U
+ PD=1.69U
* device instance $468 r0 *1 33,22.545 nfet
M$468 \$597 \$517 VSS VSS nfet L=0.6U W=0.36U AS=0.1584P AD=0.0432P PS=1.6U
+ PD=0.6U
* device instance $469 r0 *1 33.84,22.545 nfet
M$469 \$597 \_003_ \$549 VSS nfet L=0.6U W=0.36U AS=0.207P AD=0.0432P PS=1.51U
+ PD=0.6U
* device instance $470 r0 *1 35.46,22.545 nfet
M$470 \$599 \$519 \$549 VSS nfet L=0.6U W=0.36U AS=0.207P AD=0.0432P PS=1.51U
+ PD=0.6U
* device instance $471 r0 *1 36.3,22.545 nfet
M$471 VSS \$518 \$599 VSS nfet L=0.6U W=0.36U AS=0.0432P AD=0.2637P PS=0.6U
+ PD=1.825U
* device instance $472 r0 *1 37.86,22.545 nfet
M$472 \$518 \$549 VSS VSS nfet L=0.6U W=0.36U AS=0.2637P AD=0.0936P PS=1.825U
+ PD=0.88U
* device instance $473 r0 *1 38.98,22.545 nfet
M$473 \$550 \$519 \$518 VSS nfet L=0.6U W=0.36U AS=0.0936P AD=0.0936P PS=0.88U
+ PD=0.88U
* device instance $474 r0 *1 40.1,22.545 nfet
M$474 \$600 \$517 \$550 VSS nfet L=0.6U W=0.36U AS=0.0936P AD=0.0432P PS=0.88U
+ PD=0.6U
* device instance $475 r0 *1 40.94,22.545 nfet
M$475 VSS \$520 \$600 VSS nfet L=0.6U W=0.36U AS=0.0432P AD=0.142P PS=0.6U
+ PD=1.14U
* device instance $476 r0 *1 42.28,22.565 nfet
M$476 \$520 \$550 VSS VSS nfet L=0.6U W=0.4U AS=0.142P AD=0.176P PS=1.14U
+ PD=1.68U
* device instance $477 r0 *1 44.22,22.77 nfet
M$477 eng4 \$520 VSS VSS nfet L=0.6U W=0.82U AS=0.3608P AD=0.3608P PS=2.52U
+ PD=2.52U
* device instance $478 r0 *1 46.28,22.77 nfet
M$478 \$521 clknet_0_clk VSS VSS nfet L=0.6U W=0.82U AS=0.3608P AD=0.2132P
+ PS=2.52U PD=1.34U
* device instance $479 r0 *1 47.4,22.77 nfet
M$479 VSS clknet_0_clk \$521 VSS nfet L=0.6U W=0.82U AS=0.2132P AD=0.2132P
+ PS=1.34U PD=1.34U
* device instance $480 r0 *1 48.52,22.77 nfet
M$480 clknet_2_1__leaf_clk \$521 VSS VSS nfet L=0.6U W=0.82U AS=0.2132P
+ AD=0.2132P PS=1.34U PD=1.34U
* device instance $481 r0 *1 49.64,22.77 nfet
M$481 VSS \$521 clknet_2_1__leaf_clk VSS nfet L=0.6U W=0.82U AS=0.2132P
+ AD=0.2132P PS=1.34U PD=1.34U
* device instance $482 r0 *1 50.76,22.77 nfet
M$482 clknet_2_1__leaf_clk \$521 VSS VSS nfet L=0.6U W=0.82U AS=0.2132P
+ AD=0.2132P PS=1.34U PD=1.34U
* device instance $483 r0 *1 51.88,22.77 nfet
M$483 VSS \$521 clknet_2_1__leaf_clk VSS nfet L=0.6U W=0.82U AS=0.2132P
+ AD=0.3608P PS=1.34U PD=2.52U
* device instance $484 r0 *1 48.14,24.27 nfet
M$484 q0 \$629 VSS VSS nfet L=0.6U W=0.82U AS=0.3608P AD=0.3608P PS=2.52U
+ PD=2.52U
* device instance $485 r0 *1 56.36,22.5625 nfet
M$485 VSS clknet_2_1__leaf_clk \$523 VSS nfet L=0.6U W=0.405U AS=0.1782P
+ AD=0.1053P PS=1.69U PD=0.925U
* device instance $486 r0 *1 57.48,22.5625 nfet
M$486 \$525 \$523 VSS VSS nfet L=0.6U W=0.405U AS=0.1053P AD=0.1782P PS=0.925U
+ PD=1.69U
* device instance $487 r0 *1 59.32,22.545 nfet
M$487 \$601 \$523 VSS VSS nfet L=0.6U W=0.36U AS=0.1584P AD=0.0432P PS=1.6U
+ PD=0.6U
* device instance $488 r0 *1 60.16,22.545 nfet
M$488 \$601 \_023_ \$552 VSS nfet L=0.6U W=0.36U AS=0.207P AD=0.0432P PS=1.51U
+ PD=0.6U
* device instance $489 r0 *1 61.78,22.545 nfet
M$489 \$602 \$525 \$552 VSS nfet L=0.6U W=0.36U AS=0.207P AD=0.0432P PS=1.51U
+ PD=0.6U
* device instance $490 r0 *1 62.62,22.545 nfet
M$490 VSS \$524 \$602 VSS nfet L=0.6U W=0.36U AS=0.0432P AD=0.2637P PS=0.6U
+ PD=1.825U
* device instance $491 r0 *1 64.18,22.545 nfet
M$491 \$524 \$552 VSS VSS nfet L=0.6U W=0.36U AS=0.2637P AD=0.0936P PS=1.825U
+ PD=0.88U
* device instance $492 r0 *1 65.3,22.545 nfet
M$492 \$554 \$525 \$524 VSS nfet L=0.6U W=0.36U AS=0.0936P AD=0.0936P PS=0.88U
+ PD=0.88U
* device instance $493 r0 *1 66.42,22.545 nfet
M$493 \$603 \$523 \$554 VSS nfet L=0.6U W=0.36U AS=0.0936P AD=0.0432P PS=0.88U
+ PD=0.6U
* device instance $494 r0 *1 67.26,22.545 nfet
M$494 VSS \$526 \$603 VSS nfet L=0.6U W=0.36U AS=0.0432P AD=0.142P PS=0.6U
+ PD=1.14U
* device instance $495 r0 *1 68.6,22.565 nfet
M$495 \$526 \$554 VSS VSS nfet L=0.6U W=0.4U AS=0.142P AD=0.176P PS=1.14U
+ PD=1.68U
* device instance $496 r0 *1 69.98,24.27 nfet
M$496 c3_r \$636 VSS VSS nfet L=0.6U W=0.82U AS=0.3608P AD=0.3608P PS=2.52U
+ PD=2.52U
* device instance $497 r0 *1 70.54,22.77 nfet
M$497 c4_r \$526 VSS VSS nfet L=0.6U W=0.82U AS=0.3608P AD=0.3608P PS=2.52U
+ PD=2.52U
* device instance $498 r0 *1 84.92,22.5625 nfet
M$498 VSS clknet_2_0__leaf_clk \$527 VSS nfet L=0.6U W=0.405U AS=0.1782P
+ AD=0.1053P PS=1.69U PD=0.925U
* device instance $499 r0 *1 86.04,22.5625 nfet
M$499 \$529 \$527 VSS VSS nfet L=0.6U W=0.405U AS=0.1053P AD=0.1782P PS=0.925U
+ PD=1.69U
* device instance $500 r0 *1 87.88,22.545 nfet
M$500 \$604 \$527 VSS VSS nfet L=0.6U W=0.36U AS=0.1584P AD=0.0432P PS=1.6U
+ PD=0.6U
* device instance $501 r0 *1 88.72,22.545 nfet
M$501 \$604 \_007_ \$555 VSS nfet L=0.6U W=0.36U AS=0.207P AD=0.0432P PS=1.51U
+ PD=0.6U
* device instance $502 r0 *1 90.34,22.545 nfet
M$502 \$605 \$529 \$555 VSS nfet L=0.6U W=0.36U AS=0.207P AD=0.0432P PS=1.51U
+ PD=0.6U
* device instance $503 r0 *1 91.18,22.545 nfet
M$503 VSS \$528 \$605 VSS nfet L=0.6U W=0.36U AS=0.0432P AD=0.2637P PS=0.6U
+ PD=1.825U
* device instance $504 r0 *1 92.74,22.545 nfet
M$504 \$528 \$555 VSS VSS nfet L=0.6U W=0.36U AS=0.2637P AD=0.0936P PS=1.825U
+ PD=0.88U
* device instance $505 r0 *1 93.86,22.545 nfet
M$505 \$556 \$529 \$528 VSS nfet L=0.6U W=0.36U AS=0.0936P AD=0.0936P PS=0.88U
+ PD=0.88U
* device instance $506 r0 *1 94.98,22.545 nfet
M$506 \$607 \$527 \$556 VSS nfet L=0.6U W=0.36U AS=0.0936P AD=0.0432P PS=0.88U
+ PD=0.6U
* device instance $507 r0 *1 95.82,22.545 nfet
M$507 VSS \$530 \$607 VSS nfet L=0.6U W=0.36U AS=0.0432P AD=0.142P PS=0.6U
+ PD=1.14U
* device instance $508 r0 *1 97.16,22.565 nfet
M$508 \$530 \$556 VSS VSS nfet L=0.6U W=0.4U AS=0.142P AD=0.176P PS=1.14U
+ PD=1.68U
* device instance $509 r0 *1 97.98,24.27 nfet
M$509 c2_r \$643 VSS VSS nfet L=0.6U W=0.82U AS=0.3608P AD=0.3608P PS=2.52U
+ PD=2.52U
* device instance $510 r0 *1 99.1,22.77 nfet
M$510 eng8 \$530 VSS VSS nfet L=0.6U W=0.82U AS=0.3608P AD=0.3608P PS=2.52U
+ PD=2.52U
* device instance $511 r0 *1 109,22.5625 nfet
M$511 VSS clknet_2_3__leaf_clk \$531 VSS nfet L=0.6U W=0.405U AS=0.1782P
+ AD=0.1053P PS=1.69U PD=0.925U
* device instance $512 r0 *1 110.12,22.5625 nfet
M$512 \$533 \$531 VSS VSS nfet L=0.6U W=0.405U AS=0.1053P AD=0.1782P PS=0.925U
+ PD=1.69U
* device instance $513 r0 *1 111.96,22.545 nfet
M$513 \$610 \$531 VSS VSS nfet L=0.6U W=0.36U AS=0.1584P AD=0.0432P PS=1.6U
+ PD=0.6U
* device instance $514 r0 *1 112.8,22.545 nfet
M$514 \$610 \_027_ \$558 VSS nfet L=0.6U W=0.36U AS=0.207P AD=0.0432P PS=1.51U
+ PD=0.6U
* device instance $515 r0 *1 114.42,22.545 nfet
M$515 \$611 \$533 \$558 VSS nfet L=0.6U W=0.36U AS=0.207P AD=0.0432P PS=1.51U
+ PD=0.6U
* device instance $516 r0 *1 115.26,22.545 nfet
M$516 VSS \$532 \$611 VSS nfet L=0.6U W=0.36U AS=0.0432P AD=0.2637P PS=0.6U
+ PD=1.825U
* device instance $517 r0 *1 116.82,22.545 nfet
M$517 \$532 \$558 VSS VSS nfet L=0.6U W=0.36U AS=0.2637P AD=0.0936P PS=1.825U
+ PD=0.88U
* device instance $518 r0 *1 117.94,22.545 nfet
M$518 \$559 \$533 \$532 VSS nfet L=0.6U W=0.36U AS=0.0936P AD=0.0936P PS=0.88U
+ PD=0.88U
* device instance $519 r0 *1 119.06,22.545 nfet
M$519 \$612 \$531 \$559 VSS nfet L=0.6U W=0.36U AS=0.0936P AD=0.0432P PS=0.88U
+ PD=0.6U
* device instance $520 r0 *1 119.9,22.545 nfet
M$520 VSS \$534 \$612 VSS nfet L=0.6U W=0.36U AS=0.0432P AD=0.142P PS=0.6U
+ PD=1.14U
* device instance $521 r0 *1 121.24,22.565 nfet
M$521 \$534 \$559 VSS VSS nfet L=0.6U W=0.4U AS=0.142P AD=0.176P PS=1.14U
+ PD=1.68U
* device instance $522 r0 *1 113.66,24.22 nfet
M$522 \$673 q6 VSS VSS nfet L=0.6U W=0.36U AS=0.218P AD=0.0432P PS=1.52U PD=0.6U
* device instance $523 r0 *1 114.5,24.22 nfet
M$523 \$588 ph[14] \$673 VSS nfet L=0.6U W=0.36U AS=0.0432P AD=0.0936P PS=0.6U
+ PD=0.88U
* device instance $524 r0 *1 115.62,24.22 nfet
M$524 \$672 \$589 \$588 VSS nfet L=0.6U W=0.36U AS=0.0936P AD=0.0432P PS=0.88U
+ PD=0.6U
* device instance $525 r0 *1 116.46,24.22 nfet
M$525 VSS c6_r \$672 VSS nfet L=0.6U W=0.36U AS=0.0432P AD=0.0936P PS=0.6U
+ PD=0.88U
* device instance $526 r0 *1 117.58,24.22 nfet
M$526 \$589 ph[14] VSS VSS nfet L=0.6U W=0.36U AS=0.0936P AD=0.1584P PS=0.88U
+ PD=1.6U
* device instance $527 r0 *1 112.36,24.27 nfet
M$527 VSS \$588 \_027_ VSS nfet L=0.6U W=0.82U AS=0.3608P AD=0.218P PS=2.52U
+ PD=1.52U
* device instance $528 r0 *1 123.18,22.77 nfet
M$528 c6_r \$534 VSS VSS nfet L=0.6U W=0.82U AS=0.3608P AD=0.3608P PS=2.52U
+ PD=2.52U
* device instance $529 r0 *1 131.42,24.115 nfet
M$529 VSS ph[13] \_004_ VSS nfet L=0.6U W=0.51U AS=0.2569P AD=0.2244P PS=1.56U
+ PD=1.9U
* device instance $530 r0 *1 129.16,24.27 nfet
M$530 \$670 \_049_ VSS VSS nfet L=0.6U W=0.82U AS=0.3608P AD=0.1312P PS=2.52U
+ PD=1.14U
* device instance $531 r0 *1 130.08,24.27 nfet
M$531 \_004_ \_037_ \$670 VSS nfet L=0.6U W=0.82U AS=0.1312P AD=0.2569P
+ PS=1.14U PD=1.56U
* device instance $532 r0 *1 130.84,22.77 nfet
M$532 \$613 \_052_ VSS VSS nfet L=0.6U W=0.82U AS=0.3608P AD=0.1312P PS=2.52U
+ PD=1.14U
* device instance $533 r0 *1 131.76,22.77 nfet
M$533 \_007_ \_040_ \$613 VSS nfet L=0.6U W=0.82U AS=0.1312P AD=0.2569P
+ PS=1.14U PD=1.56U
* device instance $534 r0 *1 133.1,22.925 nfet
M$534 VSS ph[13] \_007_ VSS nfet L=0.6U W=0.51U AS=0.2569P AD=0.2244P PS=1.56U
+ PD=1.9U
* device instance $535 r0 *1 136.46,24.115 nfet
M$535 VSS ph[13] \_008_ VSS nfet L=0.6U W=0.51U AS=0.2569P AD=0.2244P PS=1.56U
+ PD=1.9U
* device instance $536 r0 *1 134.2,24.27 nfet
M$536 \$667 \_053_ VSS VSS nfet L=0.6U W=0.82U AS=0.3608P AD=0.1312P PS=2.52U
+ PD=1.14U
* device instance $537 r0 *1 135.12,24.27 nfet
M$537 \_008_ \_041_ \$667 VSS nfet L=0.6U W=0.82U AS=0.1312P AD=0.2569P
+ PS=1.14U PD=1.56U
* device instance $538 r0 *1 135.32,22.6 nfet
M$538 \_041_ eng9 VSS VSS nfet L=0.6U W=0.48U AS=0.2112P AD=0.2112P PS=1.84U
+ PD=1.84U
* device instance $539 r0 *1 143.16,22.77 nfet
M$539 \$536 clknet_0_clk VSS VSS nfet L=0.6U W=0.82U AS=0.3608P AD=0.2132P
+ PS=2.52U PD=1.34U
* device instance $540 r0 *1 144.28,22.77 nfet
M$540 VSS clknet_0_clk \$536 VSS nfet L=0.6U W=0.82U AS=0.2132P AD=0.2132P
+ PS=1.34U PD=1.34U
* device instance $541 r0 *1 145.4,22.77 nfet
M$541 clknet_2_2__leaf_clk \$536 VSS VSS nfet L=0.6U W=0.82U AS=0.2132P
+ AD=0.2132P PS=1.34U PD=1.34U
* device instance $542 r0 *1 146.52,22.77 nfet
M$542 VSS \$536 clknet_2_2__leaf_clk VSS nfet L=0.6U W=0.82U AS=0.2132P
+ AD=0.2132P PS=1.34U PD=1.34U
* device instance $543 r0 *1 147.64,22.77 nfet
M$543 clknet_2_2__leaf_clk \$536 VSS VSS nfet L=0.6U W=0.82U AS=0.2132P
+ AD=0.2132P PS=1.34U PD=1.34U
* device instance $544 r0 *1 148.76,22.77 nfet
M$544 VSS \$536 clknet_2_2__leaf_clk VSS nfet L=0.6U W=0.82U AS=0.2132P
+ AD=0.3608P PS=1.34U PD=2.52U
* device instance $545 r0 *1 151,22.7125 nfet
M$545 \_009_[8] start VSS VSS nfet L=0.6U W=0.565U AS=0.2486P AD=0.1469P
+ PS=2.01U PD=1.085U
* device instance $546 r0 *1 152.12,22.7125 nfet
M$546 VSS \_050_ \_009_[8] VSS nfet L=0.6U W=0.565U AS=0.1469P AD=0.2486P
+ PS=1.085U PD=2.01U
* device instance $547 r0 *1 154.36,22.6 nfet
M$547 \_051_ ph[6] VSS VSS nfet L=0.6U W=0.48U AS=0.2112P AD=0.2112P PS=1.84U
+ PD=1.84U
* device instance $548 r0 *1 155.1,24.27 nfet
M$548 eng7 \$650 VSS VSS nfet L=0.6U W=0.82U AS=0.3608P AD=0.3608P PS=2.52U
+ PD=2.52U
* device instance $549 r0 *1 156.6,22.5625 nfet
M$549 VSS clknet_2_3__leaf_clk \$538 VSS nfet L=0.6U W=0.405U AS=0.1782P
+ AD=0.1053P PS=1.69U PD=0.925U
* device instance $550 r0 *1 157.72,22.5625 nfet
M$550 \$540 \$538 VSS VSS nfet L=0.6U W=0.405U AS=0.1053P AD=0.1782P PS=0.925U
+ PD=1.69U
* device instance $551 r0 *1 159.56,22.545 nfet
M$551 \$609 \$538 VSS VSS nfet L=0.6U W=0.36U AS=0.1584P AD=0.0432P PS=1.6U
+ PD=0.6U
* device instance $552 r0 *1 160.4,22.545 nfet
M$552 \$609 \_019_ \$562 VSS nfet L=0.6U W=0.36U AS=0.207P AD=0.0432P PS=1.51U
+ PD=0.6U
* device instance $553 r0 *1 162.02,22.545 nfet
M$553 \$608 \$540 \$562 VSS nfet L=0.6U W=0.36U AS=0.207P AD=0.0432P PS=1.51U
+ PD=0.6U
* device instance $554 r0 *1 162.86,22.545 nfet
M$554 VSS \$539 \$608 VSS nfet L=0.6U W=0.36U AS=0.0432P AD=0.2637P PS=0.6U
+ PD=1.825U
* device instance $555 r0 *1 164.42,22.545 nfet
M$555 \$539 \$562 VSS VSS nfet L=0.6U W=0.36U AS=0.2637P AD=0.0936P PS=1.825U
+ PD=0.88U
* device instance $556 r0 *1 165.54,22.545 nfet
M$556 \$563 \$540 \$539 VSS nfet L=0.6U W=0.36U AS=0.0936P AD=0.0936P PS=0.88U
+ PD=0.88U
* device instance $557 r0 *1 166.66,22.545 nfet
M$557 \$606 \$538 \$563 VSS nfet L=0.6U W=0.36U AS=0.0936P AD=0.0432P PS=0.88U
+ PD=0.6U
* device instance $558 r0 *1 167.5,22.545 nfet
M$558 VSS \$541 \$606 VSS nfet L=0.6U W=0.36U AS=0.0432P AD=0.142P PS=0.6U
+ PD=1.14U
* device instance $559 r0 *1 168.84,22.565 nfet
M$559 \$541 \$563 VSS VSS nfet L=0.6U W=0.4U AS=0.142P AD=0.176P PS=1.14U
+ PD=1.68U
* device instance $560 r0 *1 162.78,24.115 nfet
M$560 VSS \_059_ \_019_ VSS nfet L=0.6U W=0.51U AS=0.2569P AD=0.2244P PS=1.56U
+ PD=1.9U
* device instance $561 r0 *1 160.52,24.27 nfet
M$561 \$659 cmp VSS VSS nfet L=0.6U W=0.82U AS=0.3608P AD=0.1312P PS=2.52U
+ PD=1.14U
* device instance $562 r0 *1 161.44,24.27 nfet
M$562 \_019_ ph[8] \$659 VSS nfet L=0.6U W=0.82U AS=0.1312P AD=0.2569P PS=1.14U
+ PD=1.56U
* device instance $563 r0 *1 170.78,22.77 nfet
M$563 q5 \$541 VSS VSS nfet L=0.6U W=0.82U AS=0.3608P AD=0.3608P PS=2.52U
+ PD=2.52U
* device instance $564 r0 *1 175.64,22.7125 nfet
M$564 \_009_[1] start VSS VSS nfet L=0.6U W=0.565U AS=0.2486P AD=0.1469P
+ PS=2.01U PD=1.085U
* device instance $565 r0 *1 176.76,22.7125 nfet
M$565 VSS \_033_ \_009_[1] VSS nfet L=0.6U W=0.565U AS=0.1469P AD=0.2486P
+ PS=1.085U PD=2.01U
* device instance $566 r0 *1 177.9,24.115 nfet
M$566 VSS \_061_ \_022_ VSS nfet L=0.6U W=0.51U AS=0.2569P AD=0.2244P PS=1.56U
+ PD=1.9U
* device instance $567 r0 *1 175.64,24.27 nfet
M$567 \$656 cmp VSS VSS nfet L=0.6U W=0.82U AS=0.3608P AD=0.1312P PS=2.52U
+ PD=1.14U
* device instance $568 r0 *1 176.56,24.27 nfet
M$568 \_022_ ph[5] \$656 VSS nfet L=0.6U W=0.82U AS=0.1312P AD=0.2569P PS=1.14U
+ PD=1.56U
* device instance $569 r0 *1 179,22.5625 nfet
M$569 VSS clknet_2_3__leaf_clk \$542 VSS nfet L=0.6U W=0.405U AS=0.1782P
+ AD=0.1053P PS=1.69U PD=0.925U
* device instance $570 r0 *1 180.12,22.5625 nfet
M$570 \$544 \$542 VSS VSS nfet L=0.6U W=0.405U AS=0.1053P AD=0.1782P PS=0.925U
+ PD=1.69U
* device instance $571 r0 *1 182.38,24.115 nfet
M$571 VSS \_063_ \_026_ VSS nfet L=0.6U W=0.51U AS=0.2569P AD=0.2244P PS=1.56U
+ PD=1.9U
* device instance $572 r0 *1 180.12,24.27 nfet
M$572 \$654 cmp VSS VSS nfet L=0.6U W=0.82U AS=0.3608P AD=0.1312P PS=2.52U
+ PD=1.14U
* device instance $573 r0 *1 181.04,24.27 nfet
M$573 \_026_ ph[4] \$654 VSS nfet L=0.6U W=0.82U AS=0.1312P AD=0.2569P PS=1.14U
+ PD=1.56U
* device instance $574 r0 *1 181.96,22.545 nfet
M$574 \$598 \$542 VSS VSS nfet L=0.6U W=0.36U AS=0.1584P AD=0.0432P PS=1.6U
+ PD=0.6U
* device instance $575 r0 *1 182.8,22.545 nfet
M$575 \$598 \_009_[4] \$565 VSS nfet L=0.6U W=0.36U AS=0.207P AD=0.0432P
+ PS=1.51U PD=0.6U
* device instance $576 r0 *1 184.42,22.545 nfet
M$576 \$596 \$544 \$565 VSS nfet L=0.6U W=0.36U AS=0.207P AD=0.0432P PS=1.51U
+ PD=0.6U
* device instance $577 r0 *1 185.26,22.545 nfet
M$577 VSS \$543 \$596 VSS nfet L=0.6U W=0.36U AS=0.0432P AD=0.2637P PS=0.6U
+ PD=1.825U
* device instance $578 r0 *1 186.82,22.545 nfet
M$578 \$543 \$565 VSS VSS nfet L=0.6U W=0.36U AS=0.2637P AD=0.0936P PS=1.825U
+ PD=0.88U
* device instance $579 r0 *1 187.94,22.545 nfet
M$579 \$566 \$544 \$543 VSS nfet L=0.6U W=0.36U AS=0.0936P AD=0.0936P PS=0.88U
+ PD=0.88U
* device instance $580 r0 *1 189.06,22.545 nfet
M$580 \$595 \$542 \$566 VSS nfet L=0.6U W=0.36U AS=0.0936P AD=0.0432P PS=0.88U
+ PD=0.6U
* device instance $581 r0 *1 189.9,22.545 nfet
M$581 VSS \$545 \$595 VSS nfet L=0.6U W=0.36U AS=0.0432P AD=0.142P PS=0.6U
+ PD=1.14U
* device instance $582 r0 *1 191.24,22.565 nfet
M$582 \$545 \$566 VSS VSS nfet L=0.6U W=0.4U AS=0.142P AD=0.176P PS=1.14U
+ PD=1.68U
* device instance $583 r0 *1 193.18,22.77 nfet
M$583 ph[4] \$545 VSS VSS nfet L=0.6U W=0.82U AS=0.3608P AD=0.3608P PS=2.52U
+ PD=2.52U
* device instance $584 r0 *1 8.76,24.3275 nfet
M$584 \_009_[10] start VSS VSS nfet L=0.6U W=0.565U AS=0.2486P AD=0.1469P
+ PS=2.01U PD=1.085U
* device instance $585 r0 *1 9.88,24.3275 nfet
M$585 VSS \_048_ \_009_[10] VSS nfet L=0.6U W=0.565U AS=0.1469P AD=0.2486P
+ PS=1.085U PD=2.01U
* device instance $586 r0 *1 12.12,24.4775 nfet
M$586 VSS clknet_2_1__leaf_clk \$615 VSS nfet L=0.6U W=0.405U AS=0.1782P
+ AD=0.1053P PS=1.69U PD=0.925U
* device instance $587 r0 *1 13.24,24.4775 nfet
M$587 \$616 \$615 VSS VSS nfet L=0.6U W=0.405U AS=0.1053P AD=0.1782P PS=0.925U
+ PD=1.69U
* device instance $588 r0 *1 30.6,24.3275 nfet
M$588 \_009_[13] start VSS VSS nfet L=0.6U W=0.565U AS=0.2486P AD=0.1469P
+ PS=2.01U PD=1.085U
* device instance $589 r0 *1 31.72,24.3275 nfet
M$589 VSS \_043_ \_009_[13] VSS nfet L=0.6U W=0.565U AS=0.1469P AD=0.2486P
+ PS=1.085U PD=2.01U
* device instance $590 r0 *1 33.96,24.4775 nfet
M$590 VSS clknet_2_1__leaf_clk \$622 VSS nfet L=0.6U W=0.405U AS=0.1782P
+ AD=0.1053P PS=1.69U PD=0.925U
* device instance $591 r0 *1 35.08,24.4775 nfet
M$591 \$623 \$622 VSS VSS nfet L=0.6U W=0.405U AS=0.1053P AD=0.1782P PS=0.925U
+ PD=1.69U
* device instance $592 r0 *1 55.8,24.4775 nfet
M$592 VSS clknet_2_1__leaf_clk \$630 VSS nfet L=0.6U W=0.405U AS=0.1782P
+ AD=0.1053P PS=1.69U PD=0.925U
* device instance $593 r0 *1 56.92,24.4775 nfet
M$593 \$631 \$630 VSS VSS nfet L=0.6U W=0.405U AS=0.1053P AD=0.1782P PS=0.925U
+ PD=1.69U
* device instance $594 r0 *1 83.8,24.4775 nfet
M$594 VSS clknet_2_1__leaf_clk \$638 VSS nfet L=0.6U W=0.405U AS=0.1782P
+ AD=0.1053P PS=1.69U PD=0.925U
* device instance $595 r0 *1 84.92,24.4775 nfet
M$595 \$639 \$638 VSS VSS nfet L=0.6U W=0.405U AS=0.1053P AD=0.1782P PS=0.925U
+ PD=1.69U
* device instance $596 r0 *1 119.64,24.44 nfet
M$596 \_054_ ph[14] VSS VSS nfet L=0.6U W=0.48U AS=0.2112P AD=0.2112P PS=1.84U
+ PD=1.84U
* device instance $597 r0 *1 140.92,24.4775 nfet
M$597 VSS clknet_2_3__leaf_clk \$645 VSS nfet L=0.6U W=0.405U AS=0.1782P
+ AD=0.1053P PS=1.69U PD=0.925U
* device instance $598 r0 *1 142.04,24.4775 nfet
M$598 \$646 \$645 VSS VSS nfet L=0.6U W=0.405U AS=0.1053P AD=0.1782P PS=0.925U
+ PD=1.69U
* device instance $599 r0 *1 157.16,24.3275 nfet
M$599 \_058_ ph[6] VSS VSS nfet L=0.6U W=0.565U AS=0.2486P AD=0.1469P PS=2.01U
+ PD=1.085U
* device instance $600 r0 *1 158.28,24.3275 nfet
M$600 VSS q7 \_058_ VSS nfet L=0.6U W=0.565U AS=0.1469P AD=0.2486P PS=1.085U
+ PD=2.01U
* device instance $601 r0 *1 184.6,24.3275 nfet
M$601 \_063_ ph[4] VSS VSS nfet L=0.6U W=0.565U AS=0.2486P AD=0.1469P PS=2.01U
+ PD=1.085U
* device instance $602 r0 *1 185.72,24.3275 nfet
M$602 VSS q9 \_063_ VSS nfet L=0.6U W=0.565U AS=0.1469P AD=0.2486P PS=1.085U
+ PD=2.01U
* device instance $603 r0 *1 187.96,24.44 nfet
M$603 \_035_ ph[3] VSS VSS nfet L=0.6U W=0.48U AS=0.2112P AD=0.2112P PS=1.84U
+ PD=1.84U
* device instance $604 r0 *1 15.08,24.495 nfet
M$604 \$652 \$615 VSS VSS nfet L=0.6U W=0.36U AS=0.1584P AD=0.0432P PS=1.6U
+ PD=0.6U
* device instance $605 r0 *1 15.92,24.495 nfet
M$605 \$617 \_009_[12] \$652 VSS nfet L=0.6U W=0.36U AS=0.0432P AD=0.207P
+ PS=0.6U PD=1.51U
* device instance $606 r0 *1 17.54,24.495 nfet
M$606 \$653 \$616 \$617 VSS nfet L=0.6U W=0.36U AS=0.207P AD=0.0432P PS=1.51U
+ PD=0.6U
* device instance $607 r0 *1 18.38,24.495 nfet
M$607 \$653 \$618 VSS VSS nfet L=0.6U W=0.36U AS=0.2637P AD=0.0432P PS=1.825U
+ PD=0.6U
* device instance $608 r0 *1 19.94,24.495 nfet
M$608 \$618 \$617 VSS VSS nfet L=0.6U W=0.36U AS=0.2637P AD=0.0936P PS=1.825U
+ PD=0.88U
* device instance $609 r0 *1 21.06,24.495 nfet
M$609 \$619 \$616 \$618 VSS nfet L=0.6U W=0.36U AS=0.0936P AD=0.0936P PS=0.88U
+ PD=0.88U
* device instance $610 r0 *1 22.18,24.495 nfet
M$610 \$655 \$615 \$619 VSS nfet L=0.6U W=0.36U AS=0.0936P AD=0.0432P PS=0.88U
+ PD=0.6U
* device instance $611 r0 *1 23.02,24.495 nfet
M$611 \$655 \$620 VSS VSS nfet L=0.6U W=0.36U AS=0.142P AD=0.0432P PS=1.14U
+ PD=0.6U
* device instance $612 r0 *1 24.36,24.475 nfet
M$612 \$620 \$619 VSS VSS nfet L=0.6U W=0.4U AS=0.142P AD=0.176P PS=1.14U
+ PD=1.68U
* device instance $613 r0 *1 15.48,30.61 nfet
M$613 \$762 cmp VSS VSS nfet L=0.6U W=0.82U AS=0.3608P AD=0.1312P PS=2.52U
+ PD=1.14U
* device instance $614 r0 *1 16.4,30.61 nfet
M$614 \_017_ ph[11] \$762 VSS nfet L=0.6U W=0.82U AS=0.1312P AD=0.2569P
+ PS=1.14U PD=1.56U
* device instance $615 r0 *1 17.74,30.765 nfet
M$615 VSS \_057_ \_017_ VSS nfet L=0.6U W=0.51U AS=0.2569P AD=0.2244P PS=1.56U
+ PD=1.9U
* device instance $616 r0 *1 25,30.61 nfet
M$616 \$763 cmp VSS VSS nfet L=0.6U W=0.82U AS=0.3608P AD=0.1312P PS=2.52U
+ PD=1.14U
* device instance $617 r0 *1 25.92,30.61 nfet
M$617 \_020_ ph[12] \$763 VSS nfet L=0.6U W=0.82U AS=0.1312P AD=0.2569P
+ PS=1.14U PD=1.56U
* device instance $618 r0 *1 27.26,30.765 nfet
M$618 VSS \_060_ \_020_ VSS nfet L=0.6U W=0.51U AS=0.2569P AD=0.2244P PS=1.56U
+ PD=1.9U
* device instance $619 r0 *1 35.64,30.61 nfet
M$619 \$766 cmp VSS VSS nfet L=0.6U W=0.82U AS=0.3608P AD=0.1312P PS=2.52U
+ PD=1.14U
* device instance $620 r0 *1 36.56,30.61 nfet
M$620 \_012_ ph[13] \$766 VSS nfet L=0.6U W=0.82U AS=0.1312P AD=0.2569P
+ PS=1.14U PD=1.56U
* device instance $621 r0 *1 37.9,30.765 nfet
M$621 VSS \_055_ \_012_ VSS nfet L=0.6U W=0.51U AS=0.2569P AD=0.2244P PS=1.56U
+ PD=1.9U
* device instance $622 r0 *1 36.92,24.495 nfet
M$622 \$657 \$622 VSS VSS nfet L=0.6U W=0.36U AS=0.1584P AD=0.0432P PS=1.6U
+ PD=0.6U
* device instance $623 r0 *1 37.76,24.495 nfet
M$623 \$625 \_012_ \$657 VSS nfet L=0.6U W=0.36U AS=0.0432P AD=0.207P PS=0.6U
+ PD=1.51U
* device instance $624 r0 *1 39.38,24.495 nfet
M$624 \$658 \$623 \$625 VSS nfet L=0.6U W=0.36U AS=0.207P AD=0.0432P PS=1.51U
+ PD=0.6U
* device instance $625 r0 *1 40.22,24.495 nfet
M$625 \$658 \$626 VSS VSS nfet L=0.6U W=0.36U AS=0.2637P AD=0.0432P PS=1.825U
+ PD=0.6U
* device instance $626 r0 *1 41.78,24.495 nfet
M$626 \$626 \$625 VSS VSS nfet L=0.6U W=0.36U AS=0.2637P AD=0.0936P PS=1.825U
+ PD=0.88U
* device instance $627 r0 *1 42.9,24.495 nfet
M$627 \$628 \$623 \$626 VSS nfet L=0.6U W=0.36U AS=0.0936P AD=0.0936P PS=0.88U
+ PD=0.88U
* device instance $628 r0 *1 44.02,24.495 nfet
M$628 \$660 \$622 \$628 VSS nfet L=0.6U W=0.36U AS=0.0936P AD=0.0432P PS=0.88U
+ PD=0.6U
* device instance $629 r0 *1 44.86,24.495 nfet
M$629 \$660 \$629 VSS VSS nfet L=0.6U W=0.36U AS=0.142P AD=0.0432P PS=1.14U
+ PD=0.6U
* device instance $630 r0 *1 46.2,24.475 nfet
M$630 \$629 \$628 VSS VSS nfet L=0.6U W=0.4U AS=0.142P AD=0.176P PS=1.14U
+ PD=1.68U
* device instance $631 r0 *1 49.08,30.44 nfet
M$631 \_045_ ph[13] VSS VSS nfet L=0.6U W=0.48U AS=0.2112P AD=0.2112P PS=1.84U
+ PD=1.84U
* device instance $632 r0 *1 58.76,24.495 nfet
M$632 \$662 \$630 VSS VSS nfet L=0.6U W=0.36U AS=0.1584P AD=0.0432P PS=1.6U
+ PD=0.6U
* device instance $633 r0 *1 59.6,24.495 nfet
M$633 \$633 \_021_ \$662 VSS nfet L=0.6U W=0.36U AS=0.0432P AD=0.207P PS=0.6U
+ PD=1.51U
* device instance $634 r0 *1 61.22,24.495 nfet
M$634 \$664 \$631 \$633 VSS nfet L=0.6U W=0.36U AS=0.207P AD=0.0432P PS=1.51U
+ PD=0.6U
* device instance $635 r0 *1 62.06,24.495 nfet
M$635 \$664 \$634 VSS VSS nfet L=0.6U W=0.36U AS=0.2637P AD=0.0432P PS=1.825U
+ PD=0.6U
* device instance $636 r0 *1 63.62,24.495 nfet
M$636 \$634 \$633 VSS VSS nfet L=0.6U W=0.36U AS=0.2637P AD=0.0936P PS=1.825U
+ PD=0.88U
* device instance $637 r0 *1 64.74,24.495 nfet
M$637 \$635 \$631 \$634 VSS nfet L=0.6U W=0.36U AS=0.0936P AD=0.0936P PS=0.88U
+ PD=0.88U
* device instance $638 r0 *1 65.86,24.495 nfet
M$638 \$666 \$630 \$635 VSS nfet L=0.6U W=0.36U AS=0.0936P AD=0.0432P PS=0.88U
+ PD=0.6U
* device instance $639 r0 *1 66.7,24.495 nfet
M$639 \$666 \$636 VSS VSS nfet L=0.6U W=0.36U AS=0.142P AD=0.0432P PS=1.14U
+ PD=0.6U
* device instance $640 r0 *1 68.04,24.475 nfet
M$640 \$636 \$635 VSS VSS nfet L=0.6U W=0.4U AS=0.142P AD=0.176P PS=1.14U
+ PD=1.68U
* device instance $641 r0 *1 61.58,30.66 nfet
M$641 \$767 q4 VSS VSS nfet L=0.6U W=0.36U AS=0.218P AD=0.0432P PS=1.52U PD=0.6U
* device instance $642 r0 *1 62.42,30.66 nfet
M$642 \$684 ph[14] \$767 VSS nfet L=0.6U W=0.36U AS=0.0432P AD=0.0936P PS=0.6U
+ PD=0.88U
* device instance $643 r0 *1 63.54,30.66 nfet
M$643 \$768 \$685 \$684 VSS nfet L=0.6U W=0.36U AS=0.0936P AD=0.0432P PS=0.88U
+ PD=0.6U
* device instance $644 r0 *1 64.38,30.66 nfet
M$644 VSS c4_r \$768 VSS nfet L=0.6U W=0.36U AS=0.0432P AD=0.0936P PS=0.6U
+ PD=0.88U
* device instance $645 r0 *1 65.5,30.66 nfet
M$645 \$685 ph[14] VSS VSS nfet L=0.6U W=0.36U AS=0.0936P AD=0.1584P PS=0.88U
+ PD=1.6U
* device instance $646 r0 *1 60.28,30.61 nfet
M$646 VSS \$684 \_023_ VSS nfet L=0.6U W=0.82U AS=0.3608P AD=0.218P PS=2.52U
+ PD=1.52U
* device instance $647 r0 *1 78.94,30.66 nfet
M$647 \$769 q8 VSS VSS nfet L=0.6U W=0.36U AS=0.218P AD=0.0432P PS=1.52U PD=0.6U
* device instance $648 r0 *1 79.78,30.66 nfet
M$648 \$686 ph[14] \$769 VSS nfet L=0.6U W=0.36U AS=0.0432P AD=0.0936P PS=0.6U
+ PD=0.88U
* device instance $649 r0 *1 80.9,30.66 nfet
M$649 \$770 \$687 \$686 VSS nfet L=0.6U W=0.36U AS=0.0936P AD=0.0432P PS=0.88U
+ PD=0.6U
* device instance $650 r0 *1 81.74,30.66 nfet
M$650 VSS c8_r \$770 VSS nfet L=0.6U W=0.36U AS=0.0432P AD=0.0936P PS=0.6U
+ PD=0.88U
* device instance $651 r0 *1 82.86,30.66 nfet
M$651 \$687 ph[14] VSS VSS nfet L=0.6U W=0.36U AS=0.0936P AD=0.1584P PS=0.88U
+ PD=1.6U
* device instance $652 r0 *1 77.64,30.61 nfet
M$652 VSS \$686 \_010_ VSS nfet L=0.6U W=0.82U AS=0.3608P AD=0.218P PS=2.52U
+ PD=1.52U
* device instance $653 r0 *1 86.76,24.495 nfet
M$653 \$668 \$638 VSS VSS nfet L=0.6U W=0.36U AS=0.1584P AD=0.0432P PS=1.6U
+ PD=0.6U
* device instance $654 r0 *1 87.6,24.495 nfet
M$654 \$640 \_016_ \$668 VSS nfet L=0.6U W=0.36U AS=0.0432P AD=0.207P PS=0.6U
+ PD=1.51U
* device instance $655 r0 *1 89.22,24.495 nfet
M$655 \$669 \$639 \$640 VSS nfet L=0.6U W=0.36U AS=0.207P AD=0.0432P PS=1.51U
+ PD=0.6U
* device instance $656 r0 *1 90.06,24.495 nfet
M$656 \$669 \$641 VSS VSS nfet L=0.6U W=0.36U AS=0.2637P AD=0.0432P PS=1.825U
+ PD=0.6U
* device instance $657 r0 *1 91.62,24.495 nfet
M$657 \$641 \$640 VSS VSS nfet L=0.6U W=0.36U AS=0.2637P AD=0.0936P PS=1.825U
+ PD=0.88U
* device instance $658 r0 *1 92.74,24.495 nfet
M$658 \$642 \$639 \$641 VSS nfet L=0.6U W=0.36U AS=0.0936P AD=0.0936P PS=0.88U
+ PD=0.88U
* device instance $659 r0 *1 93.86,24.495 nfet
M$659 \$671 \$638 \$642 VSS nfet L=0.6U W=0.36U AS=0.0936P AD=0.0432P PS=0.88U
+ PD=0.6U
* device instance $660 r0 *1 94.7,24.495 nfet
M$660 \$671 \$643 VSS VSS nfet L=0.6U W=0.36U AS=0.142P AD=0.0432P PS=1.14U
+ PD=0.6U
* device instance $661 r0 *1 96.04,24.475 nfet
M$661 \$643 \$642 VSS VSS nfet L=0.6U W=0.4U AS=0.142P AD=0.176P PS=1.14U
+ PD=1.68U
* device instance $662 r0 *1 93.5,30.66 nfet
M$662 \$771 q5 VSS VSS nfet L=0.6U W=0.36U AS=0.218P AD=0.0432P PS=1.52U PD=0.6U
* device instance $663 r0 *1 94.34,30.66 nfet
M$663 \$688 ph[14] \$771 VSS nfet L=0.6U W=0.36U AS=0.0432P AD=0.0936P PS=0.6U
+ PD=0.88U
* device instance $664 r0 *1 95.46,30.66 nfet
M$664 \$772 \$689 \$688 VSS nfet L=0.6U W=0.36U AS=0.0936P AD=0.0432P PS=0.88U
+ PD=0.6U
* device instance $665 r0 *1 96.3,30.66 nfet
M$665 VSS c5_r \$772 VSS nfet L=0.6U W=0.36U AS=0.0432P AD=0.0936P PS=0.6U
+ PD=0.88U
* device instance $666 r0 *1 97.42,30.66 nfet
M$666 \$689 ph[14] VSS VSS nfet L=0.6U W=0.36U AS=0.0936P AD=0.1584P PS=0.88U
+ PD=1.6U
* device instance $667 r0 *1 92.2,30.61 nfet
M$667 VSS \$688 \_024_ VSS nfet L=0.6U W=0.82U AS=0.3608P AD=0.218P PS=2.52U
+ PD=1.52U
* device instance $668 r0 *1 111.42,30.66 nfet
M$668 \$774 q1 VSS VSS nfet L=0.6U W=0.36U AS=0.218P AD=0.0432P PS=1.52U PD=0.6U
* device instance $669 r0 *1 112.26,30.66 nfet
M$669 \$690 ph[14] \$774 VSS nfet L=0.6U W=0.36U AS=0.0432P AD=0.0936P PS=0.6U
+ PD=0.88U
* device instance $670 r0 *1 113.38,30.66 nfet
M$670 \$775 \$691 \$690 VSS nfet L=0.6U W=0.36U AS=0.0936P AD=0.0432P PS=0.88U
+ PD=0.6U
* device instance $671 r0 *1 114.22,30.66 nfet
M$671 VSS c1_r \$775 VSS nfet L=0.6U W=0.36U AS=0.0432P AD=0.0936P PS=0.6U
+ PD=0.88U
* device instance $672 r0 *1 115.34,30.66 nfet
M$672 \$691 ph[14] VSS VSS nfet L=0.6U W=0.36U AS=0.0936P AD=0.1584P PS=0.88U
+ PD=1.6U
* device instance $673 r0 *1 110.12,30.61 nfet
M$673 VSS \$690 \_015_ VSS nfet L=0.6U W=0.82U AS=0.3608P AD=0.218P PS=2.52U
+ PD=1.52U
* device instance $674 r0 *1 128.04,30.4025 nfet
M$674 VSS clknet_2_3__leaf_clk \$720 VSS nfet L=0.6U W=0.405U AS=0.1782P
+ AD=0.1053P PS=1.69U PD=0.925U
* device instance $675 r0 *1 129.16,30.4025 nfet
M$675 \$723 \$720 VSS VSS nfet L=0.6U W=0.405U AS=0.1053P AD=0.1782P PS=0.925U
+ PD=1.69U
* device instance $676 r0 *1 142.22,30.61 nfet
M$676 eng9 \$725 VSS VSS nfet L=0.6U W=0.82U AS=0.3608P AD=0.3608P PS=2.52U
+ PD=2.52U
* device instance $677 r0 *1 143.88,24.495 nfet
M$677 \$665 \$645 VSS VSS nfet L=0.6U W=0.36U AS=0.1584P AD=0.0432P PS=1.6U
+ PD=0.6U
* device instance $678 r0 *1 144.72,24.495 nfet
M$678 \$647 \_006_ \$665 VSS nfet L=0.6U W=0.36U AS=0.0432P AD=0.207P PS=0.6U
+ PD=1.51U
* device instance $679 r0 *1 146.34,24.495 nfet
M$679 \$663 \$646 \$647 VSS nfet L=0.6U W=0.36U AS=0.207P AD=0.0432P PS=1.51U
+ PD=0.6U
* device instance $680 r0 *1 147.18,24.495 nfet
M$680 \$663 \$648 VSS VSS nfet L=0.6U W=0.36U AS=0.2637P AD=0.0432P PS=1.825U
+ PD=0.6U
* device instance $681 r0 *1 148.74,24.495 nfet
M$681 \$648 \$647 VSS VSS nfet L=0.6U W=0.36U AS=0.2637P AD=0.0936P PS=1.825U
+ PD=0.88U
* device instance $682 r0 *1 149.86,24.495 nfet
M$682 \$649 \$646 \$648 VSS nfet L=0.6U W=0.36U AS=0.0936P AD=0.0936P PS=0.88U
+ PD=0.88U
* device instance $683 r0 *1 150.98,24.495 nfet
M$683 \$661 \$645 \$649 VSS nfet L=0.6U W=0.36U AS=0.0936P AD=0.0432P PS=0.88U
+ PD=0.6U
* device instance $684 r0 *1 151.82,24.495 nfet
M$684 \$661 \$650 VSS VSS nfet L=0.6U W=0.36U AS=0.142P AD=0.0432P PS=1.14U
+ PD=0.6U
* device instance $685 r0 *1 153.16,24.475 nfet
M$685 \$650 \$649 VSS VSS nfet L=0.6U W=0.4U AS=0.142P AD=0.176P PS=1.14U
+ PD=1.68U
* device instance $686 r0 *1 144.28,30.61 nfet
M$686 \$726 clknet_0_clk VSS VSS nfet L=0.6U W=0.82U AS=0.3608P AD=0.2132P
+ PS=2.52U PD=1.34U
* device instance $687 r0 *1 145.4,30.61 nfet
M$687 VSS clknet_0_clk \$726 VSS nfet L=0.6U W=0.82U AS=0.2132P AD=0.2132P
+ PS=1.34U PD=1.34U
* device instance $688 r0 *1 146.52,30.61 nfet
M$688 clknet_2_3__leaf_clk \$726 VSS VSS nfet L=0.6U W=0.82U AS=0.2132P
+ AD=0.2132P PS=1.34U PD=1.34U
* device instance $689 r0 *1 147.64,30.61 nfet
M$689 VSS \$726 clknet_2_3__leaf_clk VSS nfet L=0.6U W=0.82U AS=0.2132P
+ AD=0.2132P PS=1.34U PD=1.34U
* device instance $690 r0 *1 148.76,30.61 nfet
M$690 clknet_2_3__leaf_clk \$726 VSS VSS nfet L=0.6U W=0.82U AS=0.2132P
+ AD=0.2132P PS=1.34U PD=1.34U
* device instance $691 r0 *1 149.88,30.61 nfet
M$691 VSS \$726 clknet_2_3__leaf_clk VSS nfet L=0.6U W=0.82U AS=0.2132P
+ AD=0.3608P PS=1.34U PD=2.52U
* device instance $692 r0 *1 152.68,30.44 nfet
M$692 \_049_ ph[8] VSS VSS nfet L=0.6U W=0.48U AS=0.2112P AD=0.2112P PS=1.84U
+ PD=1.84U
* device instance $693 r0 *1 154.92,30.61 nfet
M$693 \$773 cmp VSS VSS nfet L=0.6U W=0.82U AS=0.3608P AD=0.1312P PS=2.52U
+ PD=1.14U
* device instance $694 r0 *1 155.84,30.61 nfet
M$694 \_018_ ph[6] \$773 VSS nfet L=0.6U W=0.82U AS=0.1312P AD=0.2569P PS=1.14U
+ PD=1.56U
* device instance $695 r0 *1 157.18,30.765 nfet
M$695 VSS \_058_ \_018_ VSS nfet L=0.6U W=0.51U AS=0.2569P AD=0.2244P PS=1.56U
+ PD=1.9U
* device instance $696 r0 *1 173.4,30.44 nfet
M$696 \_052_ ph[5] VSS VSS nfet L=0.6U W=0.48U AS=0.2112P AD=0.2112P PS=1.84U
+ PD=1.84U
* device instance $697 r0 *1 179.56,30.44 nfet
M$697 \_053_ ph[4] VSS VSS nfet L=0.6U W=0.48U AS=0.2112P AD=0.2112P PS=1.84U
+ PD=1.84U
* device instance $698 r0 *1 181.8,30.4025 nfet
M$698 VSS clknet_2_3__leaf_clk \$729 VSS nfet L=0.6U W=0.405U AS=0.1782P
+ AD=0.1053P PS=1.69U PD=0.925U
* device instance $699 r0 *1 182.92,30.4025 nfet
M$699 \$732 \$729 VSS VSS nfet L=0.6U W=0.405U AS=0.1053P AD=0.1782P PS=0.925U
+ PD=1.69U
* device instance $700 r0 *1 195.98,30.61 nfet
M$700 ph[5] \$734 VSS VSS nfet L=0.6U W=0.82U AS=0.3608P AD=0.3608P PS=2.52U
+ PD=2.52U
* device instance $701 r0 *1 8.76,30.5525 nfet
M$701 \_009_[9] start VSS VSS nfet L=0.6U W=0.565U AS=0.2486P AD=0.1469P
+ PS=2.01U PD=1.085U
* device instance $702 r0 *1 9.88,30.5525 nfet
M$702 VSS \_049_ \_009_[9] VSS nfet L=0.6U W=0.565U AS=0.1469P AD=0.2486P
+ PS=1.085U PD=2.01U
* device instance $703 r0 *1 12.12,30.5525 nfet
M$703 \_062_ ph[9] VSS VSS nfet L=0.6U W=0.565U AS=0.2486P AD=0.1469P PS=2.01U
+ PD=1.085U
* device instance $704 r0 *1 13.24,30.5525 nfet
M$704 VSS q4 \_062_ VSS nfet L=0.6U W=0.565U AS=0.1469P AD=0.2486P PS=1.085U
+ PD=2.01U
* device instance $705 r0 *1 29.48,30.5525 nfet
M$705 \_060_ q1 VSS VSS nfet L=0.6U W=0.565U AS=0.2486P AD=0.1469P PS=2.01U
+ PD=1.085U
* device instance $706 r0 *1 30.6,30.5525 nfet
M$706 VSS ph[12] \_060_ VSS nfet L=0.6U W=0.565U AS=0.1469P AD=0.2486P
+ PS=1.085U PD=2.01U
* device instance $707 r0 *1 40.12,30.5525 nfet
M$707 \_055_ q0 VSS VSS nfet L=0.6U W=0.565U AS=0.2486P AD=0.1469P PS=2.01U
+ PD=1.085U
* device instance $708 r0 *1 41.24,30.5525 nfet
M$708 VSS ph[13] \_055_ VSS nfet L=0.6U W=0.565U AS=0.1469P AD=0.2486P
+ PS=1.085U PD=2.01U
* device instance $709 r0 *1 117.96,30.5525 nfet
M$709 \_009_[15] start VSS VSS nfet L=0.6U W=0.565U AS=0.2486P AD=0.1469P
+ PS=2.01U PD=1.085U
* device instance $710 r0 *1 119.08,30.5525 nfet
M$710 VSS \_054_ \_009_[15] VSS nfet L=0.6U W=0.565U AS=0.1469P AD=0.2486P
+ PS=1.085U PD=2.01U
* device instance $711 r0 *1 131,30.385 nfet
M$711 \$776 \$720 VSS VSS nfet L=0.6U W=0.36U AS=0.1584P AD=0.0432P PS=1.6U
+ PD=0.6U
* device instance $712 r0 *1 131.84,30.385 nfet
M$712 \$776 \_008_ \$721 VSS nfet L=0.6U W=0.36U AS=0.207P AD=0.0432P PS=1.51U
+ PD=0.6U
* device instance $713 r0 *1 133.46,30.385 nfet
M$713 \$777 \$723 \$721 VSS nfet L=0.6U W=0.36U AS=0.207P AD=0.0432P PS=1.51U
+ PD=0.6U
* device instance $714 r0 *1 134.3,30.385 nfet
M$714 VSS \$722 \$777 VSS nfet L=0.6U W=0.36U AS=0.0432P AD=0.2637P PS=0.6U
+ PD=1.825U
* device instance $715 r0 *1 135.86,30.385 nfet
M$715 \$722 \$721 VSS VSS nfet L=0.6U W=0.36U AS=0.2637P AD=0.0936P PS=1.825U
+ PD=0.88U
* device instance $716 r0 *1 136.98,30.385 nfet
M$716 \$724 \$723 \$722 VSS nfet L=0.6U W=0.36U AS=0.0936P AD=0.0936P PS=0.88U
+ PD=0.88U
* device instance $717 r0 *1 138.1,30.385 nfet
M$717 \$778 \$720 \$724 VSS nfet L=0.6U W=0.36U AS=0.0936P AD=0.0432P PS=0.88U
+ PD=0.6U
* device instance $718 r0 *1 138.94,30.385 nfet
M$718 VSS \$725 \$778 VSS nfet L=0.6U W=0.36U AS=0.0432P AD=0.142P PS=0.6U
+ PD=1.14U
* device instance $719 r0 *1 140.28,30.405 nfet
M$719 \$725 \$724 VSS VSS nfet L=0.6U W=0.4U AS=0.142P AD=0.176P PS=1.14U
+ PD=1.68U
* device instance $720 r0 *1 160.52,30.5525 nfet
M$720 \_059_ ph[8] VSS VSS nfet L=0.6U W=0.565U AS=0.2486P AD=0.1469P PS=2.01U
+ PD=1.085U
* device instance $721 r0 *1 161.64,30.5525 nfet
M$721 VSS q5 \_059_ VSS nfet L=0.6U W=0.565U AS=0.1469P AD=0.2486P PS=1.085U
+ PD=2.01U
* device instance $722 r0 *1 176.2,30.5525 nfet
M$722 \_009_[5] start VSS VSS nfet L=0.6U W=0.565U AS=0.2486P AD=0.1469P
+ PS=2.01U PD=1.085U
* device instance $723 r0 *1 177.32,30.5525 nfet
M$723 VSS \_053_ \_009_[5] VSS nfet L=0.6U W=0.565U AS=0.1469P AD=0.2486P
+ PS=1.085U PD=2.01U
* device instance $724 r0 *1 184.76,30.385 nfet
M$724 \$765 \$729 VSS VSS nfet L=0.6U W=0.36U AS=0.1584P AD=0.0432P PS=1.6U
+ PD=0.6U
* device instance $725 r0 *1 185.6,30.385 nfet
M$725 \$765 \_009_[5] \$730 VSS nfet L=0.6U W=0.36U AS=0.207P AD=0.0432P
+ PS=1.51U PD=0.6U
* device instance $726 r0 *1 187.22,30.385 nfet
M$726 \$764 \$732 \$730 VSS nfet L=0.6U W=0.36U AS=0.207P AD=0.0432P PS=1.51U
+ PD=0.6U
* device instance $727 r0 *1 188.06,30.385 nfet
M$727 VSS \$731 \$764 VSS nfet L=0.6U W=0.36U AS=0.0432P AD=0.2637P PS=0.6U
+ PD=1.825U
* device instance $728 r0 *1 189.62,30.385 nfet
M$728 \$731 \$730 VSS VSS nfet L=0.6U W=0.36U AS=0.2637P AD=0.0936P PS=1.825U
+ PD=0.88U
* device instance $729 r0 *1 190.74,30.385 nfet
M$729 \$733 \$732 \$731 VSS nfet L=0.6U W=0.36U AS=0.0936P AD=0.0936P PS=0.88U
+ PD=0.88U
* device instance $730 r0 *1 191.86,30.385 nfet
M$730 \$761 \$729 \$733 VSS nfet L=0.6U W=0.36U AS=0.0936P AD=0.0432P PS=0.88U
+ PD=0.6U
* device instance $731 r0 *1 192.7,30.385 nfet
M$731 VSS \$734 \$761 VSS nfet L=0.6U W=0.36U AS=0.0432P AD=0.142P PS=0.6U
+ PD=1.14U
* device instance $732 r0 *1 194.04,30.405 nfet
M$732 \$734 \$733 VSS VSS nfet L=0.6U W=0.4U AS=0.142P AD=0.176P PS=1.14U
+ PD=1.68U
* device instance $733 r0 *1 4.84,32.3175 nfet
M$733 VSS clknet_2_1__leaf_clk \$783 VSS nfet L=0.6U W=0.405U AS=0.1782P
+ AD=0.1053P PS=1.69U PD=0.925U
* device instance $734 r0 *1 5.96,32.3175 nfet
M$734 \$784 \$783 VSS VSS nfet L=0.6U W=0.405U AS=0.1053P AD=0.1782P PS=0.925U
+ PD=1.69U
* device instance $735 r0 *1 7.8,32.335 nfet
M$735 \$826 \$783 VSS VSS nfet L=0.6U W=0.36U AS=0.1584P AD=0.0432P PS=1.6U
+ PD=0.6U
* device instance $736 r0 *1 8.64,32.335 nfet
M$736 \$785 \_025_ \$826 VSS nfet L=0.6U W=0.36U AS=0.0432P AD=0.207P PS=0.6U
+ PD=1.51U
* device instance $737 r0 *1 10.26,32.335 nfet
M$737 \$827 \$784 \$785 VSS nfet L=0.6U W=0.36U AS=0.207P AD=0.0432P PS=1.51U
+ PD=0.6U
* device instance $738 r0 *1 11.1,32.335 nfet
M$738 \$827 \$786 VSS VSS nfet L=0.6U W=0.36U AS=0.2637P AD=0.0432P PS=1.825U
+ PD=0.6U
* device instance $739 r0 *1 12.66,32.335 nfet
M$739 \$786 \$785 VSS VSS nfet L=0.6U W=0.36U AS=0.2637P AD=0.0936P PS=1.825U
+ PD=0.88U
* device instance $740 r0 *1 13.78,32.335 nfet
M$740 \$787 \$784 \$786 VSS nfet L=0.6U W=0.36U AS=0.0936P AD=0.0936P PS=0.88U
+ PD=0.88U
* device instance $741 r0 *1 14.9,32.335 nfet
M$741 \$829 \$783 \$787 VSS nfet L=0.6U W=0.36U AS=0.0936P AD=0.0432P PS=0.88U
+ PD=0.6U
* device instance $742 r0 *1 15.74,32.335 nfet
M$742 \$829 \$788 VSS VSS nfet L=0.6U W=0.36U AS=0.142P AD=0.0432P PS=1.14U
+ PD=0.6U
* device instance $743 r0 *1 17.08,32.315 nfet
M$743 \$788 \$787 VSS VSS nfet L=0.6U W=0.4U AS=0.142P AD=0.176P PS=1.14U
+ PD=1.68U
* device instance $744 r0 *1 19.02,32.11 nfet
M$744 q4 \$788 VSS VSS nfet L=0.6U W=0.82U AS=0.3608P AD=0.3608P PS=2.52U
+ PD=2.52U
* device instance $745 r0 *1 27.24,32.3175 nfet
M$745 VSS clknet_2_1__leaf_clk \$789 VSS nfet L=0.6U W=0.405U AS=0.1782P
+ AD=0.1053P PS=1.69U PD=0.925U
* device instance $746 r0 *1 28.36,32.3175 nfet
M$746 \$790 \$789 VSS VSS nfet L=0.6U W=0.405U AS=0.1053P AD=0.1782P PS=0.925U
+ PD=1.69U
* device instance $747 r0 *1 30.2,32.335 nfet
M$747 \$832 \$789 VSS VSS nfet L=0.6U W=0.36U AS=0.1584P AD=0.0432P PS=1.6U
+ PD=0.6U
* device instance $748 r0 *1 31.04,32.335 nfet
M$748 \$791 \_009_[13] \$832 VSS nfet L=0.6U W=0.36U AS=0.0432P AD=0.207P
+ PS=0.6U PD=1.51U
* device instance $749 r0 *1 32.66,32.335 nfet
M$749 \$833 \$790 \$791 VSS nfet L=0.6U W=0.36U AS=0.207P AD=0.0432P PS=1.51U
+ PD=0.6U
* device instance $750 r0 *1 33.5,32.335 nfet
M$750 \$833 \$792 VSS VSS nfet L=0.6U W=0.36U AS=0.2637P AD=0.0432P PS=1.825U
+ PD=0.6U
* device instance $751 r0 *1 35.06,32.335 nfet
M$751 \$792 \$791 VSS VSS nfet L=0.6U W=0.36U AS=0.2637P AD=0.0936P PS=1.825U
+ PD=0.88U
* device instance $752 r0 *1 36.18,32.335 nfet
M$752 \$793 \$790 \$792 VSS nfet L=0.6U W=0.36U AS=0.0936P AD=0.0936P PS=0.88U
+ PD=0.88U
* device instance $753 r0 *1 37.3,32.335 nfet
M$753 \$835 \$789 \$793 VSS nfet L=0.6U W=0.36U AS=0.0936P AD=0.0432P PS=0.88U
+ PD=0.6U
* device instance $754 r0 *1 38.14,32.335 nfet
M$754 \$835 \$794 VSS VSS nfet L=0.6U W=0.36U AS=0.142P AD=0.0432P PS=1.14U
+ PD=0.6U
* device instance $755 r0 *1 39.48,32.315 nfet
M$755 \$794 \$793 VSS VSS nfet L=0.6U W=0.4U AS=0.142P AD=0.176P PS=1.14U
+ PD=1.68U
* device instance $756 r0 *1 41.42,32.11 nfet
M$756 ph[13] \$794 VSS VSS nfet L=0.6U W=0.82U AS=0.3608P AD=0.3608P PS=2.52U
+ PD=2.52U
* device instance $757 r0 *1 47.96,32.1675 nfet
M$757 \_009_[14] start VSS VSS nfet L=0.6U W=0.565U AS=0.2486P AD=0.1469P
+ PS=2.01U PD=1.085U
* device instance $758 r0 *1 49.08,32.1675 nfet
M$758 VSS \_045_ \_009_[14] VSS nfet L=0.6U W=0.565U AS=0.1469P AD=0.2486P
+ PS=1.085U PD=2.01U
* device instance $759 r0 *1 51.32,32.3175 nfet
M$759 VSS clknet_2_1__leaf_clk \$795 VSS nfet L=0.6U W=0.405U AS=0.1782P
+ AD=0.1053P PS=1.69U PD=0.925U
* device instance $760 r0 *1 52.44,32.3175 nfet
M$760 \$796 \$795 VSS VSS nfet L=0.6U W=0.405U AS=0.1053P AD=0.1782P PS=0.925U
+ PD=1.69U
* device instance $761 r0 *1 54.28,32.335 nfet
M$761 \$838 \$795 VSS VSS nfet L=0.6U W=0.36U AS=0.1584P AD=0.0432P PS=1.6U
+ PD=0.6U
* device instance $762 r0 *1 55.12,32.335 nfet
M$762 \$797 \_013_ \$838 VSS nfet L=0.6U W=0.36U AS=0.0432P AD=0.207P PS=0.6U
+ PD=1.51U
* device instance $763 r0 *1 56.74,32.335 nfet
M$763 \$839 \$796 \$797 VSS nfet L=0.6U W=0.36U AS=0.207P AD=0.0432P PS=1.51U
+ PD=0.6U
* device instance $764 r0 *1 57.58,32.335 nfet
M$764 \$839 \$798 VSS VSS nfet L=0.6U W=0.36U AS=0.2637P AD=0.0432P PS=1.825U
+ PD=0.6U
* device instance $765 r0 *1 59.14,32.335 nfet
M$765 \$798 \$797 VSS VSS nfet L=0.6U W=0.36U AS=0.2637P AD=0.0936P PS=1.825U
+ PD=0.88U
* device instance $766 r0 *1 60.26,32.335 nfet
M$766 \$799 \$796 \$798 VSS nfet L=0.6U W=0.36U AS=0.0936P AD=0.0936P PS=0.88U
+ PD=0.88U
* device instance $767 r0 *1 61.38,32.335 nfet
M$767 \$841 \$795 \$799 VSS nfet L=0.6U W=0.36U AS=0.0936P AD=0.0432P PS=0.88U
+ PD=0.6U
* device instance $768 r0 *1 62.22,32.335 nfet
M$768 \$841 \$800 VSS VSS nfet L=0.6U W=0.36U AS=0.142P AD=0.0432P PS=1.14U
+ PD=0.6U
* device instance $769 r0 *1 63.56,32.315 nfet
M$769 \$800 \$799 VSS VSS nfet L=0.6U W=0.4U AS=0.142P AD=0.176P PS=1.14U
+ PD=1.68U
* device instance $770 r0 *1 65.5,32.11 nfet
M$770 c0_r \$800 VSS VSS nfet L=0.6U W=0.82U AS=0.3608P AD=0.3608P PS=2.52U
+ PD=2.52U
* device instance $771 r0 *1 76.52,32.3175 nfet
M$771 VSS clknet_2_1__leaf_clk \$801 VSS nfet L=0.6U W=0.405U AS=0.1782P
+ AD=0.1053P PS=1.69U PD=0.925U
* device instance $772 r0 *1 77.64,32.3175 nfet
M$772 \$802 \$801 VSS VSS nfet L=0.6U W=0.405U AS=0.1053P AD=0.1782P PS=0.925U
+ PD=1.69U
* device instance $773 r0 *1 79.48,32.335 nfet
M$773 \$844 \$801 VSS VSS nfet L=0.6U W=0.36U AS=0.1584P AD=0.0432P PS=1.6U
+ PD=0.6U
* device instance $774 r0 *1 80.32,32.335 nfet
M$774 \$803 \_011_ \$844 VSS nfet L=0.6U W=0.36U AS=0.0432P AD=0.207P PS=0.6U
+ PD=1.51U
* device instance $775 r0 *1 81.94,32.335 nfet
M$775 \$845 \$802 \$803 VSS nfet L=0.6U W=0.36U AS=0.207P AD=0.0432P PS=1.51U
+ PD=0.6U
* device instance $776 r0 *1 82.78,32.335 nfet
M$776 \$845 \$804 VSS VSS nfet L=0.6U W=0.36U AS=0.2637P AD=0.0432P PS=1.825U
+ PD=0.6U
* device instance $777 r0 *1 84.34,32.335 nfet
M$777 \$804 \$803 VSS VSS nfet L=0.6U W=0.36U AS=0.2637P AD=0.0936P PS=1.825U
+ PD=0.88U
* device instance $778 r0 *1 85.46,32.335 nfet
M$778 \$805 \$802 \$804 VSS nfet L=0.6U W=0.36U AS=0.0936P AD=0.0936P PS=0.88U
+ PD=0.88U
* device instance $779 r0 *1 86.58,32.335 nfet
M$779 \$847 \$801 \$805 VSS nfet L=0.6U W=0.36U AS=0.0936P AD=0.0432P PS=0.88U
+ PD=0.6U
* device instance $780 r0 *1 87.42,32.335 nfet
M$780 \$847 \$806 VSS VSS nfet L=0.6U W=0.36U AS=0.142P AD=0.0432P PS=1.14U
+ PD=0.6U
* device instance $781 r0 *1 88.76,32.315 nfet
M$781 \$806 \$805 VSS VSS nfet L=0.6U W=0.4U AS=0.142P AD=0.176P PS=1.14U
+ PD=1.68U
* device instance $782 r0 *1 90.7,32.11 nfet
M$782 c9_r \$806 VSS VSS nfet L=0.6U W=0.82U AS=0.3608P AD=0.3608P PS=2.52U
+ PD=2.52U
* device instance $783 r0 *1 92.76,32.11 nfet
M$783 \$782 clk VSS VSS nfet L=0.6U W=0.82U AS=0.3608P AD=0.2132P PS=2.52U
+ PD=1.34U
* device instance $784 r0 *1 93.88,32.11 nfet
M$784 VSS clk \$782 VSS nfet L=0.6U W=0.82U AS=0.2132P AD=0.2132P PS=1.34U
+ PD=1.34U
* device instance $785 r0 *1 95,32.11 nfet
M$785 clknet_0_clk \$782 VSS VSS nfet L=0.6U W=0.82U AS=0.2132P AD=0.2132P
+ PS=1.34U PD=1.34U
* device instance $786 r0 *1 96.12,32.11 nfet
M$786 VSS \$782 clknet_0_clk VSS nfet L=0.6U W=0.82U AS=0.2132P AD=0.2132P
+ PS=1.34U PD=1.34U
* device instance $787 r0 *1 97.24,32.11 nfet
M$787 clknet_0_clk \$782 VSS VSS nfet L=0.6U W=0.82U AS=0.2132P AD=0.2132P
+ PS=1.34U PD=1.34U
* device instance $788 r0 *1 98.36,32.11 nfet
M$788 VSS \$782 clknet_0_clk VSS nfet L=0.6U W=0.82U AS=0.2132P AD=0.3608P
+ PS=1.34U PD=2.52U
* device instance $789 r0 *1 111.42,32.06 nfet
M$789 \$848 q7 VSS VSS nfet L=0.6U W=0.36U AS=0.218P AD=0.0432P PS=1.52U PD=0.6U
* device instance $790 r0 *1 112.26,32.06 nfet
M$790 \$779 ph[14] \$848 VSS nfet L=0.6U W=0.36U AS=0.0432P AD=0.0936P PS=0.6U
+ PD=0.88U
* device instance $791 r0 *1 113.38,32.06 nfet
M$791 \$846 \$780 \$779 VSS nfet L=0.6U W=0.36U AS=0.0936P AD=0.0432P PS=0.88U
+ PD=0.6U
* device instance $792 r0 *1 114.22,32.06 nfet
M$792 VSS c7_r \$846 VSS nfet L=0.6U W=0.36U AS=0.0432P AD=0.0936P PS=0.6U
+ PD=0.88U
* device instance $793 r0 *1 115.34,32.06 nfet
M$793 \$780 ph[14] VSS VSS nfet L=0.6U W=0.36U AS=0.0936P AD=0.1584P PS=0.88U
+ PD=1.6U
* device instance $794 r0 *1 110.12,32.11 nfet
M$794 VSS \$779 \_028_ VSS nfet L=0.6U W=0.82U AS=0.3608P AD=0.218P PS=2.52U
+ PD=1.52U
* device instance $795 r0 *1 118.52,32.3175 nfet
M$795 VSS clknet_2_3__leaf_clk \$808 VSS nfet L=0.6U W=0.405U AS=0.1782P
+ AD=0.1053P PS=1.69U PD=0.925U
* device instance $796 r0 *1 119.64,32.3175 nfet
M$796 \$809 \$808 VSS VSS nfet L=0.6U W=0.405U AS=0.1053P AD=0.1782P PS=0.925U
+ PD=1.69U
* device instance $797 r0 *1 121.48,32.335 nfet
M$797 \$843 \$808 VSS VSS nfet L=0.6U W=0.36U AS=0.1584P AD=0.0432P PS=1.6U
+ PD=0.6U
* device instance $798 r0 *1 122.32,32.335 nfet
M$798 \$810 \_009_[15] \$843 VSS nfet L=0.6U W=0.36U AS=0.0432P AD=0.207P
+ PS=0.6U PD=1.51U
* device instance $799 r0 *1 123.94,32.335 nfet
M$799 \$842 \$809 \$810 VSS nfet L=0.6U W=0.36U AS=0.207P AD=0.0432P PS=1.51U
+ PD=0.6U
* device instance $800 r0 *1 124.78,32.335 nfet
M$800 \$842 \$811 VSS VSS nfet L=0.6U W=0.36U AS=0.2637P AD=0.0432P PS=1.825U
+ PD=0.6U
* device instance $801 r0 *1 126.34,32.335 nfet
M$801 \$811 \$810 VSS VSS nfet L=0.6U W=0.36U AS=0.2637P AD=0.0936P PS=1.825U
+ PD=0.88U
* device instance $802 r0 *1 127.46,32.335 nfet
M$802 \$812 \$809 \$811 VSS nfet L=0.6U W=0.36U AS=0.0936P AD=0.0936P PS=0.88U
+ PD=0.88U
* device instance $803 r0 *1 128.58,32.335 nfet
M$803 \$840 \$808 \$812 VSS nfet L=0.6U W=0.36U AS=0.0936P AD=0.0432P PS=0.88U
+ PD=0.6U
* device instance $804 r0 *1 129.42,32.335 nfet
M$804 \$840 \$813 VSS VSS nfet L=0.6U W=0.36U AS=0.142P AD=0.0432P PS=1.14U
+ PD=0.6U
* device instance $805 r0 *1 130.76,32.315 nfet
M$805 \$813 \$812 VSS VSS nfet L=0.6U W=0.4U AS=0.142P AD=0.176P PS=1.14U
+ PD=1.68U
* device instance $806 r0 *1 132.7,32.11 nfet
M$806 ph[15] \$813 VSS VSS nfet L=0.6U W=0.82U AS=0.3608P AD=0.3608P PS=2.52U
+ PD=2.52U
* device instance $807 r0 *1 148.2,32.3175 nfet
M$807 VSS clknet_2_3__leaf_clk \$814 VSS nfet L=0.6U W=0.405U AS=0.1782P
+ AD=0.1053P PS=1.69U PD=0.925U
* device instance $808 r0 *1 149.32,32.3175 nfet
M$808 \$815 \$814 VSS VSS nfet L=0.6U W=0.405U AS=0.1053P AD=0.1782P PS=0.925U
+ PD=1.69U
* device instance $809 r0 *1 151.16,32.335 nfet
M$809 \$837 \$814 VSS VSS nfet L=0.6U W=0.36U AS=0.1584P AD=0.0432P PS=1.6U
+ PD=0.6U
* device instance $810 r0 *1 152,32.335 nfet
M$810 \$816 \_009_[8] \$837 VSS nfet L=0.6U W=0.36U AS=0.0432P AD=0.207P
+ PS=0.6U PD=1.51U
* device instance $811 r0 *1 153.62,32.335 nfet
M$811 \$836 \$815 \$816 VSS nfet L=0.6U W=0.36U AS=0.207P AD=0.0432P PS=1.51U
+ PD=0.6U
* device instance $812 r0 *1 154.46,32.335 nfet
M$812 \$836 \$817 VSS VSS nfet L=0.6U W=0.36U AS=0.2637P AD=0.0432P PS=1.825U
+ PD=0.6U
* device instance $813 r0 *1 156.02,32.335 nfet
M$813 \$817 \$816 VSS VSS nfet L=0.6U W=0.36U AS=0.2637P AD=0.0936P PS=1.825U
+ PD=0.88U
* device instance $814 r0 *1 157.14,32.335 nfet
M$814 \$818 \$815 \$817 VSS nfet L=0.6U W=0.36U AS=0.0936P AD=0.0936P PS=0.88U
+ PD=0.88U
* device instance $815 r0 *1 158.26,32.335 nfet
M$815 \$834 \$814 \$818 VSS nfet L=0.6U W=0.36U AS=0.0936P AD=0.0432P PS=0.88U
+ PD=0.6U
* device instance $816 r0 *1 159.1,32.335 nfet
M$816 \$834 \$819 VSS VSS nfet L=0.6U W=0.36U AS=0.142P AD=0.0432P PS=1.14U
+ PD=0.6U
* device instance $817 r0 *1 160.44,32.315 nfet
M$817 \$819 \$818 VSS VSS nfet L=0.6U W=0.4U AS=0.142P AD=0.176P PS=1.14U
+ PD=1.68U
* device instance $818 r0 *1 162.38,32.11 nfet
M$818 ph[8] \$819 VSS VSS nfet L=0.6U W=0.82U AS=0.3608P AD=0.3608P PS=2.52U
+ PD=2.52U
* device instance $819 r0 *1 177.32,32.3175 nfet
M$819 VSS clknet_2_3__leaf_clk \$820 VSS nfet L=0.6U W=0.405U AS=0.1782P
+ AD=0.1053P PS=1.69U PD=0.925U
* device instance $820 r0 *1 178.44,32.3175 nfet
M$820 \$821 \$820 VSS VSS nfet L=0.6U W=0.405U AS=0.1053P AD=0.1782P PS=0.925U
+ PD=1.69U
* device instance $821 r0 *1 180.28,32.335 nfet
M$821 \$831 \$820 VSS VSS nfet L=0.6U W=0.36U AS=0.1584P AD=0.0432P PS=1.6U
+ PD=0.6U
* device instance $822 r0 *1 181.12,32.335 nfet
M$822 \$822 \_009_[2] \$831 VSS nfet L=0.6U W=0.36U AS=0.0432P AD=0.207P
+ PS=0.6U PD=1.51U
* device instance $823 r0 *1 182.74,32.335 nfet
M$823 \$830 \$821 \$822 VSS nfet L=0.6U W=0.36U AS=0.207P AD=0.0432P PS=1.51U
+ PD=0.6U
* device instance $824 r0 *1 183.58,32.335 nfet
M$824 \$830 \$823 VSS VSS nfet L=0.6U W=0.36U AS=0.2637P AD=0.0432P PS=1.825U
+ PD=0.6U
* device instance $825 r0 *1 185.14,32.335 nfet
M$825 \$823 \$822 VSS VSS nfet L=0.6U W=0.36U AS=0.2637P AD=0.0936P PS=1.825U
+ PD=0.88U
* device instance $826 r0 *1 186.26,32.335 nfet
M$826 \$824 \$821 \$823 VSS nfet L=0.6U W=0.36U AS=0.0936P AD=0.0936P PS=0.88U
+ PD=0.88U
* device instance $827 r0 *1 187.38,32.335 nfet
M$827 \$828 \$820 \$824 VSS nfet L=0.6U W=0.36U AS=0.0936P AD=0.0432P PS=0.88U
+ PD=0.6U
* device instance $828 r0 *1 188.22,32.335 nfet
M$828 \$828 \$825 VSS VSS nfet L=0.6U W=0.36U AS=0.142P AD=0.0432P PS=1.14U
+ PD=0.6U
* device instance $829 r0 *1 189.56,32.315 nfet
M$829 \$825 \$824 VSS VSS nfet L=0.6U W=0.4U AS=0.142P AD=0.176P PS=1.14U
+ PD=1.68U
* device instance $830 r0 *1 191.5,32.11 nfet
M$830 ph[2] \$825 VSS VSS nfet L=0.6U W=0.82U AS=0.3608P AD=0.3608P PS=2.52U
+ PD=2.52U
* device instance $831 r0 *1 2.04,38.2425 nfet
M$831 VSS clknet_2_1__leaf_clk \$876 VSS nfet L=0.6U W=0.405U AS=0.1782P
+ AD=0.1053P PS=1.69U PD=0.925U
* device instance $832 r0 *1 3.16,38.2425 nfet
M$832 \$878 \$876 VSS VSS nfet L=0.6U W=0.405U AS=0.1053P AD=0.1782P PS=0.925U
+ PD=1.69U
* device instance $833 r0 *1 5,38.225 nfet
M$833 \$944 \$876 VSS VSS nfet L=0.6U W=0.36U AS=0.1584P AD=0.0432P PS=1.6U
+ PD=0.6U
* device instance $834 r0 *1 5.84,38.225 nfet
M$834 \$944 \_009_[9] \$907 VSS nfet L=0.6U W=0.36U AS=0.207P AD=0.0432P
+ PS=1.51U PD=0.6U
* device instance $835 r0 *1 7.46,38.225 nfet
M$835 \$945 \$878 \$907 VSS nfet L=0.6U W=0.36U AS=0.207P AD=0.0432P PS=1.51U
+ PD=0.6U
* device instance $836 r0 *1 8.3,38.225 nfet
M$836 VSS \$877 \$945 VSS nfet L=0.6U W=0.36U AS=0.0432P AD=0.2637P PS=0.6U
+ PD=1.825U
* device instance $837 r0 *1 9.86,38.225 nfet
M$837 \$877 \$907 VSS VSS nfet L=0.6U W=0.36U AS=0.2637P AD=0.0936P PS=1.825U
+ PD=0.88U
* device instance $838 r0 *1 10.98,38.225 nfet
M$838 \$908 \$878 \$877 VSS nfet L=0.6U W=0.36U AS=0.0936P AD=0.0936P PS=0.88U
+ PD=0.88U
* device instance $839 r0 *1 12.1,38.225 nfet
M$839 \$946 \$876 \$908 VSS nfet L=0.6U W=0.36U AS=0.0936P AD=0.0432P PS=0.88U
+ PD=0.6U
* device instance $840 r0 *1 12.94,38.225 nfet
M$840 VSS \$879 \$946 VSS nfet L=0.6U W=0.36U AS=0.0432P AD=0.142P PS=0.6U
+ PD=1.14U
* device instance $841 r0 *1 14.28,38.245 nfet
M$841 \$879 \$908 VSS VSS nfet L=0.6U W=0.4U AS=0.142P AD=0.176P PS=1.14U
+ PD=1.68U
* device instance $842 r0 *1 16.22,38.45 nfet
M$842 ph[9] \$879 VSS VSS nfet L=0.6U W=0.82U AS=0.3608P AD=0.3608P PS=2.52U
+ PD=2.52U
* device instance $843 r0 *1 21.64,38.2425 nfet
M$843 VSS clknet_2_1__leaf_clk \$880 VSS nfet L=0.6U W=0.405U AS=0.1782P
+ AD=0.1053P PS=1.69U PD=0.925U
* device instance $844 r0 *1 22.76,38.2425 nfet
M$844 \$882 \$880 VSS VSS nfet L=0.6U W=0.405U AS=0.1053P AD=0.1782P PS=0.925U
+ PD=1.69U
* device instance $845 r0 *1 24.6,38.225 nfet
M$845 \$947 \$880 VSS VSS nfet L=0.6U W=0.36U AS=0.1584P AD=0.0432P PS=1.6U
+ PD=0.6U
* device instance $846 r0 *1 25.44,38.225 nfet
M$846 \$947 \_020_ \$909 VSS nfet L=0.6U W=0.36U AS=0.207P AD=0.0432P PS=1.51U
+ PD=0.6U
* device instance $847 r0 *1 27.06,38.225 nfet
M$847 \$948 \$882 \$909 VSS nfet L=0.6U W=0.36U AS=0.207P AD=0.0432P PS=1.51U
+ PD=0.6U
* device instance $848 r0 *1 27.9,38.225 nfet
M$848 VSS \$881 \$948 VSS nfet L=0.6U W=0.36U AS=0.0432P AD=0.2637P PS=0.6U
+ PD=1.825U
* device instance $849 r0 *1 29.46,38.225 nfet
M$849 \$881 \$909 VSS VSS nfet L=0.6U W=0.36U AS=0.2637P AD=0.0936P PS=1.825U
+ PD=0.88U
* device instance $850 r0 *1 30.58,38.225 nfet
M$850 \$910 \$882 \$881 VSS nfet L=0.6U W=0.36U AS=0.0936P AD=0.0936P PS=0.88U
+ PD=0.88U
* device instance $851 r0 *1 31.7,38.225 nfet
M$851 \$949 \$880 \$910 VSS nfet L=0.6U W=0.36U AS=0.0936P AD=0.0432P PS=0.88U
+ PD=0.6U
* device instance $852 r0 *1 32.54,38.225 nfet
M$852 VSS \$883 \$949 VSS nfet L=0.6U W=0.36U AS=0.0432P AD=0.142P PS=0.6U
+ PD=1.14U
* device instance $853 r0 *1 33.88,38.245 nfet
M$853 \$883 \$910 VSS VSS nfet L=0.6U W=0.4U AS=0.142P AD=0.176P PS=1.14U
+ PD=1.68U
* device instance $854 r0 *1 35.82,38.45 nfet
M$854 q1 \$883 VSS VSS nfet L=0.6U W=0.82U AS=0.3608P AD=0.3608P PS=2.52U
+ PD=2.52U
* device instance $855 r0 *1 40.12,38.45 nfet
M$855 \$884 clknet_2_0__leaf_clk VSS VSS nfet L=0.6U W=0.82U AS=0.3608P
+ AD=0.2132P PS=2.52U PD=1.34U
* device instance $856 r0 *1 41.24,38.45 nfet
M$856 VSS clknet_2_0__leaf_clk \$884 VSS nfet L=0.6U W=0.82U AS=0.2132P
+ AD=0.2132P PS=1.34U PD=1.34U
* device instance $857 r0 *1 42.36,38.45 nfet
M$857 Z \$884 VSS VSS nfet L=0.6U W=0.82U AS=0.2132P AD=0.2132P PS=1.34U
+ PD=1.34U
* device instance $858 r0 *1 43.48,38.45 nfet
M$858 VSS \$884 Z VSS nfet L=0.6U W=0.82U AS=0.2132P AD=0.2132P PS=1.34U
+ PD=1.34U
* device instance $859 r0 *1 44.6,38.45 nfet
M$859 Z \$884 VSS VSS nfet L=0.6U W=0.82U AS=0.2132P AD=0.2132P PS=1.34U
+ PD=1.34U
* device instance $860 r0 *1 45.72,38.45 nfet
M$860 VSS \$884 Z VSS nfet L=0.6U W=0.82U AS=0.2132P AD=0.3608P PS=1.34U
+ PD=2.52U
* device instance $861 r0 *1 47.96,38.2425 nfet
M$861 VSS clknet_2_1__leaf_clk \$886 VSS nfet L=0.6U W=0.405U AS=0.1782P
+ AD=0.1053P PS=1.69U PD=0.925U
* device instance $862 r0 *1 49.08,38.2425 nfet
M$862 \$888 \$886 VSS VSS nfet L=0.6U W=0.405U AS=0.1053P AD=0.1782P PS=0.925U
+ PD=1.69U
* device instance $863 r0 *1 50.92,38.225 nfet
M$863 \$950 \$886 VSS VSS nfet L=0.6U W=0.36U AS=0.1584P AD=0.0432P PS=1.6U
+ PD=0.6U
* device instance $864 r0 *1 51.76,38.225 nfet
M$864 \$950 \_009_[14] \$911 VSS nfet L=0.6U W=0.36U AS=0.207P AD=0.0432P
+ PS=1.51U PD=0.6U
* device instance $865 r0 *1 53.38,38.225 nfet
M$865 \$951 \$888 \$911 VSS nfet L=0.6U W=0.36U AS=0.207P AD=0.0432P PS=1.51U
+ PD=0.6U
* device instance $866 r0 *1 54.22,38.225 nfet
M$866 VSS \$887 \$951 VSS nfet L=0.6U W=0.36U AS=0.0432P AD=0.2637P PS=0.6U
+ PD=1.825U
* device instance $867 r0 *1 55.78,38.225 nfet
M$867 \$887 \$911 VSS VSS nfet L=0.6U W=0.36U AS=0.2637P AD=0.0936P PS=1.825U
+ PD=0.88U
* device instance $868 r0 *1 56.9,38.225 nfet
M$868 \$912 \$888 \$887 VSS nfet L=0.6U W=0.36U AS=0.0936P AD=0.0936P PS=0.88U
+ PD=0.88U
* device instance $869 r0 *1 58.02,38.225 nfet
M$869 \$952 \$886 \$912 VSS nfet L=0.6U W=0.36U AS=0.0936P AD=0.0432P PS=0.88U
+ PD=0.6U
* device instance $870 r0 *1 58.86,38.225 nfet
M$870 VSS \$889 \$952 VSS nfet L=0.6U W=0.36U AS=0.0432P AD=0.142P PS=0.6U
+ PD=1.14U
* device instance $871 r0 *1 60.2,38.245 nfet
M$871 \$889 \$912 VSS VSS nfet L=0.6U W=0.4U AS=0.142P AD=0.176P PS=1.14U
+ PD=1.68U
* device instance $872 r0 *1 62.14,38.45 nfet
M$872 ph[14] \$889 VSS VSS nfet L=0.6U W=0.82U AS=0.3608P AD=0.3608P PS=2.52U
+ PD=2.52U
* device instance $873 r0 *1 65.5,38.5 nfet
M$873 \$953 q3 VSS VSS nfet L=0.6U W=0.36U AS=0.218P AD=0.0432P PS=1.52U PD=0.6U
* device instance $874 r0 *1 66.34,38.5 nfet
M$874 \$890 ph[14] \$953 VSS nfet L=0.6U W=0.36U AS=0.0432P AD=0.0936P PS=0.6U
+ PD=0.88U
* device instance $875 r0 *1 67.46,38.5 nfet
M$875 \$954 \$851 \$890 VSS nfet L=0.6U W=0.36U AS=0.0936P AD=0.0432P PS=0.88U
+ PD=0.6U
* device instance $876 r0 *1 68.3,38.5 nfet
M$876 VSS c3_r \$954 VSS nfet L=0.6U W=0.36U AS=0.0432P AD=0.0936P PS=0.6U
+ PD=0.88U
* device instance $877 r0 *1 69.42,38.5 nfet
M$877 \$851 ph[14] VSS VSS nfet L=0.6U W=0.36U AS=0.0936P AD=0.1584P PS=0.88U
+ PD=1.6U
* device instance $878 r0 *1 64.2,38.45 nfet
M$878 VSS \$890 \_021_ VSS nfet L=0.6U W=0.82U AS=0.3608P AD=0.218P PS=2.52U
+ PD=1.52U
* device instance $879 r0 *1 73.16,38.2425 nfet
M$879 VSS clknet_2_1__leaf_clk \$891 VSS nfet L=0.6U W=0.405U AS=0.1782P
+ AD=0.1053P PS=1.69U PD=0.925U
* device instance $880 r0 *1 74.28,38.2425 nfet
M$880 \$893 \$891 VSS VSS nfet L=0.6U W=0.405U AS=0.1053P AD=0.1782P PS=0.925U
+ PD=1.69U
* device instance $881 r0 *1 76.12,38.225 nfet
M$881 \$955 \$891 VSS VSS nfet L=0.6U W=0.36U AS=0.1584P AD=0.0432P PS=1.6U
+ PD=0.6U
* device instance $882 r0 *1 76.96,38.225 nfet
M$882 \$955 \_010_ \$913 VSS nfet L=0.6U W=0.36U AS=0.207P AD=0.0432P PS=1.51U
+ PD=0.6U
* device instance $883 r0 *1 78.58,38.225 nfet
M$883 \$956 \$893 \$913 VSS nfet L=0.6U W=0.36U AS=0.207P AD=0.0432P PS=1.51U
+ PD=0.6U
* device instance $884 r0 *1 79.42,38.225 nfet
M$884 VSS \$892 \$956 VSS nfet L=0.6U W=0.36U AS=0.0432P AD=0.2637P PS=0.6U
+ PD=1.825U
* device instance $885 r0 *1 80.98,38.225 nfet
M$885 \$892 \$913 VSS VSS nfet L=0.6U W=0.36U AS=0.2637P AD=0.0936P PS=1.825U
+ PD=0.88U
* device instance $886 r0 *1 82.1,38.225 nfet
M$886 \$914 \$893 \$892 VSS nfet L=0.6U W=0.36U AS=0.0936P AD=0.0936P PS=0.88U
+ PD=0.88U
* device instance $887 r0 *1 83.22,38.225 nfet
M$887 \$957 \$891 \$914 VSS nfet L=0.6U W=0.36U AS=0.0936P AD=0.0432P PS=0.88U
+ PD=0.6U
* device instance $888 r0 *1 84.06,38.225 nfet
M$888 VSS \$894 \$957 VSS nfet L=0.6U W=0.36U AS=0.0432P AD=0.142P PS=0.6U
+ PD=1.14U
* device instance $889 r0 *1 85.4,38.245 nfet
M$889 \$894 \$914 VSS VSS nfet L=0.6U W=0.4U AS=0.142P AD=0.176P PS=1.14U
+ PD=1.68U
* device instance $890 r0 *1 87.34,38.45 nfet
M$890 c8_r \$894 VSS VSS nfet L=0.6U W=0.82U AS=0.3608P AD=0.3608P PS=2.52U
+ PD=2.52U
* device instance $891 r0 *1 107.88,38.2425 nfet
M$891 VSS clknet_2_3__leaf_clk \$895 VSS nfet L=0.6U W=0.405U AS=0.1782P
+ AD=0.1053P PS=1.69U PD=0.925U
* device instance $892 r0 *1 109,38.2425 nfet
M$892 \$897 \$895 VSS VSS nfet L=0.6U W=0.405U AS=0.1053P AD=0.1782P PS=0.925U
+ PD=1.69U
* device instance $893 r0 *1 110.84,38.225 nfet
M$893 \$958 \$895 VSS VSS nfet L=0.6U W=0.36U AS=0.1584P AD=0.0432P PS=1.6U
+ PD=0.6U
* device instance $894 r0 *1 111.68,38.225 nfet
M$894 \$958 \_028_ \$915 VSS nfet L=0.6U W=0.36U AS=0.207P AD=0.0432P PS=1.51U
+ PD=0.6U
* device instance $895 r0 *1 113.3,38.225 nfet
M$895 \$959 \$897 \$915 VSS nfet L=0.6U W=0.36U AS=0.207P AD=0.0432P PS=1.51U
+ PD=0.6U
* device instance $896 r0 *1 114.14,38.225 nfet
M$896 VSS \$896 \$959 VSS nfet L=0.6U W=0.36U AS=0.0432P AD=0.2637P PS=0.6U
+ PD=1.825U
* device instance $897 r0 *1 115.7,38.225 nfet
M$897 \$896 \$915 VSS VSS nfet L=0.6U W=0.36U AS=0.2637P AD=0.0936P PS=1.825U
+ PD=0.88U
* device instance $898 r0 *1 116.82,38.225 nfet
M$898 \$916 \$897 \$896 VSS nfet L=0.6U W=0.36U AS=0.0936P AD=0.0936P PS=0.88U
+ PD=0.88U
* device instance $899 r0 *1 117.94,38.225 nfet
M$899 \$960 \$895 \$916 VSS nfet L=0.6U W=0.36U AS=0.0936P AD=0.0432P PS=0.88U
+ PD=0.6U
* device instance $900 r0 *1 118.78,38.225 nfet
M$900 VSS \$898 \$960 VSS nfet L=0.6U W=0.36U AS=0.0432P AD=0.142P PS=0.6U
+ PD=1.14U
* device instance $901 r0 *1 120.12,38.245 nfet
M$901 \$898 \$916 VSS VSS nfet L=0.6U W=0.4U AS=0.142P AD=0.176P PS=1.14U
+ PD=1.68U
* device instance $902 r0 *1 122.06,38.45 nfet
M$902 c7_r \$898 VSS VSS nfet L=0.6U W=0.82U AS=0.3608P AD=0.3608P PS=2.52U
+ PD=2.52U
* device instance $903 r0 *1 149.32,38.2425 nfet
M$903 VSS clknet_2_3__leaf_clk \$899 VSS nfet L=0.6U W=0.405U AS=0.1782P
+ AD=0.1053P PS=1.69U PD=0.925U
* device instance $904 r0 *1 150.44,38.2425 nfet
M$904 \$901 \$899 VSS VSS nfet L=0.6U W=0.405U AS=0.1053P AD=0.1782P PS=0.925U
+ PD=1.69U
* device instance $905 r0 *1 152.28,38.225 nfet
M$905 \$961 \$899 VSS VSS nfet L=0.6U W=0.36U AS=0.1584P AD=0.0432P PS=1.6U
+ PD=0.6U
* device instance $906 r0 *1 153.12,38.225 nfet
M$906 \$961 \_018_ \$917 VSS nfet L=0.6U W=0.36U AS=0.207P AD=0.0432P PS=1.51U
+ PD=0.6U
* device instance $907 r0 *1 154.74,38.225 nfet
M$907 \$962 \$901 \$917 VSS nfet L=0.6U W=0.36U AS=0.207P AD=0.0432P PS=1.51U
+ PD=0.6U
* device instance $908 r0 *1 155.58,38.225 nfet
M$908 VSS \$900 \$962 VSS nfet L=0.6U W=0.36U AS=0.0432P AD=0.2637P PS=0.6U
+ PD=1.825U
* device instance $909 r0 *1 157.14,38.225 nfet
M$909 \$900 \$917 VSS VSS nfet L=0.6U W=0.36U AS=0.2637P AD=0.0936P PS=1.825U
+ PD=0.88U
* device instance $910 r0 *1 158.26,38.225 nfet
M$910 \$918 \$901 \$900 VSS nfet L=0.6U W=0.36U AS=0.0936P AD=0.0936P PS=0.88U
+ PD=0.88U
* device instance $911 r0 *1 159.38,38.225 nfet
M$911 \$963 \$899 \$918 VSS nfet L=0.6U W=0.36U AS=0.0936P AD=0.0432P PS=0.88U
+ PD=0.6U
* device instance $912 r0 *1 160.22,38.225 nfet
M$912 VSS \$902 \$963 VSS nfet L=0.6U W=0.36U AS=0.0432P AD=0.142P PS=0.6U
+ PD=1.14U
* device instance $913 r0 *1 161.56,38.245 nfet
M$913 \$902 \$918 VSS VSS nfet L=0.6U W=0.4U AS=0.142P AD=0.176P PS=1.14U
+ PD=1.68U
* device instance $914 r0 *1 163.5,38.45 nfet
M$914 q7 \$902 VSS VSS nfet L=0.6U W=0.82U AS=0.3608P AD=0.3608P PS=2.52U
+ PD=2.52U
* device instance $915 r0 *1 179,38.2425 nfet
M$915 VSS clknet_2_3__leaf_clk \$903 VSS nfet L=0.6U W=0.405U AS=0.1782P
+ AD=0.1053P PS=1.69U PD=0.925U
* device instance $916 r0 *1 180.12,38.2425 nfet
M$916 \$905 \$903 VSS VSS nfet L=0.6U W=0.405U AS=0.1053P AD=0.1782P PS=0.925U
+ PD=1.69U
* device instance $917 r0 *1 181.96,38.225 nfet
M$917 \$964 \$903 VSS VSS nfet L=0.6U W=0.36U AS=0.1584P AD=0.0432P PS=1.6U
+ PD=0.6U
* device instance $918 r0 *1 182.8,38.225 nfet
M$918 \$964 \_009_[3] \$919 VSS nfet L=0.6U W=0.36U AS=0.207P AD=0.0432P
+ PS=1.51U PD=0.6U
* device instance $919 r0 *1 184.42,38.225 nfet
M$919 \$965 \$905 \$919 VSS nfet L=0.6U W=0.36U AS=0.207P AD=0.0432P PS=1.51U
+ PD=0.6U
* device instance $920 r0 *1 185.26,38.225 nfet
M$920 VSS \$904 \$965 VSS nfet L=0.6U W=0.36U AS=0.0432P AD=0.2637P PS=0.6U
+ PD=1.825U
* device instance $921 r0 *1 186.82,38.225 nfet
M$921 \$904 \$919 VSS VSS nfet L=0.6U W=0.36U AS=0.2637P AD=0.0936P PS=1.825U
+ PD=0.88U
* device instance $922 r0 *1 187.94,38.225 nfet
M$922 \$920 \$905 \$904 VSS nfet L=0.6U W=0.36U AS=0.0936P AD=0.0936P PS=0.88U
+ PD=0.88U
* device instance $923 r0 *1 189.06,38.225 nfet
M$923 \$966 \$903 \$920 VSS nfet L=0.6U W=0.36U AS=0.0936P AD=0.0432P PS=0.88U
+ PD=0.6U
* device instance $924 r0 *1 189.9,38.225 nfet
M$924 VSS \$906 \$966 VSS nfet L=0.6U W=0.36U AS=0.0432P AD=0.142P PS=0.6U
+ PD=1.14U
* device instance $925 r0 *1 191.24,38.245 nfet
M$925 \$906 \$920 VSS VSS nfet L=0.6U W=0.4U AS=0.142P AD=0.176P PS=1.14U
+ PD=1.68U
* device instance $926 r0 *1 193.18,38.45 nfet
M$926 ph[3] \$906 VSS VSS nfet L=0.6U W=0.82U AS=0.3608P AD=0.3608P PS=2.52U
+ PD=2.52U
* device instance $927 r0 *1 3.21,2.7925 pfet
M$927 VDD clknet_2_0__leaf_clk \$35 VDD pfet L=0.5U W=0.865U AS=0.3806P
+ AD=0.2249P PS=2.61U PD=1.385U
* device instance $928 r0 *1 4.23,2.7925 pfet
M$928 \$37 \$35 VDD VDD pfet L=0.5U W=0.865U AS=0.2249P AD=0.3806P PS=1.385U
+ PD=2.61U
* device instance $929 r0 *1 17.23,2.97 pfet
M$929 ph[11] \$42 VDD VDD pfet L=0.5U W=1.22U AS=0.5368P AD=0.5368P PS=3.32U
+ PD=3.32U
* device instance $930 r0 *1 19.35,2.97 pfet
M$930 \_047_ ph[10] VDD VDD pfet L=0.5U W=1.22U AS=0.5368P AD=0.5368P PS=3.32U
+ PD=3.32U
* device instance $931 r0 *1 31.77,2.7925 pfet
M$931 VDD clknet_2_0__leaf_clk \$46 VDD pfet L=0.5U W=0.865U AS=0.3806P
+ AD=0.2249P PS=2.61U PD=1.385U
* device instance $932 r0 *1 32.79,2.7925 pfet
M$932 \$47 \$46 VDD VDD pfet L=0.5U W=0.865U AS=0.2249P AD=0.3806P PS=1.385U
+ PD=2.61U
* device instance $933 r0 *1 45.79,2.97 pfet
M$933 eng2 \$52 VDD VDD pfet L=0.5U W=1.22U AS=0.5368P AD=0.5368P PS=3.32U
+ PD=3.32U
* device instance $934 r0 *1 54.63,2.97 pfet
M$934 \$116 q2 VDD VDD pfet L=0.5U W=1.22U AS=0.5368P AD=0.4087P PS=3.32U
+ PD=1.89U
* device instance $935 r0 *1 55.8,2.97 pfet
M$935 sel_lo_n_2p \_042_ \$116 VDD pfet L=0.5U W=1.22U AS=0.4087P AD=0.5368P
+ PS=1.89U PD=3.32U
* device instance $936 r0 *1 57.99,2.97 pfet
M$936 \$117 q3 VDD VDD pfet L=0.5U W=1.22U AS=0.5368P AD=0.4087P PS=3.32U
+ PD=1.89U
* device instance $937 r0 *1 59.16,2.97 pfet
M$937 sel_lo_n_4p \_030_ \$117 VDD pfet L=0.5U W=1.22U AS=0.4087P AD=0.5368P
+ PS=1.89U PD=3.32U
* device instance $938 r0 *1 76.47,2.9675 pfet
M$938 rel_n_8n eng4 \$104 VDD pfet L=0.5U W=1.215U AS=0.5346P AD=0.3159P
+ PS=3.31U PD=1.735U
* device instance $939 r0 *1 77.49,2.9675 pfet
M$939 \$104 mode rel_n_8n VDD pfet L=0.5U W=1.215U AS=0.3159P AD=0.44955P
+ PS=1.735U PD=1.955U
* device instance $940 r0 *1 78.73,2.9675 pfet
M$940 VDD sel_in_n \$104 VDD pfet L=0.5U W=1.215U AS=0.44955P AD=0.5346P
+ PS=1.955U PD=3.31U
* device instance $941 r0 *1 84.31,2.97 pfet
M$941 \$121 sel_in_n VDD VDD pfet L=0.5U W=1.22U AS=0.5368P AD=0.4087P PS=3.32U
+ PD=1.89U
* device instance $942 r0 *1 85.48,2.97 pfet
M$942 rel_n_32p eng6 \$121 VDD pfet L=0.5U W=1.22U AS=0.4087P AD=0.5368P
+ PS=1.89U PD=3.32U
* device instance $943 r0 *1 87.67,2.9675 pfet
M$943 rel_n_128n eng8 \$105 VDD pfet L=0.5U W=1.215U AS=0.5346P AD=0.3159P
+ PS=3.31U PD=1.735U
* device instance $944 r0 *1 88.69,2.9675 pfet
M$944 \$105 mode rel_n_128n VDD pfet L=0.5U W=1.215U AS=0.3159P AD=0.44955P
+ PS=1.735U PD=1.955U
* device instance $945 r0 *1 89.93,2.9675 pfet
M$945 VDD sel_in_n \$105 VDD pfet L=0.5U W=1.215U AS=0.44955P AD=0.5346P
+ PS=1.955U PD=3.31U
* device instance $946 r0 *1 93.27,2.97 pfet
M$946 \_031_ mode VDD VDD pfet L=0.5U W=1.22U AS=0.5368P AD=0.5368P PS=3.32U
+ PD=3.32U
* device instance $947 r0 *1 97.19,2.97 pfet
M$947 \$123 sel_in_n VDD VDD pfet L=0.5U W=1.22U AS=0.5368P AD=0.4087P PS=3.32U
+ PD=1.89U
* device instance $948 r0 *1 98.36,2.97 pfet
M$948 rel_n_128p eng8 \$123 VDD pfet L=0.5U W=1.22U AS=0.4087P AD=0.5368P
+ PS=1.89U PD=3.32U
* device instance $949 r0 *1 113.53,2.97 pfet
M$949 \$125 q1 VDD VDD pfet L=0.5U W=1.22U AS=0.5368P AD=0.3172P PS=3.32U
+ PD=1.74U
* device instance $950 r0 *1 114.55,2.97 pfet
M$950 \$126 \_044_ \$125 VDD pfet L=0.5U W=1.22U AS=0.3172P AD=0.3782P PS=1.74U
+ PD=1.84U
* device instance $951 r0 *1 115.67,2.97 pfet
M$951 sel_hi_n_1n \_031_ \$126 VDD pfet L=0.5U W=1.22U AS=0.3782P AD=0.5368P
+ PS=1.84U PD=3.32U
* device instance $952 r0 *1 122.39,2.9675 pfet
M$952 rel_n_1n eng1 \$106 VDD pfet L=0.5U W=1.215U AS=0.5346P AD=0.3159P
+ PS=3.31U PD=1.735U
* device instance $953 r0 *1 123.41,2.9675 pfet
M$953 \$106 mode rel_n_1n VDD pfet L=0.5U W=1.215U AS=0.3159P AD=0.44955P
+ PS=1.735U PD=1.955U
* device instance $954 r0 *1 124.65,2.9675 pfet
M$954 VDD sel_in_n \$106 VDD pfet L=0.5U W=1.215U AS=0.44955P AD=0.5346P
+ PS=1.955U PD=3.31U
* device instance $955 r0 *1 134.25,2.97 pfet
M$955 \$128 \_038_ VDD VDD pfet L=0.5U W=1.22U AS=0.5368P AD=0.3172P PS=3.32U
+ PD=1.74U
* device instance $956 r0 *1 135.27,2.97 pfet
M$956 \$127 q6 \$128 VDD pfet L=0.5U W=1.22U AS=0.3172P AD=0.3782P PS=1.74U
+ PD=1.84U
* device instance $957 r0 *1 136.39,2.97 pfet
M$957 sel_hi_n_32n \_031_ \$127 VDD pfet L=0.5U W=1.22U AS=0.3782P AD=0.5368P
+ PS=1.84U PD=3.32U
* device instance $958 r0 *1 140.87,2.97 pfet
M$958 \_038_ eng6 VDD VDD pfet L=0.5U W=1.22U AS=0.5368P AD=0.5368P PS=3.32U
+ PD=3.32U
* device instance $959 r0 *1 144.23,2.97 pfet
M$959 ZN clknet_2_2__leaf_clk VDD VDD pfet L=0.5U W=1.22U AS=0.5368P AD=0.4392P
+ PS=3.32U PD=1.94U
* device instance $960 r0 *1 145.45,2.97 pfet
M$960 VDD clknet_2_2__leaf_clk ZN VDD pfet L=0.5U W=1.22U AS=0.4392P AD=0.3172P
+ PS=1.94U PD=1.74U
* device instance $961 r0 *1 146.47,2.97 pfet
M$961 ZN clknet_2_2__leaf_clk VDD VDD pfet L=0.5U W=1.22U AS=0.3172P AD=0.5368P
+ PS=1.74U PD=3.32U
* device instance $962 r0 *1 152.17,2.7925 pfet
M$962 VDD clknet_2_2__leaf_clk \$66 VDD pfet L=0.5U W=0.865U AS=0.3806P
+ AD=0.2249P PS=2.61U PD=1.385U
* device instance $963 r0 *1 153.19,2.7925 pfet
M$963 \$67 \$66 VDD VDD pfet L=0.5U W=0.865U AS=0.2249P AD=0.3806P PS=1.385U
+ PD=2.61U
* device instance $964 r0 *1 166.19,2.97 pfet
M$964 ph[7] \$72 VDD VDD pfet L=0.5U W=1.22U AS=0.5368P AD=0.5368P PS=3.32U
+ PD=3.32U
* device instance $965 r0 *1 177.37,2.7925 pfet
M$965 VDD clknet_2_2__leaf_clk \$73 VDD pfet L=0.5U W=0.865U AS=0.3806P
+ AD=0.2249P PS=2.61U PD=1.385U
* device instance $966 r0 *1 178.39,2.7925 pfet
M$966 \$74 \$73 VDD VDD pfet L=0.5U W=0.865U AS=0.2249P AD=0.3806P PS=1.385U
+ PD=2.61U
* device instance $967 r0 *1 191.39,2.97 pfet
M$967 ph[1] \$79 VDD VDD pfet L=0.5U W=1.22U AS=0.5368P AD=0.5368P PS=3.32U
+ PD=3.32U
* device instance $968 r0 *1 6.39,2.815 pfet
M$968 \$109 \$37 VDD VDD pfet L=0.5U W=0.36U AS=0.4554P AD=0.054P PS=3.25U
+ PD=0.66U
* device instance $969 r0 *1 7.19,2.815 pfet
M$969 \$39 \_009_[11] \$109 VDD pfet L=0.5U W=0.36U AS=0.054P AD=0.1872P
+ PS=0.66U PD=1.4U
* device instance $970 r0 *1 8.73,2.815 pfet
M$970 \$110 \$35 \$39 VDD pfet L=0.5U W=0.36U AS=0.1872P AD=0.0432P PS=1.4U
+ PD=0.6U
* device instance $971 r0 *1 9.47,2.815 pfet
M$971 VDD \$40 \$110 VDD pfet L=0.5U W=0.36U AS=0.0432P AD=0.1044P PS=0.6U
+ PD=0.94U
* device instance $972 r0 *1 10.55,2.815 pfet
M$972 \$40 \$39 VDD VDD pfet L=0.5U W=0.36U AS=0.1044P AD=0.1791P PS=0.94U
+ PD=1.355U
* device instance $973 r0 *1 12.045,2.815 pfet
M$973 \$41 \$35 \$40 VDD pfet L=0.5U W=0.36U AS=0.1791P AD=0.1665P PS=1.355U
+ PD=1.285U
* device instance $974 r0 *1 13.47,2.815 pfet
M$974 \$111 \$37 \$41 VDD pfet L=0.5U W=0.36U AS=0.1665P AD=0.0504P PS=1.285U
+ PD=0.64U
* device instance $975 r0 *1 14.25,2.815 pfet
M$975 VDD \$42 \$111 VDD pfet L=0.5U W=0.36U AS=0.0504P AD=0.23P PS=0.64U
+ PD=1.54U
* device instance $976 r0 *1 15.49,3.035 pfet
M$976 \$42 \$41 VDD VDD pfet L=0.5U W=0.8U AS=0.23P AD=0.352P PS=1.54U PD=2.48U
* device instance $977 r0 *1 22.27,4.87 pfet
M$977 q3 \$132 VDD VDD pfet L=0.5U W=1.22U AS=0.5368P AD=0.5368P PS=3.32U
+ PD=3.32U
* device instance $978 r0 *1 34.95,2.815 pfet
M$978 \$112 \$47 VDD VDD pfet L=0.5U W=0.36U AS=0.4554P AD=0.054P PS=3.25U
+ PD=0.66U
* device instance $979 r0 *1 35.75,2.815 pfet
M$979 \$49 \_001_ \$112 VDD pfet L=0.5U W=0.36U AS=0.054P AD=0.1872P PS=0.66U
+ PD=1.4U
* device instance $980 r0 *1 37.29,2.815 pfet
M$980 \$113 \$46 \$49 VDD pfet L=0.5U W=0.36U AS=0.1872P AD=0.0432P PS=1.4U
+ PD=0.6U
* device instance $981 r0 *1 38.03,2.815 pfet
M$981 VDD \$50 \$113 VDD pfet L=0.5U W=0.36U AS=0.0432P AD=0.1044P PS=0.6U
+ PD=0.94U
* device instance $982 r0 *1 39.11,2.815 pfet
M$982 \$50 \$49 VDD VDD pfet L=0.5U W=0.36U AS=0.1044P AD=0.1791P PS=0.94U
+ PD=1.355U
* device instance $983 r0 *1 40.605,2.815 pfet
M$983 \$51 \$46 \$50 VDD pfet L=0.5U W=0.36U AS=0.1791P AD=0.1665P PS=1.355U
+ PD=1.285U
* device instance $984 r0 *1 42.03,2.815 pfet
M$984 \$114 \$47 \$51 VDD pfet L=0.5U W=0.36U AS=0.1665P AD=0.0504P PS=1.285U
+ PD=0.64U
* device instance $985 r0 *1 42.81,2.815 pfet
M$985 VDD \$52 \$114 VDD pfet L=0.5U W=0.36U AS=0.0504P AD=0.23P PS=0.64U
+ PD=1.54U
* device instance $986 r0 *1 44.05,3.035 pfet
M$986 \$52 \$51 VDD VDD pfet L=0.5U W=0.8U AS=0.23P AD=0.352P PS=1.54U PD=2.48U
* device instance $987 r0 *1 43.55,4.87 pfet
M$987 eng3 \$136 VDD VDD pfet L=0.5U W=1.22U AS=0.5368P AD=0.5368P PS=3.32U
+ PD=3.32U
* device instance $988 r0 *1 45.67,4.87 pfet
M$988 \_030_ eng3 VDD VDD pfet L=0.5U W=1.22U AS=0.5368P AD=0.5368P PS=3.32U
+ PD=3.32U
* device instance $989 r0 *1 56.97,4.87 pfet
M$989 \$184 q2 VDD VDD pfet L=0.5U W=1.22U AS=0.5368P AD=0.3172P PS=3.32U
+ PD=1.74U
* device instance $990 r0 *1 57.99,4.87 pfet
M$990 \$185 \_042_ \$184 VDD pfet L=0.5U W=1.22U AS=0.3172P AD=0.3782P PS=1.74U
+ PD=1.84U
* device instance $991 r0 *1 59.11,4.87 pfet
M$991 sel_hi_n_2n \_031_ \$185 VDD pfet L=0.5U W=1.22U AS=0.3782P AD=0.5368P
+ PS=1.84U PD=3.32U
* device instance $992 r0 *1 61.35,3.275 pfet
M$992 \$55 mode VDD VDD pfet L=0.5U W=0.6U AS=0.264P AD=0.156P PS=2.08U PD=1.12U
* device instance $993 r0 *1 62.37,3.275 pfet
M$993 \$55 sel_hi_n_64p VDD VDD pfet L=0.5U W=0.6U AS=0.40575P AD=0.156P
+ PS=2.055U PD=1.12U
* device instance $994 r0 *1 63.71,2.9675 pfet
M$994 sel_lo_n_64n \$55 VDD VDD pfet L=0.5U W=1.215U AS=0.40575P AD=0.5346P
+ PS=2.055U PD=3.31U
* device instance $995 r0 *1 92.15,4.87 pfet
M$995 \$192 sel_in_n VDD VDD pfet L=0.5U W=1.22U AS=0.5368P AD=0.4087P PS=3.32U
+ PD=1.89U
* device instance $996 r0 *1 93.32,4.87 pfet
M$996 rel_n_64p eng7 \$192 VDD pfet L=0.5U W=1.22U AS=0.4087P AD=0.5368P
+ PS=1.89U PD=3.32U
* device instance $997 r0 *1 97.19,4.87 pfet
M$997 \$195 sel_in_n VDD VDD pfet L=0.5U W=1.22U AS=0.5368P AD=0.4087P PS=3.32U
+ PD=1.89U
* device instance $998 r0 *1 98.36,4.87 pfet
M$998 rel_n_2p eng2 \$195 VDD pfet L=0.5U W=1.22U AS=0.4087P AD=0.5368P
+ PS=1.89U PD=3.32U
* device instance $999 r0 *1 101.67,3.275 pfet
M$999 \$59 mode VDD VDD pfet L=0.5U W=0.6U AS=0.264P AD=0.156P PS=2.08U PD=1.12U
* device instance $1000 r0 *1 102.69,3.275 pfet
M$1000 \$59 sel_hi_n_2p VDD VDD pfet L=0.5U W=0.6U AS=0.40575P AD=0.156P
+ PS=2.055U PD=1.12U
* device instance $1001 r0 *1 104.03,2.9675 pfet
M$1001 sel_lo_n_2n \$59 VDD VDD pfet L=0.5U W=1.215U AS=0.40575P AD=0.5346P
+ PS=2.055U PD=3.31U
* device instance $1002 r0 *1 102.23,4.87 pfet
M$1002 \$196 sel_in_n VDD VDD pfet L=0.5U W=1.22U AS=0.5368P AD=0.4087P
+ PS=3.32U PD=1.89U
* device instance $1003 r0 *1 103.4,4.87 pfet
M$1003 rel_n_1p eng1 \$196 VDD pfet L=0.5U W=1.22U AS=0.4087P AD=0.5368P
+ PS=1.89U PD=3.32U
* device instance $1004 r0 *1 105.59,4.87 pfet
M$1004 \$198 sel_in_n VDD VDD pfet L=0.5U W=1.22U AS=0.5368P AD=0.4087P
+ PS=3.32U PD=1.89U
* device instance $1005 r0 *1 106.76,4.87 pfet
M$1005 rel_n_4p eng3 \$198 VDD pfet L=0.5U W=1.22U AS=0.4087P AD=0.5368P
+ PS=1.89U PD=3.32U
* device instance $1006 r0 *1 108.95,3.275 pfet
M$1006 \$60 q6 VDD VDD pfet L=0.5U W=0.6U AS=0.264P AD=0.156P PS=2.08U PD=1.12U
* device instance $1007 r0 *1 109.97,3.275 pfet
M$1007 \$60 eng6 VDD VDD pfet L=0.5U W=0.6U AS=0.40575P AD=0.156P PS=2.055U
+ PD=1.12U
* device instance $1008 r0 *1 111.31,2.9675 pfet
M$1008 sel_hi_n_32p \$60 VDD VDD pfet L=0.5U W=1.215U AS=0.40575P AD=0.5346P
+ PS=2.055U PD=3.31U
* device instance $1009 r0 *1 124.07,4.87 pfet
M$1009 \$197 sel_in_n VDD VDD pfet L=0.5U W=1.22U AS=0.5368P AD=0.4087P
+ PS=3.32U PD=1.89U
* device instance $1010 r0 *1 125.24,4.87 pfet
M$1010 rel_n_256p eng9 \$197 VDD pfet L=0.5U W=1.22U AS=0.4087P AD=0.5368P
+ PS=1.89U PD=3.32U
* device instance $1011 r0 *1 128.55,4.87 pfet
M$1011 \$194 sel_in_n VDD VDD pfet L=0.5U W=1.22U AS=0.5368P AD=0.4087P
+ PS=3.32U PD=1.89U
* device instance $1012 r0 *1 129.72,4.87 pfet
M$1012 rel_n_8p eng4 \$194 VDD pfet L=0.5U W=1.22U AS=0.4087P AD=0.5368P
+ PS=1.89U PD=3.32U
* device instance $1013 r0 *1 132.57,4.87 pfet
M$1013 \$193 \_039_ VDD VDD pfet L=0.5U W=1.22U AS=0.5368P AD=0.3172P PS=3.32U
+ PD=1.74U
* device instance $1014 r0 *1 133.59,4.87 pfet
M$1014 \$191 q7 \$193 VDD pfet L=0.5U W=1.22U AS=0.3172P AD=0.3782P PS=1.74U
+ PD=1.84U
* device instance $1015 r0 *1 134.71,4.87 pfet
M$1015 sel_hi_n_64n \_031_ \$191 VDD pfet L=0.5U W=1.22U AS=0.3782P AD=0.5368P
+ PS=1.84U PD=3.32U
* device instance $1016 r0 *1 136.95,4.87 pfet
M$1016 \$190 sel_in_n VDD VDD pfet L=0.5U W=1.22U AS=0.5368P AD=0.4087P
+ PS=3.32U PD=1.89U
* device instance $1017 r0 *1 138.12,4.87 pfet
M$1017 rel_n_16p eng5 \$190 VDD pfet L=0.5U W=1.22U AS=0.4087P AD=0.5368P
+ PS=1.89U PD=3.32U
* device instance $1018 r0 *1 155.35,2.815 pfet
M$1018 \$124 \$67 VDD VDD pfet L=0.5U W=0.36U AS=0.4554P AD=0.054P PS=3.25U
+ PD=0.66U
* device instance $1019 r0 *1 156.15,2.815 pfet
M$1019 \$69 \_009_[7] \$124 VDD pfet L=0.5U W=0.36U AS=0.054P AD=0.1872P
+ PS=0.66U PD=1.4U
* device instance $1020 r0 *1 157.69,2.815 pfet
M$1020 \$122 \$66 \$69 VDD pfet L=0.5U W=0.36U AS=0.1872P AD=0.0432P PS=1.4U
+ PD=0.6U
* device instance $1021 r0 *1 158.43,2.815 pfet
M$1021 VDD \$70 \$122 VDD pfet L=0.5U W=0.36U AS=0.0432P AD=0.1044P PS=0.6U
+ PD=0.94U
* device instance $1022 r0 *1 159.51,2.815 pfet
M$1022 \$70 \$69 VDD VDD pfet L=0.5U W=0.36U AS=0.1044P AD=0.1791P PS=0.94U
+ PD=1.355U
* device instance $1023 r0 *1 161.005,2.815 pfet
M$1023 \$71 \$66 \$70 VDD pfet L=0.5U W=0.36U AS=0.1791P AD=0.1665P PS=1.355U
+ PD=1.285U
* device instance $1024 r0 *1 162.43,2.815 pfet
M$1024 \$120 \$67 \$71 VDD pfet L=0.5U W=0.36U AS=0.1665P AD=0.0504P PS=1.285U
+ PD=0.64U
* device instance $1025 r0 *1 163.21,2.815 pfet
M$1025 VDD \$72 \$120 VDD pfet L=0.5U W=0.36U AS=0.0504P AD=0.23P PS=0.64U
+ PD=1.54U
* device instance $1026 r0 *1 164.45,3.035 pfet
M$1026 \$72 \$71 VDD VDD pfet L=0.5U W=0.8U AS=0.23P AD=0.352P PS=1.54U PD=2.48U
* device instance $1027 r0 *1 155.55,4.87 pfet
M$1027 eng6 \$152 VDD VDD pfet L=0.5U W=1.22U AS=0.5368P AD=0.5368P PS=3.32U
+ PD=3.32U
* device instance $1028 r0 *1 175.15,4.87 pfet
M$1028 ph[0] \$156 VDD VDD pfet L=0.5U W=1.22U AS=0.5368P AD=0.5368P PS=3.32U
+ PD=3.32U
* device instance $1029 r0 *1 177.83,4.87 pfet
M$1029 \_033_ ph[0] VDD VDD pfet L=0.5U W=1.22U AS=0.5368P AD=0.5368P PS=3.32U
+ PD=3.32U
* device instance $1030 r0 *1 180.55,2.815 pfet
M$1030 \$119 \$74 VDD VDD pfet L=0.5U W=0.36U AS=0.4554P AD=0.054P PS=3.25U
+ PD=0.66U
* device instance $1031 r0 *1 181.35,2.815 pfet
M$1031 \$76 \_009_[1] \$119 VDD pfet L=0.5U W=0.36U AS=0.054P AD=0.1872P
+ PS=0.66U PD=1.4U
* device instance $1032 r0 *1 182.89,2.815 pfet
M$1032 \$118 \$73 \$76 VDD pfet L=0.5U W=0.36U AS=0.1872P AD=0.0432P PS=1.4U
+ PD=0.6U
* device instance $1033 r0 *1 183.63,2.815 pfet
M$1033 VDD \$77 \$118 VDD pfet L=0.5U W=0.36U AS=0.0432P AD=0.1044P PS=0.6U
+ PD=0.94U
* device instance $1034 r0 *1 184.71,2.815 pfet
M$1034 \$77 \$76 VDD VDD pfet L=0.5U W=0.36U AS=0.1044P AD=0.1791P PS=0.94U
+ PD=1.355U
* device instance $1035 r0 *1 186.205,2.815 pfet
M$1035 \$78 \$73 \$77 VDD pfet L=0.5U W=0.36U AS=0.1791P AD=0.1665P PS=1.355U
+ PD=1.285U
* device instance $1036 r0 *1 187.63,2.815 pfet
M$1036 \$115 \$74 \$78 VDD pfet L=0.5U W=0.36U AS=0.1665P AD=0.0504P PS=1.285U
+ PD=0.64U
* device instance $1037 r0 *1 188.41,2.815 pfet
M$1037 VDD \$79 \$115 VDD pfet L=0.5U W=0.36U AS=0.0504P AD=0.23P PS=0.64U
+ PD=1.54U
* device instance $1038 r0 *1 189.65,3.035 pfet
M$1038 \$79 \$78 VDD VDD pfet L=0.5U W=0.8U AS=0.23P AD=0.352P PS=1.54U PD=2.48U
* device instance $1039 r0 *1 185.67,4.87 pfet
M$1039 \_034_ ph[1] VDD VDD pfet L=0.5U W=1.22U AS=0.5368P AD=0.5368P PS=3.32U
+ PD=3.32U
* device instance $1040 r0 *1 187.91,4.87 pfet
M$1040 \_032_ ph[2] VDD VDD pfet L=0.5U W=1.22U AS=0.5368P AD=0.5368P PS=3.32U
+ PD=3.32U
* device instance $1041 r0 *1 8.25,5.0475 pfet
M$1041 VDD clknet_2_0__leaf_clk \$129 VDD pfet L=0.5U W=0.865U AS=0.3806P
+ AD=0.2249P PS=2.61U PD=1.385U
* device instance $1042 r0 *1 9.27,5.0475 pfet
M$1042 \$131 \$129 VDD VDD pfet L=0.5U W=0.865U AS=0.2249P AD=0.3806P PS=1.385U
+ PD=2.61U
* device instance $1043 r0 *1 29.53,5.0475 pfet
M$1043 VDD clknet_2_0__leaf_clk \$133 VDD pfet L=0.5U W=0.865U AS=0.3806P
+ AD=0.2249P PS=2.61U PD=1.385U
* device instance $1044 r0 *1 30.55,5.0475 pfet
M$1044 \$135 \$133 VDD VDD pfet L=0.5U W=0.865U AS=0.2249P AD=0.3806P PS=1.385U
+ PD=2.61U
* device instance $1045 r0 *1 61.35,4.565 pfet
M$1045 \$137 q4 VDD VDD pfet L=0.5U W=0.6U AS=0.264P AD=0.156P PS=2.08U PD=1.12U
* device instance $1046 r0 *1 62.37,4.565 pfet
M$1046 VDD eng4 \$137 VDD pfet L=0.5U W=0.6U AS=0.156P AD=0.40575P PS=1.12U
+ PD=2.055U
* device instance $1047 r0 *1 63.71,4.8725 pfet
M$1047 sel_hi_n_8p \$137 VDD VDD pfet L=0.5U W=1.215U AS=0.40575P AD=0.5346P
+ PS=2.055U PD=3.31U
* device instance $1048 r0 *1 68.07,4.565 pfet
M$1048 \$139 mode VDD VDD pfet L=0.5U W=0.6U AS=0.264P AD=0.156P PS=2.08U
+ PD=1.12U
* device instance $1049 r0 *1 69.09,4.565 pfet
M$1049 VDD sel_hi_n_8p \$139 VDD pfet L=0.5U W=0.6U AS=0.156P AD=0.40575P
+ PS=1.12U PD=2.055U
* device instance $1050 r0 *1 70.43,4.8725 pfet
M$1050 sel_lo_n_8n \$139 VDD VDD pfet L=0.5U W=1.215U AS=0.40575P AD=0.5346P
+ PS=2.055U PD=3.31U
* device instance $1051 r0 *1 73.11,4.565 pfet
M$1051 \$141 mode VDD VDD pfet L=0.5U W=0.6U AS=0.264P AD=0.156P PS=2.08U
+ PD=1.12U
* device instance $1052 r0 *1 74.13,4.565 pfet
M$1052 VDD sel_hi_n_1p \$141 VDD pfet L=0.5U W=0.6U AS=0.156P AD=0.40575P
+ PS=1.12U PD=2.055U
* device instance $1053 r0 *1 75.47,4.8725 pfet
M$1053 sel_lo_n_1n \$141 VDD VDD pfet L=0.5U W=1.215U AS=0.40575P AD=0.5346P
+ PS=2.055U PD=3.31U
* device instance $1054 r0 *1 80.39,4.8725 pfet
M$1054 rel_n_2n eng2 \$142 VDD pfet L=0.5U W=1.215U AS=0.5346P AD=0.3159P
+ PS=3.31U PD=1.735U
* device instance $1055 r0 *1 81.41,4.8725 pfet
M$1055 \$142 mode rel_n_2n VDD pfet L=0.5U W=1.215U AS=0.3159P AD=0.44955P
+ PS=1.735U PD=1.955U
* device instance $1056 r0 *1 82.65,4.8725 pfet
M$1056 VDD sel_in_n \$142 VDD pfet L=0.5U W=1.215U AS=0.44955P AD=0.5346P
+ PS=1.955U PD=3.31U
* device instance $1057 r0 *1 86.55,4.565 pfet
M$1057 \$143 mode VDD VDD pfet L=0.5U W=0.6U AS=0.264P AD=0.156P PS=2.08U
+ PD=1.12U
* device instance $1058 r0 *1 87.57,4.565 pfet
M$1058 VDD sel_hi_n_4p \$143 VDD pfet L=0.5U W=0.6U AS=0.156P AD=0.40575P
+ PS=1.12U PD=2.055U
* device instance $1059 r0 *1 88.91,4.8725 pfet
M$1059 sel_lo_n_4n \$143 VDD VDD pfet L=0.5U W=1.215U AS=0.40575P AD=0.5346P
+ PS=2.055U PD=3.31U
* device instance $1060 r0 *1 110.07,4.8725 pfet
M$1060 rel_n_64n eng7 \$146 VDD pfet L=0.5U W=1.215U AS=0.5346P AD=0.3159P
+ PS=3.31U PD=1.735U
* device instance $1061 r0 *1 111.09,4.8725 pfet
M$1061 \$146 mode rel_n_64n VDD pfet L=0.5U W=1.215U AS=0.3159P AD=0.44955P
+ PS=1.735U PD=1.955U
* device instance $1062 r0 *1 112.33,4.8725 pfet
M$1062 VDD sel_in_n \$146 VDD pfet L=0.5U W=1.215U AS=0.44955P AD=0.5346P
+ PS=1.955U PD=3.31U
* device instance $1063 r0 *1 114.55,4.565 pfet
M$1063 \$147 mode VDD VDD pfet L=0.5U W=0.6U AS=0.264P AD=0.156P PS=2.08U
+ PD=1.12U
* device instance $1064 r0 *1 115.57,4.565 pfet
M$1064 VDD sel_hi_n_32p \$147 VDD pfet L=0.5U W=0.6U AS=0.156P AD=0.40575P
+ PS=1.12U PD=2.055U
* device instance $1065 r0 *1 116.91,4.8725 pfet
M$1065 sel_lo_n_32n \$147 VDD VDD pfet L=0.5U W=1.215U AS=0.40575P AD=0.5346P
+ PS=2.055U PD=3.31U
* device instance $1066 r0 *1 119.59,4.8725 pfet
M$1066 rel_n_4n mode \$148 VDD pfet L=0.5U W=1.215U AS=0.5346P AD=0.3159P
+ PS=3.31U PD=1.735U
* device instance $1067 r0 *1 120.61,4.8725 pfet
M$1067 \$148 eng3 rel_n_4n VDD pfet L=0.5U W=1.215U AS=0.3159P AD=0.44955P
+ PS=1.735U PD=1.955U
* device instance $1068 r0 *1 121.85,4.8725 pfet
M$1068 VDD sel_in_n \$148 VDD pfet L=0.5U W=1.215U AS=0.44955P AD=0.5346P
+ PS=1.955U PD=3.31U
* device instance $1069 r0 *1 141.53,5.0475 pfet
M$1069 VDD clknet_2_2__leaf_clk \$149 VDD pfet L=0.5U W=0.865U AS=0.3806P
+ AD=0.2249P PS=2.61U PD=1.385U
* device instance $1070 r0 *1 142.55,5.0475 pfet
M$1070 \$151 \$149 VDD VDD pfet L=0.5U W=0.865U AS=0.2249P AD=0.3806P PS=1.385U
+ PD=2.61U
* device instance $1071 r0 *1 161.13,5.0475 pfet
M$1071 VDD clknet_2_2__leaf_clk \$153 VDD pfet L=0.5U W=0.865U AS=0.3806P
+ AD=0.2249P PS=2.61U PD=1.385U
* device instance $1072 r0 *1 162.15,5.0475 pfet
M$1072 \$155 \$153 VDD VDD pfet L=0.5U W=0.865U AS=0.2249P AD=0.3806P PS=1.385U
+ PD=2.61U
* device instance $1073 r0 *1 181.885,4.9075 pfet
M$1073 samp_tp_n \_034_ VDD VDD pfet L=0.5U W=0.985U AS=0.4334P AD=0.2561P
+ PS=2.85U PD=1.505U
* device instance $1074 r0 *1 182.905,4.9075 pfet
M$1074 VDD \_033_ samp_tp_n VDD pfet L=0.5U W=0.985U AS=0.2561P AD=0.2561P
+ PS=1.505U PD=1.505U
* device instance $1075 r0 *1 183.925,4.9075 pfet
M$1075 samp_tp_n \_032_ VDD VDD pfet L=0.5U W=0.985U AS=0.2561P AD=0.4334P
+ PS=1.505U PD=2.85U
* device instance $1076 r0 *1 8.71,10.81 pfet
M$1076 \$303 start VDD$1 VDD$1 pfet L=0.5U W=1.22U AS=0.5368P AD=0.4087P
+ PS=3.32U PD=1.89U
* device instance $1077 r0 *1 9.88,10.81 pfet
M$1077 \_009_[11] \_047_ \$303 VDD$1 pfet L=0.5U W=1.22U AS=0.4087P AD=0.5368P
+ PS=1.89U PD=3.32U
* device instance $1078 r0 *1 11.43,5.025 pfet
M$1078 \$176 \$131 VDD VDD pfet L=0.5U W=0.36U AS=0.4554P AD=0.054P PS=3.25U
+ PD=0.66U
* device instance $1079 r0 *1 12.23,5.025 pfet
M$1079 \$157 \_029_ \$176 VDD pfet L=0.5U W=0.36U AS=0.054P AD=0.1872P PS=0.66U
+ PD=1.4U
* device instance $1080 r0 *1 13.77,5.025 pfet
M$1080 \$177 \$129 \$157 VDD pfet L=0.5U W=0.36U AS=0.1872P AD=0.0432P PS=1.4U
+ PD=0.6U
* device instance $1081 r0 *1 14.51,5.025 pfet
M$1081 VDD \$130 \$177 VDD pfet L=0.5U W=0.36U AS=0.0432P AD=0.1044P PS=0.6U
+ PD=0.94U
* device instance $1082 r0 *1 15.59,5.025 pfet
M$1082 \$130 \$157 VDD VDD pfet L=0.5U W=0.36U AS=0.1044P AD=0.1791P PS=0.94U
+ PD=1.355U
* device instance $1083 r0 *1 17.085,5.025 pfet
M$1083 \$158 \$129 \$130 VDD pfet L=0.5U W=0.36U AS=0.1791P AD=0.1665P
+ PS=1.355U PD=1.285U
* device instance $1084 r0 *1 18.51,5.025 pfet
M$1084 \$178 \$131 \$158 VDD pfet L=0.5U W=0.36U AS=0.1665P AD=0.0504P
+ PS=1.285U PD=0.64U
* device instance $1085 r0 *1 19.29,5.025 pfet
M$1085 \$178 \$132 VDD VDD pfet L=0.5U W=0.36U AS=0.23P AD=0.0504P PS=1.54U
+ PD=0.64U
* device instance $1086 r0 *1 20.53,4.805 pfet
M$1086 \$132 \$158 VDD VDD pfet L=0.5U W=0.8U AS=0.23P AD=0.352P PS=1.54U
+ PD=2.48U
* device instance $1087 r0 *1 12.07,10.8075 pfet
M$1087 \_029_ cmp \$294 VDD$1 pfet L=0.5U W=1.215U AS=0.5346P AD=0.3159P
+ PS=3.31U PD=1.735U
* device instance $1088 r0 *1 13.09,10.8075 pfet
M$1088 \$294 ph[10] \_029_ VDD$1 pfet L=0.5U W=1.215U AS=0.3159P AD=0.44955P
+ PS=1.735U PD=1.955U
* device instance $1089 r0 *1 14.33,10.8075 pfet
M$1089 VDD$1 \_064_ \$294 VDD$1 pfet L=0.5U W=1.215U AS=0.44955P AD=0.5346P
+ PS=1.955U PD=3.31U
* device instance $1090 r0 *1 16.55,10.81 pfet
M$1090 \$304 ph[10] VDD$1 VDD$1 pfet L=0.5U W=1.22U AS=0.5368P AD=0.4087P
+ PS=3.32U PD=1.89U
* device instance $1091 r0 *1 17.72,10.81 pfet
M$1091 \_064_ q3 \$304 VDD$1 pfet L=0.5U W=1.22U AS=0.4087P AD=0.5368P PS=1.89U
+ PD=3.32U
* device instance $1092 r0 *1 19.91,10.81 pfet
M$1092 \$306 ph[11] VDD$1 VDD$1 pfet L=0.5U W=1.22U AS=0.5368P AD=0.4087P
+ PS=3.32U PD=1.89U
* device instance $1093 r0 *1 21.08,10.81 pfet
M$1093 \_057_ q2 \$306 VDD$1 pfet L=0.5U W=1.22U AS=0.4087P AD=0.5368P PS=1.89U
+ PD=3.32U
* device instance $1094 r0 *1 32.71,5.025 pfet
M$1094 \$179 \$135 VDD VDD pfet L=0.5U W=0.36U AS=0.4554P AD=0.054P PS=3.25U
+ PD=0.66U
* device instance $1095 r0 *1 33.51,5.025 pfet
M$1095 \$159 \_002_ \$179 VDD pfet L=0.5U W=0.36U AS=0.054P AD=0.1872P PS=0.66U
+ PD=1.4U
* device instance $1096 r0 *1 35.05,5.025 pfet
M$1096 \$180 \$133 \$159 VDD pfet L=0.5U W=0.36U AS=0.1872P AD=0.0432P PS=1.4U
+ PD=0.6U
* device instance $1097 r0 *1 35.79,5.025 pfet
M$1097 VDD \$134 \$180 VDD pfet L=0.5U W=0.36U AS=0.0432P AD=0.1044P PS=0.6U
+ PD=0.94U
* device instance $1098 r0 *1 36.87,5.025 pfet
M$1098 \$134 \$159 VDD VDD pfet L=0.5U W=0.36U AS=0.1044P AD=0.1791P PS=0.94U
+ PD=1.355U
* device instance $1099 r0 *1 38.365,5.025 pfet
M$1099 \$160 \$133 \$134 VDD pfet L=0.5U W=0.36U AS=0.1791P AD=0.1665P
+ PS=1.355U PD=1.285U
* device instance $1100 r0 *1 39.79,5.025 pfet
M$1100 \$181 \$135 \$160 VDD pfet L=0.5U W=0.36U AS=0.1665P AD=0.0504P
+ PS=1.285U PD=0.64U
* device instance $1101 r0 *1 40.57,5.025 pfet
M$1101 \$181 \$136 VDD VDD pfet L=0.5U W=0.36U AS=0.23P AD=0.0504P PS=1.54U
+ PD=0.64U
* device instance $1102 r0 *1 41.81,4.805 pfet
M$1102 \$136 \$160 VDD VDD pfet L=0.5U W=0.8U AS=0.23P AD=0.352P PS=1.54U
+ PD=2.48U
* device instance $1103 r0 *1 32.79,10.8075 pfet
M$1103 \_002_ \_047_ \$295 VDD$1 pfet L=0.5U W=1.215U AS=0.5346P AD=0.3159P
+ PS=3.31U PD=1.735U
* device instance $1104 r0 *1 33.81,10.8075 pfet
M$1104 \$295 \_030_ \_002_ VDD$1 pfet L=0.5U W=1.215U AS=0.3159P AD=0.44955P
+ PS=1.735U PD=1.955U
* device instance $1105 r0 *1 35.05,10.8075 pfet
M$1105 VDD$1 ph[13] \$295 VDD$1 pfet L=0.5U W=1.215U AS=0.44955P AD=0.5346P
+ PS=1.955U PD=3.31U
* device instance $1106 r0 *1 37.27,10.8075 pfet
M$1106 \_000_ \_044_ \$296 VDD$1 pfet L=0.5U W=1.215U AS=0.5346P AD=0.3159P
+ PS=3.31U PD=1.735U
* device instance $1107 r0 *1 38.29,10.8075 pfet
M$1107 \$296 \_043_ \_000_ VDD$1 pfet L=0.5U W=1.215U AS=0.3159P AD=0.44955P
+ PS=1.735U PD=1.955U
* device instance $1108 r0 *1 39.53,10.8075 pfet
M$1108 VDD$1 ph[13] \$296 VDD$1 pfet L=0.5U W=1.215U AS=0.44955P AD=0.5346P
+ PS=1.955U PD=3.31U
* device instance $1109 r0 *1 45.67,10.81 pfet
M$1109 \_036_ eng4 VDD$1 VDD$1 pfet L=0.5U W=1.22U AS=0.5368P AD=0.5368P
+ PS=3.32U PD=3.32U
* device instance $1110 r0 *1 47.91,10.81 pfet
M$1110 \_042_ eng2 VDD$1 VDD$1 pfet L=0.5U W=1.22U AS=0.5368P AD=0.5368P
+ PS=3.32U PD=3.32U
* device instance $1111 r0 *1 56.41,10.81 pfet
M$1111 \$313 \_036_ VDD$1 VDD$1 pfet L=0.5U W=1.22U AS=0.5368P AD=0.3172P
+ PS=3.32U PD=1.74U
* device instance $1112 r0 *1 57.43,10.81 pfet
M$1112 \$315 q4 \$313 VDD$1 pfet L=0.5U W=1.22U AS=0.3172P AD=0.3782P PS=1.74U
+ PD=1.84U
* device instance $1113 r0 *1 58.55,10.81 pfet
M$1113 sel_hi_n_8n \_031_ \$315 VDD$1 pfet L=0.5U W=1.22U AS=0.3782P AD=0.5368P
+ PS=1.84U PD=3.32U
* device instance $1114 r0 *1 79.83,10.8075 pfet
M$1114 rel_n_32n eng6 \$297 VDD$1 pfet L=0.5U W=1.215U AS=0.5346P AD=0.3159P
+ PS=3.31U PD=1.735U
* device instance $1115 r0 *1 80.85,10.8075 pfet
M$1115 \$297 mode rel_n_32n VDD$1 pfet L=0.5U W=1.215U AS=0.3159P AD=0.44955P
+ PS=1.735U PD=1.955U
* device instance $1116 r0 *1 82.09,10.8075 pfet
M$1116 VDD$1 sel_in_n \$297 VDD$1 pfet L=0.5U W=1.215U AS=0.44955P AD=0.5346P
+ PS=1.955U PD=3.31U
* device instance $1117 r0 *1 84.31,10.8075 pfet
M$1117 rel_n_256n eng9 \$298 VDD$1 pfet L=0.5U W=1.215U AS=0.5346P AD=0.3159P
+ PS=3.31U PD=1.735U
* device instance $1118 r0 *1 85.33,10.8075 pfet
M$1118 \$298 mode rel_n_256n VDD$1 pfet L=0.5U W=1.215U AS=0.3159P AD=0.44955P
+ PS=1.735U PD=1.955U
* device instance $1119 r0 *1 86.57,10.8075 pfet
M$1119 VDD$1 sel_in_n \$298 VDD$1 pfet L=0.5U W=1.215U AS=0.44955P AD=0.5346P
+ PS=1.955U PD=3.31U
* device instance $1120 r0 *1 111.75,10.81 pfet
M$1120 \$318 q1 VDD$1 VDD$1 pfet L=0.5U W=1.22U AS=0.5368P AD=0.4087P PS=3.32U
+ PD=1.89U
* device instance $1121 r0 *1 112.92,10.81 pfet
M$1121 sel_lo_n_1p \_044_ \$318 VDD$1 pfet L=0.5U W=1.22U AS=0.4087P AD=0.5368P
+ PS=1.89U PD=3.32U
* device instance $1122 r0 *1 115.21,10.81 pfet
M$1122 \$319 \_037_ VDD$1 VDD$1 pfet L=0.5U W=1.22U AS=0.5368P AD=0.3172P
+ PS=3.32U PD=1.74U
* device instance $1123 r0 *1 116.23,10.81 pfet
M$1123 \$320 q5 \$319 VDD$1 pfet L=0.5U W=1.22U AS=0.3172P AD=0.3782P PS=1.74U
+ PD=1.84U
* device instance $1124 r0 *1 117.35,10.81 pfet
M$1124 sel_hi_n_16n \_031_ \$320 VDD$1 pfet L=0.5U W=1.22U AS=0.3782P
+ AD=0.5368P PS=1.84U PD=3.32U
* device instance $1125 r0 *1 120.71,10.8075 pfet
M$1125 rel_n_16n eng5 \$299 VDD$1 pfet L=0.5U W=1.215U AS=0.5346P AD=0.3159P
+ PS=3.31U PD=1.735U
* device instance $1126 r0 *1 121.73,10.8075 pfet
M$1126 \$299 mode rel_n_16n VDD$1 pfet L=0.5U W=1.215U AS=0.3159P AD=0.44955P
+ PS=1.735U PD=1.955U
* device instance $1127 r0 *1 122.97,10.8075 pfet
M$1127 VDD$1 sel_in_n \$299 VDD$1 pfet L=0.5U W=1.215U AS=0.44955P AD=0.5346P
+ PS=1.955U PD=3.31U
* device instance $1128 r0 *1 127.43,10.81 pfet
M$1128 \$321 \_037_ VDD$1 VDD$1 pfet L=0.5U W=1.22U AS=0.5368P AD=0.4087P
+ PS=3.32U PD=1.89U
* device instance $1129 r0 *1 128.6,10.81 pfet
M$1129 sel_lo_n_16p q5 \$321 VDD$1 pfet L=0.5U W=1.22U AS=0.4087P AD=0.5368P
+ PS=1.89U PD=3.32U
* device instance $1130 r0 *1 132.57,10.81 pfet
M$1130 \$323 \_040_ VDD$1 VDD$1 pfet L=0.5U W=1.22U AS=0.5368P AD=0.3172P
+ PS=3.32U PD=1.74U
* device instance $1131 r0 *1 133.59,10.81 pfet
M$1131 \$322 q8 \$323 VDD$1 pfet L=0.5U W=1.22U AS=0.3172P AD=0.3782P PS=1.74U
+ PD=1.84U
* device instance $1132 r0 *1 134.71,10.81 pfet
M$1132 sel_hi_n_128n \_031_ \$322 VDD$1 pfet L=0.5U W=1.22U AS=0.3782P
+ AD=0.5368P PS=1.84U PD=3.32U
* device instance $1133 r0 *1 140.87,10.81 pfet
M$1133 \_039_ eng7 VDD$1 VDD$1 pfet L=0.5U W=1.22U AS=0.5368P AD=0.5368P
+ PS=3.32U PD=3.32U
* device instance $1134 r0 *1 143.11,10.8075 pfet
M$1134 \_006_ \_051_ \$300 VDD$1 pfet L=0.5U W=1.215U AS=0.5346P AD=0.3159P
+ PS=3.31U PD=1.735U
* device instance $1135 r0 *1 144.13,10.8075 pfet
M$1135 \$300 \_039_ \_006_ VDD$1 pfet L=0.5U W=1.215U AS=0.3159P AD=0.44955P
+ PS=1.735U PD=1.955U
* device instance $1136 r0 *1 145.37,10.8075 pfet
M$1136 VDD$1 ph[13] \$300 VDD$1 pfet L=0.5U W=1.215U AS=0.44955P AD=0.5346P
+ PS=1.955U PD=3.31U
* device instance $1137 r0 *1 144.71,5.025 pfet
M$1137 \$189 \$151 VDD VDD pfet L=0.5U W=0.36U AS=0.4554P AD=0.054P PS=3.25U
+ PD=0.66U
* device instance $1138 r0 *1 145.51,5.025 pfet
M$1138 \$169 \_005_ \$189 VDD pfet L=0.5U W=0.36U AS=0.054P AD=0.1872P PS=0.66U
+ PD=1.4U
* device instance $1139 r0 *1 147.05,5.025 pfet
M$1139 \$188 \$149 \$169 VDD pfet L=0.5U W=0.36U AS=0.1872P AD=0.0432P PS=1.4U
+ PD=0.6U
* device instance $1140 r0 *1 147.79,5.025 pfet
M$1140 VDD \$150 \$188 VDD pfet L=0.5U W=0.36U AS=0.0432P AD=0.1044P PS=0.6U
+ PD=0.94U
* device instance $1141 r0 *1 148.87,5.025 pfet
M$1141 \$150 \$169 VDD VDD pfet L=0.5U W=0.36U AS=0.1044P AD=0.1791P PS=0.94U
+ PD=1.355U
* device instance $1142 r0 *1 150.365,5.025 pfet
M$1142 \$170 \$149 \$150 VDD pfet L=0.5U W=0.36U AS=0.1791P AD=0.1665P
+ PS=1.355U PD=1.285U
* device instance $1143 r0 *1 151.79,5.025 pfet
M$1143 \$187 \$151 \$170 VDD pfet L=0.5U W=0.36U AS=0.1665P AD=0.0504P
+ PS=1.285U PD=0.64U
* device instance $1144 r0 *1 152.57,5.025 pfet
M$1144 \$187 \$152 VDD VDD pfet L=0.5U W=0.36U AS=0.23P AD=0.0504P PS=1.54U
+ PD=0.64U
* device instance $1145 r0 *1 153.81,4.805 pfet
M$1145 \$152 \$170 VDD VDD pfet L=0.5U W=0.8U AS=0.23P AD=0.352P PS=1.54U
+ PD=2.48U
* device instance $1146 r0 *1 158.33,10.6325 pfet
M$1146 VDD$1 clknet_2_2__leaf_clk \$262 VDD$1 pfet L=0.5U W=0.865U AS=0.3806P
+ AD=0.2249P PS=2.61U PD=1.385U
* device instance $1147 r0 *1 159.35,10.6325 pfet
M$1147 \$263 \$262 VDD$1 VDD$1 pfet L=0.5U W=0.865U AS=0.2249P AD=0.3806P
+ PS=1.385U PD=2.61U
* device instance $1148 r0 *1 164.31,5.025 pfet
M$1148 \$186 \$155 VDD VDD pfet L=0.5U W=0.36U AS=0.4554P AD=0.054P PS=3.25U
+ PD=0.66U
* device instance $1149 r0 *1 165.11,5.025 pfet
M$1149 \$171 \_009_[0] \$186 VDD pfet L=0.5U W=0.36U AS=0.054P AD=0.1872P
+ PS=0.66U PD=1.4U
* device instance $1150 r0 *1 166.65,5.025 pfet
M$1150 \$183 \$153 \$171 VDD pfet L=0.5U W=0.36U AS=0.1872P AD=0.0432P PS=1.4U
+ PD=0.6U
* device instance $1151 r0 *1 167.39,5.025 pfet
M$1151 VDD \$154 \$183 VDD pfet L=0.5U W=0.36U AS=0.0432P AD=0.1044P PS=0.6U
+ PD=0.94U
* device instance $1152 r0 *1 168.47,5.025 pfet
M$1152 \$154 \$171 VDD VDD pfet L=0.5U W=0.36U AS=0.1044P AD=0.1791P PS=0.94U
+ PD=1.355U
* device instance $1153 r0 *1 169.965,5.025 pfet
M$1153 \$172 \$153 \$154 VDD pfet L=0.5U W=0.36U AS=0.1791P AD=0.1665P
+ PS=1.355U PD=1.285U
* device instance $1154 r0 *1 171.39,5.025 pfet
M$1154 \$182 \$155 \$172 VDD pfet L=0.5U W=0.36U AS=0.1665P AD=0.0504P
+ PS=1.285U PD=0.64U
* device instance $1155 r0 *1 172.17,5.025 pfet
M$1155 \$182 \$156 VDD VDD pfet L=0.5U W=0.36U AS=0.23P AD=0.0504P PS=1.54U
+ PD=0.64U
* device instance $1156 r0 *1 173.41,4.805 pfet
M$1156 \$156 \$172 VDD VDD pfet L=0.5U W=0.8U AS=0.23P AD=0.352P PS=1.54U
+ PD=2.48U
* device instance $1157 r0 *1 172.35,10.81 pfet
M$1157 q6 \$268 VDD$1 VDD$1 pfet L=0.5U W=1.22U AS=0.5368P AD=0.5368P PS=3.32U
+ PD=3.32U
* device instance $1158 r0 *1 175.59,10.81 pfet
M$1158 \$311 start VDD$1 VDD$1 pfet L=0.5U W=1.22U AS=0.5368P AD=0.4087P
+ PS=3.32U PD=1.89U
* device instance $1159 r0 *1 176.76,10.81 pfet
M$1159 \_009_[2] \_034_ \$311 VDD$1 pfet L=0.5U W=1.22U AS=0.4087P AD=0.5368P
+ PS=1.89U PD=3.32U
* device instance $1160 r0 *1 178.95,10.81 pfet
M$1160 \$310 ph[5] VDD$1 VDD$1 pfet L=0.5U W=1.22U AS=0.5368P AD=0.4087P
+ PS=3.32U PD=1.89U
* device instance $1161 r0 *1 180.12,10.81 pfet
M$1161 \_061_ q8 \$310 VDD$1 pfet L=0.5U W=1.22U AS=0.4087P AD=0.5368P PS=1.89U
+ PD=3.32U
* device instance $1162 r0 *1 182.31,10.81 pfet
M$1162 \$309 start VDD$1 VDD$1 pfet L=0.5U W=1.22U AS=0.5368P AD=0.4087P
+ PS=3.32U PD=1.89U
* device instance $1163 r0 *1 183.48,10.81 pfet
M$1163 \_009_[3] \_032_ \$309 VDD$1 pfet L=0.5U W=1.22U AS=0.4087P AD=0.5368P
+ PS=1.89U PD=3.32U
* device instance $1164 r0 *1 16.11,12.71 pfet
M$1164 ph[10] \$329 VDD$1 VDD$1 pfet L=0.5U W=1.22U AS=0.5368P AD=0.5368P
+ PS=3.32U PD=3.32U
* device instance $1165 r0 *1 19.35,12.71 pfet
M$1165 \_046_ ph[11] VDD$1 VDD$1 pfet L=0.5U W=1.22U AS=0.5368P AD=0.5368P
+ PS=3.32U PD=3.32U
* device instance $1166 r0 *1 33.35,12.7125 pfet
M$1166 \_003_ \_048_ \$330 VDD$1 pfet L=0.5U W=1.215U AS=0.5346P AD=0.3159P
+ PS=3.31U PD=1.735U
* device instance $1167 r0 *1 34.37,12.7125 pfet
M$1167 \$330 \_036_ \_003_ VDD$1 pfet L=0.5U W=1.215U AS=0.3159P AD=0.44955P
+ PS=1.735U PD=1.955U
* device instance $1168 r0 *1 35.61,12.7125 pfet
M$1168 VDD$1 ph[13] \$330 VDD$1 pfet L=0.5U W=1.215U AS=0.44955P AD=0.5346P
+ PS=1.955U PD=3.31U
* device instance $1169 r0 *1 37.83,12.7125 pfet
M$1169 \_001_ \_046_ \$331 VDD$1 pfet L=0.5U W=1.215U AS=0.5346P AD=0.3159P
+ PS=3.31U PD=1.735U
* device instance $1170 r0 *1 38.85,12.7125 pfet
M$1170 \$331 \_042_ \_001_ VDD$1 pfet L=0.5U W=1.215U AS=0.3159P AD=0.44955P
+ PS=1.735U PD=1.955U
* device instance $1171 r0 *1 40.09,12.7125 pfet
M$1171 VDD$1 ph[13] \$331 VDD$1 pfet L=0.5U W=1.215U AS=0.44955P AD=0.5346P
+ PS=1.955U PD=3.31U
* device instance $1172 r0 *1 42.31,12.71 pfet
M$1172 \$332 clknet_0_clk VDD$1 VDD$1 pfet L=0.5U W=1.22U AS=0.5368P AD=0.3782P
+ PS=3.32U PD=1.84U
* device instance $1173 r0 *1 43.43,12.71 pfet
M$1173 VDD$1 clknet_0_clk \$332 VDD$1 pfet L=0.5U W=1.22U AS=0.3782P AD=0.3782P
+ PS=1.84U PD=1.84U
* device instance $1174 r0 *1 44.55,12.71 pfet
M$1174 clknet_2_0__leaf_clk \$332 VDD$1 VDD$1 pfet L=0.5U W=1.22U AS=0.3782P
+ AD=0.3782P PS=1.84U PD=1.84U
* device instance $1175 r0 *1 45.67,12.71 pfet
M$1175 VDD$1 \$332 clknet_2_0__leaf_clk VDD$1 pfet L=0.5U W=1.22U AS=0.3782P
+ AD=0.3782P PS=1.84U PD=1.84U
* device instance $1176 r0 *1 46.79,12.71 pfet
M$1176 clknet_2_0__leaf_clk \$332 VDD$1 VDD$1 pfet L=0.5U W=1.22U AS=0.3782P
+ AD=0.3782P PS=1.84U PD=1.84U
* device instance $1177 r0 *1 47.91,12.71 pfet
M$1177 VDD$1 \$332 clknet_2_0__leaf_clk VDD$1 pfet L=0.5U W=1.22U AS=0.3782P
+ AD=0.5368P PS=1.84U PD=3.32U
* device instance $1178 r0 *1 50.71,12.71 pfet
M$1178 \_044_ eng1 VDD$1 VDD$1 pfet L=0.5U W=1.22U AS=0.5368P AD=0.5368P
+ PS=3.32U PD=3.32U
* device instance $1179 r0 *1 54.63,12.71 pfet
M$1179 \$372 \_036_ VDD$1 VDD$1 pfet L=0.5U W=1.22U AS=0.5368P AD=0.4087P
+ PS=3.32U PD=1.89U
* device instance $1180 r0 *1 55.8,12.71 pfet
M$1180 sel_lo_n_8p q4 \$372 VDD$1 pfet L=0.5U W=1.22U AS=0.4087P AD=0.5368P
+ PS=1.89U PD=3.32U
* device instance $1181 r0 *1 58.09,12.71 pfet
M$1181 \$373 q3 VDD$1 VDD$1 pfet L=0.5U W=1.22U AS=0.5368P AD=0.3172P PS=3.32U
+ PD=1.74U
* device instance $1182 r0 *1 59.11,12.71 pfet
M$1182 \$374 \_031_ \$373 VDD$1 pfet L=0.5U W=1.22U AS=0.3172P AD=0.3782P
+ PS=1.74U PD=1.84U
* device instance $1183 r0 *1 60.23,12.71 pfet
M$1183 sel_hi_n_4n \_030_ \$374 VDD$1 pfet L=0.5U W=1.22U AS=0.3782P AD=0.5368P
+ PS=1.84U PD=3.32U
* device instance $1184 r0 *1 60.79,11.115 pfet
M$1184 \$248 eng3 VDD$1 VDD$1 pfet L=0.5U W=0.6U AS=0.264P AD=0.156P PS=2.08U
+ PD=1.12U
* device instance $1185 r0 *1 61.81,11.115 pfet
M$1185 \$248 q3 VDD$1 VDD$1 pfet L=0.5U W=0.6U AS=0.40575P AD=0.156P PS=2.055U
+ PD=1.12U
* device instance $1186 r0 *1 63.15,10.8075 pfet
M$1186 sel_hi_n_4p \$248 VDD$1 VDD$1 pfet L=0.5U W=1.215U AS=0.40575P
+ AD=0.5346P PS=2.055U PD=3.31U
* device instance $1187 r0 *1 62.47,12.405 pfet
M$1187 \$334 mode VDD$1 VDD$1 pfet L=0.5U W=0.6U AS=0.264P AD=0.156P PS=2.08U
+ PD=1.12U
* device instance $1188 r0 *1 63.49,12.405 pfet
M$1188 VDD$1 sel_hi_n_256p \$334 VDD$1 pfet L=0.5U W=0.6U AS=0.156P AD=0.40575P
+ PS=1.12U PD=2.055U
* device instance $1189 r0 *1 64.83,12.7125 pfet
M$1189 sel_lo_n_256n \$334 VDD$1 VDD$1 pfet L=0.5U W=1.215U AS=0.40575P
+ AD=0.5346P PS=2.055U PD=3.31U
* device instance $1190 r0 *1 65.27,11.115 pfet
M$1190 \$249 mode VDD$1 VDD$1 pfet L=0.5U W=0.6U AS=0.264P AD=0.156P PS=2.08U
+ PD=1.12U
* device instance $1191 r0 *1 66.29,11.115 pfet
M$1191 \$249 sel_hi_n_128p VDD$1 VDD$1 pfet L=0.5U W=0.6U AS=0.40575P AD=0.156P
+ PS=2.055U PD=1.12U
* device instance $1192 r0 *1 67.63,10.8075 pfet
M$1192 sel_lo_n_128n \$249 VDD$1 VDD$1 pfet L=0.5U W=1.215U AS=0.40575P
+ AD=0.5346P PS=2.055U PD=3.31U
* device instance $1193 r0 *1 73.67,12.405 pfet
M$1193 \$336 q8 VDD$1 VDD$1 pfet L=0.5U W=0.6U AS=0.264P AD=0.156P PS=2.08U
+ PD=1.12U
* device instance $1194 r0 *1 74.69,12.405 pfet
M$1194 VDD$1 eng8 \$336 VDD$1 pfet L=0.5U W=0.6U AS=0.156P AD=0.40575P PS=1.12U
+ PD=2.055U
* device instance $1195 r0 *1 76.03,12.7125 pfet
M$1195 sel_hi_n_128p \$336 VDD$1 VDD$1 pfet L=0.5U W=1.215U AS=0.40575P
+ AD=0.5346P PS=2.055U PD=3.31U
* device instance $1196 r0 *1 74.23,11.115 pfet
M$1196 \$250 eng1 VDD$1 VDD$1 pfet L=0.5U W=0.6U AS=0.264P AD=0.156P PS=2.08U
+ PD=1.12U
* device instance $1197 r0 *1 75.25,11.115 pfet
M$1197 \$250 q1 VDD$1 VDD$1 pfet L=0.5U W=0.6U AS=0.40575P AD=0.156P PS=2.055U
+ PD=1.12U
* device instance $1198 r0 *1 76.59,10.8075 pfet
M$1198 sel_hi_n_1p \$250 VDD$1 VDD$1 pfet L=0.5U W=1.215U AS=0.40575P
+ AD=0.5346P PS=2.055U PD=3.31U
* device instance $1199 r0 *1 82.63,12.405 pfet
M$1199 \$337 q9 VDD$1 VDD$1 pfet L=0.5U W=0.6U AS=0.264P AD=0.156P PS=2.08U
+ PD=1.12U
* device instance $1200 r0 *1 83.65,12.405 pfet
M$1200 VDD$1 eng9 \$337 VDD$1 pfet L=0.5U W=0.6U AS=0.156P AD=0.40575P PS=1.12U
+ PD=2.055U
* device instance $1201 r0 *1 84.99,12.7125 pfet
M$1201 sel_hi_n_256p \$337 VDD$1 VDD$1 pfet L=0.5U W=1.215U AS=0.40575P
+ AD=0.5346P PS=2.055U PD=3.31U
* device instance $1202 r0 *1 93.27,11.115 pfet
M$1202 \$251 eng2 VDD$1 VDD$1 pfet L=0.5U W=0.6U AS=0.264P AD=0.156P PS=2.08U
+ PD=1.12U
* device instance $1203 r0 *1 94.29,11.115 pfet
M$1203 \$251 q2 VDD$1 VDD$1 pfet L=0.5U W=0.6U AS=0.40575P AD=0.156P PS=2.055U
+ PD=1.12U
* device instance $1204 r0 *1 95.63,10.8075 pfet
M$1204 sel_hi_n_2p \$251 VDD$1 VDD$1 pfet L=0.5U W=1.215U AS=0.40575P
+ AD=0.5346P PS=2.055U PD=3.31U
* device instance $1205 r0 *1 101.67,11.115 pfet
M$1205 \$252 q7 VDD$1 VDD$1 pfet L=0.5U W=0.6U AS=0.264P AD=0.156P PS=2.08U
+ PD=1.12U
* device instance $1206 r0 *1 102.69,11.115 pfet
M$1206 \$252 eng7 VDD$1 VDD$1 pfet L=0.5U W=0.6U AS=0.40575P AD=0.156P
+ PS=2.055U PD=1.12U
* device instance $1207 r0 *1 104.03,10.8075 pfet
M$1207 sel_hi_n_64p \$252 VDD$1 VDD$1 pfet L=0.5U W=1.215U AS=0.40575P
+ AD=0.5346P PS=2.055U PD=3.31U
* device instance $1208 r0 *1 101.79,12.71 pfet
M$1208 c5_r \$343 VDD$1 VDD$1 pfet L=0.5U W=1.22U AS=0.5368P AD=0.5368P
+ PS=3.32U PD=3.32U
* device instance $1209 r0 *1 107.27,11.115 pfet
M$1209 \$253 q5 VDD$1 VDD$1 pfet L=0.5U W=0.6U AS=0.264P AD=0.156P PS=2.08U
+ PD=1.12U
* device instance $1210 r0 *1 108.29,11.115 pfet
M$1210 \$253 eng5 VDD$1 VDD$1 pfet L=0.5U W=0.6U AS=0.40575P AD=0.156P
+ PS=2.055U PD=1.12U
* device instance $1211 r0 *1 109.63,10.8075 pfet
M$1211 sel_hi_n_16p \$253 VDD$1 VDD$1 pfet L=0.5U W=1.215U AS=0.40575P
+ AD=0.5346P PS=2.055U PD=3.31U
* device instance $1212 r0 *1 112.97,12.71 pfet
M$1212 \$380 \_041_ VDD$1 VDD$1 pfet L=0.5U W=1.22U AS=0.5368P AD=0.3172P
+ PS=3.32U PD=1.74U
* device instance $1213 r0 *1 113.99,12.71 pfet
M$1213 \$381 q9 \$380 VDD$1 pfet L=0.5U W=1.22U AS=0.3172P AD=0.3782P PS=1.74U
+ PD=1.84U
* device instance $1214 r0 *1 115.11,12.71 pfet
M$1214 sel_hi_n_256n \_031_ \$381 VDD$1 pfet L=0.5U W=1.22U AS=0.3782P
+ AD=0.5368P PS=1.84U PD=3.32U
* device instance $1215 r0 *1 117.35,12.71 pfet
M$1215 \$382 \_041_ VDD$1 VDD$1 pfet L=0.5U W=1.22U AS=0.5368P AD=0.4087P
+ PS=3.32U PD=1.89U
* device instance $1216 r0 *1 118.52,12.71 pfet
M$1216 sel_lo_n_256p q9 \$382 VDD$1 pfet L=0.5U W=1.22U AS=0.4087P AD=0.5368P
+ PS=1.89U PD=3.32U
* device instance $1217 r0 *1 131.35,12.71 pfet
M$1217 \$384 \_039_ VDD$1 VDD$1 pfet L=0.5U W=1.22U AS=0.5368P AD=0.4087P
+ PS=3.32U PD=1.89U
* device instance $1218 r0 *1 132.52,12.71 pfet
M$1218 sel_lo_n_64p q7 \$384 VDD$1 pfet L=0.5U W=1.22U AS=0.4087P AD=0.5368P
+ PS=1.89U PD=3.32U
* device instance $1219 r0 *1 134.71,12.71 pfet
M$1219 \$383 \_038_ VDD$1 VDD$1 pfet L=0.5U W=1.22U AS=0.5368P AD=0.4087P
+ PS=3.32U PD=1.89U
* device instance $1220 r0 *1 135.88,12.71 pfet
M$1220 sel_lo_n_32p q6 \$383 VDD$1 pfet L=0.5U W=1.22U AS=0.4087P AD=0.5368P
+ PS=1.89U PD=3.32U
* device instance $1221 r0 *1 141.99,12.7125 pfet
M$1221 \_005_ \_050_ \$345 VDD$1 pfet L=0.5U W=1.215U AS=0.5346P AD=0.3159P
+ PS=3.31U PD=1.735U
* device instance $1222 r0 *1 143.01,12.7125 pfet
M$1222 \$345 \_038_ \_005_ VDD$1 pfet L=0.5U W=1.215U AS=0.3159P AD=0.44955P
+ PS=1.735U PD=1.955U
* device instance $1223 r0 *1 144.25,12.7125 pfet
M$1223 VDD$1 ph[13] \$345 VDD$1 pfet L=0.5U W=1.215U AS=0.44955P AD=0.5346P
+ PS=1.955U PD=3.31U
* device instance $1224 r0 *1 147.59,12.71 pfet
M$1224 \$376 start VDD$1 VDD$1 pfet L=0.5U W=1.22U AS=0.5368P AD=0.4087P
+ PS=3.32U PD=1.89U
* device instance $1225 r0 *1 148.76,12.71 pfet
M$1225 \_009_[6] \_052_ \$376 VDD$1 pfet L=0.5U W=1.22U AS=0.4087P AD=0.5368P
+ PS=1.89U PD=3.32U
* device instance $1226 r0 *1 152.63,12.71 pfet
M$1226 \$375 start VDD$1 VDD$1 pfet L=0.5U W=1.22U AS=0.5368P AD=0.4087P
+ PS=3.32U PD=1.89U
* device instance $1227 r0 *1 153.8,12.71 pfet
M$1227 \_009_[7] \_051_ \$375 VDD$1 pfet L=0.5U W=1.22U AS=0.4087P AD=0.5368P
+ PS=1.89U PD=3.32U
* device instance $1228 r0 *1 153.905,11.1375 pfet
M$1228 \$317 start \$261 VDD$1 pfet L=0.5U W=0.565U AS=0.2486P AD=0.1469P
+ PS=2.01U PD=1.085U
* device instance $1229 r0 *1 154.925,11.1375 pfet
M$1229 \$317 ph[15] VDD$1 VDD$1 pfet L=0.5U W=0.565U AS=0.38705P AD=0.1469P
+ PS=2.08U PD=1.085U
* device instance $1230 r0 *1 156.285,10.81 pfet
M$1230 \_009_[0] \$261 VDD$1 VDD$1 pfet L=0.5U W=1.22U AS=0.38705P AD=0.5368P
+ PS=2.08U PD=3.32U
* device instance $1231 r0 *1 158.23,12.71 pfet
M$1231 \_050_ ph[7] VDD$1 VDD$1 pfet L=0.5U W=1.22U AS=0.5368P AD=0.5368P
+ PS=3.32U PD=3.32U
* device instance $1232 r0 *1 161.51,10.655 pfet
M$1232 \$316 \$263 VDD$1 VDD$1 pfet L=0.5U W=0.36U AS=0.4554P AD=0.054P
+ PS=3.25U PD=0.66U
* device instance $1233 r0 *1 162.31,10.655 pfet
M$1233 \$265 \_014_ \$316 VDD$1 pfet L=0.5U W=0.36U AS=0.054P AD=0.1872P
+ PS=0.66U PD=1.4U
* device instance $1234 r0 *1 163.85,10.655 pfet
M$1234 \$314 \$262 \$265 VDD$1 pfet L=0.5U W=0.36U AS=0.1872P AD=0.0432P
+ PS=1.4U PD=0.6U
* device instance $1235 r0 *1 164.59,10.655 pfet
M$1235 VDD$1 \$266 \$314 VDD$1 pfet L=0.5U W=0.36U AS=0.0432P AD=0.1044P
+ PS=0.6U PD=0.94U
* device instance $1236 r0 *1 165.67,10.655 pfet
M$1236 \$266 \$265 VDD$1 VDD$1 pfet L=0.5U W=0.36U AS=0.1044P AD=0.1791P
+ PS=0.94U PD=1.355U
* device instance $1237 r0 *1 167.165,10.655 pfet
M$1237 \$267 \$262 \$266 VDD$1 pfet L=0.5U W=0.36U AS=0.1791P AD=0.1665P
+ PS=1.355U PD=1.285U
* device instance $1238 r0 *1 168.59,10.655 pfet
M$1238 \$312 \$263 \$267 VDD$1 pfet L=0.5U W=0.36U AS=0.1665P AD=0.0504P
+ PS=1.285U PD=0.64U
* device instance $1239 r0 *1 169.37,10.655 pfet
M$1239 VDD$1 \$268 \$312 VDD$1 pfet L=0.5U W=0.36U AS=0.0504P AD=0.23P PS=0.64U
+ PD=1.54U
* device instance $1240 r0 *1 170.61,10.875 pfet
M$1240 \$268 \$267 VDD$1 VDD$1 pfet L=0.5U W=0.8U AS=0.23P AD=0.352P PS=1.54U
+ PD=2.48U
* device instance $1241 r0 *1 163.83,12.71 pfet
M$1241 \$371 ph[7] VDD$1 VDD$1 pfet L=0.5U W=1.22U AS=0.5368P AD=0.4087P
+ PS=3.32U PD=1.89U
* device instance $1242 r0 *1 165,12.71 pfet
M$1242 \_056_ q6 \$371 VDD$1 pfet L=0.5U W=1.22U AS=0.4087P AD=0.5368P PS=1.89U
+ PD=3.32U
* device instance $1243 r0 *1 185.77,11.14 pfet
M$1243 \$308 ph[2] \$272 VDD$1 pfet L=0.5U W=0.56U AS=0.2464P AD=0.196P PS=2U
+ PD=1.26U
* device instance $1244 r0 *1 186.97,11.14 pfet
M$1244 \$307 ph[0] \$308 VDD$1 pfet L=0.5U W=0.56U AS=0.196P AD=0.1736P
+ PS=1.26U PD=1.18U
* device instance $1245 r0 *1 188.09,11.14 pfet
M$1245 \$305 ph[1] \$307 VDD$1 pfet L=0.5U W=0.56U AS=0.1736P AD=0.1736P
+ PS=1.18U PD=1.18U
* device instance $1246 r0 *1 189.21,11.14 pfet
M$1246 \$305 ph[3] VDD$1 VDD$1 pfet L=0.5U W=0.56U AS=0.389P AD=0.1736P
+ PS=2.02U PD=1.18U
* device instance $1247 r0 *1 190.51,10.81 pfet
M$1247 sel_in_n \$272 VDD$1 VDD$1 pfet L=0.5U W=1.22U AS=0.389P AD=0.5368P
+ PS=2.02U PD=3.32U
* device instance $1248 r0 *1 190.27,12.71 pfet
M$1248 q9 \$354 VDD$1 VDD$1 pfet L=0.5U W=1.22U AS=0.5368P AD=0.5368P PS=3.32U
+ PD=3.32U
* device instance $1249 r0 *1 2.09,12.8875 pfet
M$1249 VDD$1 clknet_2_0__leaf_clk \$324 VDD$1 pfet L=0.5U W=0.865U AS=0.3806P
+ AD=0.2249P PS=2.61U PD=1.385U
* device instance $1250 r0 *1 3.11,12.8875 pfet
M$1250 \$327 \$324 VDD$1 VDD$1 pfet L=0.5U W=0.865U AS=0.2249P AD=0.3806P
+ PS=1.385U PD=2.61U
* device instance $1251 r0 *1 5.27,12.865 pfet
M$1251 \$365 \$327 VDD$1 VDD$1 pfet L=0.5U W=0.36U AS=0.4554P AD=0.054P
+ PS=3.25U PD=0.66U
* device instance $1252 r0 *1 6.07,12.865 pfet
M$1252 \$325 \_009_[10] \$365 VDD$1 pfet L=0.5U W=0.36U AS=0.054P AD=0.1872P
+ PS=0.66U PD=1.4U
* device instance $1253 r0 *1 7.61,12.865 pfet
M$1253 \$366 \$324 \$325 VDD$1 pfet L=0.5U W=0.36U AS=0.1872P AD=0.0432P
+ PS=1.4U PD=0.6U
* device instance $1254 r0 *1 8.35,12.865 pfet
M$1254 VDD$1 \$326 \$366 VDD$1 pfet L=0.5U W=0.36U AS=0.0432P AD=0.1044P
+ PS=0.6U PD=0.94U
* device instance $1255 r0 *1 9.43,12.865 pfet
M$1255 \$326 \$325 VDD$1 VDD$1 pfet L=0.5U W=0.36U AS=0.1044P AD=0.1791P
+ PS=0.94U PD=1.355U
* device instance $1256 r0 *1 10.925,12.865 pfet
M$1256 \$328 \$324 \$326 VDD$1 pfet L=0.5U W=0.36U AS=0.1791P AD=0.1665P
+ PS=1.355U PD=1.285U
* device instance $1257 r0 *1 12.35,12.865 pfet
M$1257 \$368 \$327 \$328 VDD$1 pfet L=0.5U W=0.36U AS=0.1665P AD=0.0504P
+ PS=1.285U PD=0.64U
* device instance $1258 r0 *1 13.13,12.865 pfet
M$1258 \$368 \$329 VDD$1 VDD$1 pfet L=0.5U W=0.36U AS=0.23P AD=0.0504P PS=1.54U
+ PD=0.64U
* device instance $1259 r0 *1 14.37,12.645 pfet
M$1259 \$329 \$328 VDD$1 VDD$1 pfet L=0.5U W=0.8U AS=0.23P AD=0.352P PS=1.54U
+ PD=2.48U
* device instance $1260 r0 *1 9.37,18.4725 pfet
M$1260 VDD$2 clknet_2_0__leaf_clk \$409 VDD$2 pfet L=0.5U W=0.865U AS=0.3806P
+ AD=0.2249P PS=2.61U PD=1.385U
* device instance $1261 r0 *1 10.39,18.4725 pfet
M$1261 \$410 \$409 VDD$2 VDD$2 pfet L=0.5U W=0.865U AS=0.2249P AD=0.3806P
+ PS=1.385U PD=2.61U
* device instance $1262 r0 *1 23.39,18.65 pfet
M$1262 q2 \$415 VDD$2 VDD$2 pfet L=0.5U W=1.22U AS=0.5368P AD=0.5368P PS=3.32U
+ PD=3.32U
* device instance $1263 r0 *1 31.67,18.65 pfet
M$1263 \_043_ ph[12] VDD$2 VDD$2 pfet L=0.5U W=1.22U AS=0.5368P AD=0.5368P
+ PS=3.32U PD=3.32U
* device instance $1264 r0 *1 35.13,18.4725 pfet
M$1264 VDD$2 clknet_2_0__leaf_clk \$417 VDD$2 pfet L=0.5U W=0.865U AS=0.3806P
+ AD=0.2249P PS=2.61U PD=1.385U
* device instance $1265 r0 *1 36.15,18.4725 pfet
M$1265 \$418 \$417 VDD$2 VDD$2 pfet L=0.5U W=0.865U AS=0.2249P AD=0.3806P
+ PS=1.385U PD=2.61U
* device instance $1266 r0 *1 49.15,18.65 pfet
M$1266 eng1 \$422 VDD$2 VDD$2 pfet L=0.5U W=1.22U AS=0.5368P AD=0.5368P
+ PS=3.32U PD=3.32U
* device instance $1267 r0 *1 56.41,18.65 pfet
M$1267 VDD$2 \$400 \_013_ VDD$2 pfet L=0.5U W=1.22U AS=0.5368P AD=0.4298375P
+ PS=3.32U PD=2.185U
* device instance $1268 r0 *1 57.875,18.9525 pfet
M$1268 \$500 q0 VDD$2 VDD$2 pfet L=0.5U W=0.615U AS=0.4298375P AD=0.0845625P
+ PS=2.185U PD=0.89U
* device instance $1269 r0 *1 58.65,18.9525 pfet
M$1269 \$400 \$401 \$500 VDD$2 pfet L=0.5U W=0.615U AS=0.0845625P AD=0.1599P
+ PS=0.89U PD=1.135U
* device instance $1270 r0 *1 59.67,18.9525 pfet
M$1270 \$501 ph[14] \$400 VDD$2 pfet L=0.5U W=0.615U AS=0.1599P AD=0.0738P
+ PS=1.135U PD=0.855U
* device instance $1271 r0 *1 60.41,18.9525 pfet
M$1271 VDD$2 c0_r \$501 VDD$2 pfet L=0.5U W=0.615U AS=0.0738P AD=0.1599P
+ PS=0.855U PD=1.135U
* device instance $1272 r0 *1 61.43,18.9525 pfet
M$1272 \$401 ph[14] VDD$2 VDD$2 pfet L=0.5U W=0.615U AS=0.1599P AD=0.2706P
+ PS=1.135U PD=2.11U
* device instance $1273 r0 *1 72.55,18.65 pfet
M$1273 \$502 \_040_ VDD$2 VDD$2 pfet L=0.5U W=1.22U AS=0.5368P AD=0.4087P
+ PS=3.32U PD=1.89U
* device instance $1274 r0 *1 73.72,18.65 pfet
M$1274 sel_lo_n_128p q8 \$502 VDD$2 pfet L=0.5U W=1.22U AS=0.4087P AD=0.5368P
+ PS=1.89U PD=3.32U
* device instance $1275 r0 *1 79.27,18.65 pfet
M$1275 \_040_ eng8 VDD$2 VDD$2 pfet L=0.5U W=1.22U AS=0.5368P AD=0.5368P
+ PS=3.32U PD=3.32U
* device instance $1276 r0 *1 81.61,18.65 pfet
M$1276 VDD$2 \$404 \_011_ VDD$2 pfet L=0.5U W=1.22U AS=0.5368P AD=0.4298375P
+ PS=3.32U PD=2.185U
* device instance $1277 r0 *1 83.075,18.9525 pfet
M$1277 \$503 q9 VDD$2 VDD$2 pfet L=0.5U W=0.615U AS=0.4298375P AD=0.0845625P
+ PS=2.185U PD=0.89U
* device instance $1278 r0 *1 83.85,18.9525 pfet
M$1278 \$404 \$405 \$503 VDD$2 pfet L=0.5U W=0.615U AS=0.0845625P AD=0.1599P
+ PS=0.89U PD=1.135U
* device instance $1279 r0 *1 84.87,18.9525 pfet
M$1279 \$504 ph[14] \$404 VDD$2 pfet L=0.5U W=0.615U AS=0.1599P AD=0.0738P
+ PS=1.135U PD=0.855U
* device instance $1280 r0 *1 85.61,18.9525 pfet
M$1280 VDD$2 c9_r \$504 VDD$2 pfet L=0.5U W=0.615U AS=0.0738P AD=0.1599P
+ PS=0.855U PD=1.135U
* device instance $1281 r0 *1 86.63,18.9525 pfet
M$1281 \$405 ph[14] VDD$2 VDD$2 pfet L=0.5U W=0.615U AS=0.1599P AD=0.2706P
+ PS=1.135U PD=2.11U
* device instance $1282 r0 *1 87.77,12.8875 pfet
M$1282 VDD$1 clknet_2_0__leaf_clk \$338 VDD$1 pfet L=0.5U W=0.865U AS=0.3806P
+ AD=0.2249P PS=2.61U PD=1.385U
* device instance $1283 r0 *1 88.79,12.8875 pfet
M$1283 \$341 \$338 VDD$1 VDD$1 pfet L=0.5U W=0.865U AS=0.2249P AD=0.3806P
+ PS=1.385U PD=2.61U
* device instance $1284 r0 *1 88.89,18.65 pfet
M$1284 VDD$2 \$406 \_016_ VDD$2 pfet L=0.5U W=1.22U AS=0.5368P AD=0.4298375P
+ PS=3.32U PD=2.185U
* device instance $1285 r0 *1 90.355,18.9525 pfet
M$1285 \$505 q2 VDD$2 VDD$2 pfet L=0.5U W=0.615U AS=0.4298375P AD=0.0845625P
+ PS=2.185U PD=0.89U
* device instance $1286 r0 *1 91.13,18.9525 pfet
M$1286 \$406 \$407 \$505 VDD$2 pfet L=0.5U W=0.615U AS=0.0845625P AD=0.1599P
+ PS=0.89U PD=1.135U
* device instance $1287 r0 *1 92.15,18.9525 pfet
M$1287 \$506 ph[14] \$406 VDD$2 pfet L=0.5U W=0.615U AS=0.1599P AD=0.0738P
+ PS=1.135U PD=0.855U
* device instance $1288 r0 *1 92.89,18.9525 pfet
M$1288 VDD$2 c2_r \$506 VDD$2 pfet L=0.5U W=0.615U AS=0.0738P AD=0.1599P
+ PS=0.855U PD=1.135U
* device instance $1289 r0 *1 93.91,18.9525 pfet
M$1289 \$407 ph[14] VDD$2 VDD$2 pfet L=0.5U W=0.615U AS=0.1599P AD=0.2706P
+ PS=1.135U PD=2.11U
* device instance $1290 r0 *1 90.95,12.865 pfet
M$1290 \$377 \$341 VDD$1 VDD$1 pfet L=0.5U W=0.36U AS=0.4554P AD=0.054P
+ PS=3.25U PD=0.66U
* device instance $1291 r0 *1 91.75,12.865 pfet
M$1291 \$339 \_024_ \$377 VDD$1 pfet L=0.5U W=0.36U AS=0.054P AD=0.1872P
+ PS=0.66U PD=1.4U
* device instance $1292 r0 *1 93.29,12.865 pfet
M$1292 \$378 \$338 \$339 VDD$1 pfet L=0.5U W=0.36U AS=0.1872P AD=0.0432P
+ PS=1.4U PD=0.6U
* device instance $1293 r0 *1 94.03,12.865 pfet
M$1293 VDD$1 \$340 \$378 VDD$1 pfet L=0.5U W=0.36U AS=0.0432P AD=0.1044P
+ PS=0.6U PD=0.94U
* device instance $1294 r0 *1 95.11,12.865 pfet
M$1294 \$340 \$339 VDD$1 VDD$1 pfet L=0.5U W=0.36U AS=0.1044P AD=0.1791P
+ PS=0.94U PD=1.355U
* device instance $1295 r0 *1 96.605,12.865 pfet
M$1295 \$342 \$338 \$340 VDD$1 pfet L=0.5U W=0.36U AS=0.1791P AD=0.1665P
+ PS=1.355U PD=1.285U
* device instance $1296 r0 *1 98.03,12.865 pfet
M$1296 \$379 \$341 \$342 VDD$1 pfet L=0.5U W=0.36U AS=0.1665P AD=0.0504P
+ PS=1.285U PD=0.64U
* device instance $1297 r0 *1 98.81,12.865 pfet
M$1297 \$379 \$343 VDD$1 VDD$1 pfet L=0.5U W=0.36U AS=0.23P AD=0.0504P PS=1.54U
+ PD=0.64U
* device instance $1298 r0 *1 100.05,12.645 pfet
M$1298 \$343 \$342 VDD$1 VDD$1 pfet L=0.5U W=0.8U AS=0.23P AD=0.352P PS=1.54U
+ PD=2.48U
* device instance $1299 r0 *1 104.01,18.4725 pfet
M$1299 VDD$2 clknet_2_2__leaf_clk \$428 VDD$2 pfet L=0.5U W=0.865U AS=0.3806P
+ AD=0.2249P PS=2.61U PD=1.385U
* device instance $1300 r0 *1 105.03,18.4725 pfet
M$1300 \$429 \$428 VDD$2 VDD$2 pfet L=0.5U W=0.865U AS=0.2249P AD=0.3806P
+ PS=1.385U PD=2.61U
* device instance $1301 r0 *1 118.03,18.65 pfet
M$1301 c1_r \$434 VDD$2 VDD$2 pfet L=0.5U W=1.22U AS=0.5368P AD=0.5368P
+ PS=3.32U PD=3.32U
* device instance $1302 r0 *1 120.15,18.65 pfet
M$1302 \_037_ eng5 VDD$2 VDD$2 pfet L=0.5U W=1.22U AS=0.5368P AD=0.5368P
+ PS=3.32U PD=3.32U
* device instance $1303 r0 *1 128.09,18.4725 pfet
M$1303 VDD$2 clknet_2_2__leaf_clk \$435 VDD$2 pfet L=0.5U W=0.865U AS=0.3806P
+ AD=0.2249P PS=2.61U PD=1.385U
* device instance $1304 r0 *1 129.11,18.4725 pfet
M$1304 \$436 \$435 VDD$2 VDD$2 pfet L=0.5U W=0.865U AS=0.2249P AD=0.3806P
+ PS=1.385U PD=2.61U
* device instance $1305 r0 *1 142.11,18.65 pfet
M$1305 eng5 \$441 VDD$2 VDD$2 pfet L=0.5U W=1.22U AS=0.5368P AD=0.5368P
+ PS=3.32U PD=3.32U
* device instance $1306 r0 *1 144.89,18.4725 pfet
M$1306 VDD$2 clknet_2_3__leaf_clk \$442 VDD$2 pfet L=0.5U W=0.865U AS=0.3806P
+ AD=0.2249P PS=2.61U PD=1.385U
* device instance $1307 r0 *1 145.91,18.4725 pfet
M$1307 \$444 \$442 VDD$2 VDD$2 pfet L=0.5U W=0.865U AS=0.2249P AD=0.3806P
+ PS=1.385U PD=2.61U
* device instance $1308 r0 *1 158.91,18.65 pfet
M$1308 ph[6] \$448 VDD$2 VDD$2 pfet L=0.5U W=1.22U AS=0.5368P AD=0.5368P
+ PS=3.32U PD=3.32U
* device instance $1309 r0 *1 162.15,18.6475 pfet
M$1309 \_014_ cmp \$485 VDD$2 pfet L=0.5U W=1.215U AS=0.5346P AD=0.3159P
+ PS=3.31U PD=1.735U
* device instance $1310 r0 *1 163.17,18.6475 pfet
M$1310 \$485 ph[7] \_014_ VDD$2 pfet L=0.5U W=1.215U AS=0.3159P AD=0.44955P
+ PS=1.735U PD=1.955U
* device instance $1311 r0 *1 164.41,18.6475 pfet
M$1311 VDD$2 \_056_ \$485 VDD$2 pfet L=0.5U W=1.215U AS=0.44955P AD=0.5346P
+ PS=1.955U PD=3.31U
* device instance $1312 r0 *1 174.01,18.4725 pfet
M$1312 VDD$2 clknet_2_2__leaf_clk \$450 VDD$2 pfet L=0.5U W=0.865U AS=0.3806P
+ AD=0.2249P PS=2.61U PD=1.385U
* device instance $1313 r0 *1 175.03,18.4725 pfet
M$1313 \$451 \$450 VDD$2 VDD$2 pfet L=0.5U W=0.865U AS=0.2249P AD=0.3806P
+ PS=1.385U PD=2.61U
* device instance $1314 r0 *1 176.25,12.8875 pfet
M$1314 VDD$1 clknet_2_2__leaf_clk \$349 VDD$1 pfet L=0.5U W=0.865U AS=0.3806P
+ AD=0.2249P PS=2.61U PD=1.385U
* device instance $1315 r0 *1 177.27,12.8875 pfet
M$1315 \$352 \$349 VDD$1 VDD$1 pfet L=0.5U W=0.865U AS=0.2249P AD=0.3806P
+ PS=1.385U PD=2.61U
* device instance $1316 r0 *1 179.43,12.865 pfet
M$1316 \$370 \$352 VDD$1 VDD$1 pfet L=0.5U W=0.36U AS=0.4554P AD=0.054P
+ PS=3.25U PD=0.66U
* device instance $1317 r0 *1 180.23,12.865 pfet
M$1317 \$350 \_026_ \$370 VDD$1 pfet L=0.5U W=0.36U AS=0.054P AD=0.1872P
+ PS=0.66U PD=1.4U
* device instance $1318 r0 *1 181.77,12.865 pfet
M$1318 \$369 \$349 \$350 VDD$1 pfet L=0.5U W=0.36U AS=0.1872P AD=0.0432P
+ PS=1.4U PD=0.6U
* device instance $1319 r0 *1 182.51,12.865 pfet
M$1319 VDD$1 \$351 \$369 VDD$1 pfet L=0.5U W=0.36U AS=0.0432P AD=0.1044P
+ PS=0.6U PD=0.94U
* device instance $1320 r0 *1 183.59,12.865 pfet
M$1320 \$351 \$350 VDD$1 VDD$1 pfet L=0.5U W=0.36U AS=0.1044P AD=0.1791P
+ PS=0.94U PD=1.355U
* device instance $1321 r0 *1 185.085,12.865 pfet
M$1321 \$353 \$349 \$351 VDD$1 pfet L=0.5U W=0.36U AS=0.1791P AD=0.1665P
+ PS=1.355U PD=1.285U
* device instance $1322 r0 *1 186.51,12.865 pfet
M$1322 \$367 \$352 \$353 VDD$1 pfet L=0.5U W=0.36U AS=0.1665P AD=0.0504P
+ PS=1.285U PD=0.64U
* device instance $1323 r0 *1 187.29,12.865 pfet
M$1323 \$367 \$354 VDD$1 VDD$1 pfet L=0.5U W=0.36U AS=0.23P AD=0.0504P PS=1.54U
+ PD=0.64U
* device instance $1324 r0 *1 188.53,12.645 pfet
M$1324 \$354 \$353 VDD$1 VDD$1 pfet L=0.5U W=0.8U AS=0.23P AD=0.352P PS=1.54U
+ PD=2.48U
* device instance $1325 r0 *1 188.03,18.65 pfet
M$1325 q8 \$456 VDD$2 VDD$2 pfet L=0.5U W=1.22U AS=0.5368P AD=0.5368P PS=3.32U
+ PD=3.32U
* device instance $1326 r0 *1 190.15,18.65 pfet
M$1326 \$490 start VDD$2 VDD$2 pfet L=0.5U W=1.22U AS=0.5368P AD=0.4087P
+ PS=3.32U PD=1.89U
* device instance $1327 r0 *1 191.32,18.65 pfet
M$1327 \_009_[4] \_035_ \$490 VDD$2 pfet L=0.5U W=1.22U AS=0.4087P AD=0.5368P
+ PS=1.89U PD=3.32U
* device instance $1328 r0 *1 12.55,18.495 pfet
M$1328 \$489 \$410 VDD$2 VDD$2 pfet L=0.5U W=0.36U AS=0.4554P AD=0.054P
+ PS=3.25U PD=0.66U
* device instance $1329 r0 *1 13.35,18.495 pfet
M$1329 \$412 \_017_ \$489 VDD$2 pfet L=0.5U W=0.36U AS=0.054P AD=0.1872P
+ PS=0.66U PD=1.4U
* device instance $1330 r0 *1 14.89,18.495 pfet
M$1330 \$491 \$409 \$412 VDD$2 pfet L=0.5U W=0.36U AS=0.1872P AD=0.0432P
+ PS=1.4U PD=0.6U
* device instance $1331 r0 *1 15.63,18.495 pfet
M$1331 VDD$2 \$413 \$491 VDD$2 pfet L=0.5U W=0.36U AS=0.0432P AD=0.1044P
+ PS=0.6U PD=0.94U
* device instance $1332 r0 *1 16.71,18.495 pfet
M$1332 \$413 \$412 VDD$2 VDD$2 pfet L=0.5U W=0.36U AS=0.1044P AD=0.1791P
+ PS=0.94U PD=1.355U
* device instance $1333 r0 *1 18.205,18.495 pfet
M$1333 \$414 \$409 \$413 VDD$2 pfet L=0.5U W=0.36U AS=0.1791P AD=0.1665P
+ PS=1.355U PD=1.285U
* device instance $1334 r0 *1 19.63,18.495 pfet
M$1334 \$493 \$410 \$414 VDD$2 pfet L=0.5U W=0.36U AS=0.1665P AD=0.0504P
+ PS=1.285U PD=0.64U
* device instance $1335 r0 *1 20.41,18.495 pfet
M$1335 VDD$2 \$415 \$493 VDD$2 pfet L=0.5U W=0.36U AS=0.0504P AD=0.23P PS=0.64U
+ PD=1.54U
* device instance $1336 r0 *1 21.65,18.715 pfet
M$1336 \$415 \$414 VDD$2 VDD$2 pfet L=0.5U W=0.8U AS=0.23P AD=0.352P PS=1.54U
+ PD=2.48U
* device instance $1337 r0 *1 38.31,18.495 pfet
M$1337 \$495 \$418 VDD$2 VDD$2 pfet L=0.5U W=0.36U AS=0.4554P AD=0.054P
+ PS=3.25U PD=0.66U
* device instance $1338 r0 *1 39.11,18.495 pfet
M$1338 \$419 \_000_ \$495 VDD$2 pfet L=0.5U W=0.36U AS=0.054P AD=0.1872P
+ PS=0.66U PD=1.4U
* device instance $1339 r0 *1 40.65,18.495 pfet
M$1339 \$496 \$417 \$419 VDD$2 pfet L=0.5U W=0.36U AS=0.1872P AD=0.0432P
+ PS=1.4U PD=0.6U
* device instance $1340 r0 *1 41.39,18.495 pfet
M$1340 VDD$2 \$420 \$496 VDD$2 pfet L=0.5U W=0.36U AS=0.0432P AD=0.1044P
+ PS=0.6U PD=0.94U
* device instance $1341 r0 *1 42.47,18.495 pfet
M$1341 \$420 \$419 VDD$2 VDD$2 pfet L=0.5U W=0.36U AS=0.1044P AD=0.1791P
+ PS=0.94U PD=1.355U
* device instance $1342 r0 *1 43.965,18.495 pfet
M$1342 \$421 \$417 \$420 VDD$2 pfet L=0.5U W=0.36U AS=0.1791P AD=0.1665P
+ PS=1.355U PD=1.285U
* device instance $1343 r0 *1 45.39,18.495 pfet
M$1343 \$497 \$418 \$421 VDD$2 pfet L=0.5U W=0.36U AS=0.1665P AD=0.0504P
+ PS=1.285U PD=0.64U
* device instance $1344 r0 *1 46.17,18.495 pfet
M$1344 VDD$2 \$422 \$497 VDD$2 pfet L=0.5U W=0.36U AS=0.0504P AD=0.23P PS=0.64U
+ PD=1.54U
* device instance $1345 r0 *1 47.41,18.715 pfet
M$1345 \$422 \$421 VDD$2 VDD$2 pfet L=0.5U W=0.8U AS=0.23P AD=0.352P PS=1.54U
+ PD=2.48U
* device instance $1346 r0 *1 107.19,18.495 pfet
M$1346 \$507 \$429 VDD$2 VDD$2 pfet L=0.5U W=0.36U AS=0.4554P AD=0.054P
+ PS=3.25U PD=0.66U
* device instance $1347 r0 *1 107.99,18.495 pfet
M$1347 \$431 \_015_ \$507 VDD$2 pfet L=0.5U W=0.36U AS=0.054P AD=0.1872P
+ PS=0.66U PD=1.4U
* device instance $1348 r0 *1 109.53,18.495 pfet
M$1348 \$508 \$428 \$431 VDD$2 pfet L=0.5U W=0.36U AS=0.1872P AD=0.0432P
+ PS=1.4U PD=0.6U
* device instance $1349 r0 *1 110.27,18.495 pfet
M$1349 VDD$2 \$432 \$508 VDD$2 pfet L=0.5U W=0.36U AS=0.0432P AD=0.1044P
+ PS=0.6U PD=0.94U
* device instance $1350 r0 *1 111.35,18.495 pfet
M$1350 \$432 \$431 VDD$2 VDD$2 pfet L=0.5U W=0.36U AS=0.1044P AD=0.1791P
+ PS=0.94U PD=1.355U
* device instance $1351 r0 *1 112.845,18.495 pfet
M$1351 \$433 \$428 \$432 VDD$2 pfet L=0.5U W=0.36U AS=0.1791P AD=0.1665P
+ PS=1.355U PD=1.285U
* device instance $1352 r0 *1 114.27,18.495 pfet
M$1352 \$509 \$429 \$433 VDD$2 pfet L=0.5U W=0.36U AS=0.1665P AD=0.0504P
+ PS=1.285U PD=0.64U
* device instance $1353 r0 *1 115.05,18.495 pfet
M$1353 VDD$2 \$434 \$509 VDD$2 pfet L=0.5U W=0.36U AS=0.0504P AD=0.23P PS=0.64U
+ PD=1.54U
* device instance $1354 r0 *1 116.29,18.715 pfet
M$1354 \$434 \$433 VDD$2 VDD$2 pfet L=0.5U W=0.8U AS=0.23P AD=0.352P PS=1.54U
+ PD=2.48U
* device instance $1355 r0 *1 131.27,18.495 pfet
M$1355 \$511 \$436 VDD$2 VDD$2 pfet L=0.5U W=0.36U AS=0.4554P AD=0.054P
+ PS=3.25U PD=0.66U
* device instance $1356 r0 *1 132.07,18.495 pfet
M$1356 \$438 \_004_ \$511 VDD$2 pfet L=0.5U W=0.36U AS=0.054P AD=0.1872P
+ PS=0.66U PD=1.4U
* device instance $1357 r0 *1 133.61,18.495 pfet
M$1357 \$513 \$435 \$438 VDD$2 pfet L=0.5U W=0.36U AS=0.1872P AD=0.0432P
+ PS=1.4U PD=0.6U
* device instance $1358 r0 *1 134.35,18.495 pfet
M$1358 VDD$2 \$439 \$513 VDD$2 pfet L=0.5U W=0.36U AS=0.0432P AD=0.1044P
+ PS=0.6U PD=0.94U
* device instance $1359 r0 *1 135.43,18.495 pfet
M$1359 \$439 \$438 VDD$2 VDD$2 pfet L=0.5U W=0.36U AS=0.1044P AD=0.1791P
+ PS=0.94U PD=1.355U
* device instance $1360 r0 *1 136.925,18.495 pfet
M$1360 \$440 \$435 \$439 VDD$2 pfet L=0.5U W=0.36U AS=0.1791P AD=0.1665P
+ PS=1.355U PD=1.285U
* device instance $1361 r0 *1 138.35,18.495 pfet
M$1361 \$515 \$436 \$440 VDD$2 pfet L=0.5U W=0.36U AS=0.1665P AD=0.0504P
+ PS=1.285U PD=0.64U
* device instance $1362 r0 *1 139.13,18.495 pfet
M$1362 VDD$2 \$441 \$515 VDD$2 pfet L=0.5U W=0.36U AS=0.0504P AD=0.23P PS=0.64U
+ PD=1.54U
* device instance $1363 r0 *1 140.37,18.715 pfet
M$1363 \$441 \$440 VDD$2 VDD$2 pfet L=0.5U W=0.8U AS=0.23P AD=0.352P PS=1.54U
+ PD=2.48U
* device instance $1364 r0 *1 148.07,18.495 pfet
M$1364 \$514 \$444 VDD$2 VDD$2 pfet L=0.5U W=0.36U AS=0.4554P AD=0.054P
+ PS=3.25U PD=0.66U
* device instance $1365 r0 *1 148.87,18.495 pfet
M$1365 \$445 \_009_[6] \$514 VDD$2 pfet L=0.5U W=0.36U AS=0.054P AD=0.1872P
+ PS=0.66U PD=1.4U
* device instance $1366 r0 *1 150.41,18.495 pfet
M$1366 \$512 \$442 \$445 VDD$2 pfet L=0.5U W=0.36U AS=0.1872P AD=0.0432P
+ PS=1.4U PD=0.6U
* device instance $1367 r0 *1 151.15,18.495 pfet
M$1367 VDD$2 \$446 \$512 VDD$2 pfet L=0.5U W=0.36U AS=0.0432P AD=0.1044P
+ PS=0.6U PD=0.94U
* device instance $1368 r0 *1 152.23,18.495 pfet
M$1368 \$446 \$445 VDD$2 VDD$2 pfet L=0.5U W=0.36U AS=0.1044P AD=0.1791P
+ PS=0.94U PD=1.355U
* device instance $1369 r0 *1 153.725,18.495 pfet
M$1369 \$447 \$442 \$446 VDD$2 pfet L=0.5U W=0.36U AS=0.1791P AD=0.1665P
+ PS=1.355U PD=1.285U
* device instance $1370 r0 *1 155.15,18.495 pfet
M$1370 \$510 \$444 \$447 VDD$2 pfet L=0.5U W=0.36U AS=0.1665P AD=0.0504P
+ PS=1.285U PD=0.64U
* device instance $1371 r0 *1 155.93,18.495 pfet
M$1371 VDD$2 \$448 \$510 VDD$2 pfet L=0.5U W=0.36U AS=0.0504P AD=0.23P PS=0.64U
+ PD=1.54U
* device instance $1372 r0 *1 157.17,18.715 pfet
M$1372 \$448 \$447 VDD$2 VDD$2 pfet L=0.5U W=0.8U AS=0.23P AD=0.352P PS=1.54U
+ PD=2.48U
* device instance $1373 r0 *1 177.19,18.495 pfet
M$1373 \$499 \$451 VDD$2 VDD$2 pfet L=0.5U W=0.36U AS=0.4554P AD=0.054P
+ PS=3.25U PD=0.66U
* device instance $1374 r0 *1 177.99,18.495 pfet
M$1374 \$453 \_022_ \$499 VDD$2 pfet L=0.5U W=0.36U AS=0.054P AD=0.1872P
+ PS=0.66U PD=1.4U
* device instance $1375 r0 *1 179.53,18.495 pfet
M$1375 \$498 \$450 \$453 VDD$2 pfet L=0.5U W=0.36U AS=0.1872P AD=0.0432P
+ PS=1.4U PD=0.6U
* device instance $1376 r0 *1 180.27,18.495 pfet
M$1376 VDD$2 \$454 \$498 VDD$2 pfet L=0.5U W=0.36U AS=0.0432P AD=0.1044P
+ PS=0.6U PD=0.94U
* device instance $1377 r0 *1 181.35,18.495 pfet
M$1377 \$454 \$453 VDD$2 VDD$2 pfet L=0.5U W=0.36U AS=0.1044P AD=0.1791P
+ PS=0.94U PD=1.355U
* device instance $1378 r0 *1 182.845,18.495 pfet
M$1378 \$455 \$450 \$454 VDD$2 pfet L=0.5U W=0.36U AS=0.1791P AD=0.1665P
+ PS=1.355U PD=1.285U
* device instance $1379 r0 *1 184.27,18.495 pfet
M$1379 \$494 \$451 \$455 VDD$2 pfet L=0.5U W=0.36U AS=0.1665P AD=0.0504P
+ PS=1.285U PD=0.64U
* device instance $1380 r0 *1 185.05,18.495 pfet
M$1380 VDD$2 \$456 \$494 VDD$2 pfet L=0.5U W=0.36U AS=0.0504P AD=0.23P PS=0.64U
+ PD=1.54U
* device instance $1381 r0 *1 186.29,18.715 pfet
M$1381 \$456 \$455 VDD$2 VDD$2 pfet L=0.5U W=0.8U AS=0.23P AD=0.352P PS=1.54U
+ PD=2.48U
* device instance $1382 r0 *1 9.83,20.5525 pfet
M$1382 \_025_ cmp \$516 VDD$2 pfet L=0.5U W=1.215U AS=0.5346P AD=0.3159P
+ PS=3.31U PD=1.735U
* device instance $1383 r0 *1 10.85,20.5525 pfet
M$1383 \$516 ph[9] \_025_ VDD$2 pfet L=0.5U W=1.215U AS=0.3159P AD=0.44955P
+ PS=1.735U PD=1.955U
* device instance $1384 r0 *1 12.09,20.5525 pfet
M$1384 VDD$2 \_062_ \$516 VDD$2 pfet L=0.5U W=1.215U AS=0.44955P AD=0.5346P
+ PS=1.955U PD=3.31U
* device instance $1385 r0 *1 14.31,20.55 pfet
M$1385 \_048_ ph[9] VDD$2 VDD$2 pfet L=0.5U W=1.22U AS=0.5368P AD=0.5368P
+ PS=3.32U PD=3.32U
* device instance $1386 r0 *1 16.55,20.55 pfet
M$1386 \$568 start VDD$2 VDD$2 pfet L=0.5U W=1.22U AS=0.5368P AD=0.4087P
+ PS=3.32U PD=1.89U
* device instance $1387 r0 *1 17.72,20.55 pfet
M$1387 \_009_[12] \_046_ \$568 VDD$2 pfet L=0.5U W=1.22U AS=0.4087P AD=0.5368P
+ PS=1.89U PD=3.32U
* device instance $1388 r0 *1 30.09,20.7275 pfet
M$1388 VDD$2 clknet_2_0__leaf_clk \$517 VDD$2 pfet L=0.5U W=0.865U AS=0.3806P
+ AD=0.2249P PS=2.61U PD=1.385U
* device instance $1389 r0 *1 31.11,20.7275 pfet
M$1389 \$519 \$517 VDD$2 VDD$2 pfet L=0.5U W=0.865U AS=0.2249P AD=0.3806P
+ PS=1.385U PD=2.61U
* device instance $1390 r0 *1 33.27,20.705 pfet
M$1390 \$570 \$519 VDD$2 VDD$2 pfet L=0.5U W=0.36U AS=0.4554P AD=0.054P
+ PS=3.25U PD=0.66U
* device instance $1391 r0 *1 34.07,20.705 pfet
M$1391 \$549 \_003_ \$570 VDD$2 pfet L=0.5U W=0.36U AS=0.054P AD=0.1872P
+ PS=0.66U PD=1.4U
* device instance $1392 r0 *1 35.61,20.705 pfet
M$1392 \$571 \$517 \$549 VDD$2 pfet L=0.5U W=0.36U AS=0.1872P AD=0.0432P
+ PS=1.4U PD=0.6U
* device instance $1393 r0 *1 36.35,20.705 pfet
M$1393 VDD$2 \$518 \$571 VDD$2 pfet L=0.5U W=0.36U AS=0.0432P AD=0.1044P
+ PS=0.6U PD=0.94U
* device instance $1394 r0 *1 37.43,20.705 pfet
M$1394 \$518 \$549 VDD$2 VDD$2 pfet L=0.5U W=0.36U AS=0.1044P AD=0.1791P
+ PS=0.94U PD=1.355U
* device instance $1395 r0 *1 38.925,20.705 pfet
M$1395 \$550 \$517 \$518 VDD$2 pfet L=0.5U W=0.36U AS=0.1791P AD=0.1665P
+ PS=1.355U PD=1.285U
* device instance $1396 r0 *1 40.35,20.705 pfet
M$1396 \$573 \$519 \$550 VDD$2 pfet L=0.5U W=0.36U AS=0.1665P AD=0.0504P
+ PS=1.285U PD=0.64U
* device instance $1397 r0 *1 41.13,20.705 pfet
M$1397 \$573 \$520 VDD$2 VDD$2 pfet L=0.5U W=0.36U AS=0.23P AD=0.0504P PS=1.54U
+ PD=0.64U
* device instance $1398 r0 *1 42.37,20.485 pfet
M$1398 \$520 \$550 VDD$2 VDD$2 pfet L=0.5U W=0.8U AS=0.23P AD=0.352P PS=1.54U
+ PD=2.48U
* device instance $1399 r0 *1 44.11,20.55 pfet
M$1399 eng4 \$520 VDD$2 VDD$2 pfet L=0.5U W=1.22U AS=0.5368P AD=0.5368P
+ PS=3.32U PD=3.32U
* device instance $1400 r0 *1 46.23,20.55 pfet
M$1400 \$521 clknet_0_clk VDD$2 VDD$2 pfet L=0.5U W=1.22U AS=0.5368P AD=0.3782P
+ PS=3.32U PD=1.84U
* device instance $1401 r0 *1 47.35,20.55 pfet
M$1401 VDD$2 clknet_0_clk \$521 VDD$2 pfet L=0.5U W=1.22U AS=0.3782P AD=0.3782P
+ PS=1.84U PD=1.84U
* device instance $1402 r0 *1 48.47,20.55 pfet
M$1402 clknet_2_1__leaf_clk \$521 VDD$2 VDD$2 pfet L=0.5U W=1.22U AS=0.3782P
+ AD=0.3782P PS=1.84U PD=1.84U
* device instance $1403 r0 *1 49.59,20.55 pfet
M$1403 VDD$2 \$521 clknet_2_1__leaf_clk VDD$2 pfet L=0.5U W=1.22U AS=0.3782P
+ AD=0.3782P PS=1.84U PD=1.84U
* device instance $1404 r0 *1 50.71,20.55 pfet
M$1404 clknet_2_1__leaf_clk \$521 VDD$2 VDD$2 pfet L=0.5U W=1.22U AS=0.3782P
+ AD=0.3782P PS=1.84U PD=1.84U
* device instance $1405 r0 *1 51.83,20.55 pfet
M$1405 VDD$2 \$521 clknet_2_1__leaf_clk VDD$2 pfet L=0.5U W=1.22U AS=0.3782P
+ AD=0.5368P PS=1.84U PD=3.32U
* device instance $1406 r0 *1 56.41,20.7275 pfet
M$1406 VDD$2 clknet_2_1__leaf_clk \$523 VDD$2 pfet L=0.5U W=0.865U AS=0.3806P
+ AD=0.2249P PS=2.61U PD=1.385U
* device instance $1407 r0 *1 57.43,20.7275 pfet
M$1407 \$525 \$523 VDD$2 VDD$2 pfet L=0.5U W=0.865U AS=0.2249P AD=0.3806P
+ PS=1.385U PD=2.61U
* device instance $1408 r0 *1 59.59,20.705 pfet
M$1408 \$574 \$525 VDD$2 VDD$2 pfet L=0.5U W=0.36U AS=0.4554P AD=0.054P
+ PS=3.25U PD=0.66U
* device instance $1409 r0 *1 60.39,20.705 pfet
M$1409 \$552 \_023_ \$574 VDD$2 pfet L=0.5U W=0.36U AS=0.054P AD=0.1872P
+ PS=0.66U PD=1.4U
* device instance $1410 r0 *1 61.93,20.705 pfet
M$1410 \$575 \$523 \$552 VDD$2 pfet L=0.5U W=0.36U AS=0.1872P AD=0.0432P
+ PS=1.4U PD=0.6U
* device instance $1411 r0 *1 62.67,20.705 pfet
M$1411 VDD$2 \$524 \$575 VDD$2 pfet L=0.5U W=0.36U AS=0.0432P AD=0.1044P
+ PS=0.6U PD=0.94U
* device instance $1412 r0 *1 63.75,20.705 pfet
M$1412 \$524 \$552 VDD$2 VDD$2 pfet L=0.5U W=0.36U AS=0.1044P AD=0.1791P
+ PS=0.94U PD=1.355U
* device instance $1413 r0 *1 65.245,20.705 pfet
M$1413 \$554 \$523 \$524 VDD$2 pfet L=0.5U W=0.36U AS=0.1791P AD=0.1665P
+ PS=1.355U PD=1.285U
* device instance $1414 r0 *1 66.67,20.705 pfet
M$1414 \$577 \$525 \$554 VDD$2 pfet L=0.5U W=0.36U AS=0.1665P AD=0.0504P
+ PS=1.285U PD=0.64U
* device instance $1415 r0 *1 67.45,20.705 pfet
M$1415 \$577 \$526 VDD$2 VDD$2 pfet L=0.5U W=0.36U AS=0.23P AD=0.0504P PS=1.54U
+ PD=0.64U
* device instance $1416 r0 *1 68.69,20.485 pfet
M$1416 \$526 \$554 VDD$2 VDD$2 pfet L=0.5U W=0.8U AS=0.23P AD=0.352P PS=1.54U
+ PD=2.48U
* device instance $1417 r0 *1 63.59,18.955 pfet
M$1417 \$424 mode VDD$2 VDD$2 pfet L=0.5U W=0.6U AS=0.264P AD=0.156P PS=2.08U
+ PD=1.12U
* device instance $1418 r0 *1 64.61,18.955 pfet
M$1418 \$424 sel_hi_n_16p VDD$2 VDD$2 pfet L=0.5U W=0.6U AS=0.40575P AD=0.156P
+ PS=2.055U PD=1.12U
* device instance $1419 r0 *1 65.95,18.6475 pfet
M$1419 sel_lo_n_16n \$424 VDD$2 VDD$2 pfet L=0.5U W=1.215U AS=0.40575P
+ AD=0.5346P PS=2.055U PD=3.31U
* device instance $1420 r0 *1 70.43,20.55 pfet
M$1420 c4_r \$526 VDD$2 VDD$2 pfet L=0.5U W=1.22U AS=0.5368P AD=0.5368P
+ PS=3.32U PD=3.32U
* device instance $1421 r0 *1 84.97,20.7275 pfet
M$1421 VDD$2 clknet_2_0__leaf_clk \$527 VDD$2 pfet L=0.5U W=0.865U AS=0.3806P
+ AD=0.2249P PS=2.61U PD=1.385U
* device instance $1422 r0 *1 85.99,20.7275 pfet
M$1422 \$529 \$527 VDD$2 VDD$2 pfet L=0.5U W=0.865U AS=0.2249P AD=0.3806P
+ PS=1.385U PD=2.61U
* device instance $1423 r0 *1 88.15,20.705 pfet
M$1423 \$578 \$529 VDD$2 VDD$2 pfet L=0.5U W=0.36U AS=0.4554P AD=0.054P
+ PS=3.25U PD=0.66U
* device instance $1424 r0 *1 88.95,20.705 pfet
M$1424 \$555 \_007_ \$578 VDD$2 pfet L=0.5U W=0.36U AS=0.054P AD=0.1872P
+ PS=0.66U PD=1.4U
* device instance $1425 r0 *1 90.49,20.705 pfet
M$1425 \$580 \$527 \$555 VDD$2 pfet L=0.5U W=0.36U AS=0.1872P AD=0.0432P
+ PS=1.4U PD=0.6U
* device instance $1426 r0 *1 91.23,20.705 pfet
M$1426 VDD$2 \$528 \$580 VDD$2 pfet L=0.5U W=0.36U AS=0.0432P AD=0.1044P
+ PS=0.6U PD=0.94U
* device instance $1427 r0 *1 92.31,20.705 pfet
M$1427 \$528 \$555 VDD$2 VDD$2 pfet L=0.5U W=0.36U AS=0.1044P AD=0.1791P
+ PS=0.94U PD=1.355U
* device instance $1428 r0 *1 93.805,20.705 pfet
M$1428 \$556 \$527 \$528 VDD$2 pfet L=0.5U W=0.36U AS=0.1791P AD=0.1665P
+ PS=1.355U PD=1.285U
* device instance $1429 r0 *1 95.23,20.705 pfet
M$1429 \$582 \$529 \$556 VDD$2 pfet L=0.5U W=0.36U AS=0.1665P AD=0.0504P
+ PS=1.285U PD=0.64U
* device instance $1430 r0 *1 96.01,20.705 pfet
M$1430 \$582 \$530 VDD$2 VDD$2 pfet L=0.5U W=0.36U AS=0.23P AD=0.0504P PS=1.54U
+ PD=0.64U
* device instance $1431 r0 *1 97.25,20.485 pfet
M$1431 \$530 \$556 VDD$2 VDD$2 pfet L=0.5U W=0.8U AS=0.23P AD=0.352P PS=1.54U
+ PD=2.48U
* device instance $1432 r0 *1 98.99,20.55 pfet
M$1432 eng8 \$530 VDD$2 VDD$2 pfet L=0.5U W=1.22U AS=0.5368P AD=0.5368P
+ PS=3.32U PD=3.32U
* device instance $1433 r0 *1 109.05,20.7275 pfet
M$1433 VDD$2 clknet_2_3__leaf_clk \$531 VDD$2 pfet L=0.5U W=0.865U AS=0.3806P
+ AD=0.2249P PS=2.61U PD=1.385U
* device instance $1434 r0 *1 110.07,20.7275 pfet
M$1434 \$533 \$531 VDD$2 VDD$2 pfet L=0.5U W=0.865U AS=0.2249P AD=0.3806P
+ PS=1.385U PD=2.61U
* device instance $1435 r0 *1 112.23,20.705 pfet
M$1435 \$584 \$533 VDD$2 VDD$2 pfet L=0.5U W=0.36U AS=0.4554P AD=0.054P
+ PS=3.25U PD=0.66U
* device instance $1436 r0 *1 113.03,20.705 pfet
M$1436 \$558 \_027_ \$584 VDD$2 pfet L=0.5U W=0.36U AS=0.054P AD=0.1872P
+ PS=0.66U PD=1.4U
* device instance $1437 r0 *1 114.57,20.705 pfet
M$1437 \$585 \$531 \$558 VDD$2 pfet L=0.5U W=0.36U AS=0.1872P AD=0.0432P
+ PS=1.4U PD=0.6U
* device instance $1438 r0 *1 115.31,20.705 pfet
M$1438 VDD$2 \$532 \$585 VDD$2 pfet L=0.5U W=0.36U AS=0.0432P AD=0.1044P
+ PS=0.6U PD=0.94U
* device instance $1439 r0 *1 116.39,20.705 pfet
M$1439 \$532 \$558 VDD$2 VDD$2 pfet L=0.5U W=0.36U AS=0.1044P AD=0.1791P
+ PS=0.94U PD=1.355U
* device instance $1440 r0 *1 117.885,20.705 pfet
M$1440 \$559 \$531 \$532 VDD$2 pfet L=0.5U W=0.36U AS=0.1791P AD=0.1665P
+ PS=1.355U PD=1.285U
* device instance $1441 r0 *1 119.31,20.705 pfet
M$1441 \$586 \$533 \$559 VDD$2 pfet L=0.5U W=0.36U AS=0.1665P AD=0.0504P
+ PS=1.285U PD=0.64U
* device instance $1442 r0 *1 120.09,20.705 pfet
M$1442 \$586 \$534 VDD$2 VDD$2 pfet L=0.5U W=0.36U AS=0.23P AD=0.0504P PS=1.54U
+ PD=0.64U
* device instance $1443 r0 *1 121.33,20.485 pfet
M$1443 \$534 \$559 VDD$2 VDD$2 pfet L=0.5U W=0.8U AS=0.23P AD=0.352P PS=1.54U
+ PD=2.48U
* device instance $1444 r0 *1 123.07,20.55 pfet
M$1444 c6_r \$534 VDD$2 VDD$2 pfet L=0.5U W=1.22U AS=0.5368P AD=0.5368P
+ PS=3.32U PD=3.32U
* device instance $1445 r0 *1 130.79,20.5525 pfet
M$1445 \_007_ \_052_ \$535 VDD$2 pfet L=0.5U W=1.215U AS=0.5346P AD=0.3159P
+ PS=3.31U PD=1.735U
* device instance $1446 r0 *1 131.81,20.5525 pfet
M$1446 \$535 \_040_ \_007_ VDD$2 pfet L=0.5U W=1.215U AS=0.3159P AD=0.44955P
+ PS=1.735U PD=1.955U
* device instance $1447 r0 *1 133.05,20.5525 pfet
M$1447 VDD$2 ph[13] \$535 VDD$2 pfet L=0.5U W=1.215U AS=0.44955P AD=0.5346P
+ PS=1.955U PD=3.31U
* device instance $1448 r0 *1 135.27,20.55 pfet
M$1448 \_041_ eng9 VDD$2 VDD$2 pfet L=0.5U W=1.22U AS=0.5368P AD=0.5368P
+ PS=3.32U PD=3.32U
* device instance $1449 r0 *1 143.11,20.55 pfet
M$1449 \$536 clknet_0_clk VDD$2 VDD$2 pfet L=0.5U W=1.22U AS=0.5368P AD=0.3782P
+ PS=3.32U PD=1.84U
* device instance $1450 r0 *1 144.23,20.55 pfet
M$1450 VDD$2 clknet_0_clk \$536 VDD$2 pfet L=0.5U W=1.22U AS=0.3782P AD=0.3782P
+ PS=1.84U PD=1.84U
* device instance $1451 r0 *1 145.35,20.55 pfet
M$1451 clknet_2_2__leaf_clk \$536 VDD$2 VDD$2 pfet L=0.5U W=1.22U AS=0.3782P
+ AD=0.3782P PS=1.84U PD=1.84U
* device instance $1452 r0 *1 146.47,20.55 pfet
M$1452 VDD$2 \$536 clknet_2_2__leaf_clk VDD$2 pfet L=0.5U W=1.22U AS=0.3782P
+ AD=0.3782P PS=1.84U PD=1.84U
* device instance $1453 r0 *1 147.59,20.55 pfet
M$1453 clknet_2_2__leaf_clk \$536 VDD$2 VDD$2 pfet L=0.5U W=1.22U AS=0.3782P
+ AD=0.3782P PS=1.84U PD=1.84U
* device instance $1454 r0 *1 148.71,20.55 pfet
M$1454 VDD$2 \$536 clknet_2_2__leaf_clk VDD$2 pfet L=0.5U W=1.22U AS=0.3782P
+ AD=0.5368P PS=1.84U PD=3.32U
* device instance $1455 r0 *1 150.95,20.55 pfet
M$1455 \$587 start VDD$2 VDD$2 pfet L=0.5U W=1.22U AS=0.5368P AD=0.4087P
+ PS=3.32U PD=1.89U
* device instance $1456 r0 *1 152.12,20.55 pfet
M$1456 \_009_[8] \_050_ \$587 VDD$2 pfet L=0.5U W=1.22U AS=0.4087P AD=0.5368P
+ PS=1.89U PD=3.32U
* device instance $1457 r0 *1 154.31,20.55 pfet
M$1457 \_051_ ph[6] VDD$2 VDD$2 pfet L=0.5U W=1.22U AS=0.5368P AD=0.5368P
+ PS=3.32U PD=3.32U
* device instance $1458 r0 *1 156.65,20.7275 pfet
M$1458 VDD$2 clknet_2_3__leaf_clk \$538 VDD$2 pfet L=0.5U W=0.865U AS=0.3806P
+ AD=0.2249P PS=2.61U PD=1.385U
* device instance $1459 r0 *1 157.67,20.7275 pfet
M$1459 \$540 \$538 VDD$2 VDD$2 pfet L=0.5U W=0.865U AS=0.2249P AD=0.3806P
+ PS=1.385U PD=2.61U
* device instance $1460 r0 *1 159.83,20.705 pfet
M$1460 \$583 \$540 VDD$2 VDD$2 pfet L=0.5U W=0.36U AS=0.4554P AD=0.054P
+ PS=3.25U PD=0.66U
* device instance $1461 r0 *1 160.63,20.705 pfet
M$1461 \$562 \_019_ \$583 VDD$2 pfet L=0.5U W=0.36U AS=0.054P AD=0.1872P
+ PS=0.66U PD=1.4U
* device instance $1462 r0 *1 162.17,20.705 pfet
M$1462 \$581 \$538 \$562 VDD$2 pfet L=0.5U W=0.36U AS=0.1872P AD=0.0432P
+ PS=1.4U PD=0.6U
* device instance $1463 r0 *1 162.91,20.705 pfet
M$1463 VDD$2 \$539 \$581 VDD$2 pfet L=0.5U W=0.36U AS=0.0432P AD=0.1044P
+ PS=0.6U PD=0.94U
* device instance $1464 r0 *1 163.99,20.705 pfet
M$1464 \$539 \$562 VDD$2 VDD$2 pfet L=0.5U W=0.36U AS=0.1044P AD=0.1791P
+ PS=0.94U PD=1.355U
* device instance $1465 r0 *1 165.485,20.705 pfet
M$1465 \$563 \$538 \$539 VDD$2 pfet L=0.5U W=0.36U AS=0.1791P AD=0.1665P
+ PS=1.355U PD=1.285U
* device instance $1466 r0 *1 166.91,20.705 pfet
M$1466 \$579 \$540 \$563 VDD$2 pfet L=0.5U W=0.36U AS=0.1665P AD=0.0504P
+ PS=1.285U PD=0.64U
* device instance $1467 r0 *1 167.69,20.705 pfet
M$1467 \$579 \$541 VDD$2 VDD$2 pfet L=0.5U W=0.36U AS=0.23P AD=0.0504P PS=1.54U
+ PD=0.64U
* device instance $1468 r0 *1 168.93,20.485 pfet
M$1468 \$541 \$563 VDD$2 VDD$2 pfet L=0.5U W=0.8U AS=0.23P AD=0.352P PS=1.54U
+ PD=2.48U
* device instance $1469 r0 *1 170.67,20.55 pfet
M$1469 q5 \$541 VDD$2 VDD$2 pfet L=0.5U W=1.22U AS=0.5368P AD=0.5368P PS=3.32U
+ PD=3.32U
* device instance $1470 r0 *1 175.59,20.55 pfet
M$1470 \$576 start VDD$2 VDD$2 pfet L=0.5U W=1.22U AS=0.5368P AD=0.4087P
+ PS=3.32U PD=1.89U
* device instance $1471 r0 *1 176.76,20.55 pfet
M$1471 \_009_[1] \_033_ \$576 VDD$2 pfet L=0.5U W=1.22U AS=0.4087P AD=0.5368P
+ PS=1.89U PD=3.32U
* device instance $1472 r0 *1 179.05,20.7275 pfet
M$1472 VDD$2 clknet_2_3__leaf_clk \$542 VDD$2 pfet L=0.5U W=0.865U AS=0.3806P
+ AD=0.2249P PS=2.61U PD=1.385U
* device instance $1473 r0 *1 180.07,20.7275 pfet
M$1473 \$544 \$542 VDD$2 VDD$2 pfet L=0.5U W=0.865U AS=0.2249P AD=0.3806P
+ PS=1.385U PD=2.61U
* device instance $1474 r0 *1 182.23,20.705 pfet
M$1474 \$572 \$544 VDD$2 VDD$2 pfet L=0.5U W=0.36U AS=0.4554P AD=0.054P
+ PS=3.25U PD=0.66U
* device instance $1475 r0 *1 183.03,20.705 pfet
M$1475 \$565 \_009_[4] \$572 VDD$2 pfet L=0.5U W=0.36U AS=0.054P AD=0.1872P
+ PS=0.66U PD=1.4U
* device instance $1476 r0 *1 184.57,20.705 pfet
M$1476 \$569 \$542 \$565 VDD$2 pfet L=0.5U W=0.36U AS=0.1872P AD=0.0432P
+ PS=1.4U PD=0.6U
* device instance $1477 r0 *1 185.31,20.705 pfet
M$1477 VDD$2 \$543 \$569 VDD$2 pfet L=0.5U W=0.36U AS=0.0432P AD=0.1044P
+ PS=0.6U PD=0.94U
* device instance $1478 r0 *1 186.39,20.705 pfet
M$1478 \$543 \$565 VDD$2 VDD$2 pfet L=0.5U W=0.36U AS=0.1044P AD=0.1791P
+ PS=0.94U PD=1.355U
* device instance $1479 r0 *1 187.885,20.705 pfet
M$1479 \$566 \$542 \$543 VDD$2 pfet L=0.5U W=0.36U AS=0.1791P AD=0.1665P
+ PS=1.355U PD=1.285U
* device instance $1480 r0 *1 189.31,20.705 pfet
M$1480 \$567 \$544 \$566 VDD$2 pfet L=0.5U W=0.36U AS=0.1665P AD=0.0504P
+ PS=1.285U PD=0.64U
* device instance $1481 r0 *1 190.09,20.705 pfet
M$1481 \$567 \$545 VDD$2 VDD$2 pfet L=0.5U W=0.36U AS=0.23P AD=0.0504P PS=1.54U
+ PD=0.64U
* device instance $1482 r0 *1 191.33,20.485 pfet
M$1482 \$545 \$566 VDD$2 VDD$2 pfet L=0.5U W=0.8U AS=0.23P AD=0.352P PS=1.54U
+ PD=2.48U
* device instance $1483 r0 *1 193.07,20.55 pfet
M$1483 ph[4] \$545 VDD$2 VDD$2 pfet L=0.5U W=1.22U AS=0.5368P AD=0.5368P
+ PS=3.32U PD=3.32U
* device instance $1484 r0 *1 8.71,28.39 pfet
M$1484 \$748 start VDD$3 VDD$3 pfet L=0.5U W=1.22U AS=0.5368P AD=0.4087P
+ PS=3.32U PD=1.89U
* device instance $1485 r0 *1 9.88,28.39 pfet
M$1485 \_009_[9] \_049_ \$748 VDD$3 pfet L=0.5U W=1.22U AS=0.4087P AD=0.5368P
+ PS=1.89U PD=3.32U
* device instance $1486 r0 *1 8.71,26.49 pfet
M$1486 \$692 start VDD$3 VDD$3 pfet L=0.5U W=1.22U AS=0.5368P AD=0.4087P
+ PS=3.32U PD=1.89U
* device instance $1487 r0 *1 9.88,26.49 pfet
M$1487 \_009_[10] \_048_ \$692 VDD$3 pfet L=0.5U W=1.22U AS=0.4087P AD=0.5368P
+ PS=1.89U PD=3.32U
* device instance $1488 r0 *1 12.07,28.39 pfet
M$1488 \$749 ph[9] VDD$3 VDD$3 pfet L=0.5U W=1.22U AS=0.5368P AD=0.4087P
+ PS=3.32U PD=1.89U
* device instance $1489 r0 *1 13.24,28.39 pfet
M$1489 \_062_ q4 \$749 VDD$3 pfet L=0.5U W=1.22U AS=0.4087P AD=0.5368P PS=1.89U
+ PD=3.32U
* device instance $1490 r0 *1 12.17,26.3125 pfet
M$1490 VDD$3 clknet_2_1__leaf_clk \$615 VDD$3 pfet L=0.5U W=0.865U AS=0.3806P
+ AD=0.2249P PS=2.61U PD=1.385U
* device instance $1491 r0 *1 13.19,26.3125 pfet
M$1491 \$616 \$615 VDD$3 VDD$3 pfet L=0.5U W=0.865U AS=0.2249P AD=0.3806P
+ PS=1.385U PD=2.61U
* device instance $1492 r0 *1 15.35,26.335 pfet
M$1492 \$693 \$616 VDD$3 VDD$3 pfet L=0.5U W=0.36U AS=0.4554P AD=0.054P
+ PS=3.25U PD=0.66U
* device instance $1493 r0 *1 16.15,26.335 pfet
M$1493 \$617 \_009_[12] \$693 VDD$3 pfet L=0.5U W=0.36U AS=0.054P AD=0.1872P
+ PS=0.66U PD=1.4U
* device instance $1494 r0 *1 17.69,26.335 pfet
M$1494 \$694 \$615 \$617 VDD$3 pfet L=0.5U W=0.36U AS=0.1872P AD=0.0432P
+ PS=1.4U PD=0.6U
* device instance $1495 r0 *1 18.43,26.335 pfet
M$1495 VDD$3 \$618 \$694 VDD$3 pfet L=0.5U W=0.36U AS=0.0432P AD=0.1044P
+ PS=0.6U PD=0.94U
* device instance $1496 r0 *1 19.51,26.335 pfet
M$1496 \$618 \$617 VDD$3 VDD$3 pfet L=0.5U W=0.36U AS=0.1044P AD=0.1791P
+ PS=0.94U PD=1.355U
* device instance $1497 r0 *1 21.005,26.335 pfet
M$1497 \$619 \$615 \$618 VDD$3 pfet L=0.5U W=0.36U AS=0.1791P AD=0.1665P
+ PS=1.355U PD=1.285U
* device instance $1498 r0 *1 22.43,26.335 pfet
M$1498 \$695 \$616 \$619 VDD$3 pfet L=0.5U W=0.36U AS=0.1665P AD=0.0504P
+ PS=1.285U PD=0.64U
* device instance $1499 r0 *1 23.21,26.335 pfet
M$1499 VDD$3 \$620 \$695 VDD$3 pfet L=0.5U W=0.36U AS=0.0504P AD=0.23P PS=0.64U
+ PD=1.54U
* device instance $1500 r0 *1 24.45,26.555 pfet
M$1500 \$620 \$619 VDD$3 VDD$3 pfet L=0.5U W=0.8U AS=0.23P AD=0.352P PS=1.54U
+ PD=2.48U
* device instance $1501 r0 *1 26.19,26.49 pfet
M$1501 ph[12] \$620 VDD$3 VDD$3 pfet L=0.5U W=1.22U AS=0.5368P AD=0.5368P
+ PS=3.32U PD=3.32U
* device instance $1502 r0 *1 29.43,28.39 pfet
M$1502 \$751 q1 VDD$3 VDD$3 pfet L=0.5U W=1.22U AS=0.5368P AD=0.4087P PS=3.32U
+ PD=1.89U
* device instance $1503 r0 *1 30.6,28.39 pfet
M$1503 \_060_ ph[12] \$751 VDD$3 pfet L=0.5U W=1.22U AS=0.4087P AD=0.5368P
+ PS=1.89U PD=3.32U
* device instance $1504 r0 *1 30.55,26.49 pfet
M$1504 \$697 start VDD$3 VDD$3 pfet L=0.5U W=1.22U AS=0.5368P AD=0.4087P
+ PS=3.32U PD=1.89U
* device instance $1505 r0 *1 31.72,26.49 pfet
M$1505 \_009_[13] \_043_ \$697 VDD$3 pfet L=0.5U W=1.22U AS=0.4087P AD=0.5368P
+ PS=1.89U PD=3.32U
* device instance $1506 r0 *1 34.01,26.3125 pfet
M$1506 VDD$3 clknet_2_1__leaf_clk \$622 VDD$3 pfet L=0.5U W=0.865U AS=0.3806P
+ AD=0.2249P PS=2.61U PD=1.385U
* device instance $1507 r0 *1 35.03,26.3125 pfet
M$1507 \$623 \$622 VDD$3 VDD$3 pfet L=0.5U W=0.865U AS=0.2249P AD=0.3806P
+ PS=1.385U PD=2.61U
* device instance $1508 r0 *1 37.19,26.335 pfet
M$1508 \$698 \$623 VDD$3 VDD$3 pfet L=0.5U W=0.36U AS=0.4554P AD=0.054P
+ PS=3.25U PD=0.66U
* device instance $1509 r0 *1 37.99,26.335 pfet
M$1509 \$625 \_012_ \$698 VDD$3 pfet L=0.5U W=0.36U AS=0.054P AD=0.1872P
+ PS=0.66U PD=1.4U
* device instance $1510 r0 *1 39.53,26.335 pfet
M$1510 \$699 \$622 \$625 VDD$3 pfet L=0.5U W=0.36U AS=0.1872P AD=0.0432P
+ PS=1.4U PD=0.6U
* device instance $1511 r0 *1 40.27,26.335 pfet
M$1511 VDD$3 \$626 \$699 VDD$3 pfet L=0.5U W=0.36U AS=0.0432P AD=0.1044P
+ PS=0.6U PD=0.94U
* device instance $1512 r0 *1 41.35,26.335 pfet
M$1512 \$626 \$625 VDD$3 VDD$3 pfet L=0.5U W=0.36U AS=0.1044P AD=0.1791P
+ PS=0.94U PD=1.355U
* device instance $1513 r0 *1 42.845,26.335 pfet
M$1513 \$628 \$622 \$626 VDD$3 pfet L=0.5U W=0.36U AS=0.1791P AD=0.1665P
+ PS=1.355U PD=1.285U
* device instance $1514 r0 *1 44.27,26.335 pfet
M$1514 \$700 \$623 \$628 VDD$3 pfet L=0.5U W=0.36U AS=0.1665P AD=0.0504P
+ PS=1.285U PD=0.64U
* device instance $1515 r0 *1 45.05,26.335 pfet
M$1515 VDD$3 \$629 \$700 VDD$3 pfet L=0.5U W=0.36U AS=0.0504P AD=0.23P PS=0.64U
+ PD=1.54U
* device instance $1516 r0 *1 46.29,26.555 pfet
M$1516 \$629 \$628 VDD$3 VDD$3 pfet L=0.5U W=0.8U AS=0.23P AD=0.352P PS=1.54U
+ PD=2.48U
* device instance $1517 r0 *1 40.07,28.39 pfet
M$1517 \$754 q0 VDD$3 VDD$3 pfet L=0.5U W=1.22U AS=0.5368P AD=0.4087P PS=3.32U
+ PD=1.89U
* device instance $1518 r0 *1 41.24,28.39 pfet
M$1518 \_055_ ph[13] \$754 VDD$3 pfet L=0.5U W=1.22U AS=0.4087P AD=0.5368P
+ PS=1.89U PD=3.32U
* device instance $1519 r0 *1 48.03,26.49 pfet
M$1519 q0 \$629 VDD$3 VDD$3 pfet L=0.5U W=1.22U AS=0.5368P AD=0.5368P PS=3.32U
+ PD=3.32U
* device instance $1520 r0 *1 49.03,28.39 pfet
M$1520 \_045_ ph[13] VDD$3 VDD$3 pfet L=0.5U W=1.22U AS=0.5368P AD=0.5368P
+ PS=3.32U PD=3.32U
* device instance $1521 r0 *1 55.85,26.3125 pfet
M$1521 VDD$3 clknet_2_1__leaf_clk \$630 VDD$3 pfet L=0.5U W=0.865U AS=0.3806P
+ AD=0.2249P PS=2.61U PD=1.385U
* device instance $1522 r0 *1 56.87,26.3125 pfet
M$1522 \$631 \$630 VDD$3 VDD$3 pfet L=0.5U W=0.865U AS=0.2249P AD=0.3806P
+ PS=1.385U PD=2.61U
* device instance $1523 r0 *1 59.03,26.335 pfet
M$1523 \$701 \$631 VDD$3 VDD$3 pfet L=0.5U W=0.36U AS=0.4554P AD=0.054P
+ PS=3.25U PD=0.66U
* device instance $1524 r0 *1 59.83,26.335 pfet
M$1524 \$633 \_021_ \$701 VDD$3 pfet L=0.5U W=0.36U AS=0.054P AD=0.1872P
+ PS=0.66U PD=1.4U
* device instance $1525 r0 *1 61.37,26.335 pfet
M$1525 \$702 \$630 \$633 VDD$3 pfet L=0.5U W=0.36U AS=0.1872P AD=0.0432P
+ PS=1.4U PD=0.6U
* device instance $1526 r0 *1 62.11,26.335 pfet
M$1526 VDD$3 \$634 \$702 VDD$3 pfet L=0.5U W=0.36U AS=0.0432P AD=0.1044P
+ PS=0.6U PD=0.94U
* device instance $1527 r0 *1 63.19,26.335 pfet
M$1527 \$634 \$633 VDD$3 VDD$3 pfet L=0.5U W=0.36U AS=0.1044P AD=0.1791P
+ PS=0.94U PD=1.355U
* device instance $1528 r0 *1 64.685,26.335 pfet
M$1528 \$635 \$630 \$634 VDD$3 pfet L=0.5U W=0.36U AS=0.1791P AD=0.1665P
+ PS=1.355U PD=1.285U
* device instance $1529 r0 *1 66.11,26.335 pfet
M$1529 \$703 \$631 \$635 VDD$3 pfet L=0.5U W=0.36U AS=0.1665P AD=0.0504P
+ PS=1.285U PD=0.64U
* device instance $1530 r0 *1 66.89,26.335 pfet
M$1530 VDD$3 \$636 \$703 VDD$3 pfet L=0.5U W=0.36U AS=0.0504P AD=0.23P PS=0.64U
+ PD=1.54U
* device instance $1531 r0 *1 68.13,26.555 pfet
M$1531 \$636 \$635 VDD$3 VDD$3 pfet L=0.5U W=0.8U AS=0.23P AD=0.352P PS=1.54U
+ PD=2.48U
* device instance $1532 r0 *1 61.795,28.0875 pfet
M$1532 \$742 q4 VDD$3 VDD$3 pfet L=0.5U W=0.615U AS=0.4298375P AD=0.0845625P
+ PS=2.185U PD=0.89U
* device instance $1533 r0 *1 62.57,28.0875 pfet
M$1533 \$684 \$685 \$742 VDD$3 pfet L=0.5U W=0.615U AS=0.0845625P AD=0.1599P
+ PS=0.89U PD=1.135U
* device instance $1534 r0 *1 63.59,28.0875 pfet
M$1534 \$741 ph[14] \$684 VDD$3 pfet L=0.5U W=0.615U AS=0.1599P AD=0.0738P
+ PS=1.135U PD=0.855U
* device instance $1535 r0 *1 64.33,28.0875 pfet
M$1535 VDD$3 c4_r \$741 VDD$3 pfet L=0.5U W=0.615U AS=0.0738P AD=0.1599P
+ PS=0.855U PD=1.135U
* device instance $1536 r0 *1 65.35,28.0875 pfet
M$1536 \$685 ph[14] VDD$3 VDD$3 pfet L=0.5U W=0.615U AS=0.1599P AD=0.2706P
+ PS=1.135U PD=2.11U
* device instance $1537 r0 *1 60.33,28.39 pfet
M$1537 VDD$3 \$684 \_023_ VDD$3 pfet L=0.5U W=1.22U AS=0.5368P AD=0.4298375P
+ PS=3.32U PD=2.185U
* device instance $1538 r0 *1 69.87,26.49 pfet
M$1538 c3_r \$636 VDD$3 VDD$3 pfet L=0.5U W=1.22U AS=0.5368P AD=0.5368P
+ PS=3.32U PD=3.32U
* device instance $1539 r0 *1 79.155,28.0875 pfet
M$1539 \$740 q8 VDD$3 VDD$3 pfet L=0.5U W=0.615U AS=0.4298375P AD=0.0845625P
+ PS=2.185U PD=0.89U
* device instance $1540 r0 *1 79.93,28.0875 pfet
M$1540 \$686 \$687 \$740 VDD$3 pfet L=0.5U W=0.615U AS=0.0845625P AD=0.1599P
+ PS=0.89U PD=1.135U
* device instance $1541 r0 *1 80.95,28.0875 pfet
M$1541 \$739 ph[14] \$686 VDD$3 pfet L=0.5U W=0.615U AS=0.1599P AD=0.0738P
+ PS=1.135U PD=0.855U
* device instance $1542 r0 *1 81.69,28.0875 pfet
M$1542 VDD$3 c8_r \$739 VDD$3 pfet L=0.5U W=0.615U AS=0.0738P AD=0.1599P
+ PS=0.855U PD=1.135U
* device instance $1543 r0 *1 82.71,28.0875 pfet
M$1543 \$687 ph[14] VDD$3 VDD$3 pfet L=0.5U W=0.615U AS=0.1599P AD=0.2706P
+ PS=1.135U PD=2.11U
* device instance $1544 r0 *1 77.69,28.39 pfet
M$1544 VDD$3 \$686 \_010_ VDD$3 pfet L=0.5U W=1.22U AS=0.5368P AD=0.4298375P
+ PS=3.32U PD=2.185U
* device instance $1545 r0 *1 83.85,26.3125 pfet
M$1545 VDD$3 clknet_2_1__leaf_clk \$638 VDD$3 pfet L=0.5U W=0.865U AS=0.3806P
+ AD=0.2249P PS=2.61U PD=1.385U
* device instance $1546 r0 *1 84.87,26.3125 pfet
M$1546 \$639 \$638 VDD$3 VDD$3 pfet L=0.5U W=0.865U AS=0.2249P AD=0.3806P
+ PS=1.385U PD=2.61U
* device instance $1547 r0 *1 87.03,26.335 pfet
M$1547 \$704 \$639 VDD$3 VDD$3 pfet L=0.5U W=0.36U AS=0.4554P AD=0.054P
+ PS=3.25U PD=0.66U
* device instance $1548 r0 *1 87.83,26.335 pfet
M$1548 \$640 \_016_ \$704 VDD$3 pfet L=0.5U W=0.36U AS=0.054P AD=0.1872P
+ PS=0.66U PD=1.4U
* device instance $1549 r0 *1 89.37,26.335 pfet
M$1549 \$705 \$638 \$640 VDD$3 pfet L=0.5U W=0.36U AS=0.1872P AD=0.0432P
+ PS=1.4U PD=0.6U
* device instance $1550 r0 *1 90.11,26.335 pfet
M$1550 VDD$3 \$641 \$705 VDD$3 pfet L=0.5U W=0.36U AS=0.0432P AD=0.1044P
+ PS=0.6U PD=0.94U
* device instance $1551 r0 *1 91.19,26.335 pfet
M$1551 \$641 \$640 VDD$3 VDD$3 pfet L=0.5U W=0.36U AS=0.1044P AD=0.1791P
+ PS=0.94U PD=1.355U
* device instance $1552 r0 *1 92.685,26.335 pfet
M$1552 \$642 \$638 \$641 VDD$3 pfet L=0.5U W=0.36U AS=0.1791P AD=0.1665P
+ PS=1.355U PD=1.285U
* device instance $1553 r0 *1 94.11,26.335 pfet
M$1553 \$706 \$639 \$642 VDD$3 pfet L=0.5U W=0.36U AS=0.1665P AD=0.0504P
+ PS=1.285U PD=0.64U
* device instance $1554 r0 *1 94.89,26.335 pfet
M$1554 VDD$3 \$643 \$706 VDD$3 pfet L=0.5U W=0.36U AS=0.0504P AD=0.23P PS=0.64U
+ PD=1.54U
* device instance $1555 r0 *1 96.13,26.555 pfet
M$1555 \$643 \$642 VDD$3 VDD$3 pfet L=0.5U W=0.8U AS=0.23P AD=0.352P PS=1.54U
+ PD=2.48U
* device instance $1556 r0 *1 93.715,28.0875 pfet
M$1556 \$738 q5 VDD$3 VDD$3 pfet L=0.5U W=0.615U AS=0.4298375P AD=0.0845625P
+ PS=2.185U PD=0.89U
* device instance $1557 r0 *1 94.49,28.0875 pfet
M$1557 \$688 \$689 \$738 VDD$3 pfet L=0.5U W=0.615U AS=0.0845625P AD=0.1599P
+ PS=0.89U PD=1.135U
* device instance $1558 r0 *1 95.51,28.0875 pfet
M$1558 \$737 ph[14] \$688 VDD$3 pfet L=0.5U W=0.615U AS=0.1599P AD=0.0738P
+ PS=1.135U PD=0.855U
* device instance $1559 r0 *1 96.25,28.0875 pfet
M$1559 VDD$3 c5_r \$737 VDD$3 pfet L=0.5U W=0.615U AS=0.0738P AD=0.1599P
+ PS=0.855U PD=1.135U
* device instance $1560 r0 *1 97.27,28.0875 pfet
M$1560 \$689 ph[14] VDD$3 VDD$3 pfet L=0.5U W=0.615U AS=0.1599P AD=0.2706P
+ PS=1.135U PD=2.11U
* device instance $1561 r0 *1 92.25,28.39 pfet
M$1561 VDD$3 \$688 \_024_ VDD$3 pfet L=0.5U W=1.22U AS=0.5368P AD=0.4298375P
+ PS=3.32U PD=2.185U
* device instance $1562 r0 *1 97.87,26.49 pfet
M$1562 c2_r \$643 VDD$3 VDD$3 pfet L=0.5U W=1.22U AS=0.5368P AD=0.5368P
+ PS=3.32U PD=3.32U
* device instance $1563 r0 *1 111.635,28.0875 pfet
M$1563 \$736 q1 VDD$3 VDD$3 pfet L=0.5U W=0.615U AS=0.4298375P AD=0.0845625P
+ PS=2.185U PD=0.89U
* device instance $1564 r0 *1 112.41,28.0875 pfet
M$1564 \$690 \$691 \$736 VDD$3 pfet L=0.5U W=0.615U AS=0.0845625P AD=0.1599P
+ PS=0.89U PD=1.135U
* device instance $1565 r0 *1 113.43,28.0875 pfet
M$1565 \$735 ph[14] \$690 VDD$3 pfet L=0.5U W=0.615U AS=0.1599P AD=0.0738P
+ PS=1.135U PD=0.855U
* device instance $1566 r0 *1 114.17,28.0875 pfet
M$1566 VDD$3 c1_r \$735 VDD$3 pfet L=0.5U W=0.615U AS=0.0738P AD=0.1599P
+ PS=0.855U PD=1.135U
* device instance $1567 r0 *1 115.19,28.0875 pfet
M$1567 \$691 ph[14] VDD$3 VDD$3 pfet L=0.5U W=0.615U AS=0.1599P AD=0.2706P
+ PS=1.135U PD=2.11U
* device instance $1568 r0 *1 110.17,28.39 pfet
M$1568 VDD$3 \$690 \_015_ VDD$3 pfet L=0.5U W=1.22U AS=0.5368P AD=0.4298375P
+ PS=3.32U PD=2.185U
* device instance $1569 r0 *1 112.41,26.49 pfet
M$1569 VDD$3 \$588 \_027_ VDD$3 pfet L=0.5U W=1.22U AS=0.5368P AD=0.4298375P
+ PS=3.32U PD=2.185U
* device instance $1570 r0 *1 113.875,26.7925 pfet
M$1570 \$708 q6 VDD$3 VDD$3 pfet L=0.5U W=0.615U AS=0.4298375P AD=0.0845625P
+ PS=2.185U PD=0.89U
* device instance $1571 r0 *1 114.65,26.7925 pfet
M$1571 \$588 \$589 \$708 VDD$3 pfet L=0.5U W=0.615U AS=0.0845625P AD=0.1599P
+ PS=0.89U PD=1.135U
* device instance $1572 r0 *1 115.67,26.7925 pfet
M$1572 \$709 ph[14] \$588 VDD$3 pfet L=0.5U W=0.615U AS=0.1599P AD=0.0738P
+ PS=1.135U PD=0.855U
* device instance $1573 r0 *1 116.41,26.7925 pfet
M$1573 VDD$3 c6_r \$709 VDD$3 pfet L=0.5U W=0.615U AS=0.0738P AD=0.1599P
+ PS=0.855U PD=1.135U
* device instance $1574 r0 *1 117.43,26.7925 pfet
M$1574 \$589 ph[14] VDD$3 VDD$3 pfet L=0.5U W=0.615U AS=0.1599P AD=0.2706P
+ PS=1.135U PD=2.11U
* device instance $1575 r0 *1 117.91,28.39 pfet
M$1575 \$756 start VDD$3 VDD$3 pfet L=0.5U W=1.22U AS=0.5368P AD=0.4087P
+ PS=3.32U PD=1.89U
* device instance $1576 r0 *1 119.08,28.39 pfet
M$1576 \_009_[15] \_054_ \$756 VDD$3 pfet L=0.5U W=1.22U AS=0.4087P AD=0.5368P
+ PS=1.89U PD=3.32U
* device instance $1577 r0 *1 119.59,26.49 pfet
M$1577 \_054_ ph[14] VDD$3 VDD$3 pfet L=0.5U W=1.22U AS=0.5368P AD=0.5368P
+ PS=3.32U PD=3.32U
* device instance $1578 r0 *1 129.11,26.4875 pfet
M$1578 \_004_ \_049_ \$678 VDD$3 pfet L=0.5U W=1.215U AS=0.5346P AD=0.3159P
+ PS=3.31U PD=1.735U
* device instance $1579 r0 *1 130.13,26.4875 pfet
M$1579 \$678 \_037_ \_004_ VDD$3 pfet L=0.5U W=1.215U AS=0.3159P AD=0.44955P
+ PS=1.735U PD=1.955U
* device instance $1580 r0 *1 131.37,26.4875 pfet
M$1580 VDD$3 ph[13] \$678 VDD$3 pfet L=0.5U W=1.215U AS=0.44955P AD=0.5346P
+ PS=1.955U PD=3.31U
* device instance $1581 r0 *1 134.15,26.4875 pfet
M$1581 \_008_ \_053_ \$679 VDD$3 pfet L=0.5U W=1.215U AS=0.5346P AD=0.3159P
+ PS=3.31U PD=1.735U
* device instance $1582 r0 *1 135.17,26.4875 pfet
M$1582 \$679 \_041_ \_008_ VDD$3 pfet L=0.5U W=1.215U AS=0.3159P AD=0.44955P
+ PS=1.735U PD=1.955U
* device instance $1583 r0 *1 136.41,26.4875 pfet
M$1583 VDD$3 ph[13] \$679 VDD$3 pfet L=0.5U W=1.215U AS=0.44955P AD=0.5346P
+ PS=1.955U PD=3.31U
* device instance $1584 r0 *1 140.97,26.3125 pfet
M$1584 VDD$3 clknet_2_3__leaf_clk \$645 VDD$3 pfet L=0.5U W=0.865U AS=0.3806P
+ AD=0.2249P PS=2.61U PD=1.385U
* device instance $1585 r0 *1 141.99,26.3125 pfet
M$1585 \$646 \$645 VDD$3 VDD$3 pfet L=0.5U W=0.865U AS=0.2249P AD=0.3806P
+ PS=1.385U PD=2.61U
* device instance $1586 r0 *1 142.11,28.39 pfet
M$1586 eng9 \$725 VDD$3 VDD$3 pfet L=0.5U W=1.22U AS=0.5368P AD=0.5368P
+ PS=3.32U PD=3.32U
* device instance $1587 r0 *1 144.15,26.335 pfet
M$1587 \$712 \$646 VDD$3 VDD$3 pfet L=0.5U W=0.36U AS=0.4554P AD=0.054P
+ PS=3.25U PD=0.66U
* device instance $1588 r0 *1 144.95,26.335 pfet
M$1588 \$647 \_006_ \$712 VDD$3 pfet L=0.5U W=0.36U AS=0.054P AD=0.1872P
+ PS=0.66U PD=1.4U
* device instance $1589 r0 *1 146.49,26.335 pfet
M$1589 \$711 \$645 \$647 VDD$3 pfet L=0.5U W=0.36U AS=0.1872P AD=0.0432P
+ PS=1.4U PD=0.6U
* device instance $1590 r0 *1 147.23,26.335 pfet
M$1590 VDD$3 \$648 \$711 VDD$3 pfet L=0.5U W=0.36U AS=0.0432P AD=0.1044P
+ PS=0.6U PD=0.94U
* device instance $1591 r0 *1 148.31,26.335 pfet
M$1591 \$648 \$647 VDD$3 VDD$3 pfet L=0.5U W=0.36U AS=0.1044P AD=0.1791P
+ PS=0.94U PD=1.355U
* device instance $1592 r0 *1 149.805,26.335 pfet
M$1592 \$649 \$645 \$648 VDD$3 pfet L=0.5U W=0.36U AS=0.1791P AD=0.1665P
+ PS=1.355U PD=1.285U
* device instance $1593 r0 *1 151.23,26.335 pfet
M$1593 \$710 \$646 \$649 VDD$3 pfet L=0.5U W=0.36U AS=0.1665P AD=0.0504P
+ PS=1.285U PD=0.64U
* device instance $1594 r0 *1 152.01,26.335 pfet
M$1594 VDD$3 \$650 \$710 VDD$3 pfet L=0.5U W=0.36U AS=0.0504P AD=0.23P PS=0.64U
+ PD=1.54U
* device instance $1595 r0 *1 153.25,26.555 pfet
M$1595 \$650 \$649 VDD$3 VDD$3 pfet L=0.5U W=0.8U AS=0.23P AD=0.352P PS=1.54U
+ PD=2.48U
* device instance $1596 r0 *1 144.23,28.39 pfet
M$1596 \$726 clknet_0_clk VDD$3 VDD$3 pfet L=0.5U W=1.22U AS=0.5368P AD=0.3782P
+ PS=3.32U PD=1.84U
* device instance $1597 r0 *1 145.35,28.39 pfet
M$1597 VDD$3 clknet_0_clk \$726 VDD$3 pfet L=0.5U W=1.22U AS=0.3782P AD=0.3782P
+ PS=1.84U PD=1.84U
* device instance $1598 r0 *1 146.47,28.39 pfet
M$1598 clknet_2_3__leaf_clk \$726 VDD$3 VDD$3 pfet L=0.5U W=1.22U AS=0.3782P
+ AD=0.3782P PS=1.84U PD=1.84U
* device instance $1599 r0 *1 147.59,28.39 pfet
M$1599 VDD$3 \$726 clknet_2_3__leaf_clk VDD$3 pfet L=0.5U W=1.22U AS=0.3782P
+ AD=0.3782P PS=1.84U PD=1.84U
* device instance $1600 r0 *1 148.71,28.39 pfet
M$1600 clknet_2_3__leaf_clk \$726 VDD$3 VDD$3 pfet L=0.5U W=1.22U AS=0.3782P
+ AD=0.3782P PS=1.84U PD=1.84U
* device instance $1601 r0 *1 149.83,28.39 pfet
M$1601 VDD$3 \$726 clknet_2_3__leaf_clk VDD$3 pfet L=0.5U W=1.22U AS=0.3782P
+ AD=0.5368P PS=1.84U PD=3.32U
* device instance $1602 r0 *1 152.63,28.39 pfet
M$1602 \_049_ ph[8] VDD$3 VDD$3 pfet L=0.5U W=1.22U AS=0.5368P AD=0.5368P
+ PS=3.32U PD=3.32U
* device instance $1603 r0 *1 154.99,26.49 pfet
M$1603 eng7 \$650 VDD$3 VDD$3 pfet L=0.5U W=1.22U AS=0.5368P AD=0.5368P
+ PS=3.32U PD=3.32U
* device instance $1604 r0 *1 157.11,26.49 pfet
M$1604 \$707 ph[6] VDD$3 VDD$3 pfet L=0.5U W=1.22U AS=0.5368P AD=0.4087P
+ PS=3.32U PD=1.89U
* device instance $1605 r0 *1 158.28,26.49 pfet
M$1605 \_058_ q7 \$707 VDD$3 pfet L=0.5U W=1.22U AS=0.4087P AD=0.5368P PS=1.89U
+ PD=3.32U
* device instance $1606 r0 *1 160.47,28.39 pfet
M$1606 \$759 ph[8] VDD$3 VDD$3 pfet L=0.5U W=1.22U AS=0.5368P AD=0.4087P
+ PS=3.32U PD=1.89U
* device instance $1607 r0 *1 161.64,28.39 pfet
M$1607 \_059_ q5 \$759 VDD$3 pfet L=0.5U W=1.22U AS=0.4087P AD=0.5368P PS=1.89U
+ PD=3.32U
* device instance $1608 r0 *1 160.47,26.4875 pfet
M$1608 \_019_ cmp \$680 VDD$3 pfet L=0.5U W=1.215U AS=0.5346P AD=0.3159P
+ PS=3.31U PD=1.735U
* device instance $1609 r0 *1 161.49,26.4875 pfet
M$1609 \$680 ph[8] \_019_ VDD$3 pfet L=0.5U W=1.215U AS=0.3159P AD=0.44955P
+ PS=1.735U PD=1.955U
* device instance $1610 r0 *1 162.73,26.4875 pfet
M$1610 VDD$3 \_059_ \$680 VDD$3 pfet L=0.5U W=1.215U AS=0.44955P AD=0.5346P
+ PS=1.955U PD=3.31U
* device instance $1611 r0 *1 173.35,28.39 pfet
M$1611 \_052_ ph[5] VDD$3 VDD$3 pfet L=0.5U W=1.22U AS=0.5368P AD=0.5368P
+ PS=3.32U PD=3.32U
* device instance $1612 r0 *1 175.59,26.4875 pfet
M$1612 \_022_ cmp \$681 VDD$3 pfet L=0.5U W=1.215U AS=0.5346P AD=0.3159P
+ PS=3.31U PD=1.735U
* device instance $1613 r0 *1 176.61,26.4875 pfet
M$1613 \$681 ph[5] \_022_ VDD$3 pfet L=0.5U W=1.215U AS=0.3159P AD=0.44955P
+ PS=1.735U PD=1.955U
* device instance $1614 r0 *1 177.85,26.4875 pfet
M$1614 VDD$3 \_061_ \$681 VDD$3 pfet L=0.5U W=1.215U AS=0.44955P AD=0.5346P
+ PS=1.955U PD=3.31U
* device instance $1615 r0 *1 176.15,28.39 pfet
M$1615 \$755 start VDD$3 VDD$3 pfet L=0.5U W=1.22U AS=0.5368P AD=0.4087P
+ PS=3.32U PD=1.89U
* device instance $1616 r0 *1 177.32,28.39 pfet
M$1616 \_009_[5] \_053_ \$755 VDD$3 pfet L=0.5U W=1.22U AS=0.4087P AD=0.5368P
+ PS=1.89U PD=3.32U
* device instance $1617 r0 *1 179.51,28.39 pfet
M$1617 \_053_ ph[4] VDD$3 VDD$3 pfet L=0.5U W=1.22U AS=0.5368P AD=0.5368P
+ PS=3.32U PD=3.32U
* device instance $1618 r0 *1 180.07,26.4875 pfet
M$1618 \_026_ cmp \$682 VDD$3 pfet L=0.5U W=1.215U AS=0.5346P AD=0.3159P
+ PS=3.31U PD=1.735U
* device instance $1619 r0 *1 181.09,26.4875 pfet
M$1619 \$682 ph[4] \_026_ VDD$3 pfet L=0.5U W=1.215U AS=0.3159P AD=0.44955P
+ PS=1.735U PD=1.955U
* device instance $1620 r0 *1 182.33,26.4875 pfet
M$1620 VDD$3 \_063_ \$682 VDD$3 pfet L=0.5U W=1.215U AS=0.44955P AD=0.5346P
+ PS=1.955U PD=3.31U
* device instance $1621 r0 *1 184.55,26.49 pfet
M$1621 \$696 ph[4] VDD$3 VDD$3 pfet L=0.5U W=1.22U AS=0.5368P AD=0.4087P
+ PS=3.32U PD=1.89U
* device instance $1622 r0 *1 185.72,26.49 pfet
M$1622 \_063_ q9 \$696 VDD$3 pfet L=0.5U W=1.22U AS=0.4087P AD=0.5368P PS=1.89U
+ PD=3.32U
* device instance $1623 r0 *1 187.91,26.49 pfet
M$1623 \_035_ ph[3] VDD$3 VDD$3 pfet L=0.5U W=1.22U AS=0.5368P AD=0.5368P
+ PS=3.32U PD=3.32U
* device instance $1624 r0 *1 195.87,28.39 pfet
M$1624 ph[5] \$734 VDD$3 VDD$3 pfet L=0.5U W=1.22U AS=0.5368P AD=0.5368P
+ PS=3.32U PD=3.32U
* device instance $1625 r0 *1 4.89,34.1525 pfet
M$1625 VDD$4 clknet_2_1__leaf_clk \$783 VDD$4 pfet L=0.5U W=0.865U AS=0.3806P
+ AD=0.2249P PS=2.61U PD=1.385U
* device instance $1626 r0 *1 5.91,34.1525 pfet
M$1626 \$784 \$783 VDD$4 VDD$4 pfet L=0.5U W=0.865U AS=0.2249P AD=0.3806P
+ PS=1.385U PD=2.61U
* device instance $1627 r0 *1 15.43,28.3925 pfet
M$1627 \_017_ cmp \$713 VDD$3 pfet L=0.5U W=1.215U AS=0.5346P AD=0.3159P
+ PS=3.31U PD=1.735U
* device instance $1628 r0 *1 16.45,28.3925 pfet
M$1628 \$713 ph[11] \_017_ VDD$3 pfet L=0.5U W=1.215U AS=0.3159P AD=0.44955P
+ PS=1.735U PD=1.955U
* device instance $1629 r0 *1 17.69,28.3925 pfet
M$1629 VDD$3 \_057_ \$713 VDD$3 pfet L=0.5U W=1.215U AS=0.44955P AD=0.5346P
+ PS=1.955U PD=3.31U
* device instance $1630 r0 *1 18.91,34.33 pfet
M$1630 q4 \$788 VDD$4 VDD$4 pfet L=0.5U W=1.22U AS=0.5368P AD=0.5368P PS=3.32U
+ PD=3.32U
* device instance $1631 r0 *1 24.95,28.3925 pfet
M$1631 \_020_ cmp \$714 VDD$3 pfet L=0.5U W=1.215U AS=0.5346P AD=0.3159P
+ PS=3.31U PD=1.735U
* device instance $1632 r0 *1 25.97,28.3925 pfet
M$1632 \$714 ph[12] \_020_ VDD$3 pfet L=0.5U W=1.215U AS=0.3159P AD=0.44955P
+ PS=1.735U PD=1.955U
* device instance $1633 r0 *1 27.21,28.3925 pfet
M$1633 VDD$3 \_060_ \$714 VDD$3 pfet L=0.5U W=1.215U AS=0.44955P AD=0.5346P
+ PS=1.955U PD=3.31U
* device instance $1634 r0 *1 27.29,34.1525 pfet
M$1634 VDD$4 clknet_2_1__leaf_clk \$789 VDD$4 pfet L=0.5U W=0.865U AS=0.3806P
+ AD=0.2249P PS=2.61U PD=1.385U
* device instance $1635 r0 *1 28.31,34.1525 pfet
M$1635 \$790 \$789 VDD$4 VDD$4 pfet L=0.5U W=0.865U AS=0.2249P AD=0.3806P
+ PS=1.385U PD=2.61U
* device instance $1636 r0 *1 35.59,28.3925 pfet
M$1636 \_012_ cmp \$716 VDD$3 pfet L=0.5U W=1.215U AS=0.5346P AD=0.3159P
+ PS=3.31U PD=1.735U
* device instance $1637 r0 *1 36.61,28.3925 pfet
M$1637 \$716 ph[13] \_012_ VDD$3 pfet L=0.5U W=1.215U AS=0.3159P AD=0.44955P
+ PS=1.735U PD=1.955U
* device instance $1638 r0 *1 37.85,28.3925 pfet
M$1638 VDD$3 \_055_ \$716 VDD$3 pfet L=0.5U W=1.215U AS=0.44955P AD=0.5346P
+ PS=1.955U PD=3.31U
* device instance $1639 r0 *1 41.31,34.33 pfet
M$1639 ph[13] \$794 VDD$4 VDD$4 pfet L=0.5U W=1.22U AS=0.5368P AD=0.5368P
+ PS=3.32U PD=3.32U
* device instance $1640 r0 *1 47.91,34.33 pfet
M$1640 \$860 start VDD$4 VDD$4 pfet L=0.5U W=1.22U AS=0.5368P AD=0.4087P
+ PS=3.32U PD=1.89U
* device instance $1641 r0 *1 49.08,34.33 pfet
M$1641 \_009_[14] \_045_ \$860 VDD$4 pfet L=0.5U W=1.22U AS=0.4087P AD=0.5368P
+ PS=1.89U PD=3.32U
* device instance $1642 r0 *1 51.37,34.1525 pfet
M$1642 VDD$4 clknet_2_1__leaf_clk \$795 VDD$4 pfet L=0.5U W=0.865U AS=0.3806P
+ AD=0.2249P PS=2.61U PD=1.385U
* device instance $1643 r0 *1 52.39,34.1525 pfet
M$1643 \$796 \$795 VDD$4 VDD$4 pfet L=0.5U W=0.865U AS=0.2249P AD=0.3806P
+ PS=1.385U PD=2.61U
* device instance $1644 r0 *1 65.39,34.33 pfet
M$1644 c0_r \$800 VDD$4 VDD$4 pfet L=0.5U W=1.22U AS=0.5368P AD=0.5368P
+ PS=3.32U PD=3.32U
* device instance $1645 r0 *1 76.57,34.1525 pfet
M$1645 VDD$4 clknet_2_1__leaf_clk \$801 VDD$4 pfet L=0.5U W=0.865U AS=0.3806P
+ AD=0.2249P PS=2.61U PD=1.385U
* device instance $1646 r0 *1 77.59,34.1525 pfet
M$1646 \$802 \$801 VDD$4 VDD$4 pfet L=0.5U W=0.865U AS=0.2249P AD=0.3806P
+ PS=1.385U PD=2.61U
* device instance $1647 r0 *1 90.59,34.33 pfet
M$1647 c9_r \$806 VDD$4 VDD$4 pfet L=0.5U W=1.22U AS=0.5368P AD=0.5368P
+ PS=3.32U PD=3.32U
* device instance $1648 r0 *1 92.71,34.33 pfet
M$1648 \$782 clk VDD$4 VDD$4 pfet L=0.5U W=1.22U AS=0.5368P AD=0.3782P PS=3.32U
+ PD=1.84U
* device instance $1649 r0 *1 93.83,34.33 pfet
M$1649 VDD$4 clk \$782 VDD$4 pfet L=0.5U W=1.22U AS=0.3782P AD=0.3782P PS=1.84U
+ PD=1.84U
* device instance $1650 r0 *1 94.95,34.33 pfet
M$1650 clknet_0_clk \$782 VDD$4 VDD$4 pfet L=0.5U W=1.22U AS=0.3782P AD=0.3782P
+ PS=1.84U PD=1.84U
* device instance $1651 r0 *1 96.07,34.33 pfet
M$1651 VDD$4 \$782 clknet_0_clk VDD$4 pfet L=0.5U W=1.22U AS=0.3782P AD=0.3782P
+ PS=1.84U PD=1.84U
* device instance $1652 r0 *1 97.19,34.33 pfet
M$1652 clknet_0_clk \$782 VDD$4 VDD$4 pfet L=0.5U W=1.22U AS=0.3782P AD=0.3782P
+ PS=1.84U PD=1.84U
* device instance $1653 r0 *1 98.31,34.33 pfet
M$1653 VDD$4 \$782 clknet_0_clk VDD$4 pfet L=0.5U W=1.22U AS=0.3782P AD=0.5368P
+ PS=1.84U PD=3.32U
* device instance $1654 r0 *1 110.17,34.33 pfet
M$1654 VDD$4 \$779 \_028_ VDD$4 pfet L=0.5U W=1.22U AS=0.5368P AD=0.4298375P
+ PS=3.32U PD=2.185U
* device instance $1655 r0 *1 111.635,34.6325 pfet
M$1655 \$868 q7 VDD$4 VDD$4 pfet L=0.5U W=0.615U AS=0.4298375P AD=0.0845625P
+ PS=2.185U PD=0.89U
* device instance $1656 r0 *1 112.41,34.6325 pfet
M$1656 \$779 \$780 \$868 VDD$4 pfet L=0.5U W=0.615U AS=0.0845625P AD=0.1599P
+ PS=0.89U PD=1.135U
* device instance $1657 r0 *1 113.43,34.6325 pfet
M$1657 \$869 ph[14] \$779 VDD$4 pfet L=0.5U W=0.615U AS=0.1599P AD=0.0738P
+ PS=1.135U PD=0.855U
* device instance $1658 r0 *1 114.17,34.6325 pfet
M$1658 VDD$4 c7_r \$869 VDD$4 pfet L=0.5U W=0.615U AS=0.0738P AD=0.1599P
+ PS=0.855U PD=1.135U
* device instance $1659 r0 *1 115.19,34.6325 pfet
M$1659 \$780 ph[14] VDD$4 VDD$4 pfet L=0.5U W=0.615U AS=0.1599P AD=0.2706P
+ PS=1.135U PD=2.11U
* device instance $1660 r0 *1 118.57,34.1525 pfet
M$1660 VDD$4 clknet_2_3__leaf_clk \$808 VDD$4 pfet L=0.5U W=0.865U AS=0.3806P
+ AD=0.2249P PS=2.61U PD=1.385U
* device instance $1661 r0 *1 119.59,34.1525 pfet
M$1661 \$809 \$808 VDD$4 VDD$4 pfet L=0.5U W=0.865U AS=0.2249P AD=0.3806P
+ PS=1.385U PD=2.61U
* device instance $1662 r0 *1 128.09,28.5675 pfet
M$1662 VDD$3 clknet_2_3__leaf_clk \$720 VDD$3 pfet L=0.5U W=0.865U AS=0.3806P
+ AD=0.2249P PS=2.61U PD=1.385U
* device instance $1663 r0 *1 129.11,28.5675 pfet
M$1663 \$723 \$720 VDD$3 VDD$3 pfet L=0.5U W=0.865U AS=0.2249P AD=0.3806P
+ PS=1.385U PD=2.61U
* device instance $1664 r0 *1 131.27,28.545 pfet
M$1664 \$757 \$723 VDD$3 VDD$3 pfet L=0.5U W=0.36U AS=0.4554P AD=0.054P
+ PS=3.25U PD=0.66U
* device instance $1665 r0 *1 132.07,28.545 pfet
M$1665 \$721 \_008_ \$757 VDD$3 pfet L=0.5U W=0.36U AS=0.054P AD=0.1872P
+ PS=0.66U PD=1.4U
* device instance $1666 r0 *1 133.61,28.545 pfet
M$1666 \$758 \$720 \$721 VDD$3 pfet L=0.5U W=0.36U AS=0.1872P AD=0.0432P
+ PS=1.4U PD=0.6U
* device instance $1667 r0 *1 134.35,28.545 pfet
M$1667 VDD$3 \$722 \$758 VDD$3 pfet L=0.5U W=0.36U AS=0.0432P AD=0.1044P
+ PS=0.6U PD=0.94U
* device instance $1668 r0 *1 135.43,28.545 pfet
M$1668 \$722 \$721 VDD$3 VDD$3 pfet L=0.5U W=0.36U AS=0.1044P AD=0.1791P
+ PS=0.94U PD=1.355U
* device instance $1669 r0 *1 136.925,28.545 pfet
M$1669 \$724 \$720 \$722 VDD$3 pfet L=0.5U W=0.36U AS=0.1791P AD=0.1665P
+ PS=1.355U PD=1.285U
* device instance $1670 r0 *1 138.35,28.545 pfet
M$1670 \$760 \$723 \$724 VDD$3 pfet L=0.5U W=0.36U AS=0.1665P AD=0.0504P
+ PS=1.285U PD=0.64U
* device instance $1671 r0 *1 139.13,28.545 pfet
M$1671 \$760 \$725 VDD$3 VDD$3 pfet L=0.5U W=0.36U AS=0.23P AD=0.0504P PS=1.54U
+ PD=0.64U
* device instance $1672 r0 *1 140.37,28.325 pfet
M$1672 \$725 \$724 VDD$3 VDD$3 pfet L=0.5U W=0.8U AS=0.23P AD=0.352P PS=1.54U
+ PD=2.48U
* device instance $1673 r0 *1 132.59,34.33 pfet
M$1673 ph[15] \$813 VDD$4 VDD$4 pfet L=0.5U W=1.22U AS=0.5368P AD=0.5368P
+ PS=3.32U PD=3.32U
* device instance $1674 r0 *1 148.25,34.1525 pfet
M$1674 VDD$4 clknet_2_3__leaf_clk \$814 VDD$4 pfet L=0.5U W=0.865U AS=0.3806P
+ AD=0.2249P PS=2.61U PD=1.385U
* device instance $1675 r0 *1 149.27,34.1525 pfet
M$1675 \$815 \$814 VDD$4 VDD$4 pfet L=0.5U W=0.865U AS=0.2249P AD=0.3806P
+ PS=1.385U PD=2.61U
* device instance $1676 r0 *1 154.87,28.3925 pfet
M$1676 \_018_ cmp \$727 VDD$3 pfet L=0.5U W=1.215U AS=0.5346P AD=0.3159P
+ PS=3.31U PD=1.735U
* device instance $1677 r0 *1 155.89,28.3925 pfet
M$1677 \$727 ph[6] \_018_ VDD$3 pfet L=0.5U W=1.215U AS=0.3159P AD=0.44955P
+ PS=1.735U PD=1.955U
* device instance $1678 r0 *1 157.13,28.3925 pfet
M$1678 VDD$3 \_058_ \$727 VDD$3 pfet L=0.5U W=1.215U AS=0.44955P AD=0.5346P
+ PS=1.955U PD=3.31U
* device instance $1679 r0 *1 162.27,34.33 pfet
M$1679 ph[8] \$819 VDD$4 VDD$4 pfet L=0.5U W=1.22U AS=0.5368P AD=0.5368P
+ PS=3.32U PD=3.32U
* device instance $1680 r0 *1 177.37,34.1525 pfet
M$1680 VDD$4 clknet_2_3__leaf_clk \$820 VDD$4 pfet L=0.5U W=0.865U AS=0.3806P
+ AD=0.2249P PS=2.61U PD=1.385U
* device instance $1681 r0 *1 178.39,34.1525 pfet
M$1681 \$821 \$820 VDD$4 VDD$4 pfet L=0.5U W=0.865U AS=0.2249P AD=0.3806P
+ PS=1.385U PD=2.61U
* device instance $1682 r0 *1 181.85,28.5675 pfet
M$1682 VDD$3 clknet_2_3__leaf_clk \$729 VDD$3 pfet L=0.5U W=0.865U AS=0.3806P
+ AD=0.2249P PS=2.61U PD=1.385U
* device instance $1683 r0 *1 182.87,28.5675 pfet
M$1683 \$732 \$729 VDD$3 VDD$3 pfet L=0.5U W=0.865U AS=0.2249P AD=0.3806P
+ PS=1.385U PD=2.61U
* device instance $1684 r0 *1 185.03,28.545 pfet
M$1684 \$753 \$732 VDD$3 VDD$3 pfet L=0.5U W=0.36U AS=0.4554P AD=0.054P
+ PS=3.25U PD=0.66U
* device instance $1685 r0 *1 185.83,28.545 pfet
M$1685 \$730 \_009_[5] \$753 VDD$3 pfet L=0.5U W=0.36U AS=0.054P AD=0.1872P
+ PS=0.66U PD=1.4U
* device instance $1686 r0 *1 187.37,28.545 pfet
M$1686 \$752 \$729 \$730 VDD$3 pfet L=0.5U W=0.36U AS=0.1872P AD=0.0432P
+ PS=1.4U PD=0.6U
* device instance $1687 r0 *1 188.11,28.545 pfet
M$1687 VDD$3 \$731 \$752 VDD$3 pfet L=0.5U W=0.36U AS=0.0432P AD=0.1044P
+ PS=0.6U PD=0.94U
* device instance $1688 r0 *1 189.19,28.545 pfet
M$1688 \$731 \$730 VDD$3 VDD$3 pfet L=0.5U W=0.36U AS=0.1044P AD=0.1791P
+ PS=0.94U PD=1.355U
* device instance $1689 r0 *1 190.685,28.545 pfet
M$1689 \$733 \$729 \$731 VDD$3 pfet L=0.5U W=0.36U AS=0.1791P AD=0.1665P
+ PS=1.355U PD=1.285U
* device instance $1690 r0 *1 192.11,28.545 pfet
M$1690 \$750 \$732 \$733 VDD$3 pfet L=0.5U W=0.36U AS=0.1665P AD=0.0504P
+ PS=1.285U PD=0.64U
* device instance $1691 r0 *1 192.89,28.545 pfet
M$1691 \$750 \$734 VDD$3 VDD$3 pfet L=0.5U W=0.36U AS=0.23P AD=0.0504P PS=1.54U
+ PD=0.64U
* device instance $1692 r0 *1 194.13,28.325 pfet
M$1692 \$734 \$733 VDD$3 VDD$3 pfet L=0.5U W=0.8U AS=0.23P AD=0.352P PS=1.54U
+ PD=2.48U
* device instance $1693 r0 *1 191.39,34.33 pfet
M$1693 ph[2] \$825 VDD$4 VDD$4 pfet L=0.5U W=1.22U AS=0.5368P AD=0.5368P
+ PS=3.32U PD=3.32U
* device instance $1694 r0 *1 8.07,34.175 pfet
M$1694 \$852 \$784 VDD$4 VDD$4 pfet L=0.5U W=0.36U AS=0.4554P AD=0.054P
+ PS=3.25U PD=0.66U
* device instance $1695 r0 *1 8.87,34.175 pfet
M$1695 \$785 \_025_ \$852 VDD$4 pfet L=0.5U W=0.36U AS=0.054P AD=0.1872P
+ PS=0.66U PD=1.4U
* device instance $1696 r0 *1 10.41,34.175 pfet
M$1696 \$853 \$783 \$785 VDD$4 pfet L=0.5U W=0.36U AS=0.1872P AD=0.0432P
+ PS=1.4U PD=0.6U
* device instance $1697 r0 *1 11.15,34.175 pfet
M$1697 VDD$4 \$786 \$853 VDD$4 pfet L=0.5U W=0.36U AS=0.0432P AD=0.1044P
+ PS=0.6U PD=0.94U
* device instance $1698 r0 *1 12.23,34.175 pfet
M$1698 \$786 \$785 VDD$4 VDD$4 pfet L=0.5U W=0.36U AS=0.1044P AD=0.1791P
+ PS=0.94U PD=1.355U
* device instance $1699 r0 *1 13.725,34.175 pfet
M$1699 \$787 \$783 \$786 VDD$4 pfet L=0.5U W=0.36U AS=0.1791P AD=0.1665P
+ PS=1.355U PD=1.285U
* device instance $1700 r0 *1 15.15,34.175 pfet
M$1700 \$854 \$784 \$787 VDD$4 pfet L=0.5U W=0.36U AS=0.1665P AD=0.0504P
+ PS=1.285U PD=0.64U
* device instance $1701 r0 *1 15.93,34.175 pfet
M$1701 VDD$4 \$788 \$854 VDD$4 pfet L=0.5U W=0.36U AS=0.0504P AD=0.23P PS=0.64U
+ PD=1.54U
* device instance $1702 r0 *1 17.17,34.395 pfet
M$1702 \$788 \$787 VDD$4 VDD$4 pfet L=0.5U W=0.8U AS=0.23P AD=0.352P PS=1.54U
+ PD=2.48U
* device instance $1703 r0 *1 30.47,34.175 pfet
M$1703 \$855 \$790 VDD$4 VDD$4 pfet L=0.5U W=0.36U AS=0.4554P AD=0.054P
+ PS=3.25U PD=0.66U
* device instance $1704 r0 *1 31.27,34.175 pfet
M$1704 \$791 \_009_[13] \$855 VDD$4 pfet L=0.5U W=0.36U AS=0.054P AD=0.1872P
+ PS=0.66U PD=1.4U
* device instance $1705 r0 *1 32.81,34.175 pfet
M$1705 \$856 \$789 \$791 VDD$4 pfet L=0.5U W=0.36U AS=0.1872P AD=0.0432P
+ PS=1.4U PD=0.6U
* device instance $1706 r0 *1 33.55,34.175 pfet
M$1706 VDD$4 \$792 \$856 VDD$4 pfet L=0.5U W=0.36U AS=0.0432P AD=0.1044P
+ PS=0.6U PD=0.94U
* device instance $1707 r0 *1 34.63,34.175 pfet
M$1707 \$792 \$791 VDD$4 VDD$4 pfet L=0.5U W=0.36U AS=0.1044P AD=0.1791P
+ PS=0.94U PD=1.355U
* device instance $1708 r0 *1 36.125,34.175 pfet
M$1708 \$793 \$789 \$792 VDD$4 pfet L=0.5U W=0.36U AS=0.1791P AD=0.1665P
+ PS=1.355U PD=1.285U
* device instance $1709 r0 *1 37.55,34.175 pfet
M$1709 \$857 \$790 \$793 VDD$4 pfet L=0.5U W=0.36U AS=0.1665P AD=0.0504P
+ PS=1.285U PD=0.64U
* device instance $1710 r0 *1 38.33,34.175 pfet
M$1710 VDD$4 \$794 \$857 VDD$4 pfet L=0.5U W=0.36U AS=0.0504P AD=0.23P PS=0.64U
+ PD=1.54U
* device instance $1711 r0 *1 39.57,34.395 pfet
M$1711 \$794 \$793 VDD$4 VDD$4 pfet L=0.5U W=0.8U AS=0.23P AD=0.352P PS=1.54U
+ PD=2.48U
* device instance $1712 r0 *1 54.55,34.175 pfet
M$1712 \$861 \$796 VDD$4 VDD$4 pfet L=0.5U W=0.36U AS=0.4554P AD=0.054P
+ PS=3.25U PD=0.66U
* device instance $1713 r0 *1 55.35,34.175 pfet
M$1713 \$797 \_013_ \$861 VDD$4 pfet L=0.5U W=0.36U AS=0.054P AD=0.1872P
+ PS=0.66U PD=1.4U
* device instance $1714 r0 *1 56.89,34.175 pfet
M$1714 \$863 \$795 \$797 VDD$4 pfet L=0.5U W=0.36U AS=0.1872P AD=0.0432P
+ PS=1.4U PD=0.6U
* device instance $1715 r0 *1 57.63,34.175 pfet
M$1715 VDD$4 \$798 \$863 VDD$4 pfet L=0.5U W=0.36U AS=0.0432P AD=0.1044P
+ PS=0.6U PD=0.94U
* device instance $1716 r0 *1 58.71,34.175 pfet
M$1716 \$798 \$797 VDD$4 VDD$4 pfet L=0.5U W=0.36U AS=0.1044P AD=0.1791P
+ PS=0.94U PD=1.355U
* device instance $1717 r0 *1 60.205,34.175 pfet
M$1717 \$799 \$795 \$798 VDD$4 pfet L=0.5U W=0.36U AS=0.1791P AD=0.1665P
+ PS=1.355U PD=1.285U
* device instance $1718 r0 *1 61.63,34.175 pfet
M$1718 \$864 \$796 \$799 VDD$4 pfet L=0.5U W=0.36U AS=0.1665P AD=0.0504P
+ PS=1.285U PD=0.64U
* device instance $1719 r0 *1 62.41,34.175 pfet
M$1719 VDD$4 \$800 \$864 VDD$4 pfet L=0.5U W=0.36U AS=0.0504P AD=0.23P PS=0.64U
+ PD=1.54U
* device instance $1720 r0 *1 63.65,34.395 pfet
M$1720 \$800 \$799 VDD$4 VDD$4 pfet L=0.5U W=0.8U AS=0.23P AD=0.352P PS=1.54U
+ PD=2.48U
* device instance $1721 r0 *1 79.75,34.175 pfet
M$1721 \$865 \$802 VDD$4 VDD$4 pfet L=0.5U W=0.36U AS=0.4554P AD=0.054P
+ PS=3.25U PD=0.66U
* device instance $1722 r0 *1 80.55,34.175 pfet
M$1722 \$803 \_011_ \$865 VDD$4 pfet L=0.5U W=0.36U AS=0.054P AD=0.1872P
+ PS=0.66U PD=1.4U
* device instance $1723 r0 *1 82.09,34.175 pfet
M$1723 \$866 \$801 \$803 VDD$4 pfet L=0.5U W=0.36U AS=0.1872P AD=0.0432P
+ PS=1.4U PD=0.6U
* device instance $1724 r0 *1 82.83,34.175 pfet
M$1724 VDD$4 \$804 \$866 VDD$4 pfet L=0.5U W=0.36U AS=0.0432P AD=0.1044P
+ PS=0.6U PD=0.94U
* device instance $1725 r0 *1 83.91,34.175 pfet
M$1725 \$804 \$803 VDD$4 VDD$4 pfet L=0.5U W=0.36U AS=0.1044P AD=0.1791P
+ PS=0.94U PD=1.355U
* device instance $1726 r0 *1 85.405,34.175 pfet
M$1726 \$805 \$801 \$804 VDD$4 pfet L=0.5U W=0.36U AS=0.1791P AD=0.1665P
+ PS=1.355U PD=1.285U
* device instance $1727 r0 *1 86.83,34.175 pfet
M$1727 \$867 \$802 \$805 VDD$4 pfet L=0.5U W=0.36U AS=0.1665P AD=0.0504P
+ PS=1.285U PD=0.64U
* device instance $1728 r0 *1 87.61,34.175 pfet
M$1728 VDD$4 \$806 \$867 VDD$4 pfet L=0.5U W=0.36U AS=0.0504P AD=0.23P PS=0.64U
+ PD=1.54U
* device instance $1729 r0 *1 88.85,34.395 pfet
M$1729 \$806 \$805 VDD$4 VDD$4 pfet L=0.5U W=0.8U AS=0.23P AD=0.352P PS=1.54U
+ PD=2.48U
* device instance $1730 r0 *1 121.75,34.175 pfet
M$1730 \$871 \$809 VDD$4 VDD$4 pfet L=0.5U W=0.36U AS=0.4554P AD=0.054P
+ PS=3.25U PD=0.66U
* device instance $1731 r0 *1 122.55,34.175 pfet
M$1731 \$810 \_009_[15] \$871 VDD$4 pfet L=0.5U W=0.36U AS=0.054P AD=0.1872P
+ PS=0.66U PD=1.4U
* device instance $1732 r0 *1 124.09,34.175 pfet
M$1732 \$872 \$808 \$810 VDD$4 pfet L=0.5U W=0.36U AS=0.1872P AD=0.0432P
+ PS=1.4U PD=0.6U
* device instance $1733 r0 *1 124.83,34.175 pfet
M$1733 VDD$4 \$811 \$872 VDD$4 pfet L=0.5U W=0.36U AS=0.0432P AD=0.1044P
+ PS=0.6U PD=0.94U
* device instance $1734 r0 *1 125.91,34.175 pfet
M$1734 \$811 \$810 VDD$4 VDD$4 pfet L=0.5U W=0.36U AS=0.1044P AD=0.1791P
+ PS=0.94U PD=1.355U
* device instance $1735 r0 *1 127.405,34.175 pfet
M$1735 \$812 \$808 \$811 VDD$4 pfet L=0.5U W=0.36U AS=0.1791P AD=0.1665P
+ PS=1.355U PD=1.285U
* device instance $1736 r0 *1 128.83,34.175 pfet
M$1736 \$873 \$809 \$812 VDD$4 pfet L=0.5U W=0.36U AS=0.1665P AD=0.0504P
+ PS=1.285U PD=0.64U
* device instance $1737 r0 *1 129.61,34.175 pfet
M$1737 VDD$4 \$813 \$873 VDD$4 pfet L=0.5U W=0.36U AS=0.0504P AD=0.23P PS=0.64U
+ PD=1.54U
* device instance $1738 r0 *1 130.85,34.395 pfet
M$1738 \$813 \$812 VDD$4 VDD$4 pfet L=0.5U W=0.8U AS=0.23P AD=0.352P PS=1.54U
+ PD=2.48U
* device instance $1739 r0 *1 151.43,34.175 pfet
M$1739 \$874 \$815 VDD$4 VDD$4 pfet L=0.5U W=0.36U AS=0.4554P AD=0.054P
+ PS=3.25U PD=0.66U
* device instance $1740 r0 *1 152.23,34.175 pfet
M$1740 \$816 \_009_[8] \$874 VDD$4 pfet L=0.5U W=0.36U AS=0.054P AD=0.1872P
+ PS=0.66U PD=1.4U
* device instance $1741 r0 *1 153.77,34.175 pfet
M$1741 \$875 \$814 \$816 VDD$4 pfet L=0.5U W=0.36U AS=0.1872P AD=0.0432P
+ PS=1.4U PD=0.6U
* device instance $1742 r0 *1 154.51,34.175 pfet
M$1742 VDD$4 \$817 \$875 VDD$4 pfet L=0.5U W=0.36U AS=0.0432P AD=0.1044P
+ PS=0.6U PD=0.94U
* device instance $1743 r0 *1 155.59,34.175 pfet
M$1743 \$817 \$816 VDD$4 VDD$4 pfet L=0.5U W=0.36U AS=0.1044P AD=0.1791P
+ PS=0.94U PD=1.355U
* device instance $1744 r0 *1 157.085,34.175 pfet
M$1744 \$818 \$814 \$817 VDD$4 pfet L=0.5U W=0.36U AS=0.1791P AD=0.1665P
+ PS=1.355U PD=1.285U
* device instance $1745 r0 *1 158.51,34.175 pfet
M$1745 \$870 \$815 \$818 VDD$4 pfet L=0.5U W=0.36U AS=0.1665P AD=0.0504P
+ PS=1.285U PD=0.64U
* device instance $1746 r0 *1 159.29,34.175 pfet
M$1746 VDD$4 \$819 \$870 VDD$4 pfet L=0.5U W=0.36U AS=0.0504P AD=0.23P PS=0.64U
+ PD=1.54U
* device instance $1747 r0 *1 160.53,34.395 pfet
M$1747 \$819 \$818 VDD$4 VDD$4 pfet L=0.5U W=0.8U AS=0.23P AD=0.352P PS=1.54U
+ PD=2.48U
* device instance $1748 r0 *1 180.55,34.175 pfet
M$1748 \$862 \$821 VDD$4 VDD$4 pfet L=0.5U W=0.36U AS=0.4554P AD=0.054P
+ PS=3.25U PD=0.66U
* device instance $1749 r0 *1 181.35,34.175 pfet
M$1749 \$822 \_009_[2] \$862 VDD$4 pfet L=0.5U W=0.36U AS=0.054P AD=0.1872P
+ PS=0.66U PD=1.4U
* device instance $1750 r0 *1 182.89,34.175 pfet
M$1750 \$859 \$820 \$822 VDD$4 pfet L=0.5U W=0.36U AS=0.1872P AD=0.0432P
+ PS=1.4U PD=0.6U
* device instance $1751 r0 *1 183.63,34.175 pfet
M$1751 VDD$4 \$823 \$859 VDD$4 pfet L=0.5U W=0.36U AS=0.0432P AD=0.1044P
+ PS=0.6U PD=0.94U
* device instance $1752 r0 *1 184.71,34.175 pfet
M$1752 \$823 \$822 VDD$4 VDD$4 pfet L=0.5U W=0.36U AS=0.1044P AD=0.1791P
+ PS=0.94U PD=1.355U
* device instance $1753 r0 *1 186.205,34.175 pfet
M$1753 \$824 \$820 \$823 VDD$4 pfet L=0.5U W=0.36U AS=0.1791P AD=0.1665P
+ PS=1.355U PD=1.285U
* device instance $1754 r0 *1 187.63,34.175 pfet
M$1754 \$858 \$821 \$824 VDD$4 pfet L=0.5U W=0.36U AS=0.1665P AD=0.0504P
+ PS=1.285U PD=0.64U
* device instance $1755 r0 *1 188.41,34.175 pfet
M$1755 VDD$4 \$825 \$858 VDD$4 pfet L=0.5U W=0.36U AS=0.0504P AD=0.23P PS=0.64U
+ PD=1.54U
* device instance $1756 r0 *1 189.65,34.395 pfet
M$1756 \$825 \$824 VDD$4 VDD$4 pfet L=0.5U W=0.8U AS=0.23P AD=0.352P PS=1.54U
+ PD=2.48U
* device instance $1757 r0 *1 2.09,36.4075 pfet
M$1757 VDD$4 clknet_2_1__leaf_clk \$876 VDD$4 pfet L=0.5U W=0.865U AS=0.3806P
+ AD=0.2249P PS=2.61U PD=1.385U
* device instance $1758 r0 *1 3.11,36.4075 pfet
M$1758 \$878 \$876 VDD$4 VDD$4 pfet L=0.5U W=0.865U AS=0.2249P AD=0.3806P
+ PS=1.385U PD=2.61U
* device instance $1759 r0 *1 5.27,36.385 pfet
M$1759 \$921 \$878 VDD$4 VDD$4 pfet L=0.5U W=0.36U AS=0.4554P AD=0.054P
+ PS=3.25U PD=0.66U
* device instance $1760 r0 *1 6.07,36.385 pfet
M$1760 \$907 \_009_[9] \$921 VDD$4 pfet L=0.5U W=0.36U AS=0.054P AD=0.1872P
+ PS=0.66U PD=1.4U
* device instance $1761 r0 *1 7.61,36.385 pfet
M$1761 \$922 \$876 \$907 VDD$4 pfet L=0.5U W=0.36U AS=0.1872P AD=0.0432P
+ PS=1.4U PD=0.6U
* device instance $1762 r0 *1 8.35,36.385 pfet
M$1762 VDD$4 \$877 \$922 VDD$4 pfet L=0.5U W=0.36U AS=0.0432P AD=0.1044P
+ PS=0.6U PD=0.94U
* device instance $1763 r0 *1 9.43,36.385 pfet
M$1763 \$877 \$907 VDD$4 VDD$4 pfet L=0.5U W=0.36U AS=0.1044P AD=0.1791P
+ PS=0.94U PD=1.355U
* device instance $1764 r0 *1 10.925,36.385 pfet
M$1764 \$908 \$876 \$877 VDD$4 pfet L=0.5U W=0.36U AS=0.1791P AD=0.1665P
+ PS=1.355U PD=1.285U
* device instance $1765 r0 *1 12.35,36.385 pfet
M$1765 \$923 \$878 \$908 VDD$4 pfet L=0.5U W=0.36U AS=0.1665P AD=0.0504P
+ PS=1.285U PD=0.64U
* device instance $1766 r0 *1 13.13,36.385 pfet
M$1766 \$923 \$879 VDD$4 VDD$4 pfet L=0.5U W=0.36U AS=0.23P AD=0.0504P PS=1.54U
+ PD=0.64U
* device instance $1767 r0 *1 14.37,36.165 pfet
M$1767 \$879 \$908 VDD$4 VDD$4 pfet L=0.5U W=0.8U AS=0.23P AD=0.352P PS=1.54U
+ PD=2.48U
* device instance $1768 r0 *1 16.11,36.23 pfet
M$1768 ph[9] \$879 VDD$4 VDD$4 pfet L=0.5U W=1.22U AS=0.5368P AD=0.5368P
+ PS=3.32U PD=3.32U
* device instance $1769 r0 *1 21.69,36.4075 pfet
M$1769 VDD$4 clknet_2_1__leaf_clk \$880 VDD$4 pfet L=0.5U W=0.865U AS=0.3806P
+ AD=0.2249P PS=2.61U PD=1.385U
* device instance $1770 r0 *1 22.71,36.4075 pfet
M$1770 \$882 \$880 VDD$4 VDD$4 pfet L=0.5U W=0.865U AS=0.2249P AD=0.3806P
+ PS=1.385U PD=2.61U
* device instance $1771 r0 *1 24.87,36.385 pfet
M$1771 \$925 \$882 VDD$4 VDD$4 pfet L=0.5U W=0.36U AS=0.4554P AD=0.054P
+ PS=3.25U PD=0.66U
* device instance $1772 r0 *1 25.67,36.385 pfet
M$1772 \$909 \_020_ \$925 VDD$4 pfet L=0.5U W=0.36U AS=0.054P AD=0.1872P
+ PS=0.66U PD=1.4U
* device instance $1773 r0 *1 27.21,36.385 pfet
M$1773 \$926 \$880 \$909 VDD$4 pfet L=0.5U W=0.36U AS=0.1872P AD=0.0432P
+ PS=1.4U PD=0.6U
* device instance $1774 r0 *1 27.95,36.385 pfet
M$1774 VDD$4 \$881 \$926 VDD$4 pfet L=0.5U W=0.36U AS=0.0432P AD=0.1044P
+ PS=0.6U PD=0.94U
* device instance $1775 r0 *1 29.03,36.385 pfet
M$1775 \$881 \$909 VDD$4 VDD$4 pfet L=0.5U W=0.36U AS=0.1044P AD=0.1791P
+ PS=0.94U PD=1.355U
* device instance $1776 r0 *1 30.525,36.385 pfet
M$1776 \$910 \$880 \$881 VDD$4 pfet L=0.5U W=0.36U AS=0.1791P AD=0.1665P
+ PS=1.355U PD=1.285U
* device instance $1777 r0 *1 31.95,36.385 pfet
M$1777 \$928 \$882 \$910 VDD$4 pfet L=0.5U W=0.36U AS=0.1665P AD=0.0504P
+ PS=1.285U PD=0.64U
* device instance $1778 r0 *1 32.73,36.385 pfet
M$1778 \$928 \$883 VDD$4 VDD$4 pfet L=0.5U W=0.36U AS=0.23P AD=0.0504P PS=1.54U
+ PD=0.64U
* device instance $1779 r0 *1 33.97,36.165 pfet
M$1779 \$883 \$910 VDD$4 VDD$4 pfet L=0.5U W=0.8U AS=0.23P AD=0.352P PS=1.54U
+ PD=2.48U
* device instance $1780 r0 *1 35.71,36.23 pfet
M$1780 q1 \$883 VDD$4 VDD$4 pfet L=0.5U W=1.22U AS=0.5368P AD=0.5368P PS=3.32U
+ PD=3.32U
* device instance $1781 r0 *1 40.07,36.23 pfet
M$1781 \$884 clknet_2_0__leaf_clk VDD$4 VDD$4 pfet L=0.5U W=1.22U AS=0.5368P
+ AD=0.3782P PS=3.32U PD=1.84U
* device instance $1782 r0 *1 41.19,36.23 pfet
M$1782 VDD$4 clknet_2_0__leaf_clk \$884 VDD$4 pfet L=0.5U W=1.22U AS=0.3782P
+ AD=0.3782P PS=1.84U PD=1.84U
* device instance $1783 r0 *1 42.31,36.23 pfet
M$1783 Z \$884 VDD$4 VDD$4 pfet L=0.5U W=1.22U AS=0.3782P AD=0.3782P PS=1.84U
+ PD=1.84U
* device instance $1784 r0 *1 43.43,36.23 pfet
M$1784 VDD$4 \$884 Z VDD$4 pfet L=0.5U W=1.22U AS=0.3782P AD=0.3782P PS=1.84U
+ PD=1.84U
* device instance $1785 r0 *1 44.55,36.23 pfet
M$1785 Z \$884 VDD$4 VDD$4 pfet L=0.5U W=1.22U AS=0.3782P AD=0.3782P PS=1.84U
+ PD=1.84U
* device instance $1786 r0 *1 45.67,36.23 pfet
M$1786 VDD$4 \$884 Z VDD$4 pfet L=0.5U W=1.22U AS=0.3782P AD=0.5368P PS=1.84U
+ PD=3.32U
* device instance $1787 r0 *1 48.01,36.4075 pfet
M$1787 VDD$4 clknet_2_1__leaf_clk \$886 VDD$4 pfet L=0.5U W=0.865U AS=0.3806P
+ AD=0.2249P PS=2.61U PD=1.385U
* device instance $1788 r0 *1 49.03,36.4075 pfet
M$1788 \$888 \$886 VDD$4 VDD$4 pfet L=0.5U W=0.865U AS=0.2249P AD=0.3806P
+ PS=1.385U PD=2.61U
* device instance $1789 r0 *1 51.19,36.385 pfet
M$1789 \$930 \$888 VDD$4 VDD$4 pfet L=0.5U W=0.36U AS=0.4554P AD=0.054P
+ PS=3.25U PD=0.66U
* device instance $1790 r0 *1 51.99,36.385 pfet
M$1790 \$911 \_009_[14] \$930 VDD$4 pfet L=0.5U W=0.36U AS=0.054P AD=0.1872P
+ PS=0.66U PD=1.4U
* device instance $1791 r0 *1 53.53,36.385 pfet
M$1791 \$931 \$886 \$911 VDD$4 pfet L=0.5U W=0.36U AS=0.1872P AD=0.0432P
+ PS=1.4U PD=0.6U
* device instance $1792 r0 *1 54.27,36.385 pfet
M$1792 VDD$4 \$887 \$931 VDD$4 pfet L=0.5U W=0.36U AS=0.0432P AD=0.1044P
+ PS=0.6U PD=0.94U
* device instance $1793 r0 *1 55.35,36.385 pfet
M$1793 \$887 \$911 VDD$4 VDD$4 pfet L=0.5U W=0.36U AS=0.1044P AD=0.1791P
+ PS=0.94U PD=1.355U
* device instance $1794 r0 *1 56.845,36.385 pfet
M$1794 \$912 \$886 \$887 VDD$4 pfet L=0.5U W=0.36U AS=0.1791P AD=0.1665P
+ PS=1.355U PD=1.285U
* device instance $1795 r0 *1 58.27,36.385 pfet
M$1795 \$932 \$888 \$912 VDD$4 pfet L=0.5U W=0.36U AS=0.1665P AD=0.0504P
+ PS=1.285U PD=0.64U
* device instance $1796 r0 *1 59.05,36.385 pfet
M$1796 \$932 \$889 VDD$4 VDD$4 pfet L=0.5U W=0.36U AS=0.23P AD=0.0504P PS=1.54U
+ PD=0.64U
* device instance $1797 r0 *1 60.29,36.165 pfet
M$1797 \$889 \$912 VDD$4 VDD$4 pfet L=0.5U W=0.8U AS=0.23P AD=0.352P PS=1.54U
+ PD=2.48U
* device instance $1798 r0 *1 62.03,36.23 pfet
M$1798 ph[14] \$889 VDD$4 VDD$4 pfet L=0.5U W=1.22U AS=0.5368P AD=0.5368P
+ PS=3.32U PD=3.32U
* device instance $1799 r0 *1 65.715,35.9275 pfet
M$1799 \$933 q3 VDD$4 VDD$4 pfet L=0.5U W=0.615U AS=0.4298375P AD=0.0845625P
+ PS=2.185U PD=0.89U
* device instance $1800 r0 *1 66.49,35.9275 pfet
M$1800 \$890 \$851 \$933 VDD$4 pfet L=0.5U W=0.615U AS=0.0845625P AD=0.1599P
+ PS=0.89U PD=1.135U
* device instance $1801 r0 *1 67.51,35.9275 pfet
M$1801 \$934 ph[14] \$890 VDD$4 pfet L=0.5U W=0.615U AS=0.1599P AD=0.0738P
+ PS=1.135U PD=0.855U
* device instance $1802 r0 *1 68.25,35.9275 pfet
M$1802 VDD$4 c3_r \$934 VDD$4 pfet L=0.5U W=0.615U AS=0.0738P AD=0.1599P
+ PS=0.855U PD=1.135U
* device instance $1803 r0 *1 69.27,35.9275 pfet
M$1803 \$851 ph[14] VDD$4 VDD$4 pfet L=0.5U W=0.615U AS=0.1599P AD=0.2706P
+ PS=1.135U PD=2.11U
* device instance $1804 r0 *1 64.25,36.23 pfet
M$1804 VDD$4 \$890 \_021_ VDD$4 pfet L=0.5U W=1.22U AS=0.5368P AD=0.4298375P
+ PS=3.32U PD=2.185U
* device instance $1805 r0 *1 73.21,36.4075 pfet
M$1805 VDD$4 clknet_2_1__leaf_clk \$891 VDD$4 pfet L=0.5U W=0.865U AS=0.3806P
+ AD=0.2249P PS=2.61U PD=1.385U
* device instance $1806 r0 *1 74.23,36.4075 pfet
M$1806 \$893 \$891 VDD$4 VDD$4 pfet L=0.5U W=0.865U AS=0.2249P AD=0.3806P
+ PS=1.385U PD=2.61U
* device instance $1807 r0 *1 76.39,36.385 pfet
M$1807 \$936 \$893 VDD$4 VDD$4 pfet L=0.5U W=0.36U AS=0.4554P AD=0.054P
+ PS=3.25U PD=0.66U
* device instance $1808 r0 *1 77.19,36.385 pfet
M$1808 \$913 \_010_ \$936 VDD$4 pfet L=0.5U W=0.36U AS=0.054P AD=0.1872P
+ PS=0.66U PD=1.4U
* device instance $1809 r0 *1 78.73,36.385 pfet
M$1809 \$937 \$891 \$913 VDD$4 pfet L=0.5U W=0.36U AS=0.1872P AD=0.0432P
+ PS=1.4U PD=0.6U
* device instance $1810 r0 *1 79.47,36.385 pfet
M$1810 VDD$4 \$892 \$937 VDD$4 pfet L=0.5U W=0.36U AS=0.0432P AD=0.1044P
+ PS=0.6U PD=0.94U
* device instance $1811 r0 *1 80.55,36.385 pfet
M$1811 \$892 \$913 VDD$4 VDD$4 pfet L=0.5U W=0.36U AS=0.1044P AD=0.1791P
+ PS=0.94U PD=1.355U
* device instance $1812 r0 *1 82.045,36.385 pfet
M$1812 \$914 \$891 \$892 VDD$4 pfet L=0.5U W=0.36U AS=0.1791P AD=0.1665P
+ PS=1.355U PD=1.285U
* device instance $1813 r0 *1 83.47,36.385 pfet
M$1813 \$938 \$893 \$914 VDD$4 pfet L=0.5U W=0.36U AS=0.1665P AD=0.0504P
+ PS=1.285U PD=0.64U
* device instance $1814 r0 *1 84.25,36.385 pfet
M$1814 \$938 \$894 VDD$4 VDD$4 pfet L=0.5U W=0.36U AS=0.23P AD=0.0504P PS=1.54U
+ PD=0.64U
* device instance $1815 r0 *1 85.49,36.165 pfet
M$1815 \$894 \$914 VDD$4 VDD$4 pfet L=0.5U W=0.8U AS=0.23P AD=0.352P PS=1.54U
+ PD=2.48U
* device instance $1816 r0 *1 87.23,36.23 pfet
M$1816 c8_r \$894 VDD$4 VDD$4 pfet L=0.5U W=1.22U AS=0.5368P AD=0.5368P
+ PS=3.32U PD=3.32U
* device instance $1817 r0 *1 107.93,36.4075 pfet
M$1817 VDD$4 clknet_2_3__leaf_clk \$895 VDD$4 pfet L=0.5U W=0.865U AS=0.3806P
+ AD=0.2249P PS=2.61U PD=1.385U
* device instance $1818 r0 *1 108.95,36.4075 pfet
M$1818 \$897 \$895 VDD$4 VDD$4 pfet L=0.5U W=0.865U AS=0.2249P AD=0.3806P
+ PS=1.385U PD=2.61U
* device instance $1819 r0 *1 111.11,36.385 pfet
M$1819 \$939 \$897 VDD$4 VDD$4 pfet L=0.5U W=0.36U AS=0.4554P AD=0.054P
+ PS=3.25U PD=0.66U
* device instance $1820 r0 *1 111.91,36.385 pfet
M$1820 \$915 \_028_ \$939 VDD$4 pfet L=0.5U W=0.36U AS=0.054P AD=0.1872P
+ PS=0.66U PD=1.4U
* device instance $1821 r0 *1 113.45,36.385 pfet
M$1821 \$942 \$895 \$915 VDD$4 pfet L=0.5U W=0.36U AS=0.1872P AD=0.0432P
+ PS=1.4U PD=0.6U
* device instance $1822 r0 *1 114.19,36.385 pfet
M$1822 VDD$4 \$896 \$942 VDD$4 pfet L=0.5U W=0.36U AS=0.0432P AD=0.1044P
+ PS=0.6U PD=0.94U
* device instance $1823 r0 *1 115.27,36.385 pfet
M$1823 \$896 \$915 VDD$4 VDD$4 pfet L=0.5U W=0.36U AS=0.1044P AD=0.1791P
+ PS=0.94U PD=1.355U
* device instance $1824 r0 *1 116.765,36.385 pfet
M$1824 \$916 \$895 \$896 VDD$4 pfet L=0.5U W=0.36U AS=0.1791P AD=0.1665P
+ PS=1.355U PD=1.285U
* device instance $1825 r0 *1 118.19,36.385 pfet
M$1825 \$943 \$897 \$916 VDD$4 pfet L=0.5U W=0.36U AS=0.1665P AD=0.0504P
+ PS=1.285U PD=0.64U
* device instance $1826 r0 *1 118.97,36.385 pfet
M$1826 \$943 \$898 VDD$4 VDD$4 pfet L=0.5U W=0.36U AS=0.23P AD=0.0504P PS=1.54U
+ PD=0.64U
* device instance $1827 r0 *1 120.21,36.165 pfet
M$1827 \$898 \$916 VDD$4 VDD$4 pfet L=0.5U W=0.8U AS=0.23P AD=0.352P PS=1.54U
+ PD=2.48U
* device instance $1828 r0 *1 121.95,36.23 pfet
M$1828 c7_r \$898 VDD$4 VDD$4 pfet L=0.5U W=1.22U AS=0.5368P AD=0.5368P
+ PS=3.32U PD=3.32U
* device instance $1829 r0 *1 149.37,36.4075 pfet
M$1829 VDD$4 clknet_2_3__leaf_clk \$899 VDD$4 pfet L=0.5U W=0.865U AS=0.3806P
+ AD=0.2249P PS=2.61U PD=1.385U
* device instance $1830 r0 *1 150.39,36.4075 pfet
M$1830 \$901 \$899 VDD$4 VDD$4 pfet L=0.5U W=0.865U AS=0.2249P AD=0.3806P
+ PS=1.385U PD=2.61U
* device instance $1831 r0 *1 152.55,36.385 pfet
M$1831 \$941 \$901 VDD$4 VDD$4 pfet L=0.5U W=0.36U AS=0.4554P AD=0.054P
+ PS=3.25U PD=0.66U
* device instance $1832 r0 *1 153.35,36.385 pfet
M$1832 \$917 \_018_ \$941 VDD$4 pfet L=0.5U W=0.36U AS=0.054P AD=0.1872P
+ PS=0.66U PD=1.4U
* device instance $1833 r0 *1 154.89,36.385 pfet
M$1833 \$940 \$899 \$917 VDD$4 pfet L=0.5U W=0.36U AS=0.1872P AD=0.0432P
+ PS=1.4U PD=0.6U
* device instance $1834 r0 *1 155.63,36.385 pfet
M$1834 VDD$4 \$900 \$940 VDD$4 pfet L=0.5U W=0.36U AS=0.0432P AD=0.1044P
+ PS=0.6U PD=0.94U
* device instance $1835 r0 *1 156.71,36.385 pfet
M$1835 \$900 \$917 VDD$4 VDD$4 pfet L=0.5U W=0.36U AS=0.1044P AD=0.1791P
+ PS=0.94U PD=1.355U
* device instance $1836 r0 *1 158.205,36.385 pfet
M$1836 \$918 \$899 \$900 VDD$4 pfet L=0.5U W=0.36U AS=0.1791P AD=0.1665P
+ PS=1.355U PD=1.285U
* device instance $1837 r0 *1 159.63,36.385 pfet
M$1837 \$935 \$901 \$918 VDD$4 pfet L=0.5U W=0.36U AS=0.1665P AD=0.0504P
+ PS=1.285U PD=0.64U
* device instance $1838 r0 *1 160.41,36.385 pfet
M$1838 \$935 \$902 VDD$4 VDD$4 pfet L=0.5U W=0.36U AS=0.23P AD=0.0504P PS=1.54U
+ PD=0.64U
* device instance $1839 r0 *1 161.65,36.165 pfet
M$1839 \$902 \$918 VDD$4 VDD$4 pfet L=0.5U W=0.8U AS=0.23P AD=0.352P PS=1.54U
+ PD=2.48U
* device instance $1840 r0 *1 163.39,36.23 pfet
M$1840 q7 \$902 VDD$4 VDD$4 pfet L=0.5U W=1.22U AS=0.5368P AD=0.5368P PS=3.32U
+ PD=3.32U
* device instance $1841 r0 *1 179.05,36.4075 pfet
M$1841 VDD$4 clknet_2_3__leaf_clk \$903 VDD$4 pfet L=0.5U W=0.865U AS=0.3806P
+ AD=0.2249P PS=2.61U PD=1.385U
* device instance $1842 r0 *1 180.07,36.4075 pfet
M$1842 \$905 \$903 VDD$4 VDD$4 pfet L=0.5U W=0.865U AS=0.2249P AD=0.3806P
+ PS=1.385U PD=2.61U
* device instance $1843 r0 *1 182.23,36.385 pfet
M$1843 \$929 \$905 VDD$4 VDD$4 pfet L=0.5U W=0.36U AS=0.4554P AD=0.054P
+ PS=3.25U PD=0.66U
* device instance $1844 r0 *1 183.03,36.385 pfet
M$1844 \$919 \_009_[3] \$929 VDD$4 pfet L=0.5U W=0.36U AS=0.054P AD=0.1872P
+ PS=0.66U PD=1.4U
* device instance $1845 r0 *1 184.57,36.385 pfet
M$1845 \$927 \$903 \$919 VDD$4 pfet L=0.5U W=0.36U AS=0.1872P AD=0.0432P
+ PS=1.4U PD=0.6U
* device instance $1846 r0 *1 185.31,36.385 pfet
M$1846 VDD$4 \$904 \$927 VDD$4 pfet L=0.5U W=0.36U AS=0.0432P AD=0.1044P
+ PS=0.6U PD=0.94U
* device instance $1847 r0 *1 186.39,36.385 pfet
M$1847 \$904 \$919 VDD$4 VDD$4 pfet L=0.5U W=0.36U AS=0.1044P AD=0.1791P
+ PS=0.94U PD=1.355U
* device instance $1848 r0 *1 187.885,36.385 pfet
M$1848 \$920 \$903 \$904 VDD$4 pfet L=0.5U W=0.36U AS=0.1791P AD=0.1665P
+ PS=1.355U PD=1.285U
* device instance $1849 r0 *1 189.31,36.385 pfet
M$1849 \$924 \$905 \$920 VDD$4 pfet L=0.5U W=0.36U AS=0.1665P AD=0.0504P
+ PS=1.285U PD=0.64U
* device instance $1850 r0 *1 190.09,36.385 pfet
M$1850 \$924 \$906 VDD$4 VDD$4 pfet L=0.5U W=0.36U AS=0.23P AD=0.0504P PS=1.54U
+ PD=0.64U
* device instance $1851 r0 *1 191.33,36.165 pfet
M$1851 \$906 \$920 VDD$4 VDD$4 pfet L=0.5U W=0.8U AS=0.23P AD=0.352P PS=1.54U
+ PD=2.48U
* device instance $1852 r0 *1 193.07,36.23 pfet
M$1852 ph[3] \$906 VDD$4 VDD$4 pfet L=0.5U W=1.22U AS=0.5368P AD=0.5368P
+ PS=3.32U PD=3.32U
.ENDS sar_ctrl_a
