* adc-rail-current @ ff_-40c_3.63v -- GENERATED by sim/harness, do not edit
* corner=ff (all device families fast)
* temp=-40.0 C  vdd=3.63 V  pdk=gf180mcuD@c6d73a35f524070e85faff4a6a9eef49553ebc2b

* ---- PVT parameters -------------------------------------------------
.param vdd_nom=3.3
.param vdd_val=3.63
.param temp_c=-40.0

* ---- gf180mcu models ------------------------------------------------
.include "/home/ubuntu/.volare/gf180mcuD/libs.tech/ngspice/design.ngspice"
.lib "/home/ubuntu/.volare/gf180mcuD/libs.tech/ngspice/sm141064.ngspice" ff
.lib "/home/ubuntu/.volare/gf180mcuD/libs.tech/ngspice/sm141064.ngspice" res_ff
.lib "/home/ubuntu/.volare/gf180mcuD/libs.tech/ngspice/sm141064.ngspice" bjt_ff
.lib "/home/ubuntu/.volare/gf180mcuD/libs.tech/ngspice/sm141064.ngspice" diode_ff
.lib "/home/ubuntu/.volare/gf180mcuD/libs.tech/ngspice/sm141064.ngspice" moscap_ff
.lib "/home/ubuntu/.volare/gf180mcuD/libs.tech/ngspice/sm141064.ngspice" mimcap_ff

* ---- CDAC MIM unit-cap aliases (bound to this PDK variant's stack) --
* variant gf180mcuD -> MIM between m4m5
.subckt mim_cap_1f0 1 2 c_width=10u c_length=10u dtemp=0
Xmim 1 2 cap_mim_1f0_m4m5_noshield c_width=c_width c_length=c_length dtemp=dtemp
.ends
.subckt mim_cap_1f5 1 2 c_width=10u c_length=10u dtemp=0
Xmim 1 2 cap_mim_1f5_m4m5_noshield c_width=c_width c_length=c_length dtemp=dtemp
.ends
.subckt mim_cap_2f0 1 2 c_width=10u c_length=10u dtemp=0
Xmim 1 2 cap_mim_2f0_m4m5_noshield c_width=c_width c_length=c_length dtemp=dtemp
.ends

.temp -40.0

* ---- testbench ------------------------------------------------------
.include "/home/ubuntu/GitHub/gf180-sar-adc/.loom/worktrees/issue-386/sim/adc-power/testbench/tb_adc_power.spice"

* ---- measurement ----------------------------------------------------
.control
set numdgt=10
set noaskquit
set num_threads=1
  tran 1n 7.4u 0 10p
  let isum = i(vddc)+i(vddd)+i(vddt)
  meas tran pk MIN isum FROM=6.99u TO=7.10u
  meas tran pkd MIN i(vddd) FROM=6.99u TO=7.10u
  meas tran qa INTEG isum FROM=6.999u TO=7.0615u
  meas tran qad INTEG i(vddd) FROM=6.999u TO=7.0615u
  meas tran qb INTEG isum FROM=7.249u TO=7.3115u
  meas tran mx MAX isum FROM=3u TO=7.4u
  meas tran mxd MAX i(vddd) FROM=3u TO=7.4u
  let npts = length(time)
  print npts
  wrdata /tmp/probe386/p10p.cir.dat isum i(vddd)
.endc
.end
