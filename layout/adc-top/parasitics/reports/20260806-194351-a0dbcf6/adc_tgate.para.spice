* extracted by klt extract --deck gf180mcu

* cell ADC_TGATE
* pin gn
* pin gp
* pin vin
* pin vout
* pin vsubs
.SUBCKT ADC_TGATE gn gp vin vout vsubs
* device instance $1 r0 *1 1.24,5 nfet
X$1 vin gn vout vsubs nfet_03v3 L=0.28U W=10U
* device instance $2 r0 *1 5.02,10 pfet
X$2 vin gp vout \$5 pfet_03v3 L=0.28U W=20U
* device instance gn r0 *1 0,0
Rgn gn gn__par 53.1159
* device instance gn r0 *1 0,0
Cgn gn__par vsubs 5.87527e-16
* device instance gp r0 *1 0,0
Rgp gp gp__par 53.1159
* device instance gp r0 *1 0,0
Cgp gp__par vsubs 5.87527e-16
* device instance vin r0 *1 0,0
Rvin vin vin__par 120.0326
* device instance vin r0 *1 0,0
Cvin vin__par vsubs 4.208827e-15
* device instance vout r0 *1 0,0
Rvout vout vout__par 76.5336
* device instance vout r0 *1 0,0
Cvout vout__par vsubs 3.851043e-15
.ENDS ADC_TGATE
