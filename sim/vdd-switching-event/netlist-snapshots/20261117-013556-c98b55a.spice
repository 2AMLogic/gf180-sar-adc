* Frozen netlist snapshot for record 20261117-013556-c98b55a
* This is a verbatim copy taken at record time. Do not edit.
* Part 1..3: the per-rail wrapper bodies; part 4: the shared netlist they .include.

* ==== sim/vdd-switching-event/testbench/tb_vdd_event_2v97.spice  sha256 2933628adfa465f102a50ce3b98f13684c9a5e3c838979e571b5784b09234f40
* tb_vdd_event_2v97 -- GENERATED by gen_requests.py, do not edit.
*
* sim/vdd-switching-event/ (issue #386), supply rail 2.97 V.
* Everything sim/harness/runner.compose_deck puts ahead of the shared
* netlist, so the circuit is the one sim/adc-power/ and
* sim/adc-rail-current/ record against; `klt sim` adds the corner's
* .lib sections and .temp card. See gen_requests.py for why the supply
* is a per-file .param rather than a corners.supply_v alter.

* ---- PVT parameters (harness: compose_deck) --------------------------
.param vdd_nom=3.3
.param vdd_val=2.97

* ---- gf180mcuD libs.tech/ngspice/design.ngspice, inlined verbatim ---
* (its only non-comment content; the harness .includes the same file)
.param
+  sw_stat_global = 0
+  sw_stat_mismatch = 0
+ mc_skew = 3
+ res_mc_skew = 3
+ cap_mc_skew = 3
+  fnoicor = 0

* ---- CDAC MIM unit-cap aliases (harness: mim_wrapper_subckts) --------
* variant gf180mcuD -> MIM between m4m5
.subckt mim_cap_1f0 1 2 c_width=10u c_length=10u dtemp=0
Xmim 1 2 cap_mim_1f0_m4m5_noshield c_width=c_width c_length=c_length dtemp=dtemp
.ends
.subckt mim_cap_1f5 1 2 c_width=10u c_length=10u dtemp=0
Xmim 1 2 cap_mim_1f5_m4m5_noshield c_width=c_width c_length=c_length dtemp=dtemp
.ends
.subckt mim_cap_2f0 1 2 c_width=10u c_length=10u dtemp=0
Xmim 1 2 cap_mim_2f0_m4m5_noshield c_width=c_width c_length=c_length dtemp=dtemp
.ends

* ---- integrator ------------------------------------------------------
* Gear, not ngspice's default trapezoidal: the trapezoidal run aborts
* (`Timestep too small`, node pa_00) at 7.71885 us with a 10 ps cap and
* at 15.3775 us with a 25 ps cap on every corner. See the investigation
* note, Finding 5. Gear keeps the window charges to <= 0.2 % of the
* trapezoidal value where both complete. Gear alone still aborted at
* 15.3775 us in the ff corners on the fleet (the same clock edge every
* time, `Timestep too small`), so the per-timepoint Newton iteration
* limit is raised from its default 10 (itl4=100): a convergence aid,
* not a model change.
.options method=gear itl4=100

* ---- the shared circuit, unmodified ---------------------------------
.include ../../adc-power/testbench/tb_adc_power.spice

* ==== sim/vdd-switching-event/testbench/tb_vdd_event_3v30.spice  sha256 8d5833436dd8683f23be1a96a890441e25935305d8e7349be956faa4c3bd7365
* tb_vdd_event_3v30 -- GENERATED by gen_requests.py, do not edit.
*
* sim/vdd-switching-event/ (issue #386), supply rail 3.30 V.
* Everything sim/harness/runner.compose_deck puts ahead of the shared
* netlist, so the circuit is the one sim/adc-power/ and
* sim/adc-rail-current/ record against; `klt sim` adds the corner's
* .lib sections and .temp card. See gen_requests.py for why the supply
* is a per-file .param rather than a corners.supply_v alter.

* ---- PVT parameters (harness: compose_deck) --------------------------
.param vdd_nom=3.3
.param vdd_val=3.3

* ---- gf180mcuD libs.tech/ngspice/design.ngspice, inlined verbatim ---
* (its only non-comment content; the harness .includes the same file)
.param
+  sw_stat_global = 0
+  sw_stat_mismatch = 0
+ mc_skew = 3
+ res_mc_skew = 3
+ cap_mc_skew = 3
+  fnoicor = 0

* ---- CDAC MIM unit-cap aliases (harness: mim_wrapper_subckts) --------
* variant gf180mcuD -> MIM between m4m5
.subckt mim_cap_1f0 1 2 c_width=10u c_length=10u dtemp=0
Xmim 1 2 cap_mim_1f0_m4m5_noshield c_width=c_width c_length=c_length dtemp=dtemp
.ends
.subckt mim_cap_1f5 1 2 c_width=10u c_length=10u dtemp=0
Xmim 1 2 cap_mim_1f5_m4m5_noshield c_width=c_width c_length=c_length dtemp=dtemp
.ends
.subckt mim_cap_2f0 1 2 c_width=10u c_length=10u dtemp=0
Xmim 1 2 cap_mim_2f0_m4m5_noshield c_width=c_width c_length=c_length dtemp=dtemp
.ends

* ---- integrator ------------------------------------------------------
* Gear, not ngspice's default trapezoidal: the trapezoidal run aborts
* (`Timestep too small`, node pa_00) at 7.71885 us with a 10 ps cap and
* at 15.3775 us with a 25 ps cap on every corner. See the investigation
* note, Finding 5. Gear keeps the window charges to <= 0.2 % of the
* trapezoidal value where both complete. Gear alone still aborted at
* 15.3775 us in the ff corners on the fleet (the same clock edge every
* time, `Timestep too small`), so the per-timepoint Newton iteration
* limit is raised from its default 10 (itl4=100): a convergence aid,
* not a model change.
.options method=gear itl4=100

* ---- the shared circuit, unmodified ---------------------------------
.include ../../adc-power/testbench/tb_adc_power.spice

* ==== sim/vdd-switching-event/testbench/tb_vdd_event_3v63.spice  sha256 4c0483aa6e5186e7a8374e78ea7fe31b2b6871663162f1f955c06e739028d1db
* tb_vdd_event_3v63 -- GENERATED by gen_requests.py, do not edit.
*
* sim/vdd-switching-event/ (issue #386), supply rail 3.63 V.
* Everything sim/harness/runner.compose_deck puts ahead of the shared
* netlist, so the circuit is the one sim/adc-power/ and
* sim/adc-rail-current/ record against; `klt sim` adds the corner's
* .lib sections and .temp card. See gen_requests.py for why the supply
* is a per-file .param rather than a corners.supply_v alter.

* ---- PVT parameters (harness: compose_deck) --------------------------
.param vdd_nom=3.3
.param vdd_val=3.63

* ---- gf180mcuD libs.tech/ngspice/design.ngspice, inlined verbatim ---
* (its only non-comment content; the harness .includes the same file)
.param
+  sw_stat_global = 0
+  sw_stat_mismatch = 0
+ mc_skew = 3
+ res_mc_skew = 3
+ cap_mc_skew = 3
+  fnoicor = 0

* ---- CDAC MIM unit-cap aliases (harness: mim_wrapper_subckts) --------
* variant gf180mcuD -> MIM between m4m5
.subckt mim_cap_1f0 1 2 c_width=10u c_length=10u dtemp=0
Xmim 1 2 cap_mim_1f0_m4m5_noshield c_width=c_width c_length=c_length dtemp=dtemp
.ends
.subckt mim_cap_1f5 1 2 c_width=10u c_length=10u dtemp=0
Xmim 1 2 cap_mim_1f5_m4m5_noshield c_width=c_width c_length=c_length dtemp=dtemp
.ends
.subckt mim_cap_2f0 1 2 c_width=10u c_length=10u dtemp=0
Xmim 1 2 cap_mim_2f0_m4m5_noshield c_width=c_width c_length=c_length dtemp=dtemp
.ends

* ---- integrator ------------------------------------------------------
* Gear, not ngspice's default trapezoidal: the trapezoidal run aborts
* (`Timestep too small`, node pa_00) at 7.71885 us with a 10 ps cap and
* at 15.3775 us with a 25 ps cap on every corner. See the investigation
* note, Finding 5. Gear keeps the window charges to <= 0.2 % of the
* trapezoidal value where both complete. Gear alone still aborted at
* 15.3775 us in the ff corners on the fleet (the same clock edge every
* time, `Timestep too small`), so the per-timepoint Newton iteration
* limit is raised from its default 10 (itl4=100): a convergence aid,
* not a model change.
.options method=gear itl4=100

* ---- the shared circuit, unmodified ---------------------------------
.include ../../adc-power/testbench/tb_adc_power.spice

* ==== sim/adc-power/testbench/tb_adc_power.spice  sha256 43fef1c1651ebb7fbd0ec2b4050f5b6376fc73a39a49efef2789cd5bdd6c53d1
* ==================================================================
* tb_adc_power -- power at 1 MS/s, broken down by block (issue #13).
*
* GENERATED by design/adc-top/gen_adc_top.py -- do not edit.
*
* Same converter as sim/adc-inl-dnl/ and sim/adc-enob-fft/, from the
* same generator function, with the supplies brought out as separate
* sources so each block's current is attributable rather than lumped:
*
*   vddc   comparator (#9)      static preamp bias + latch dynamic
*   vddd   CDAC (#8)            bottom-plate T-gates and their local
*                               drivers -- FOUR legs per cell under
*                               DR-0014, so the V_in leg and its
*                               driver are measured here, not
*                               apportioned
*   vddt   sampling (#10)       DR-0014's top-plate V_cm switch and
*                               its driver. Before that record this
*                               rail supplied the dedicated top-plate
*                               sampling switch, so the block still
*                               means 'the switch that defines the
*                               sampling instant' -- but it is now a
*                               DRIVEN switch, so what used to be an
*                               analytic gate-drive term is measured
*   vrefs  reference            charge drawn from V_REF through
*                               DR-0002's network
*   vcms   reference            charge drawn from V_cm
*
* WHAT IS NOT MEASURED HERE, STATED PLAINLY. The SAR sequencer and
* output register are DR-0010 rung 1 -- ideal XSPICE event-driven
* primitives, which draw no supply current because they contain no
* devices. design/sar-logic/README.md says so directly: that netlist
* 'is not evidence about ... power'. The dominant digital term in a
* SAR ADC is driving the array's switch gates, and THAT is measured
* here (the local drivers are real devices on vddd); what is missing
* is the sequencer's own flip-flops and decode. It is carried as an
* analytic bound in the record, not as a measurement, and it cannot
* be closed until rung 3 -- which DR-0010 states is itself blocked on
* the open gf180mcu PDK shipping no 3.3 V standard-cell library.
* DR-0014 CLOSES one previously-analytic term rather than adding one:
* the dedicated sampling switch it removes was driven by a rung-1
* ideal inverter (to preserve the NMOS/PMOS turn-off skew DR-0013's
* charge-split measurement was taken with), so its gate-drive power
* was carried analytically. The top-plate switch that replaces it has
* a real adc_drv on vddt, and the fourth bottom-plate leg has a real
* adc_drv on vddd, so both are measured here.
*
* INPUT LEVELS. Switching energy in an MCS array depends on the code
* being converted, so the deck converts at five input levels
* (0, 1/4, 1/2, 3/4, full scale), four conversions each, and reports
* each block's average current per level. Reporting one level would
* be reporting one point of a curve as if it were the worst case.
* ==================================================================

* ---- ratiometric rails --------------------------------------------
* V_REF = V_DD. README.md note [c] makes V_REF <= V_DD a hard
* condition of the ratified spec, so a fixed 3.3 V reference is not
* legal at the 2.97 V corner; taking V_REF = V_DD keeps the deck legal
* at every point of the supply axis, and every figure below is in LSB
* of whatever full scale that point has.
.param vref={vdd_val}
.param vcm={vdd_val/2}
.param vth={vdd_val/2}
.param lsb={vdd_val/1024}

* ---- clocks --------------------------------------------------------
* DR-0003: one external clock pin at 16 x f_s. The comparator strobe
* is the same clock shifted half a bit cycle, so the CDAC settles in
* the first 31.25 ns and the comparator decides in the second -- the
* split spec/prior-art-survey.md Sec 1.4 allocates and
* sim/comparator-regeneration/ measured 863 ps of worst-case decision
* delay against.
vclk clk 0 pulse(0 {vdd_val} 0 100p 100p 31.25n 62.5n)
vcmpclk cmpclk 0 pulse(0 {vdd_val} 31.25n 100p 100p 31.25n 62.5n)
vcmpclkb cmpclkb 0 pulse({vdd_val} 0 31.25n 100p 100p 31.25n 62.5n)

* ---- supplies, split per block so power is attributable -----------
vddt vddt 0 dc {vdd_val}
vddd vddd 0 dc {vdd_val}
vddc vddc 0 dc {vdd_val}

* ---- reference network, DR-0002 -----------------------------------
* DR-0002 specifies an EXTERNAL V_REF pin with an effective source
* impedance <= 240 ohm IN THE SWITCHING BAND and >= 40 nF of external
* decoupling. Both halves of that sentence are modelled: the inductor
* in parallel with the 240 ohm makes the network 240 ohm at the
* switching band and DC-accurate below it, which is what an external
* reference buffer behind a decoupling capacitor actually is. A bare
* 240 ohm series resistor would instead assert a DC offset DR-0002
* never specified -- and, with 40 nF, a 9.6 us settling tail that
* would dominate any run shorter than ~50 us.
vrefs vrefs 0 dc {vref}
rref vrefs vrefn 240
lref vrefs vrefn 2.3873u
cref vrefn 0 40n
* V_cm generation is explicitly unbudgeted work (DR-0011
* Consequences: 'a new, currently-unbudgeted deliverable for a future
* issue'), so there is no ratified envelope to model it against and it
* is an IDEAL source here. That is a stated assumption of every record
* this deck produces, not a measured result -- see the known-
* limitations section of spec/testbench-suite-memo.md.
vcms vcmn 0 dc {vcm}

* ---- input: staircase over the code range -------------------------
vseinp se_vinp 0 pwl(
+ 0 0 4990.0n 0 5000.0n {0.25*vref} 7990.0n {0.25*vref} 8000.0n {0.5*vref} 10990.0n {0.5*vref} 11000.0n {0.75*vref} 13990.0n {0.75*vref} 14000.0n {1.0*vref} 17000.0n {1.0*vref})
vsevinn se_vinn 0 dc {vcm}

* ================= core se (single-ended) ==
vsestart se_start 0 dc 0
vsemode se_mode 0 dc 0
xsectrl clk se_start se_mode se_cmp se_samp_tp_n se_sel_in_n se_drdy se_c9
+ se_c8 se_c7 se_c6 se_c5 se_c4 se_c3 se_c2 se_c1 se_c0 se_rel_n_256p
+ se_sel_hi_n_256p se_sel_lo_n_256p se_rel_n_128p se_sel_hi_n_128p
+ se_sel_lo_n_128p se_rel_n_64p se_sel_hi_n_64p se_sel_lo_n_64p
+ se_rel_n_32p se_sel_hi_n_32p se_sel_lo_n_32p se_rel_n_16p
+ se_sel_hi_n_16p se_sel_lo_n_16p se_rel_n_8p se_sel_hi_n_8p
+ se_sel_lo_n_8p se_rel_n_4p se_sel_hi_n_4p se_sel_lo_n_4p se_rel_n_2p
+ se_sel_hi_n_2p se_sel_lo_n_2p se_rel_n_1p se_sel_hi_n_1p se_sel_lo_n_1p
+ se_rel_n_256n se_sel_hi_n_256n se_sel_lo_n_256n se_rel_n_128n
+ se_sel_hi_n_128n se_sel_lo_n_128n se_rel_n_64n se_sel_hi_n_64n
+ se_sel_lo_n_64n se_rel_n_32n se_sel_hi_n_32n se_sel_lo_n_32n
+ se_rel_n_16n se_sel_hi_n_16n se_sel_lo_n_16n se_rel_n_8n se_sel_hi_n_8n
+ se_sel_lo_n_8n se_rel_n_4n se_sel_hi_n_4n se_sel_lo_n_4n se_rel_n_2n
+ se_sel_hi_n_2n se_sel_lo_n_2n se_rel_n_1n se_sel_hi_n_1n se_sel_lo_n_1n
+ sar_ctrl_a
* Input drive network, DR-0013: series source resistance and a pin
* capacitor, at the compliant point sim/track-switch-sampling/
* measured the ratified gain-error number at (25 ohm, 1n). DR-0014 leaves that contract standing and removes the
* DEDICATED sampling switch that used to sit behind it: the pin now
* drives the array's fourth-leg T-gates directly, nine per side.
Rsesp se_vinp se_pinp 25
Csexp se_pinp 0 1n
Rsesn se_vinn se_pinn 25
Csexn se_pinn 0 1n
* The top-plate V_cm switch, one per side (DR-0014). It opens on the
* edge into ph3 -- one whole bit cycle before the bottom plates leave
* V_in -- and THAT edge is the sampling instant. Both sides are driven
* by the SAME control net: their skew is precisely the term this
* topology cannot cancel, so it is not manufactured here by routing
* two copies. Body ties go to vddt, which used to supply the
* dedicated sampling switch, so the power record's `trk` block still
* reports 'the switch that defines the sampling instant'.
Xsetswp se_topp vcmn se_samp_tp_n vddt 0 adc_tp_sw
Xsetswn se_topn vcmn se_samp_tp_n vddt 0 adc_tp_sw
Xsearrp se_topp se_pinp vrefn vcmn 0 vddd se_sel_in_n se_rel_n_256p
+ se_sel_hi_n_256p se_sel_lo_n_256p se_rel_n_128p se_sel_hi_n_128p
+ se_sel_lo_n_128p se_rel_n_64p se_sel_hi_n_64p se_sel_lo_n_64p
+ se_rel_n_32p se_sel_hi_n_32p se_sel_lo_n_32p se_rel_n_16p
+ se_sel_hi_n_16p se_sel_lo_n_16p se_rel_n_8p se_sel_hi_n_8p
+ se_sel_lo_n_8p se_rel_n_4p se_sel_hi_n_4p se_sel_lo_n_4p se_rel_n_2p
+ se_sel_hi_n_2p se_sel_lo_n_2p se_rel_n_1p se_sel_hi_n_1p se_sel_lo_n_1p
+ adc_cdac_side
Xsearrn se_topn se_pinn vrefn vcmn 0 vddd se_sel_in_n se_rel_n_256n
+ se_sel_hi_n_256n se_sel_lo_n_256n se_rel_n_128n se_sel_hi_n_128n
+ se_sel_lo_n_128n se_rel_n_64n se_sel_hi_n_64n se_sel_lo_n_64n
+ se_rel_n_32n se_sel_hi_n_32n se_sel_lo_n_32n se_rel_n_16n
+ se_sel_hi_n_16n se_sel_lo_n_16n se_rel_n_8n se_sel_hi_n_8n
+ se_sel_lo_n_8n se_rel_n_4n se_sel_hi_n_4n se_sel_lo_n_4n se_rel_n_2n
+ se_sel_hi_n_2n se_sel_lo_n_2n se_rel_n_1n se_sel_hi_n_1n se_sel_lo_n_1n
+ adc_cdac_side
* Comparator, DR-0015: static preamp + StrongARM latch. Its inputs
* ARE the CDAC top plates, so its input capacitance and its kickback
* are inside every number this deck reports, not bolted on after.
* Wired conventionally (top_p to the + input) even though DR-0014
* inverts the residue: the inversion is taken once inside the
* controller instead, so `cmp` keeps meaning 'top_p > top_n'
* everywhere in this repo. Under this record the comparator's own
* input capacitance is still ON the sampling node, but it no longer
* divides the DAC step against an undivided sampled input -- both are
* now over the same C_arr + C_par, which is the term that cancels.
iseb vddc se_ibias dc 10u
Xsecmp se_topp se_topn cmpclk se_ibias se_cmp se_cmpb vddc 0 comparator
* ---- the ideal shadow --------------------------------------------
* The reference this deck measures against is NOT a second simulation:
* it is the exact charge-domain result of THE DECISIONS THE REAL
* CONVERTER JUST MADE, computed from the controller's own switch-
* driver outputs. So the error node below isolates the analog error
* mechanisms (acquisition, charge injection, incomplete settling,
* reference movement, comparator kickback, top-plate parasitic
* attenuation) from decision errors, which the code check catches
* separately.
bsedacp se_dacp 0 V = (1.0/512)*(
+ 256*((v(se_rel_n_256p)*vcm+v(se_sel_hi_n_256p)*vref+v(se_sel_in_n)*v(se_vinp))/vdd_val-vcm) + 128*((v(se_rel_n_128p)*vcm+v(se_sel_hi_n_128p)*vref+v(se_sel_in_n)*v(se_vinp))/vdd_val-vcm) + 64*((v(se_rel_n_64p)*vcm+v(se_sel_hi_n_64p)*vref+v(se_sel_in_n)*v(se_vinp))/vdd_val-vcm) + 32*((v(se_rel_n_32p)*vcm+v(se_sel_hi_n_32p)*vref+v(se_sel_in_n)*v(se_vinp))/vdd_val-vcm) + 16*((v(se_rel_n_16p)*vcm+v(se_sel_hi_n_16p)*vref+v(se_sel_in_n)*v(se_vinp))/vdd_val-vcm) + 8*((v(se_rel_n_8p)*vcm+v(se_sel_hi_n_8p)*vref+v(se_sel_in_n)*v(se_vinp))/vdd_val-vcm) + 4*((v(se_rel_n_4p)*vcm+v(se_sel_hi_n_4p)*vref+v(se_sel_in_n)*v(se_vinp))/vdd_val-vcm) + 2*((v(se_rel_n_2p)*vcm+v(se_sel_hi_n_2p)*vref+v(se_sel_in_n)*v(se_vinp))/vdd_val-vcm) + 1*((v(se_rel_n_1p)*vcm+v(se_sel_hi_n_1p)*vref+v(se_sel_in_n)*v(se_vinp))/vdd_val-vcm) )
bsedacn se_dacn 0 V = (1.0/512)*(
+ 256*((v(se_rel_n_256n)*vcm+v(se_sel_hi_n_256n)*vref+v(se_sel_in_n)*v(se_vinn))/vdd_val-vcm) + 128*((v(se_rel_n_128n)*vcm+v(se_sel_hi_n_128n)*vref+v(se_sel_in_n)*v(se_vinn))/vdd_val-vcm) + 64*((v(se_rel_n_64n)*vcm+v(se_sel_hi_n_64n)*vref+v(se_sel_in_n)*v(se_vinn))/vdd_val-vcm) + 32*((v(se_rel_n_32n)*vcm+v(se_sel_hi_n_32n)*vref+v(se_sel_in_n)*v(se_vinn))/vdd_val-vcm) + 16*((v(se_rel_n_16n)*vcm+v(se_sel_hi_n_16n)*vref+v(se_sel_in_n)*v(se_vinn))/vdd_val-vcm) + 8*((v(se_rel_n_8n)*vcm+v(se_sel_hi_n_8n)*vref+v(se_sel_in_n)*v(se_vinn))/vdd_val-vcm) + 4*((v(se_rel_n_4n)*vcm+v(se_sel_hi_n_4n)*vref+v(se_sel_in_n)*v(se_vinn))/vdd_val-vcm) + 2*((v(se_rel_n_2n)*vcm+v(se_sel_hi_n_2n)*vref+v(se_sel_in_n)*v(se_vinn))/vdd_val-vcm) + 1*((v(se_rel_n_1n)*vcm+v(se_sel_hi_n_1n)*vref+v(se_sel_in_n)*v(se_vinn))/vdd_val-vcm) )
* The ideal differential top plate under DR-0014 bottom-plate
* sampling. The sampled input enters INVERTED about V_cm -- charge
* conservation on a top node released at V_cm gives
*   V_top,s = V_cm + k*[(V_cm - V_in,s) + dac_s],  k = C_arr/(C_arr+C_par)
* -- so the ideal (k = 1) differential residue is
*   di = (V_inn - V_inp) + dac_p - dac_n
* where under DR-0011 it was +(V_inp - V_inn) + dac_p - dac_n. This
* one sign is the whole behavioural consequence of the record, and it
* is why the controller inverts the comparator once at its own
* boundary (design/sar-logic/, `dec = !cmp`).
bsedi se_di 0 V = v(se_vinn)-v(se_vinp)+v(se_dacp)-v(se_dacn)
* Error, in LSB of this deck's own mode. Referenced to zero, not to a
* mid-rail level, so the ~1 uV `meas` result-precision floor
* (sim/harness/README.md) lands 3 decades below one LSB instead of on
* top of the quantity being measured.
*
* NEGATED with respect to the superseded version, deliberately: the
* residue now moves OPPOSITE the input, so d(top_p-top_n)/dV_in = -1
* and an INPUT-REFERRED error is (ideal - actual), not (actual -
* ideal). Keeping the node input-referred is what makes this deck's
* terr/INL numbers comparable in sign with the records taken before
* DR-0014 instead of silently flipping every one of them.
bsee se_err 0 V = (v(se_di)-(v(se_topp)-v(se_topn)))/lsb
* The error, GATED TO THE DECIDE PHASES ONLY. A comparator decides on
* the strobe, so the only instants at which the input-referred error
* matters are the ten strobe-high windows; in between, the residue is
* still settling and its excursion is a transient nobody samples. So
* this node is |err| while cmpclk is high and zero otherwise, and MAX
* over a conversion's trial window is that conversion's WORST DECISION
* ERROR -- one number instead of ten.
*
* An earlier draft used a track-and-hold switched by cmpclkb instead.
* That was wrong in a way worth recording: the T/H TRACKS during the
* settling half of each bit cycle, so a MAX over the same window picked
* up the settling transient it was supposed to blank -- reporting ~300
* LSB where the decisions were actually taken within a few LSB. Gating
* is the correct primitive here; holding is not.
bseea se_aerrh 0 V = abs(v(se_err))*(v(cmpclk)>vth ? 1 : 0)
* Decoded output code (the parallel register, DR-0005).
bsecode se_code 0 V =
+ (512)*(v(se_c9)>vth ? 1 : 0) + (256)*(v(se_c8)>vth ? 1 : 0) + (128)*(v(se_c7)>vth ? 1 : 0) + (64)*(v(se_c6)>vth ? 1 : 0) + (32)*(v(se_c5)>vth ? 1 : 0) + (16)*(v(se_c4)>vth ? 1 : 0) + (8)*(v(se_c3)>vth ? 1 : 0) + (4)*(v(se_c2)>vth ? 1 : 0) + (2)*(v(se_c1)>vth ? 1 : 0) + (1)*(v(se_c0)>vth ? 1 : 0)

* ==================================================================
* The three netlists below are COPIES, kept honest by unit tests:
*   design/comparator/comparator.spice   (test_comparator_netlist)
*   design/sar-logic/sar_ctrl.spice      (test_sar_logic_netlist)
*   design/adc-top/adc_top.spice         (test_adc_top_netlist)
* sim/harness/testbench.py rejects .include in a fragment, so a
* testbench has to carry its DUT inline; generating the copies is
* what stops them drifting from the design they claim to verify.
* ==================================================================

* --- COMPARATOR-NETLIST-BEGIN (verbatim-copied into every testbench) ---
.subckt preamp vinp vinn ibias pop pon vdd vss
* 1:1 NMOS current mirror; ibias is forced into the diode branch.
Xmb  ibias ibias vss vss nfet_03v3 w=20u l=2u
Xmt  ptail ibias vss vss nfet_03v3 w=20u l=2u
* Input pair. The device whose gate is vinp drives the INVERTING node
* pon, so v(pop) - v(pon) = +A_v * (v(vinp) - v(vinn)).
Xmip pon vinp ptail vss nfet_03v3 w=40u l=1u
Xmin pop vinn ptail vss nfet_03v3 w=40u l=1u
* Unsalicided 1 kohm/sq p+ poly loads, 150 squares = 150 kohm nominal.
* Third terminal is the substrate/body contact. `ppolyf_u_1k`, not the
* 2 kohm/sq `ppolyf_u_2k` an earlier revision assumed: issue #118 drew
* SAB(49/0)+RES_MK(110/5)+Resistor(62/0) markers over the load-resistor
* bodies so `klt extract`'s gf180mcu deck recognises them as real devices
* instead of a Poly2 short, and at this repo's pinned klt commit that
* marker geometry can only select `ppolyf_u_1k` (1000 ohm/sq) -- the
* `_2k`/`_3k` flavours share the identical drawn geometry and are chosen by
* a build-time deck option this curated deck does not implement
* (`2AMLogic/klayout-tools#595`, open). `r_length` is doubled (75u -> 150u)
* at the same `r_width=1u` to preserve the 150 kohm target at the new
* sheet-rho -- see layout/adc-top/README.md "Resistors".
Xrlp vdd pop vss ppolyf_u_1k r_width=1u r_length=150u
Xrln vdd pon vss ppolyf_u_1k r_width=1u r_length=150u
.ends preamp

.subckt sarlatch inp inn clk outp outn vdd vss
* clk low  -> tail off; outp/outn/dip/din precharged to vdd
* clk high -> tail on; the input pair discharges dip/din at rates set by
*             v(inp)/v(inn), then the cross-coupled pairs regenerate.
Xmlt ltail clk   vss   vss nfet_03v3 w=16u l=0.35u
Xmlp dip   inp   ltail vss nfet_03v3 w=8u  l=0.5u
Xmln din   inn   ltail vss nfet_03v3 w=8u  l=0.5u
Xmnp outn  outp  dip   vss nfet_03v3 w=6u  l=0.35u
Xmnn outp  outn  din   vss nfet_03v3 w=6u  l=0.35u
Xmpp outn  outp  vdd   vdd pfet_03v3 w=8u  l=0.35u
Xmpn outp  outn  vdd   vdd pfet_03v3 w=8u  l=0.35u
Xmrp outn  clk   vdd   vdd pfet_03v3 w=4u  l=0.35u
Xmrn outp  clk   vdd   vdd pfet_03v3 w=4u  l=0.35u
Xmrd dip   clk   vdd   vdd pfet_03v3 w=2u  l=0.35u
Xmre din   clk   vdd   vdd pfet_03v3 w=2u  l=0.35u
.ends sarlatch

* Minimum-ish isolation inverter. Deliberately small: it is the only
* thing the regeneration nodes drive, so its gate capacitance is added
* directly to the latch's own output nodes and shows up as regeneration
* time.
.subckt inv a y vdd vss
Xp y a vdd vdd pfet_03v3 w=2u   l=0.35u
Xn y a vss vss nfet_03v3 w=1u   l=0.35u
.ends inv

.subckt nor2 a b y vdd vss
Xp1 ps a vdd vdd pfet_03v3 w=8u l=0.35u
Xp2 y  b ps  vdd pfet_03v3 w=8u l=0.35u
Xn1 y  a vss vss nfet_03v3 w=4u l=0.35u
Xn2 y  b vss vss nfet_03v3 w=4u l=0.35u
.ends nor2

.subckt comparator vinp vinn clk ibias dout doutb vdd vss
Xpre preamp_in1 preamp_in2 ibias pop pon vdd vss preamp
Xlat pop pon clk outp outn vdd vss sarlatch
* THE ISOLATION INVERTERS ARE NOT OPTIONAL -- they fix a measured
* hysteresis defect. Both StrongARM outputs precharge HIGH, so the
* decision arrives as an active-low pulse on exactly one of them, and
* the obvious way to hold it is a NAND SR latch wired straight to
* outp/outn. That circuit was built first and MEASURED: after deciding
* one way it would not flip back until the input reached ~10 mV of the
* opposite polarity -- about 3 LSB of hysteresis, which in a SAR (where
* the same comparator makes ten successive decisions on a shrinking
* residue) is a code-dependent error, not an offset.
*
* The cause is that a NAND SR latch's HELD STATE loads the two
* regeneration nodes asymmetrically. Wired directly, the node driving
* the NAND whose output is LOW sees that output swing when it falls
* (Miller-multiplied C_gd, ~26 fF against a regeneration node of a few
* tens of fF), while its twin drives a NAND whose output is already
* HIGH and stays there. The latch is therefore biased toward keeping
* the answer it already holds.
*
* Interposing one small inverter per side removes the coupling: the
* inverters are identical, both of their inputs precharge to V_DD, and
* neither loading depends on what the SR latch is holding. The SR latch
* becomes NOR-type because the inverters make the decision pulses
* active-HIGH. dout goes HIGH when outn falls, i.e. when
* v(vinp) > v(vinn), exactly as before.
Xis outn sset vdd vss inv
Xir outp srst vdd vss inv
Xno1 srst doutb dout  vdd vss nor2
Xno2 sset dout  doutb vdd vss nor2
* Input pass-through (zero-volt sources) so a testbench can probe the
* current the comparator draws from each CDAC top plate directly.
Vpp preamp_in1 vinp dc 0
Vpn preamp_in2 vinn dc 0
.ends comparator
* --- COMPARATOR-NETLIST-END ---

* ------------------------------------------------------------------
* sar_ctrl.spice -- synchronous SAR control logic, rung-1 abstraction
*
* GENERATED by design/sar-logic/gen_sar_logic.py -- do not edit.
*
* Ideal XSPICE event-driven digital primitives (digital.cm: d_dff,
* d_and, d_or, d_inverter) plus adc_bridge/dac_bridge at the analog
* boundary. This is rung 1 of the fidelity ladder in DR-0010: it fixes
* the SEQUENCING and the SWITCH DECODE, and deliberately says nothing
* about gf180mcu gate delay (rung 3 / sim/sar-logic-cell-delay/ owns
* that).
*
* Conversion, M = 16 clocks (DR-0003), with DR-0014's TWO-PHASE
* BOTTOM-PLATE sample laid inside the same 4-clock sample window:
*   ph0..ph2   acquire  samp_tp and samp_bp both asserted: the top
*                       plate is held at Vcm by its own switch and
*                       every bottom plate tracks V_in through the
*                       cell's fourth leg
*   ph2->ph3   THE SAMPLING INSTANT -- samp_tp falls, the top-plate
*                       switch opens and the top node floats
*   ph3        the bottom plates stay on V_in one more clock
*   ph3->ph4   samp_bp falls a full bit cycle after the sampling
*                       instant: the bottom plates leave V_in for Vcm
*                       onto a node that is ALREADY isolated, which
*                       is the whole reason bottom-plate sampling is
*                       worth a fourth leg (DR-0014, README note [d])
*   ph4        trial 1  free MSB -- no array switching at all, the
*                       comparator decides the sign of the sampled
*                       residue (DR-0014 keeps DR-0011's free MSB)
*   ph5..ph13  trials 2..10, weights 256,128,...,1 engaged in turn
*   ph14       output register loads the 10 decisions
*   ph15       drdy asserted; array released back to Vcm
*
* Switch decode per weight w and side s -- FOUR one-hot legs per cell
* now, not three -- from the slice's own engage flag `eng`, the
* direction bit `dir` (= the decision of the PREVIOUS trial, which is
* also that trial's output bit) and the shared sample control `smp`:
*   in  = smp                      bottom plate on V_in (DR-0014)
*   rel = !eng & !smp              bottom plate parked at Vcm
*   p-side:  hi = eng &  dir       -> V_REF      lo = eng & !dir -> GND
*   n-side:  hi = eng & !dir       -> V_REF      lo = eng &  dir -> GND
*   n-side is additionally gated by `mode` (1 = differential): in
*   single-ended mode every n-side cell stays released to Vcm for the
*   whole conversion, per DR-0011 -- driving it too would double every
*   step and cost a bit of resolution. The `in` leg is NOT mode-gated:
*   both sides must acquire their own input pin, and DR-0011's mode
*   rule is about bit trials, not about the sample phase.
*   `eng` is zero for the whole sample window, so exactly one of the
*   four legs conducts at every instant -- the invariant
*   sim/sar-logic-functional/ measures directly as sw_conflict_*.
*
* Sign convention, RE-DERIVED FOR DR-0014 and the one place the
* superseded record's decode could not simply be carried forward.
* Sampling on the bottom plate INVERTS the residue with respect to the
* input: after the sample, top_p - top_n = -k*(V_inp - V_inn). The
* comparator is wired conventionally (cmp = 1 when top_p > top_n), so
* the controller inverts it ONCE at its own boundary --
*
*     dec = !cmp    = 1 when the sampled input is ABOVE the DAC's
*                     current estimate, i.e. 'add this weight'
*
* -- and `dir` therefore still holds the OUTPUT BIT of its position,
* exactly as under DR-0011, at the cost of the hi/lo assignment above
* being the mirror of DR-0011's. Inverting only one of the two would
* either diverge (right code polarity, wrong feedback direction) or
* emit the one's complement of the code (right feedback, wrong bits);
* both were checked against the closed loop before this form was
* chosen, and sim/sar-logic-functional/ falsifies either error on
* every one of the 1024 codes in both modes.
* ------------------------------------------------------------------

* --- ideal digital primitives -------------------------------------
.model sarl_dff d_dff(clk_delay=0.5n set_delay=0.5n
+ reset_delay=0.5n ic=0 rise_delay=0.5n fall_delay=0.5n)
.model sarl_dff1 d_dff(clk_delay=0.5n set_delay=0.5n
+ reset_delay=0.5n ic=1 rise_delay=0.5n fall_delay=0.5n)
.model sarl_and d_and(rise_delay=0.2n fall_delay=0.2n input_load=0)
.model sarl_or d_or(rise_delay=0.2n fall_delay=0.2n input_load=0)
.model sarl_inv d_inverter(rise_delay=0.2n fall_delay=0.2n
+ input_load=0)

* --- enabled bit register -----------------------------------------
* Captures `d` on the clock edge that ENDS the phase in which `en` is
* asserted, and holds otherwise. Written as an explicit D-mux rather
* than a gated clock: gating the clock with a phase signal that itself
* changes one gate delay after the clock edge creates a spurious
* rising edge on the gated clock, which is a real bug in a real
* implementation, not just in this model.
.subckt sar_bitreg clk d en q qb
a_inv en enb sarl_inv
a_sel [en d] dsel sarl_and
a_hold [enb q] dhold sarl_and
a_mux [dsel dhold] dnext sarl_or
a_ff dnext clk NULL NULL q qb sarl_dff
.ends sar_bitreg

* --- one bit slice: engage flag + direction bit + switch decode -----
* `arm`     one-hot phase pulse of the trial BEFORE this slice's own
*           trial: the slice engages on the edge entering its trial,
*           and the direction bit captures the decision made during
*           `arm` (which is also this bit position's output bit).
* `endconv` forces the engage flag low on the edge leaving the last
*           trial, releasing the whole array back to Vcm for the next
*           sample phase.
* `dec`     the comparator decision in OUTPUT-BIT polarity (= !cmp;
*           see the sign-convention note in the header).
* `smpb`    the inverse of the shared bottom-plate sample control,
*           distributed already-inverted so that all four legs of the
*           cell come out at the SAME logic depth. That is not
*           cosmetic: `rel` and the V_in leg are complementary during
*           the sample window, so a one-gate depth difference between
*           them opens a window in which a cell drives V_in and Vcm at
*           once -- which is exactly what the one-hot invariant is
*           there to catch, and it would catch this generator.
.subckt sar_slice clk dec mode arm endconv smpb dir dirb
+ rel_p hi_p lo_p rel_n hi_n lo_n
a_set [arm eng] eng_set sarl_or
a_ninv endconv nend sarl_inv
a_keep [eng_set nend] eng_d sarl_and
a_ff eng_d clk NULL NULL eng engb sarl_dff
xdir clk dec arm dir dirb sar_bitreg
* p side: always driven
a_relp [engb smpb] rel_p sarl_and
a_hip [eng dir] hi_p sarl_and
a_lop [eng dirb] lo_p sarl_and
* n side: driven only in differential mode (DR-0011). `engnb` is built
* as !eng | !mode rather than as an inverter on `engn`, so that it
* lands at the same depth as `engn` and rel_n/hi_n/lo_n switch
* together -- the same delay-balance argument as `smpb` above.
a_engn [eng mode] engn sarl_and
a_modeb mode modeb sarl_inv
a_engnb [engb modeb] engnb sarl_or
a_reln [engnb smpb] rel_n sarl_and
a_hin [engn dirb] hi_n sarl_and
a_lon [engn dir] lo_n sarl_and
.ends sar_slice

* --- 16-phase one-hot sequencer ------------------------------------
* A one-hot ring, seeded by ph15's ic=1 so the very first clock edge
* enters ph0 (sample) with exactly one token in the ring. `start`
* forces a synchronous restart: it sets stage 0 and clears every other
* stage on the same edge, so an asserted `start` cannot inject a
* SECOND token alongside the circulating one.
.subckt sar_seq clk start ph0 ph1 ph2 ph3 ph4 ph5 ph6 ph7 ph8 ph9 ph10 ph11 ph12 ph13 ph14 ph15
a_nstart start nstart sarl_inv
a_d0 [ph15 start] d0 sarl_or
a_ff0 d0 clk NULL NULL ph0 ph0b sarl_dff
a_d1 [ph0 nstart] d1 sarl_and
a_ff1 d1 clk NULL NULL ph1 ph1b sarl_dff
a_d2 [ph1 nstart] d2 sarl_and
a_ff2 d2 clk NULL NULL ph2 ph2b sarl_dff
a_d3 [ph2 nstart] d3 sarl_and
a_ff3 d3 clk NULL NULL ph3 ph3b sarl_dff
a_d4 [ph3 nstart] d4 sarl_and
a_ff4 d4 clk NULL NULL ph4 ph4b sarl_dff
a_d5 [ph4 nstart] d5 sarl_and
a_ff5 d5 clk NULL NULL ph5 ph5b sarl_dff
a_d6 [ph5 nstart] d6 sarl_and
a_ff6 d6 clk NULL NULL ph6 ph6b sarl_dff
a_d7 [ph6 nstart] d7 sarl_and
a_ff7 d7 clk NULL NULL ph7 ph7b sarl_dff
a_d8 [ph7 nstart] d8 sarl_and
a_ff8 d8 clk NULL NULL ph8 ph8b sarl_dff
a_d9 [ph8 nstart] d9 sarl_and
a_ff9 d9 clk NULL NULL ph9 ph9b sarl_dff
a_d10 [ph9 nstart] d10 sarl_and
a_ff10 d10 clk NULL NULL ph10 ph10b sarl_dff
a_d11 [ph10 nstart] d11 sarl_and
a_ff11 d11 clk NULL NULL ph11 ph11b sarl_dff
a_d12 [ph11 nstart] d12 sarl_and
a_ff12 d12 clk NULL NULL ph12 ph12b sarl_dff
a_d13 [ph12 nstart] d13 sarl_and
a_ff13 d13 clk NULL NULL ph13 ph13b sarl_dff
a_d14 [ph13 nstart] d14 sarl_and
a_ff14 d14 clk NULL NULL ph14 ph14b sarl_dff
a_d15 [ph14 nstart] d15 sarl_and
a_ff15 d15 clk NULL NULL ph15 ph15b sarl_dff1
.ends sar_seq

* --- digital top ----------------------------------------------------
.subckt sar_ctrl clk start mode cmp samp_tp samp_bp drdy b9 b8 b7 b6 b5 b4
+ b3 b2 b1 b0 rel_256p hi_256p lo_256p rel_128p hi_128p lo_128p rel_64p
+ hi_64p lo_64p rel_32p hi_32p lo_32p rel_16p hi_16p lo_16p rel_8p hi_8p
+ lo_8p rel_4p hi_4p lo_4p rel_2p hi_2p lo_2p rel_1p hi_1p lo_1p rel_256n
+ hi_256n lo_256n rel_128n hi_128n lo_128n rel_64n hi_64n lo_64n rel_32n
+ hi_32n lo_32n rel_16n hi_16n lo_16n rel_8n hi_8n lo_8n rel_4n hi_4n
+ lo_4n rel_2n hi_2n lo_2n rel_1n hi_1n lo_1n
xseq clk start ph0 ph1 ph2 ph3 ph4 ph5 ph6 ph7 ph8 ph9 ph10 ph11 ph12 ph13 ph14 ph15 sar_seq
* ---- DR-0014's two-phase sample ----------------------------------
* `samp_tp` closes the top-plate switch for ph0..ph2 and opens it on
* the edge into ph3: THAT edge is the sampling instant. `samp_bp`
* keeps every bottom plate on V_in for the whole 4-clock window, so
* the input legs turn off one full clock LATER, onto a top node that
* is already floating. Both are one-hot phase ORs off the same ring:
* one external clock, rising edges only (DR-0008), no gated or
* inverted clock anywhere in the sample path.
* `samp_bp` is emitted through smpb -> inverter rather than straight
* off the OR so that it lands at the SAME logic depth as each cell's
* `rel`, which is AND(engb, smpb). Those two legs are complementary
* across the sample boundary, so a one-gate depth difference would
* leave every cell driving V_in and V_cm together for 0.2 ns.
a_samp4 [ph0 ph1 ph2 ph3] samp4 sarl_or
a_samptp [ph0 ph1 ph2] samp_tp sarl_or
a_smpb samp4 smpb sarl_inv
a_sampbp smpb samp_bp sarl_inv
* The comparator decision, inverted once here into output-bit
* polarity: bottom-plate sampling inverts the residue with respect to
* the input (DR-0014). See the header's sign-convention note.
a_dec cmp dec sarl_inv
a_drdy ph15 drdy_n sarl_inv
a_drdy2 drdy_n drdy sarl_inv
xs256 clk dec mode ph4 ph13 smpb q9 q9b rel_256p hi_256p lo_256p rel_256n hi_256n lo_256n sar_slice
xs128 clk dec mode ph5 ph13 smpb q8 q8b rel_128p hi_128p lo_128p rel_128n hi_128n lo_128n sar_slice
xs64 clk dec mode ph6 ph13 smpb q7 q7b rel_64p hi_64p lo_64p rel_64n hi_64n lo_64n sar_slice
xs32 clk dec mode ph7 ph13 smpb q6 q6b rel_32p hi_32p lo_32p rel_32n hi_32n lo_32n sar_slice
xs16 clk dec mode ph8 ph13 smpb q5 q5b rel_16p hi_16p lo_16p rel_16n hi_16n lo_16n sar_slice
xs8 clk dec mode ph9 ph13 smpb q4 q4b rel_8p hi_8p lo_8p rel_8n hi_8n lo_8n sar_slice
xs4 clk dec mode ph10 ph13 smpb q3 q3b rel_4p hi_4p lo_4p rel_4n hi_4n lo_4n sar_slice
xs2 clk dec mode ph11 ph13 smpb q2 q2b rel_2p hi_2p lo_2p rel_2n hi_2n lo_2n sar_slice
xs1 clk dec mode ph12 ph13 smpb q1 q1b rel_1p hi_1p lo_1p rel_1n hi_1n lo_1n sar_slice
xb0 clk dec ph13 q0 q0b sar_bitreg
* 10-bit parallel output register (DR-0005: in scope, SPI deferred)
xo9 clk q9 ph14 b9 b9b sar_bitreg
xo8 clk q8 ph14 b8 b8b sar_bitreg
xo7 clk q7 ph14 b7 b7b sar_bitreg
xo6 clk q6 ph14 b6 b6b sar_bitreg
xo5 clk q5 ph14 b5 b5b sar_bitreg
xo4 clk q4 ph14 b4 b4b sar_bitreg
xo3 clk q3 ph14 b3 b3b sar_bitreg
xo2 clk q2 ph14 b2 b2b sar_bitreg
xo1 clk q1 ph14 b1 b1b sar_bitreg
xo0 clk q0 ph14 b0 b0b sar_bitreg
.ends sar_ctrl

* --- analog-boundary wrapper ----------------------------------------
* Presents the controller at the analog boundary with the port names
* design/cdac/cdac_array.sch uses, so the two connect directly. Only
* the NMOS-gate (active-high) half of each T-gate leg is routed out of
* the controller; `sar_tgate_drv` below makes the PMOS gate locally at
* the cell. Bridges are VECTOR instances on purpose: 54 scalar
* dac_bridges would put 54 separate sources in the analog matrix.
* DR-0014's two additions ride on the SCALAR bridge group with drdy
* and the code bits, not on the 54-wide array bus: `sel_in_n` is one
* broadcast net feeding every cell's fourth leg and `samp_tp_n` is the
* per-side top-plate switch, so the array control bus grows from 54 to
* 55 wires, not to 72.
.subckt sar_ctrl_a clk start mode cmp samp_tp_n sel_in_n drdy c9 c8 c7 c6
+ c5 c4 c3 c2 c1 c0 rel_n_256p sel_hi_n_256p sel_lo_n_256p rel_n_128p
+ sel_hi_n_128p sel_lo_n_128p rel_n_64p sel_hi_n_64p sel_lo_n_64p
+ rel_n_32p sel_hi_n_32p sel_lo_n_32p rel_n_16p sel_hi_n_16p sel_lo_n_16p
+ rel_n_8p sel_hi_n_8p sel_lo_n_8p rel_n_4p sel_hi_n_4p sel_lo_n_4p
+ rel_n_2p sel_hi_n_2p sel_lo_n_2p rel_n_1p sel_hi_n_1p sel_lo_n_1p
+ rel_n_256n sel_hi_n_256n sel_lo_n_256n rel_n_128n sel_hi_n_128n
+ sel_lo_n_128n rel_n_64n sel_hi_n_64n sel_lo_n_64n rel_n_32n sel_hi_n_32n
+ sel_lo_n_32n rel_n_16n sel_hi_n_16n sel_lo_n_16n rel_n_8n sel_hi_n_8n
+ sel_lo_n_8n rel_n_4n sel_hi_n_4n sel_lo_n_4n rel_n_2n sel_hi_n_2n
+ sel_lo_n_2n rel_n_1n sel_hi_n_1n sel_lo_n_1n
a_in [clk start mode cmp] [dclk dstart dmode dcmp] sarl_adc
xctrl dclk dstart dmode dcmp dsamp_tp dsamp_bp ddrdy db9 db8 db7 db6 db5
+ db4 db3 db2 db1 db0 drel_256p dhi_256p dlo_256p drel_128p dhi_128p
+ dlo_128p drel_64p dhi_64p dlo_64p drel_32p dhi_32p dlo_32p drel_16p
+ dhi_16p dlo_16p drel_8p dhi_8p dlo_8p drel_4p dhi_4p dlo_4p drel_2p
+ dhi_2p dlo_2p drel_1p dhi_1p dlo_1p drel_256n dhi_256n dlo_256n
+ drel_128n dhi_128n dlo_128n drel_64n dhi_64n dlo_64n drel_32n dhi_32n
+ dlo_32n drel_16n dhi_16n dlo_16n drel_8n dhi_8n dlo_8n drel_4n dhi_4n
+ dlo_4n drel_2n dhi_2n dlo_2n drel_1n dhi_1n dlo_1n sar_ctrl
a_dout [dsamp_tp dsamp_bp ddrdy db9 db8 db7 db6 db5 db4 db3 db2 db1 db0]
+ [samp_tp_n sel_in_n drdy c9 c8 c7 c6 c5 c4 c3 c2 c1 c0] sarl_dac
a_gn [drel_256p dhi_256p dlo_256p drel_128p dhi_128p dlo_128p drel_64p dhi_64p dlo_64p drel_32p dhi_32p dlo_32p drel_16p dhi_16p dlo_16p drel_8p dhi_8p dlo_8p drel_4p dhi_4p dlo_4p drel_2p dhi_2p dlo_2p drel_1p dhi_1p dlo_1p drel_256n dhi_256n dlo_256n drel_128n dhi_128n dlo_128n drel_64n dhi_64n dlo_64n drel_32n dhi_32n dlo_32n drel_16n dhi_16n dlo_16n drel_8n dhi_8n dlo_8n drel_4n dhi_4n dlo_4n drel_2n dhi_2n dlo_2n drel_1n dhi_1n dlo_1n]
+ [rel_n_256p sel_hi_n_256p sel_lo_n_256p rel_n_128p sel_hi_n_128p sel_lo_n_128p rel_n_64p sel_hi_n_64p sel_lo_n_64p rel_n_32p sel_hi_n_32p sel_lo_n_32p rel_n_16p sel_hi_n_16p sel_lo_n_16p rel_n_8p sel_hi_n_8p sel_lo_n_8p rel_n_4p sel_hi_n_4p sel_lo_n_4p rel_n_2p sel_hi_n_2p sel_lo_n_2p rel_n_1p sel_hi_n_1p sel_lo_n_1p rel_n_256n sel_hi_n_256n sel_lo_n_256n rel_n_128n sel_hi_n_128n sel_lo_n_128n rel_n_64n sel_hi_n_64n sel_lo_n_64n rel_n_32n sel_hi_n_32n sel_lo_n_32n rel_n_16n sel_hi_n_16n sel_lo_n_16n rel_n_8n sel_hi_n_8n sel_lo_n_8n rel_n_4n sel_hi_n_4n sel_lo_n_4n rel_n_2n sel_hi_n_2n sel_lo_n_2n rel_n_1n sel_hi_n_1n sel_lo_n_1n] sarl_dac
.ends sar_ctrl_a

* --- local T-gate driver -------------------------------------------
* One per T-gate leg, placed with the CDAC cell (#15/#16), not with
* the controller: `gn` is the controller's active-high control and
* `gp` the complementary PMOS gate. Modelled as an ideal inverter at
* rung 1; at rung 3 it is one standard-cell inverter.
.subckt sar_tgate_drv gn gp
a_adc gn dgn sarl_adc
a_inv dgn dgp sarl_inv
a_dac dgp gp sarl_dac
.ends sar_tgate_drv

* Bridge models. Thresholds and rails track the PVT point's supply, so
* the supply axis of the corner grid actually moves something in this
* otherwise PVT-invariant model.
.model sarl_adc adc_bridge(in_low={vdd_val*0.4} in_high={vdd_val*0.6})
.model sarl_dac dac_bridge(out_low=0 out_high={vdd_val}
+ out_undef={vdd_val/2} t_rise=0.3n t_fall=0.3n)

* ==================================================================
* adc_top.spice -- the SAR ADC analog core: CDAC array, its four-leg
* bottom-plate switch network and the local drivers, and the
* top-plate V_cm switch DR-0014's sampling phase turns on.
*
* GENERATED by design/adc-top/gen_adc_top.py -- do not edit.
*
* This library holds ONLY what is not already owned by another
* canonical file. The comparator lives in design/comparator/
* comparator.spice and the SAR controller in design/sar-logic/
* sar_ctrl.spice; the testbenches under sim/adc-*/ inline all three.
*
* Fidelity (DR-0010): everything here is transistor level. The
* sequencer and the output register stay at rung 1 (ideal XSPICE
* primitives) because the open gf180mcu PDK ships no 3.3 V standard-
* cell library -- the gap DR-0010 names as an open precondition of
* rung 3. The T-gate DRIVERS are transistor level even so: they are
* custom cells placed with the CDAC (design/sar-logic/README.md), not
* standard cells, so the library gap does not apply to them, and they
* are the dominant digital load in a SAR ADC.
* ==================================================================

* --- ADC-TOP-NETLIST-BEGIN (verbatim-copied into every testbench) ---
* ---- switches ----------------------------------------------------
* CDAC bottom-plate T-gate. Same geometry as sim/device-switch-ron/
* and sim/cdac-bit-settling/, so R_on carries the corner sensitivity
* those records already characterised.
.subckt adc_tgate vin vout gn gp vdd wn=10u wp=20u
XN vin gn vout 0   nfet_03v3 w='wn' l=0.28u
XP vin gp vout vdd pfet_03v3 w='wp' l=0.28u
.ends adc_tgate

* Dedicated top-plate input sampling switch: dummy-compensated T-gate,
* DR-0007 (track switch) / DR-0013. NO LONGER IN THE CONVERTER --
* DR-0014 samples on the bottom plates, so the input reaches the array
* through the nine cell T-gates of each side's fourth leg and this
* switch is gone from adc_cdac_side and from every adc-* deck. It is
* kept in the library because sim/top-plate-cpar/ instantiates it to
* measure the SUPERSEDED topology's top-plate load set -- the measured
* evidence DR-0014's Context rests on -- and because #61 re-takes that
* measurement on the new topology from this same library. Identical
* device text to the `tgate_dum` subckt sim/track-switch-sampling/
* measured the ratified gain-error number with, at the same default
* rd = 7/16.
.subckt adc_tgate_dum vin vout clk clkb vdd wn=40u wp=80u rd=0.4375
XN  vin  clk  vout 0   nfet_03v3 w='wn' l=0.28u
XP  vin  clkb vout vdd pfet_03v3 w='wp' l=0.28u
XDN vout clkb vout 0   nfet_03v3 w='wn*rd' l=0.28u
XDP vout clk  vout vdd pfet_03v3 w='wp*rd' l=0.28u
.ends adc_tgate_dum

* Local T-gate driver -- one per leg, placed with the CDAC cell. This
* is design/sar-logic/sar_ctrl.spice's `sar_tgate_drv` promoted from
* its rung-1 ideal inverter to real devices: the controller routes
* only the active-high (NMOS gate) half of each leg, and the
* complementary PMOS gate is made here.
.subckt adc_drv a y vdd vss
Xp y a vdd vdd pfet_03v3 w=8u l=0.35u
Xn y a vss vss nfet_03v3 w=4u l=0.35u
.ends adc_drv

* ---- top-plate V_cm switch (DR-0014) ------------------------------
* One per array side. Closed for ph0..ph2 and OPENED ON THE EDGE INTO
* ph3 -- that edge is the sampling instant, and it is the reason the
* whole record exists: with the top plate released before the bottom
* plates move, the sampled input and every subsequent DAC step land in
* the same numerator over the same denominator, so C_arr/(C_arr+C_par)
* cancels from the comparator's decision instead of dividing the DAC
* step alone.
*
* Plain T-gate at the CDAC bottom-plate geometry -- deliberately NOT
* dummy-compensated, and this is a choice, not an omission. DR-0013's
* dummies exist because the OLD sampling switch opened with an
* input-dependent voltage on its channel. This switch always opens
* with its node at V_cm, so its injection is signal-independent: a
* fixed offset, common to both sides, which differential operation
* removes and which DR-0007's Offset row already covers. Adding
* dummies would instead re-hang two permanently-connected MOS
* capacitors on the top plate -- the 194 fF sim/top-plate-cpar/
* measured as 66 % of C_par -- which no longer costs gain under this
* record but does cost bit-trial settling. The residual side-to-side
* MISMATCH of this injection is one of the four things DR-0014's
* Consequences require #61 to measure; it is not claimed here.
*
* Sizing, from the acquisition it has to support: it holds the top
* node at V_cm while the bottom plates slew, so its own time constant
* is R_on * (C_arr + C_par) = 570 ohm * 9.1 pF = 5.2 ns worst case,
* i.e. 36 tau inside the 187.5 ns acquisition window and 0.21 of the
* input network's own 25 ns tau. The lag it leaves at the sampling
* instant is (tau_sw/tau_in)*exp(-7.5) = 1.1e-4 of the input step --
* 0.12 LSB at full scale, and LINEAR in the input, so it is a gain
* term and not a linearity term. Widening it would buy that back at
* the price of more injection to mismatch, which is the term this
* topology cannot cancel.
.subckt adc_tp_sw top vcm gn vdd vss
Xd gn gp vdd vss adc_drv
Xs vcm top gn gp vdd adc_tgate wn=10u wp=20u
.ends adc_tp_sw

* ---- one CDAC cell ------------------------------------------------
* A weight-w block of unit capacitors and its FOUR-way bottom-plate
* switch: driven to V_in while sampling (DR-0014's fourth leg),
* released to V_cm, or engaged to V_REF or GND (DR-0011, unchanged).
* Exactly one leg conducts at a time -- the four-leg one-hot invariant
* sim/sar-logic-functional/ checks on the control side.
*
* The fourth leg is the same T-gate as the other three. That is what
* makes the cell one repeated device rather than four different ones,
* and it is why the Input-structure row's series R_on has to be
* re-measured rather than carried over (DR-0014, and #61 owns it): the
* input now reaches the array through nine of these in parallel,
* instead of through one dedicated 40u/80u switch.
.subckt adc_cdac_cell top vin vref vcm vss vdd gn_in gn_rel gn_hi gn_lo
+ cw=10u cl=10u
Xc  top bp mim_cap_2f0 c_width='cw' c_length='cl'
Xdi gn_in  gp_in  vdd vss adc_drv
Xdr gn_rel gp_rel vdd vss adc_drv
Xdh gn_hi  gp_hi  vdd vss adc_drv
Xdl gn_lo  gp_lo  vdd vss adc_drv
Xsi vin  bp gn_in  gp_in  vdd adc_tgate wn=10u wp=20u
Xsr vcm  bp gn_rel gp_rel vdd adc_tgate wn=10u wp=20u
Xsh vref bp gn_hi  gp_hi  vdd adc_tgate wn=10u wp=20u
Xsl vss  bp gn_lo  gp_lo  vdd adc_tgate wn=10u wp=20u
.ends adc_cdac_cell

* ---- one array side -----------------------------------------------
* DR-0011: 2^(N-1) = 512 unit positions per side -- nine binary
* weighted blocks (256..1, 511 units) plus one terminating unit fixed
* to V_cm. C_u = 35.6528 fF (spec/cdac-sizing-memo.md Sec 4), so the
* per-side track-mode capacitance is 512 * C_u = 18.254 pF, which is
* the C_in the ratified Input-structure row publishes.
*
* Each block is drawn as ONE capacitor of the block's total area, not
* as w separate unit cells. That is exact for this campaign and it is
* deliberate: these records verify the NOMINAL design over PVT, where
* unit-to-unit mismatch is zero by construction, and the statistical
* spread of the same array is sim/mc-cdac-mismatch/'s claim, taken at
* nominal PVT with a behavioural model because the open PDK ships no
* local capacitor mismatch model at all. Drawing 1022 unit cells here
* would multiply simulation cost by ~50x and change no number.
*
* Areas from the measured MiM density law (devchar Sec 1.2),
* C(s) = 1.99*s^2 + 0.9532*s fF for a square of side s um:
*   w=256  C =   9127.12 fF  ->  s = 67.4846 um
*   w=128  C =   4563.56 fF  ->  s = 47.6489 um
*   w= 64  C =   2281.78 fF  ->  s = 33.6232 um
*   w= 32  C =   1140.89 fF  ->  s = 23.7056 um
*   w= 16  C =    570.44 fF  ->  s = 16.6931 um
*   w=  8  C =    285.22 fF  ->  s = 11.7349 um
*   w=  4  C =    142.61 fF  ->  s = 8.2293 um
*   w=  2  C =     71.31 fF  ->  s = 5.7513 um
*   w=  1  C =     35.65 fF  ->  s = 4.0000 um
*
* `sel_in` is ONE port, not nine: every cell's fourth leg is driven by
* the same broadcast control, because all bottom plates sample
* together by construction (design/sar-logic/README.md states the same
* bus-width argument from the controller side). The per-cell decode is
* still four one-hot legs; one of the four is shared.
.subckt adc_cdac_side top vin vref vcm vss vdd sel_in rel_256 hi_256
+ lo_256 rel_128 hi_128 lo_128 rel_64 hi_64 lo_64 rel_32 hi_32 lo_32
+ rel_16 hi_16 lo_16 rel_8 hi_8 lo_8 rel_4 hi_4 lo_4 rel_2 hi_2 lo_2 rel_1
+ hi_1 lo_1
X256 top vin vref vcm vss vdd sel_in rel_256 hi_256 lo_256 adc_cdac_cell cw=67.4846u cl=67.4846u
X128 top vin vref vcm vss vdd sel_in rel_128 hi_128 lo_128 adc_cdac_cell cw=47.6489u cl=47.6489u
X64 top vin vref vcm vss vdd sel_in rel_64 hi_64 lo_64 adc_cdac_cell cw=33.6232u cl=33.6232u
X32 top vin vref vcm vss vdd sel_in rel_32 hi_32 lo_32 adc_cdac_cell cw=23.7056u cl=23.7056u
X16 top vin vref vcm vss vdd sel_in rel_16 hi_16 lo_16 adc_cdac_cell cw=16.6931u cl=16.6931u
X8 top vin vref vcm vss vdd sel_in rel_8 hi_8 lo_8 adc_cdac_cell cw=11.7349u cl=11.7349u
X4 top vin vref vcm vss vdd sel_in rel_4 hi_4 lo_4 adc_cdac_cell cw=8.2293u cl=8.2293u
X2 top vin vref vcm vss vdd sel_in rel_2 hi_2 lo_2 adc_cdac_cell cw=5.7513u cl=5.7513u
X1 top vin vref vcm vss vdd sel_in rel_1 hi_1 lo_1 adc_cdac_cell cw=4.0000u cl=4.0000u
* terminating unit: DR-0011's 512th position, fixed to V_cm, never
* switched -- it is what makes the weight-1 trial resolve exactly one
* LSB of full scale rather than one part in 511. Under DR-0014 it is
* also the one unit that does NOT track V_in during acquisition, so
* the capacitance the input PIN drives is 511*C_u = 18.219 pF while the
* C_arr the charge balance runs on is still 512*C_u = 18.254 pF. The
* 0.2 % difference sits inside the ratified Input-structure row's own
* rounding and does not change DR-0013's <= 30 ns drive contract.
Xterm top vcm mim_cap_2f0 c_width=4.0000u c_length=4.0000u
.ends adc_cdac_side
* --- ADC-TOP-NETLIST-END ---
