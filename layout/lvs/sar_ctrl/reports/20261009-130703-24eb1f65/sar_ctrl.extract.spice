* extracted by klt extract --deck gf180mcu

* cell sar_ctrl_a
* pin VDD
* pin VDD
* pin VDD
* pin VDD
* pin VDD
* pin VSS
* pin c0_r
* pin c1_r
* pin c2_r
* pin c3_r
* pin c4_r
* pin c5_r
* pin c6_r
* pin c7_r
* pin c8_r
* pin c9_r
* pin clk
* pin cmp
* pin mode
* pin ph[15]
* pin rel_n_128n
* pin rel_n_128p
* pin rel_n_16n
* pin rel_n_16p
* pin rel_n_1n
* pin rel_n_1p
* pin rel_n_256n
* pin rel_n_256p
* pin rel_n_2n
* pin rel_n_2p
* pin rel_n_32n
* pin rel_n_32p
* pin rel_n_4n
* pin rel_n_4p
* pin rel_n_64n
* pin rel_n_64p
* pin rel_n_8n
* pin rel_n_8p
* pin samp_tp_n
* pin sel_hi_n_128n
* pin sel_hi_n_128p
* pin sel_hi_n_16n
* pin sel_hi_n_16p
* pin sel_hi_n_1n
* pin sel_hi_n_1p
* pin sel_hi_n_256n
* pin sel_hi_n_256p
* pin sel_hi_n_2n
* pin sel_hi_n_2p
* pin sel_hi_n_32n
* pin sel_hi_n_32p
* pin sel_hi_n_4n
* pin sel_hi_n_4p
* pin sel_hi_n_64n
* pin sel_hi_n_64p
* pin sel_hi_n_8n
* pin sel_hi_n_8p
* pin sel_in_n
* pin sel_lo_n_128n
* pin sel_lo_n_128p
* pin sel_lo_n_16n
* pin sel_lo_n_16p
* pin sel_lo_n_1n
* pin sel_lo_n_1p
* pin sel_lo_n_256n
* pin sel_lo_n_256p
* pin sel_lo_n_2n
* pin sel_lo_n_2p
* pin sel_lo_n_32n
* pin sel_lo_n_32p
* pin sel_lo_n_4n
* pin sel_lo_n_4p
* pin sel_lo_n_64n
* pin sel_lo_n_64p
* pin sel_lo_n_8n
* pin sel_lo_n_8p
* pin start
.SUBCKT sar_ctrl_a VDD VDD$1 VDD$2 VDD$3 VDD$4 VSS c0_r c1_r c2_r c3_r c4_r
+ c5_r c6_r c7_r c8_r c9_r clk cmp mode ph[15] rel_n_128n rel_n_128p rel_n_16n
+ rel_n_16p rel_n_1n rel_n_1p rel_n_256n rel_n_256p rel_n_2n rel_n_2p rel_n_32n
+ rel_n_32p rel_n_4n rel_n_4p rel_n_64n rel_n_64p rel_n_8n rel_n_8p samp_tp_n
+ sel_hi_n_128n sel_hi_n_128p sel_hi_n_16n sel_hi_n_16p sel_hi_n_1n sel_hi_n_1p
+ sel_hi_n_256n sel_hi_n_256p sel_hi_n_2n sel_hi_n_2p sel_hi_n_32n sel_hi_n_32p
+ sel_hi_n_4n sel_hi_n_4p sel_hi_n_64n sel_hi_n_64p sel_hi_n_8n sel_hi_n_8p
+ sel_in_n sel_lo_n_128n sel_lo_n_128p sel_lo_n_16n sel_lo_n_16p sel_lo_n_1n
+ sel_lo_n_1p sel_lo_n_256n sel_lo_n_256p sel_lo_n_2n sel_lo_n_2p sel_lo_n_32n
+ sel_lo_n_32p sel_lo_n_4n sel_lo_n_4p sel_lo_n_64n sel_lo_n_64p sel_lo_n_8n
+ sel_lo_n_8p start
* device instance $1 r0 *1 17.34,0.75 nfet
M$1 ph[11] \$44 VSS VSS nfet L=0.6U W=0.82U AS=0.3608P AD=0.3608P PS=2.52U
+ PD=2.52U
* device instance $2 r0 *1 45.9,0.75 nfet
M$2 eng2 \$52 VSS VSS nfet L=0.6U W=0.82U AS=0.3608P AD=0.3608P PS=2.52U
+ PD=2.52U
* device instance $3 r0 *1 78.78,0.595 nfet
M$3 VSS sel_in_n rel_n_8n VSS nfet L=0.6U W=0.51U AS=0.2569P AD=0.2244P
+ PS=1.56U PD=1.9U
* device instance $4 r0 *1 76.52,0.75 nfet
M$4 \$93 eng4 VSS VSS nfet L=0.6U W=0.82U AS=0.3608P AD=0.1312P PS=2.52U
+ PD=1.14U
* device instance $5 r0 *1 77.44,0.75 nfet
M$5 rel_n_8n mode \$93 VSS nfet L=0.6U W=0.82U AS=0.1312P AD=0.2569P PS=1.14U
+ PD=1.56U
* device instance $6 r0 *1 89.98,0.595 nfet
M$6 VSS sel_in_n rel_n_128n VSS nfet L=0.6U W=0.51U AS=0.2569P AD=0.2244P
+ PS=1.56U PD=1.9U
* device instance $7 r0 *1 87.72,0.75 nfet
M$7 \$94 eng8 VSS VSS nfet L=0.6U W=0.82U AS=0.3608P AD=0.1312P PS=2.52U
+ PD=1.14U
* device instance $8 r0 *1 88.64,0.75 nfet
M$8 rel_n_128n mode \$94 VSS nfet L=0.6U W=0.82U AS=0.1312P AD=0.2569P PS=1.14U
+ PD=1.56U
* device instance $9 r0 *1 124.7,0.595 nfet
M$9 VSS sel_in_n rel_n_1n VSS nfet L=0.6U W=0.51U AS=0.2569P AD=0.2244P
+ PS=1.56U PD=1.9U
* device instance $10 r0 *1 122.44,0.75 nfet
M$10 \$96 eng1 VSS VSS nfet L=0.6U W=0.82U AS=0.3608P AD=0.1312P PS=2.52U
+ PD=1.14U
* device instance $11 r0 *1 123.36,0.75 nfet
M$11 rel_n_1n mode \$96 VSS nfet L=0.6U W=0.82U AS=0.1312P AD=0.2569P PS=1.14U
+ PD=1.56U
* device instance $12 r0 *1 144.28,0.75 nfet
M$12 ZN clknet_2_2__leaf_clk VSS VSS nfet L=0.6U W=0.82U AS=0.3608P AD=0.2132P
+ PS=2.52U PD=1.34U
* device instance $13 r0 *1 145.4,0.75 nfet
M$13 VSS clknet_2_2__leaf_clk ZN VSS nfet L=0.6U W=0.82U AS=0.2132P AD=0.2132P
+ PS=1.34U PD=1.34U
* device instance $14 r0 *1 146.52,0.75 nfet
M$14 ZN clknet_2_2__leaf_clk VSS VSS nfet L=0.6U W=0.82U AS=0.2132P AD=0.3608P
+ PS=1.34U PD=2.52U
* device instance $15 r0 *1 166.3,0.75 nfet
M$15 ph[7] \$72 VSS VSS nfet L=0.6U W=0.82U AS=0.3608P AD=0.3608P PS=2.52U
+ PD=2.52U
* device instance $16 r0 *1 191.5,0.75 nfet
M$16 ph[1] \$79 VSS VSS nfet L=0.6U W=0.82U AS=0.3608P AD=0.3608P PS=2.52U
+ PD=2.52U
* device instance $17 r0 *1 19.4,0.92 nfet
M$17 \_047_ ph[10] VSS VSS nfet L=0.6U W=0.48U AS=0.2112P AD=0.2112P PS=1.84U
+ PD=1.84U
* device instance $18 r0 *1 54.68,0.8075 nfet
M$18 sel_lo_n_2p q2 VSS VSS nfet L=0.6U W=0.565U AS=0.2486P AD=0.1469P PS=2.01U
+ PD=1.085U
* device instance $19 r0 *1 55.8,0.8075 nfet
M$19 VSS \_042_ sel_lo_n_2p VSS nfet L=0.6U W=0.565U AS=0.1469P AD=0.2486P
+ PS=1.085U PD=2.01U
* device instance $20 r0 *1 58.04,0.8075 nfet
M$20 sel_lo_n_4p q3 VSS VSS nfet L=0.6U W=0.565U AS=0.2486P AD=0.1469P PS=2.01U
+ PD=1.085U
* device instance $21 r0 *1 59.16,0.8075 nfet
M$21 VSS \_030_ sel_lo_n_4p VSS nfet L=0.6U W=0.565U AS=0.1469P AD=0.2486P
+ PS=1.085U PD=2.01U
* device instance $22 r0 *1 84.36,0.8075 nfet
M$22 rel_n_32p sel_in_n VSS VSS nfet L=0.6U W=0.565U AS=0.2486P AD=0.1469P
+ PS=2.01U PD=1.085U
* device instance $23 r0 *1 85.48,0.8075 nfet
M$23 VSS eng6 rel_n_32p VSS nfet L=0.6U W=0.565U AS=0.1469P AD=0.2486P
+ PS=1.085U PD=2.01U
* device instance $24 r0 *1 93.32,0.92 nfet
M$24 \_031_ mode VSS VSS nfet L=0.6U W=0.48U AS=0.2112P AD=0.2112P PS=1.84U
+ PD=1.84U
* device instance $25 r0 *1 97.24,0.8075 nfet
M$25 rel_n_128p sel_in_n VSS VSS nfet L=0.6U W=0.565U AS=0.2486P AD=0.1469P
+ PS=2.01U PD=1.085U
* device instance $26 r0 *1 98.36,0.8075 nfet
M$26 VSS eng8 rel_n_128p VSS nfet L=0.6U W=0.565U AS=0.1469P AD=0.2486P
+ PS=1.085U PD=2.01U
* device instance $27 r0 *1 113.48,0.7575 nfet
M$27 sel_hi_n_1n q1 VSS VSS nfet L=0.6U W=0.465U AS=0.2046P AD=0.1209P PS=1.81U
+ PD=0.985U
* device instance $28 r0 *1 114.6,0.7575 nfet
M$28 VSS \_044_ sel_hi_n_1n VSS nfet L=0.6U W=0.465U AS=0.1209P AD=0.1209P
+ PS=0.985U PD=0.985U
* device instance $29 r0 *1 115.72,0.7575 nfet
M$29 sel_hi_n_1n \_031_ VSS VSS nfet L=0.6U W=0.465U AS=0.1209P AD=0.2046P
+ PS=0.985U PD=1.81U
* device instance $30 r0 *1 134.2,0.7575 nfet
M$30 sel_hi_n_32n \_038_ VSS VSS nfet L=0.6U W=0.465U AS=0.2046P AD=0.1209P
+ PS=1.81U PD=0.985U
* device instance $31 r0 *1 135.32,0.7575 nfet
M$31 VSS q6 sel_hi_n_32n VSS nfet L=0.6U W=0.465U AS=0.1209P AD=0.1209P
+ PS=0.985U PD=0.985U
* device instance $32 r0 *1 136.44,0.7575 nfet
M$32 sel_hi_n_32n \_031_ VSS VSS nfet L=0.6U W=0.465U AS=0.1209P AD=0.2046P
+ PS=0.985U PD=1.81U
* device instance $33 r0 *1 140.92,0.92 nfet
M$33 \_038_ eng6 VSS VSS nfet L=0.6U W=0.48U AS=0.2112P AD=0.2112P PS=1.84U
+ PD=1.84U
* device instance $34 r0 *1 3.16,0.9575 nfet
M$34 VSS clknet_2_0__leaf_clk \$37 VSS nfet L=0.6U W=0.405U AS=0.1782P
+ AD=0.1053P PS=1.69U PD=0.925U
* device instance $35 r0 *1 4.28,0.9575 nfet
M$35 \$39 \$37 VSS VSS nfet L=0.6U W=0.405U AS=0.1053P AD=0.1782P PS=0.925U
+ PD=1.69U
* device instance $36 r0 *1 6.12,0.975 nfet
M$36 \$80 \$37 VSS VSS nfet L=0.6U W=0.36U AS=0.1584P AD=0.0432P PS=1.6U PD=0.6U
* device instance $37 r0 *1 6.96,0.975 nfet
M$37 \$41 \_009_[11] \$80 VSS nfet L=0.6U W=0.36U AS=0.0432P AD=0.207P PS=0.6U
+ PD=1.51U
* device instance $38 r0 *1 8.58,0.975 nfet
M$38 \$81 \$39 \$41 VSS nfet L=0.6U W=0.36U AS=0.207P AD=0.0432P PS=1.51U
+ PD=0.6U
* device instance $39 r0 *1 9.42,0.975 nfet
M$39 \$81 \$42 VSS VSS nfet L=0.6U W=0.36U AS=0.2637P AD=0.0432P PS=1.825U
+ PD=0.6U
* device instance $40 r0 *1 10.98,0.975 nfet
M$40 \$42 \$41 VSS VSS nfet L=0.6U W=0.36U AS=0.2637P AD=0.0936P PS=1.825U
+ PD=0.88U
* device instance $41 r0 *1 12.1,0.975 nfet
M$41 \$43 \$39 \$42 VSS nfet L=0.6U W=0.36U AS=0.0936P AD=0.0936P PS=0.88U
+ PD=0.88U
* device instance $42 r0 *1 13.22,0.975 nfet
M$42 \$83 \$37 \$43 VSS nfet L=0.6U W=0.36U AS=0.0936P AD=0.0432P PS=0.88U
+ PD=0.6U
* device instance $43 r0 *1 14.06,0.975 nfet
M$43 \$83 \$44 VSS VSS nfet L=0.6U W=0.36U AS=0.142P AD=0.0432P PS=1.14U PD=0.6U
* device instance $44 r0 *1 15.4,0.955 nfet
M$44 \$44 \$43 VSS VSS nfet L=0.6U W=0.4U AS=0.142P AD=0.176P PS=1.14U PD=1.68U
* device instance $45 r0 *1 31.72,0.9575 nfet
M$45 VSS clknet_2_0__leaf_clk \$46 VSS nfet L=0.6U W=0.405U AS=0.1782P
+ AD=0.1053P PS=1.69U PD=0.925U
* device instance $46 r0 *1 32.84,0.9575 nfet
M$46 \$47 \$46 VSS VSS nfet L=0.6U W=0.405U AS=0.1053P AD=0.1782P PS=0.925U
+ PD=1.69U
* device instance $47 r0 *1 34.68,0.975 nfet
M$47 \$86 \$46 VSS VSS nfet L=0.6U W=0.36U AS=0.1584P AD=0.0432P PS=1.6U PD=0.6U
* device instance $48 r0 *1 35.52,0.975 nfet
M$48 \$49 \_001_ \$86 VSS nfet L=0.6U W=0.36U AS=0.0432P AD=0.207P PS=0.6U
+ PD=1.51U
* device instance $49 r0 *1 37.14,0.975 nfet
M$49 \$87 \$47 \$49 VSS nfet L=0.6U W=0.36U AS=0.207P AD=0.0432P PS=1.51U
+ PD=0.6U
* device instance $50 r0 *1 37.98,0.975 nfet
M$50 \$87 \$50 VSS VSS nfet L=0.6U W=0.36U AS=0.2637P AD=0.0432P PS=1.825U
+ PD=0.6U
* device instance $51 r0 *1 39.54,0.975 nfet
M$51 \$50 \$49 VSS VSS nfet L=0.6U W=0.36U AS=0.2637P AD=0.0936P PS=1.825U
+ PD=0.88U
* device instance $52 r0 *1 40.66,0.975 nfet
M$52 \$51 \$47 \$50 VSS nfet L=0.6U W=0.36U AS=0.0936P AD=0.0936P PS=0.88U
+ PD=0.88U
* device instance $53 r0 *1 41.78,0.975 nfet
M$53 \$88 \$46 \$51 VSS nfet L=0.6U W=0.36U AS=0.0936P AD=0.0432P PS=0.88U
+ PD=0.6U
* device instance $54 r0 *1 42.62,0.975 nfet
M$54 \$88 \$52 VSS VSS nfet L=0.6U W=0.36U AS=0.142P AD=0.0432P PS=1.14U PD=0.6U
* device instance $55 r0 *1 43.96,0.955 nfet
M$55 \$52 \$51 VSS VSS nfet L=0.6U W=0.4U AS=0.142P AD=0.176P PS=1.14U PD=1.68U
* device instance $56 r0 *1 61.4,0.9775 nfet
M$56 \$92 mode \$55 VSS nfet L=0.6U W=0.365U AS=0.1606P AD=0.0584P PS=1.61U
+ PD=0.685U
* device instance $57 r0 *1 62.32,0.9775 nfet
M$57 \$92 sel_hi_n_64p VSS VSS nfet L=0.6U W=0.365U AS=0.23405P AD=0.0584P
+ PS=1.555U PD=0.685U
* device instance $58 r0 *1 63.66,0.7525 nfet
M$58 sel_lo_n_64n \$55 VSS VSS nfet L=0.6U W=0.815U AS=0.23405P AD=0.3586P
+ PS=1.555U PD=2.51U
* device instance $59 r0 *1 101.72,0.9775 nfet
M$59 \$95 mode \$59 VSS nfet L=0.6U W=0.365U AS=0.1606P AD=0.0584P PS=1.61U
+ PD=0.685U
* device instance $60 r0 *1 102.64,0.9775 nfet
M$60 \$95 sel_hi_n_2p VSS VSS nfet L=0.6U W=0.365U AS=0.23405P AD=0.0584P
+ PS=1.555U PD=0.685U
* device instance $61 r0 *1 103.98,0.7525 nfet
M$61 sel_lo_n_2n \$59 VSS VSS nfet L=0.6U W=0.815U AS=0.23405P AD=0.3586P
+ PS=1.555U PD=2.51U
* device instance $62 r0 *1 109,0.9775 nfet
M$62 \$97 q6 \$60 VSS nfet L=0.6U W=0.365U AS=0.1606P AD=0.0584P PS=1.61U
+ PD=0.685U
* device instance $63 r0 *1 109.92,0.9775 nfet
M$63 \$97 eng6 VSS VSS nfet L=0.6U W=0.365U AS=0.23405P AD=0.0584P PS=1.555U
+ PD=0.685U
* device instance $64 r0 *1 111.26,0.7525 nfet
M$64 sel_hi_n_32p \$60 VSS VSS nfet L=0.6U W=0.815U AS=0.23405P AD=0.3586P
+ PS=1.555U PD=2.51U
* device instance $65 r0 *1 152.12,0.9575 nfet
M$65 VSS clknet_2_2__leaf_clk \$66 VSS nfet L=0.6U W=0.405U AS=0.1782P
+ AD=0.1053P PS=1.69U PD=0.925U
* device instance $66 r0 *1 153.24,0.9575 nfet
M$66 \$67 \$66 VSS VSS nfet L=0.6U W=0.405U AS=0.1053P AD=0.1782P PS=0.925U
+ PD=1.69U
* device instance $67 r0 *1 155.08,0.975 nfet
M$67 \$91 \$66 VSS VSS nfet L=0.6U W=0.36U AS=0.1584P AD=0.0432P PS=1.6U PD=0.6U
* device instance $68 r0 *1 155.92,0.975 nfet
M$68 \$69 \_009_[7] \$91 VSS nfet L=0.6U W=0.36U AS=0.0432P AD=0.207P PS=0.6U
+ PD=1.51U
* device instance $69 r0 *1 157.54,0.975 nfet
M$69 \$90 \$67 \$69 VSS nfet L=0.6U W=0.36U AS=0.207P AD=0.0432P PS=1.51U
+ PD=0.6U
* device instance $70 r0 *1 158.38,0.975 nfet
M$70 \$90 \$70 VSS VSS nfet L=0.6U W=0.36U AS=0.2637P AD=0.0432P PS=1.825U
+ PD=0.6U
* device instance $71 r0 *1 159.94,0.975 nfet
M$71 \$70 \$69 VSS VSS nfet L=0.6U W=0.36U AS=0.2637P AD=0.0936P PS=1.825U
+ PD=0.88U
* device instance $72 r0 *1 161.06,0.975 nfet
M$72 \$71 \$67 \$70 VSS nfet L=0.6U W=0.36U AS=0.0936P AD=0.0936P PS=0.88U
+ PD=0.88U
* device instance $73 r0 *1 162.18,0.975 nfet
M$73 \$89 \$66 \$71 VSS nfet L=0.6U W=0.36U AS=0.0936P AD=0.0432P PS=0.88U
+ PD=0.6U
* device instance $74 r0 *1 163.02,0.975 nfet
M$74 \$89 \$72 VSS VSS nfet L=0.6U W=0.36U AS=0.142P AD=0.0432P PS=1.14U PD=0.6U
* device instance $75 r0 *1 164.36,0.955 nfet
M$75 \$72 \$71 VSS VSS nfet L=0.6U W=0.4U AS=0.142P AD=0.176P PS=1.14U PD=1.68U
* device instance $76 r0 *1 177.32,0.9575 nfet
M$76 VSS clknet_2_2__leaf_clk \$73 VSS nfet L=0.6U W=0.405U AS=0.1782P
+ AD=0.1053P PS=1.69U PD=0.925U
* device instance $77 r0 *1 178.44,0.9575 nfet
M$77 \$74 \$73 VSS VSS nfet L=0.6U W=0.405U AS=0.1053P AD=0.1782P PS=0.925U
+ PD=1.69U
* device instance $78 r0 *1 180.28,0.975 nfet
M$78 \$85 \$73 VSS VSS nfet L=0.6U W=0.36U AS=0.1584P AD=0.0432P PS=1.6U PD=0.6U
* device instance $79 r0 *1 181.12,0.975 nfet
M$79 \$76 \_009_[1] \$85 VSS nfet L=0.6U W=0.36U AS=0.0432P AD=0.207P PS=0.6U
+ PD=1.51U
* device instance $80 r0 *1 182.74,0.975 nfet
M$80 \$84 \$74 \$76 VSS nfet L=0.6U W=0.36U AS=0.207P AD=0.0432P PS=1.51U
+ PD=0.6U
* device instance $81 r0 *1 183.58,0.975 nfet
M$81 \$84 \$77 VSS VSS nfet L=0.6U W=0.36U AS=0.2637P AD=0.0432P PS=1.825U
+ PD=0.6U
* device instance $82 r0 *1 185.14,0.975 nfet
M$82 \$77 \$76 VSS VSS nfet L=0.6U W=0.36U AS=0.2637P AD=0.0936P PS=1.825U
+ PD=0.88U
* device instance $83 r0 *1 186.26,0.975 nfet
M$83 \$78 \$74 \$77 VSS nfet L=0.6U W=0.36U AS=0.0936P AD=0.0936P PS=0.88U
+ PD=0.88U
* device instance $84 r0 *1 187.38,0.975 nfet
M$84 \$82 \$73 \$78 VSS nfet L=0.6U W=0.36U AS=0.0936P AD=0.0432P PS=0.88U
+ PD=0.6U
* device instance $85 r0 *1 188.22,0.975 nfet
M$85 \$82 \$79 VSS VSS nfet L=0.6U W=0.36U AS=0.142P AD=0.0432P PS=1.14U PD=0.6U
* device instance $86 r0 *1 189.56,0.955 nfet
M$86 \$79 \$78 VSS VSS nfet L=0.6U W=0.4U AS=0.142P AD=0.176P PS=1.14U PD=1.68U
* device instance $87 r0 *1 8.2,6.8825 nfet
M$87 VSS clknet_2_0__leaf_clk \$131 VSS nfet L=0.6U W=0.405U AS=0.1782P
+ AD=0.1053P PS=1.69U PD=0.925U
* device instance $88 r0 *1 9.32,6.8825 nfet
M$88 \$133 \$131 VSS VSS nfet L=0.6U W=0.405U AS=0.1053P AD=0.1782P PS=0.925U
+ PD=1.69U
* device instance $89 r0 *1 11.16,6.865 nfet
M$89 \$211 \$131 VSS VSS nfet L=0.6U W=0.36U AS=0.1584P AD=0.0432P PS=1.6U
+ PD=0.6U
* device instance $90 r0 *1 12,6.865 nfet
M$90 \$211 \_029_ \$160 VSS nfet L=0.6U W=0.36U AS=0.207P AD=0.0432P PS=1.51U
+ PD=0.6U
* device instance $91 r0 *1 13.62,6.865 nfet
M$91 \$212 \$133 \$160 VSS nfet L=0.6U W=0.36U AS=0.207P AD=0.0432P PS=1.51U
+ PD=0.6U
* device instance $92 r0 *1 14.46,6.865 nfet
M$92 VSS \$132 \$212 VSS nfet L=0.6U W=0.36U AS=0.0432P AD=0.2637P PS=0.6U
+ PD=1.825U
* device instance $93 r0 *1 16.02,6.865 nfet
M$93 \$132 \$160 VSS VSS nfet L=0.6U W=0.36U AS=0.2637P AD=0.0936P PS=1.825U
+ PD=0.88U
* device instance $94 r0 *1 17.14,6.865 nfet
M$94 \$161 \$133 \$132 VSS nfet L=0.6U W=0.36U AS=0.0936P AD=0.0936P PS=0.88U
+ PD=0.88U
* device instance $95 r0 *1 18.26,6.865 nfet
M$95 \$213 \$131 \$161 VSS nfet L=0.6U W=0.36U AS=0.0936P AD=0.0432P PS=0.88U
+ PD=0.6U
* device instance $96 r0 *1 19.1,6.865 nfet
M$96 VSS \$134 \$213 VSS nfet L=0.6U W=0.36U AS=0.0432P AD=0.142P PS=0.6U
+ PD=1.14U
* device instance $97 r0 *1 20.44,6.885 nfet
M$97 \$134 \$161 VSS VSS nfet L=0.6U W=0.4U AS=0.142P AD=0.176P PS=1.14U
+ PD=1.68U
* device instance $98 r0 *1 22.38,7.09 nfet
M$98 q3 \$134 VSS VSS nfet L=0.6U W=0.82U AS=0.3608P AD=0.3608P PS=2.52U
+ PD=2.52U
* device instance $99 r0 *1 29.48,6.8825 nfet
M$99 VSS clknet_2_0__leaf_clk \$135 VSS nfet L=0.6U W=0.405U AS=0.1782P
+ AD=0.1053P PS=1.69U PD=0.925U
* device instance $100 r0 *1 30.6,6.8825 nfet
M$100 \$137 \$135 VSS VSS nfet L=0.6U W=0.405U AS=0.1053P AD=0.1782P PS=0.925U
+ PD=1.69U
* device instance $101 r0 *1 32.44,6.865 nfet
M$101 \$215 \$135 VSS VSS nfet L=0.6U W=0.36U AS=0.1584P AD=0.0432P PS=1.6U
+ PD=0.6U
* device instance $102 r0 *1 33.28,6.865 nfet
M$102 \$215 \_002_ \$162 VSS nfet L=0.6U W=0.36U AS=0.207P AD=0.0432P PS=1.51U
+ PD=0.6U
* device instance $103 r0 *1 34.9,6.865 nfet
M$103 \$216 \$137 \$162 VSS nfet L=0.6U W=0.36U AS=0.207P AD=0.0432P PS=1.51U
+ PD=0.6U
* device instance $104 r0 *1 35.74,6.865 nfet
M$104 VSS \$136 \$216 VSS nfet L=0.6U W=0.36U AS=0.0432P AD=0.2637P PS=0.6U
+ PD=1.825U
* device instance $105 r0 *1 37.3,6.865 nfet
M$105 \$136 \$162 VSS VSS nfet L=0.6U W=0.36U AS=0.2637P AD=0.0936P PS=1.825U
+ PD=0.88U
* device instance $106 r0 *1 38.42,6.865 nfet
M$106 \$163 \$137 \$136 VSS nfet L=0.6U W=0.36U AS=0.0936P AD=0.0936P PS=0.88U
+ PD=0.88U
* device instance $107 r0 *1 39.54,6.865 nfet
M$107 \$217 \$135 \$163 VSS nfet L=0.6U W=0.36U AS=0.0936P AD=0.0432P PS=0.88U
+ PD=0.6U
* device instance $108 r0 *1 40.38,6.865 nfet
M$108 VSS \$138 \$217 VSS nfet L=0.6U W=0.36U AS=0.0432P AD=0.142P PS=0.6U
+ PD=1.14U
* device instance $109 r0 *1 41.72,6.885 nfet
M$109 \$138 \$163 VSS VSS nfet L=0.6U W=0.4U AS=0.142P AD=0.176P PS=1.14U
+ PD=1.68U
* device instance $110 r0 *1 43.66,7.09 nfet
M$110 eng3 \$138 VSS VSS nfet L=0.6U W=0.82U AS=0.3608P AD=0.3608P PS=2.52U
+ PD=2.52U
* device instance $111 r0 *1 45.72,6.92 nfet
M$111 \_030_ eng3 VSS VSS nfet L=0.6U W=0.48U AS=0.2112P AD=0.2112P PS=1.84U
+ PD=1.84U
* device instance $112 r0 *1 61.4,6.8625 nfet
M$112 \$219 q4 \$140 VSS nfet L=0.6U W=0.365U AS=0.1606P AD=0.0584P PS=1.61U
+ PD=0.685U
* device instance $113 r0 *1 62.32,6.8625 nfet
M$113 VSS eng4 \$219 VSS nfet L=0.6U W=0.365U AS=0.0584P AD=0.23405P PS=0.685U
+ PD=1.555U
* device instance $114 r0 *1 63.66,7.0875 nfet
M$114 sel_hi_n_8p \$140 VSS VSS nfet L=0.6U W=0.815U AS=0.23405P AD=0.3586P
+ PS=1.555U PD=2.51U
* device instance $115 r0 *1 68.12,6.8625 nfet
M$115 \$220 mode \$142 VSS nfet L=0.6U W=0.365U AS=0.1606P AD=0.0584P PS=1.61U
+ PD=0.685U
* device instance $116 r0 *1 69.04,6.8625 nfet
M$116 VSS sel_hi_n_8p \$220 VSS nfet L=0.6U W=0.365U AS=0.0584P AD=0.23405P
+ PS=0.685U PD=1.555U
* device instance $117 r0 *1 70.38,7.0875 nfet
M$117 sel_lo_n_8n \$142 VSS VSS nfet L=0.6U W=0.815U AS=0.23405P AD=0.3586P
+ PS=1.555U PD=2.51U
* device instance $118 r0 *1 73.16,6.8625 nfet
M$118 \$221 mode \$144 VSS nfet L=0.6U W=0.365U AS=0.1606P AD=0.0584P PS=1.61U
+ PD=0.685U
* device instance $119 r0 *1 74.08,6.8625 nfet
M$119 VSS sel_hi_n_1p \$221 VSS nfet L=0.6U W=0.365U AS=0.0584P AD=0.23405P
+ PS=0.685U PD=1.555U
* device instance $120 r0 *1 75.42,7.0875 nfet
M$120 sel_lo_n_1n \$144 VSS VSS nfet L=0.6U W=0.815U AS=0.23405P AD=0.3586P
+ PS=1.555U PD=2.51U
* device instance $121 r0 *1 80.44,7.09 nfet
M$121 \$224 eng2 VSS VSS nfet L=0.6U W=0.82U AS=0.3608P AD=0.1312P PS=2.52U
+ PD=1.14U
* device instance $122 r0 *1 81.36,7.09 nfet
M$122 rel_n_2n mode \$224 VSS nfet L=0.6U W=0.82U AS=0.1312P AD=0.2569P
+ PS=1.14U PD=1.56U
* device instance $123 r0 *1 82.7,7.245 nfet
M$123 VSS sel_in_n rel_n_2n VSS nfet L=0.6U W=0.51U AS=0.2569P AD=0.2244P
+ PS=1.56U PD=1.9U
* device instance $124 r0 *1 86.6,6.8625 nfet
M$124 \$226 mode \$146 VSS nfet L=0.6U W=0.365U AS=0.1606P AD=0.0584P PS=1.61U
+ PD=0.685U
* device instance $125 r0 *1 87.52,6.8625 nfet
M$125 VSS sel_hi_n_4p \$226 VSS nfet L=0.6U W=0.365U AS=0.0584P AD=0.23405P
+ PS=0.685U PD=1.555U
* device instance $126 r0 *1 88.86,7.0875 nfet
M$126 sel_lo_n_4n \$146 VSS VSS nfet L=0.6U W=0.815U AS=0.23405P AD=0.3586P
+ PS=1.555U PD=2.51U
* device instance $127 r0 *1 92.2,7.0325 nfet
M$127 rel_n_64p sel_in_n VSS VSS nfet L=0.6U W=0.565U AS=0.2486P AD=0.1469P
+ PS=2.01U PD=1.085U
* device instance $128 r0 *1 93.32,7.0325 nfet
M$128 VSS eng7 rel_n_64p VSS nfet L=0.6U W=0.565U AS=0.1469P AD=0.2486P
+ PS=1.085U PD=2.01U
* device instance $129 r0 *1 97.24,7.0325 nfet
M$129 rel_n_2p sel_in_n VSS VSS nfet L=0.6U W=0.565U AS=0.2486P AD=0.1469P
+ PS=2.01U PD=1.085U
* device instance $130 r0 *1 98.36,7.0325 nfet
M$130 VSS eng2 rel_n_2p VSS nfet L=0.6U W=0.565U AS=0.1469P AD=0.2486P
+ PS=1.085U PD=2.01U
* device instance $131 r0 *1 102.28,7.0325 nfet
M$131 rel_n_1p sel_in_n VSS VSS nfet L=0.6U W=0.565U AS=0.2486P AD=0.1469P
+ PS=2.01U PD=1.085U
* device instance $132 r0 *1 103.4,7.0325 nfet
M$132 VSS eng1 rel_n_1p VSS nfet L=0.6U W=0.565U AS=0.1469P AD=0.2486P
+ PS=1.085U PD=2.01U
* device instance $133 r0 *1 105.64,7.0325 nfet
M$133 rel_n_4p sel_in_n VSS VSS nfet L=0.6U W=0.565U AS=0.2486P AD=0.1469P
+ PS=2.01U PD=1.085U
* device instance $134 r0 *1 106.76,7.0325 nfet
M$134 VSS eng3 rel_n_4p VSS nfet L=0.6U W=0.565U AS=0.1469P AD=0.2486P
+ PS=1.085U PD=2.01U
* device instance $135 r0 *1 110.12,7.09 nfet
M$135 \$230 eng7 VSS VSS nfet L=0.6U W=0.82U AS=0.3608P AD=0.1312P PS=2.52U
+ PD=1.14U
* device instance $136 r0 *1 111.04,7.09 nfet
M$136 rel_n_64n mode \$230 VSS nfet L=0.6U W=0.82U AS=0.1312P AD=0.2569P
+ PS=1.14U PD=1.56U
* device instance $137 r0 *1 112.38,7.245 nfet
M$137 VSS sel_in_n rel_n_64n VSS nfet L=0.6U W=0.51U AS=0.2569P AD=0.2244P
+ PS=1.56U PD=1.9U
* device instance $138 r0 *1 114.6,6.8625 nfet
M$138 \$231 mode \$150 VSS nfet L=0.6U W=0.365U AS=0.1606P AD=0.0584P PS=1.61U
+ PD=0.685U
* device instance $139 r0 *1 115.52,6.8625 nfet
M$139 VSS sel_hi_n_32p \$231 VSS nfet L=0.6U W=0.365U AS=0.0584P AD=0.23405P
+ PS=0.685U PD=1.555U
* device instance $140 r0 *1 116.86,7.0875 nfet
M$140 sel_lo_n_32n \$150 VSS VSS nfet L=0.6U W=0.815U AS=0.23405P AD=0.3586P
+ PS=1.555U PD=2.51U
* device instance $141 r0 *1 119.64,7.09 nfet
M$141 \$232 mode VSS VSS nfet L=0.6U W=0.82U AS=0.3608P AD=0.1312P PS=2.52U
+ PD=1.14U
* device instance $142 r0 *1 120.56,7.09 nfet
M$142 rel_n_4n eng3 \$232 VSS nfet L=0.6U W=0.82U AS=0.1312P AD=0.2569P
+ PS=1.14U PD=1.56U
* device instance $143 r0 *1 121.9,7.245 nfet
M$143 VSS sel_in_n rel_n_4n VSS nfet L=0.6U W=0.51U AS=0.2569P AD=0.2244P
+ PS=1.56U PD=1.9U
* device instance $144 r0 *1 124.12,7.0325 nfet
M$144 rel_n_256p sel_in_n VSS VSS nfet L=0.6U W=0.565U AS=0.2486P AD=0.1469P
+ PS=2.01U PD=1.085U
* device instance $145 r0 *1 125.24,7.0325 nfet
M$145 VSS eng9 rel_n_256p VSS nfet L=0.6U W=0.565U AS=0.1469P AD=0.2486P
+ PS=1.085U PD=2.01U
* device instance $146 r0 *1 128.6,7.0325 nfet
M$146 rel_n_8p sel_in_n VSS VSS nfet L=0.6U W=0.565U AS=0.2486P AD=0.1469P
+ PS=2.01U PD=1.085U
* device instance $147 r0 *1 129.72,7.0325 nfet
M$147 VSS eng4 rel_n_8p VSS nfet L=0.6U W=0.565U AS=0.1469P AD=0.2486P
+ PS=1.085U PD=2.01U
* device instance $148 r0 *1 137,7.0325 nfet
M$148 rel_n_16p sel_in_n VSS VSS nfet L=0.6U W=0.565U AS=0.2486P AD=0.1469P
+ PS=2.01U PD=1.085U
* device instance $149 r0 *1 138.12,7.0325 nfet
M$149 VSS eng5 rel_n_16p VSS nfet L=0.6U W=0.565U AS=0.1469P AD=0.2486P
+ PS=1.085U PD=2.01U
* device instance $150 r0 *1 141.48,6.8825 nfet
M$150 VSS clknet_2_2__leaf_clk \$152 VSS nfet L=0.6U W=0.405U AS=0.1782P
+ AD=0.1053P PS=1.69U PD=0.925U
* device instance $151 r0 *1 142.6,6.8825 nfet
M$151 \$154 \$152 VSS VSS nfet L=0.6U W=0.405U AS=0.1053P AD=0.1782P PS=0.925U
+ PD=1.69U
* device instance $152 r0 *1 144.44,6.865 nfet
M$152 \$229 \$152 VSS VSS nfet L=0.6U W=0.36U AS=0.1584P AD=0.0432P PS=1.6U
+ PD=0.6U
* device instance $153 r0 *1 145.28,6.865 nfet
M$153 \$229 \_005_ \$170 VSS nfet L=0.6U W=0.36U AS=0.207P AD=0.0432P PS=1.51U
+ PD=0.6U
* device instance $154 r0 *1 146.9,6.865 nfet
M$154 \$228 \$154 \$170 VSS nfet L=0.6U W=0.36U AS=0.207P AD=0.0432P PS=1.51U
+ PD=0.6U
* device instance $155 r0 *1 147.74,6.865 nfet
M$155 VSS \$153 \$228 VSS nfet L=0.6U W=0.36U AS=0.0432P AD=0.2637P PS=0.6U
+ PD=1.825U
* device instance $156 r0 *1 149.3,6.865 nfet
M$156 \$153 \$170 VSS VSS nfet L=0.6U W=0.36U AS=0.2637P AD=0.0936P PS=1.825U
+ PD=0.88U
* device instance $157 r0 *1 150.42,6.865 nfet
M$157 \$171 \$154 \$153 VSS nfet L=0.6U W=0.36U AS=0.0936P AD=0.0936P PS=0.88U
+ PD=0.88U
* device instance $158 r0 *1 151.54,6.865 nfet
M$158 \$227 \$152 \$171 VSS nfet L=0.6U W=0.36U AS=0.0936P AD=0.0432P PS=0.88U
+ PD=0.6U
* device instance $159 r0 *1 152.38,6.865 nfet
M$159 VSS \$155 \$227 VSS nfet L=0.6U W=0.36U AS=0.0432P AD=0.142P PS=0.6U
+ PD=1.14U
* device instance $160 r0 *1 153.72,6.885 nfet
M$160 \$155 \$171 VSS VSS nfet L=0.6U W=0.4U AS=0.142P AD=0.176P PS=1.14U
+ PD=1.68U
* device instance $161 r0 *1 155.66,7.09 nfet
M$161 eng6 \$155 VSS VSS nfet L=0.6U W=0.82U AS=0.3608P AD=0.3608P PS=2.52U
+ PD=2.52U
* device instance $162 r0 *1 161.08,6.8825 nfet
M$162 VSS clknet_2_2__leaf_clk \$156 VSS nfet L=0.6U W=0.405U AS=0.1782P
+ AD=0.1053P PS=1.69U PD=0.925U
* device instance $163 r0 *1 162.2,6.8825 nfet
M$163 \$158 \$156 VSS VSS nfet L=0.6U W=0.405U AS=0.1053P AD=0.1782P PS=0.925U
+ PD=1.69U
* device instance $164 r0 *1 164.04,6.865 nfet
M$164 \$225 \$156 VSS VSS nfet L=0.6U W=0.36U AS=0.1584P AD=0.0432P PS=1.6U
+ PD=0.6U
* device instance $165 r0 *1 164.88,6.865 nfet
M$165 \$225 \_009_[0] \$172 VSS nfet L=0.6U W=0.36U AS=0.207P AD=0.0432P
+ PS=1.51U PD=0.6U
* device instance $166 r0 *1 166.5,6.865 nfet
M$166 \$223 \$158 \$172 VSS nfet L=0.6U W=0.36U AS=0.207P AD=0.0432P PS=1.51U
+ PD=0.6U
* device instance $167 r0 *1 167.34,6.865 nfet
M$167 VSS \$157 \$223 VSS nfet L=0.6U W=0.36U AS=0.0432P AD=0.2637P PS=0.6U
+ PD=1.825U
* device instance $168 r0 *1 168.9,6.865 nfet
M$168 \$157 \$172 VSS VSS nfet L=0.6U W=0.36U AS=0.2637P AD=0.0936P PS=1.825U
+ PD=0.88U
* device instance $169 r0 *1 170.02,6.865 nfet
M$169 \$173 \$158 \$157 VSS nfet L=0.6U W=0.36U AS=0.0936P AD=0.0936P PS=0.88U
+ PD=0.88U
* device instance $170 r0 *1 171.14,6.865 nfet
M$170 \$222 \$156 \$173 VSS nfet L=0.6U W=0.36U AS=0.0936P AD=0.0432P PS=0.88U
+ PD=0.6U
* device instance $171 r0 *1 171.98,6.865 nfet
M$171 VSS \$159 \$222 VSS nfet L=0.6U W=0.36U AS=0.0432P AD=0.142P PS=0.6U
+ PD=1.14U
* device instance $172 r0 *1 173.32,6.885 nfet
M$172 \$159 \$173 VSS VSS nfet L=0.6U W=0.4U AS=0.142P AD=0.176P PS=1.14U
+ PD=1.68U
* device instance $173 r0 *1 175.26,7.09 nfet
M$173 ph[0] \$159 VSS VSS nfet L=0.6U W=0.82U AS=0.3608P AD=0.3608P PS=2.52U
+ PD=2.52U
* device instance $174 r0 *1 177.88,6.92 nfet
M$174 \_033_ ph[0] VSS VSS nfet L=0.6U W=0.48U AS=0.2112P AD=0.2112P PS=1.84U
+ PD=1.84U
* device instance $175 r0 *1 181.935,7.09 nfet
M$175 \$218 \_034_ VSS VSS nfet L=0.6U W=0.82U AS=0.3608P AD=0.1312P PS=2.52U
+ PD=1.14U
* device instance $176 r0 *1 182.855,7.09 nfet
M$176 \$214 \_033_ \$218 VSS nfet L=0.6U W=0.82U AS=0.1312P AD=0.1722P PS=1.14U
+ PD=1.24U
* device instance $177 r0 *1 183.875,7.09 nfet
M$177 samp_tp_n \_032_ \$214 VSS nfet L=0.6U W=0.82U AS=0.1722P AD=0.3608P
+ PS=1.24U PD=2.52U
* device instance $178 r0 *1 185.72,6.92 nfet
M$178 \_034_ ph[1] VSS VSS nfet L=0.6U W=0.48U AS=0.2112P AD=0.2112P PS=1.84U
+ PD=1.84U
* device instance $179 r0 *1 187.96,6.92 nfet
M$179 \_032_ ph[2] VSS VSS nfet L=0.6U W=0.48U AS=0.2112P AD=0.2112P PS=1.84U
+ PD=1.84U
* device instance $180 r0 *1 8.76,8.6475 nfet
M$180 \_009_[11] start VSS VSS nfet L=0.6U W=0.565U AS=0.2486P AD=0.1469P
+ PS=2.01U PD=1.085U
* device instance $181 r0 *1 9.88,8.6475 nfet
M$181 VSS \_047_ \_009_[11] VSS nfet L=0.6U W=0.565U AS=0.1469P AD=0.2486P
+ PS=1.085U PD=2.01U
* device instance $182 r0 *1 14.38,8.435 nfet
M$182 VSS \_064_ \_029_ VSS nfet L=0.6U W=0.51U AS=0.2569P AD=0.2244P PS=1.56U
+ PD=1.9U
* device instance $183 r0 *1 12.12,8.59 nfet
M$183 \$276 cmp VSS VSS nfet L=0.6U W=0.82U AS=0.3608P AD=0.1312P PS=2.52U
+ PD=1.14U
* device instance $184 r0 *1 13.04,8.59 nfet
M$184 \_029_ ph[10] \$276 VSS nfet L=0.6U W=0.82U AS=0.1312P AD=0.2569P
+ PS=1.14U PD=1.56U
* device instance $185 r0 *1 16.6,8.6475 nfet
M$185 \_064_ ph[10] VSS VSS nfet L=0.6U W=0.565U AS=0.2486P AD=0.1469P PS=2.01U
+ PD=1.085U
* device instance $186 r0 *1 17.72,8.6475 nfet
M$186 VSS q3 \_064_ VSS nfet L=0.6U W=0.565U AS=0.1469P AD=0.2486P PS=1.085U
+ PD=2.01U
* device instance $187 r0 *1 19.96,8.6475 nfet
M$187 \_057_ ph[11] VSS VSS nfet L=0.6U W=0.565U AS=0.2486P AD=0.1469P PS=2.01U
+ PD=1.085U
* device instance $188 r0 *1 21.08,8.6475 nfet
M$188 VSS q2 \_057_ VSS nfet L=0.6U W=0.565U AS=0.1469P AD=0.2486P PS=1.085U
+ PD=2.01U
* device instance $189 r0 *1 35.1,8.435 nfet
M$189 VSS ph[13] \_002_ VSS nfet L=0.6U W=0.51U AS=0.2569P AD=0.2244P PS=1.56U
+ PD=1.9U
* device instance $190 r0 *1 32.84,8.59 nfet
M$190 \$277 \_047_ VSS VSS nfet L=0.6U W=0.82U AS=0.3608P AD=0.1312P PS=2.52U
+ PD=1.14U
* device instance $191 r0 *1 33.76,8.59 nfet
M$191 \_002_ \_030_ \$277 VSS nfet L=0.6U W=0.82U AS=0.1312P AD=0.2569P
+ PS=1.14U PD=1.56U
* device instance $192 r0 *1 39.58,8.435 nfet
M$192 VSS ph[13] \_000_ VSS nfet L=0.6U W=0.51U AS=0.2569P AD=0.2244P PS=1.56U
+ PD=1.9U
* device instance $193 r0 *1 37.32,8.59 nfet
M$193 \$278 \_044_ VSS VSS nfet L=0.6U W=0.82U AS=0.3608P AD=0.1312P PS=2.52U
+ PD=1.14U
* device instance $194 r0 *1 38.24,8.59 nfet
M$194 \_000_ \_043_ \$278 VSS nfet L=0.6U W=0.82U AS=0.1312P AD=0.2569P
+ PS=1.14U PD=1.56U
* device instance $195 r0 *1 45.72,8.76 nfet
M$195 \_036_ eng4 VSS VSS nfet L=0.6U W=0.48U AS=0.2112P AD=0.2112P PS=1.84U
+ PD=1.84U
* device instance $196 r0 *1 47.96,8.76 nfet
M$196 \_042_ eng2 VSS VSS nfet L=0.6U W=0.48U AS=0.2112P AD=0.2112P PS=1.84U
+ PD=1.84U
* device instance $197 r0 *1 56.36,8.5975 nfet
M$197 sel_hi_n_8n \_036_ VSS VSS nfet L=0.6U W=0.465U AS=0.2046P AD=0.1209P
+ PS=1.81U PD=0.985U
* device instance $198 r0 *1 57.48,8.5975 nfet
M$198 VSS q4 sel_hi_n_8n VSS nfet L=0.6U W=0.465U AS=0.1209P AD=0.1209P
+ PS=0.985U PD=0.985U
* device instance $199 r0 *1 58.6,8.5975 nfet
M$199 sel_hi_n_8n \_031_ VSS VSS nfet L=0.6U W=0.465U AS=0.1209P AD=0.2046P
+ PS=0.985U PD=1.81U
* device instance $200 r0 *1 56.92,7.0825 nfet
M$200 sel_hi_n_2n q2 VSS VSS nfet L=0.6U W=0.465U AS=0.2046P AD=0.1209P
+ PS=1.81U PD=0.985U
* device instance $201 r0 *1 58.04,7.0825 nfet
M$201 VSS \_042_ sel_hi_n_2n VSS nfet L=0.6U W=0.465U AS=0.1209P AD=0.1209P
+ PS=0.985U PD=0.985U
* device instance $202 r0 *1 59.16,7.0825 nfet
M$202 sel_hi_n_2n \_031_ VSS VSS nfet L=0.6U W=0.465U AS=0.1209P AD=0.2046P
+ PS=0.985U PD=1.81U
* device instance $203 r0 *1 60.84,8.8175 nfet
M$203 \$281 eng3 \$250 VSS nfet L=0.6U W=0.365U AS=0.1606P AD=0.0584P PS=1.61U
+ PD=0.685U
* device instance $204 r0 *1 61.76,8.8175 nfet
M$204 \$281 q3 VSS VSS nfet L=0.6U W=0.365U AS=0.23405P AD=0.0584P PS=1.555U
+ PD=0.685U
* device instance $205 r0 *1 63.1,8.5925 nfet
M$205 sel_hi_n_4p \$250 VSS VSS nfet L=0.6U W=0.815U AS=0.23405P AD=0.3586P
+ PS=1.555U PD=2.51U
* device instance $206 r0 *1 65.32,8.8175 nfet
M$206 \$283 mode \$251 VSS nfet L=0.6U W=0.365U AS=0.1606P AD=0.0584P PS=1.61U
+ PD=0.685U
* device instance $207 r0 *1 66.24,8.8175 nfet
M$207 \$283 sel_hi_n_128p VSS VSS nfet L=0.6U W=0.365U AS=0.23405P AD=0.0584P
+ PS=1.555U PD=0.685U
* device instance $208 r0 *1 67.58,8.5925 nfet
M$208 sel_lo_n_128n \$251 VSS VSS nfet L=0.6U W=0.815U AS=0.23405P AD=0.3586P
+ PS=1.555U PD=2.51U
* device instance $209 r0 *1 74.28,8.8175 nfet
M$209 \$284 eng1 \$252 VSS nfet L=0.6U W=0.365U AS=0.1606P AD=0.0584P PS=1.61U
+ PD=0.685U
* device instance $210 r0 *1 75.2,8.8175 nfet
M$210 \$284 q1 VSS VSS nfet L=0.6U W=0.365U AS=0.23405P AD=0.0584P PS=1.555U
+ PD=0.685U
* device instance $211 r0 *1 76.54,8.5925 nfet
M$211 sel_hi_n_1p \$252 VSS VSS nfet L=0.6U W=0.815U AS=0.23405P AD=0.3586P
+ PS=1.555U PD=2.51U
* device instance $212 r0 *1 82.14,8.435 nfet
M$212 VSS sel_in_n rel_n_32n VSS nfet L=0.6U W=0.51U AS=0.2569P AD=0.2244P
+ PS=1.56U PD=1.9U
* device instance $213 r0 *1 79.88,8.59 nfet
M$213 \$286 eng6 VSS VSS nfet L=0.6U W=0.82U AS=0.3608P AD=0.1312P PS=2.52U
+ PD=1.14U
* device instance $214 r0 *1 80.8,8.59 nfet
M$214 rel_n_32n mode \$286 VSS nfet L=0.6U W=0.82U AS=0.1312P AD=0.2569P
+ PS=1.14U PD=1.56U
* device instance $215 r0 *1 86.62,8.435 nfet
M$215 VSS sel_in_n rel_n_256n VSS nfet L=0.6U W=0.51U AS=0.2569P AD=0.2244P
+ PS=1.56U PD=1.9U
* device instance $216 r0 *1 84.36,8.59 nfet
M$216 \$287 eng9 VSS VSS nfet L=0.6U W=0.82U AS=0.3608P AD=0.1312P PS=2.52U
+ PD=1.14U
* device instance $217 r0 *1 85.28,8.59 nfet
M$217 rel_n_256n mode \$287 VSS nfet L=0.6U W=0.82U AS=0.1312P AD=0.2569P
+ PS=1.14U PD=1.56U
* device instance $218 r0 *1 93.32,8.8175 nfet
M$218 \$288 eng2 \$253 VSS nfet L=0.6U W=0.365U AS=0.1606P AD=0.0584P PS=1.61U
+ PD=0.685U
* device instance $219 r0 *1 94.24,8.8175 nfet
M$219 \$288 q2 VSS VSS nfet L=0.6U W=0.365U AS=0.23405P AD=0.0584P PS=1.555U
+ PD=0.685U
* device instance $220 r0 *1 95.58,8.5925 nfet
M$220 sel_hi_n_2p \$253 VSS VSS nfet L=0.6U W=0.815U AS=0.23405P AD=0.3586P
+ PS=1.555U PD=2.51U
* device instance $221 r0 *1 101.72,8.8175 nfet
M$221 \$289 q7 \$254 VSS nfet L=0.6U W=0.365U AS=0.1606P AD=0.0584P PS=1.61U
+ PD=0.685U
* device instance $222 r0 *1 102.64,8.8175 nfet
M$222 \$289 eng7 VSS VSS nfet L=0.6U W=0.365U AS=0.23405P AD=0.0584P PS=1.555U
+ PD=0.685U
* device instance $223 r0 *1 103.98,8.5925 nfet
M$223 sel_hi_n_64p \$254 VSS VSS nfet L=0.6U W=0.815U AS=0.23405P AD=0.3586P
+ PS=1.555U PD=2.51U
* device instance $224 r0 *1 107.32,8.8175 nfet
M$224 \$291 q5 \$256 VSS nfet L=0.6U W=0.365U AS=0.1606P AD=0.0584P PS=1.61U
+ PD=0.685U
* device instance $225 r0 *1 108.24,8.8175 nfet
M$225 \$291 eng5 VSS VSS nfet L=0.6U W=0.365U AS=0.23405P AD=0.0584P PS=1.555U
+ PD=0.685U
* device instance $226 r0 *1 109.58,8.5925 nfet
M$226 sel_hi_n_16p \$256 VSS VSS nfet L=0.6U W=0.815U AS=0.23405P AD=0.3586P
+ PS=1.555U PD=2.51U
* device instance $227 r0 *1 111.8,8.6475 nfet
M$227 sel_lo_n_1p q1 VSS VSS nfet L=0.6U W=0.565U AS=0.2486P AD=0.1469P
+ PS=2.01U PD=1.085U
* device instance $228 r0 *1 112.92,8.6475 nfet
M$228 VSS \_044_ sel_lo_n_1p VSS nfet L=0.6U W=0.565U AS=0.1469P AD=0.2486P
+ PS=1.085U PD=2.01U
* device instance $229 r0 *1 115.16,8.5975 nfet
M$229 sel_hi_n_16n \_037_ VSS VSS nfet L=0.6U W=0.465U AS=0.2046P AD=0.1209P
+ PS=1.81U PD=0.985U
* device instance $230 r0 *1 116.28,8.5975 nfet
M$230 VSS q5 sel_hi_n_16n VSS nfet L=0.6U W=0.465U AS=0.1209P AD=0.1209P
+ PS=0.985U PD=0.985U
* device instance $231 r0 *1 117.4,8.5975 nfet
M$231 sel_hi_n_16n \_031_ VSS VSS nfet L=0.6U W=0.465U AS=0.1209P AD=0.2046P
+ PS=0.985U PD=1.81U
* device instance $232 r0 *1 123.02,8.435 nfet
M$232 VSS sel_in_n rel_n_16n VSS nfet L=0.6U W=0.51U AS=0.2569P AD=0.2244P
+ PS=1.56U PD=1.9U
* device instance $233 r0 *1 120.76,8.59 nfet
M$233 \$290 eng5 VSS VSS nfet L=0.6U W=0.82U AS=0.3608P AD=0.1312P PS=2.52U
+ PD=1.14U
* device instance $234 r0 *1 121.68,8.59 nfet
M$234 rel_n_16n mode \$290 VSS nfet L=0.6U W=0.82U AS=0.1312P AD=0.2569P
+ PS=1.14U PD=1.56U
* device instance $235 r0 *1 127.48,8.6475 nfet
M$235 sel_lo_n_16p \_037_ VSS VSS nfet L=0.6U W=0.565U AS=0.2486P AD=0.1469P
+ PS=2.01U PD=1.085U
* device instance $236 r0 *1 128.6,8.6475 nfet
M$236 VSS q5 sel_lo_n_16p VSS nfet L=0.6U W=0.565U AS=0.1469P AD=0.2486P
+ PS=1.085U PD=2.01U
* device instance $237 r0 *1 132.52,7.0825 nfet
M$237 sel_hi_n_64n \_039_ VSS VSS nfet L=0.6U W=0.465U AS=0.2046P AD=0.1209P
+ PS=1.81U PD=0.985U
* device instance $238 r0 *1 133.64,7.0825 nfet
M$238 VSS q7 sel_hi_n_64n VSS nfet L=0.6U W=0.465U AS=0.1209P AD=0.1209P
+ PS=0.985U PD=0.985U
* device instance $239 r0 *1 134.76,7.0825 nfet
M$239 sel_hi_n_64n \_031_ VSS VSS nfet L=0.6U W=0.465U AS=0.1209P AD=0.2046P
+ PS=0.985U PD=1.81U
* device instance $240 r0 *1 132.52,8.5975 nfet
M$240 sel_hi_n_128n \_040_ VSS VSS nfet L=0.6U W=0.465U AS=0.2046P AD=0.1209P
+ PS=1.81U PD=0.985U
* device instance $241 r0 *1 133.64,8.5975 nfet
M$241 VSS q8 sel_hi_n_128n VSS nfet L=0.6U W=0.465U AS=0.1209P AD=0.1209P
+ PS=0.985U PD=0.985U
* device instance $242 r0 *1 134.76,8.5975 nfet
M$242 sel_hi_n_128n \_031_ VSS VSS nfet L=0.6U W=0.465U AS=0.1209P AD=0.2046P
+ PS=0.985U PD=1.81U
* device instance $243 r0 *1 140.92,8.76 nfet
M$243 \_039_ eng7 VSS VSS nfet L=0.6U W=0.48U AS=0.2112P AD=0.2112P PS=1.84U
+ PD=1.84U
* device instance $244 r0 *1 145.42,8.435 nfet
M$244 VSS ph[13] \_006_ VSS nfet L=0.6U W=0.51U AS=0.2569P AD=0.2244P PS=1.56U
+ PD=1.9U
* device instance $245 r0 *1 143.16,8.59 nfet
M$245 \$285 \_051_ VSS VSS nfet L=0.6U W=0.82U AS=0.3608P AD=0.1312P PS=2.52U
+ PD=1.14U
* device instance $246 r0 *1 144.08,8.59 nfet
M$246 \_006_ \_039_ \$285 VSS nfet L=0.6U W=0.82U AS=0.1312P AD=0.2569P
+ PS=1.14U PD=1.56U
* device instance $247 r0 *1 153.855,8.485 nfet
M$247 \$264 start VSS VSS nfet L=0.6U W=0.36U AS=0.1584P AD=0.0936P PS=1.6U
+ PD=0.88U
* device instance $248 r0 *1 154.975,8.485 nfet
M$248 \$264 ph[15] VSS VSS nfet L=0.6U W=0.36U AS=0.2288P AD=0.0936P PS=1.58U
+ PD=0.88U
* device instance $249 r0 *1 156.335,8.59 nfet
M$249 \_009_[0] \$264 VSS VSS nfet L=0.6U W=0.82U AS=0.2288P AD=0.3608P
+ PS=1.58U PD=2.52U
* device instance $250 r0 *1 158.28,8.7975 nfet
M$250 VSS clknet_2_2__leaf_clk \$265 VSS nfet L=0.6U W=0.405U AS=0.1782P
+ AD=0.1053P PS=1.69U PD=0.925U
* device instance $251 r0 *1 159.4,8.7975 nfet
M$251 \$266 \$265 VSS VSS nfet L=0.6U W=0.405U AS=0.1053P AD=0.1782P PS=0.925U
+ PD=1.69U
* device instance $252 r0 *1 161.24,8.815 nfet
M$252 \$282 \$265 VSS VSS nfet L=0.6U W=0.36U AS=0.1584P AD=0.0432P PS=1.6U
+ PD=0.6U
* device instance $253 r0 *1 162.08,8.815 nfet
M$253 \$268 \_014_ \$282 VSS nfet L=0.6U W=0.36U AS=0.0432P AD=0.207P PS=0.6U
+ PD=1.51U
* device instance $254 r0 *1 163.7,8.815 nfet
M$254 \$280 \$266 \$268 VSS nfet L=0.6U W=0.36U AS=0.207P AD=0.0432P PS=1.51U
+ PD=0.6U
* device instance $255 r0 *1 164.54,8.815 nfet
M$255 \$280 \$269 VSS VSS nfet L=0.6U W=0.36U AS=0.2637P AD=0.0432P PS=1.825U
+ PD=0.6U
* device instance $256 r0 *1 166.1,8.815 nfet
M$256 \$269 \$268 VSS VSS nfet L=0.6U W=0.36U AS=0.2637P AD=0.0936P PS=1.825U
+ PD=0.88U
* device instance $257 r0 *1 167.22,8.815 nfet
M$257 \$270 \$266 \$269 VSS nfet L=0.6U W=0.36U AS=0.0936P AD=0.0936P PS=0.88U
+ PD=0.88U
* device instance $258 r0 *1 168.34,8.815 nfet
M$258 \$279 \$265 \$270 VSS nfet L=0.6U W=0.36U AS=0.0936P AD=0.0432P PS=0.88U
+ PD=0.6U
* device instance $259 r0 *1 169.18,8.815 nfet
M$259 \$279 \$271 VSS VSS nfet L=0.6U W=0.36U AS=0.142P AD=0.0432P PS=1.14U
+ PD=0.6U
* device instance $260 r0 *1 170.52,8.795 nfet
M$260 \$271 \$270 VSS VSS nfet L=0.6U W=0.4U AS=0.142P AD=0.176P PS=1.14U
+ PD=1.68U
* device instance $261 r0 *1 172.46,8.59 nfet
M$261 q6 \$271 VSS VSS nfet L=0.6U W=0.82U AS=0.3608P AD=0.3608P PS=2.52U
+ PD=2.52U
* device instance $262 r0 *1 175.64,8.6475 nfet
M$262 \_009_[2] start VSS VSS nfet L=0.6U W=0.565U AS=0.2486P AD=0.1469P
+ PS=2.01U PD=1.085U
* device instance $263 r0 *1 176.76,8.6475 nfet
M$263 VSS \_034_ \_009_[2] VSS nfet L=0.6U W=0.565U AS=0.1469P AD=0.2486P
+ PS=1.085U PD=2.01U
* device instance $264 r0 *1 179,8.6475 nfet
M$264 \_061_ ph[5] VSS VSS nfet L=0.6U W=0.565U AS=0.2486P AD=0.1469P PS=2.01U
+ PD=1.085U
* device instance $265 r0 *1 180.12,8.6475 nfet
M$265 VSS q8 \_061_ VSS nfet L=0.6U W=0.565U AS=0.1469P AD=0.2486P PS=1.085U
+ PD=2.01U
* device instance $266 r0 *1 182.36,8.6475 nfet
M$266 \_009_[3] start VSS VSS nfet L=0.6U W=0.565U AS=0.2486P AD=0.1469P
+ PS=2.01U PD=1.085U
* device instance $267 r0 *1 183.48,8.6475 nfet
M$267 VSS \_032_ \_009_[3] VSS nfet L=0.6U W=0.565U AS=0.1469P AD=0.2486P
+ PS=1.085U PD=2.01U
* device instance $268 r0 *1 185.72,8.485 nfet
M$268 \$275 ph[2] VSS VSS nfet L=0.6U W=0.36U AS=0.1584P AD=0.126P PS=1.6U
+ PD=1.06U
* device instance $269 r0 *1 187.02,8.485 nfet
M$269 VSS ph[0] \$275 VSS nfet L=0.6U W=0.36U AS=0.126P AD=0.0936P PS=1.06U
+ PD=0.88U
* device instance $270 r0 *1 188.14,8.485 nfet
M$270 \$275 ph[1] VSS VSS nfet L=0.6U W=0.36U AS=0.0936P AD=0.0936P PS=0.88U
+ PD=0.88U
* device instance $271 r0 *1 189.26,8.485 nfet
M$271 \$275 ph[3] VSS VSS nfet L=0.6U W=0.36U AS=0.218P AD=0.0936P PS=1.52U
+ PD=0.88U
* device instance $272 r0 *1 190.56,8.59 nfet
M$272 sel_in_n \$275 VSS VSS nfet L=0.6U W=0.82U AS=0.218P AD=0.3608P PS=1.52U
+ PD=2.52U
* device instance $273 r0 *1 2.04,14.7225 nfet
M$273 VSS clknet_2_0__leaf_clk \$305 VSS nfet L=0.6U W=0.405U AS=0.1782P
+ AD=0.1053P PS=1.69U PD=0.925U
* device instance $274 r0 *1 3.16,14.7225 nfet
M$274 \$306 \$305 VSS VSS nfet L=0.6U W=0.405U AS=0.1053P AD=0.1782P PS=0.925U
+ PD=1.69U
* device instance $275 r0 *1 5,14.705 nfet
M$275 \$399 \$305 VSS VSS nfet L=0.6U W=0.36U AS=0.1584P AD=0.0432P PS=1.6U
+ PD=0.6U
* device instance $276 r0 *1 5.84,14.705 nfet
M$276 \$399 \_009_[10] \$335 VSS nfet L=0.6U W=0.36U AS=0.207P AD=0.0432P
+ PS=1.51U PD=0.6U
* device instance $277 r0 *1 7.46,14.705 nfet
M$277 \$400 \$306 \$335 VSS nfet L=0.6U W=0.36U AS=0.207P AD=0.0432P PS=1.51U
+ PD=0.6U
* device instance $278 r0 *1 8.3,14.705 nfet
M$278 VSS \$336 \$400 VSS nfet L=0.6U W=0.36U AS=0.0432P AD=0.2637P PS=0.6U
+ PD=1.825U
* device instance $279 r0 *1 9.86,14.705 nfet
M$279 \$336 \$335 VSS VSS nfet L=0.6U W=0.36U AS=0.2637P AD=0.0936P PS=1.825U
+ PD=0.88U
* device instance $280 r0 *1 10.98,14.705 nfet
M$280 \$337 \$306 \$336 VSS nfet L=0.6U W=0.36U AS=0.0936P AD=0.0936P PS=0.88U
+ PD=0.88U
* device instance $281 r0 *1 12.1,14.705 nfet
M$281 \$401 \$305 \$337 VSS nfet L=0.6U W=0.36U AS=0.0936P AD=0.0432P PS=0.88U
+ PD=0.6U
* device instance $282 r0 *1 12.94,14.705 nfet
M$282 VSS \$338 \$401 VSS nfet L=0.6U W=0.36U AS=0.0432P AD=0.142P PS=0.6U
+ PD=1.14U
* device instance $283 r0 *1 14.28,14.725 nfet
M$283 \$338 \$337 VSS VSS nfet L=0.6U W=0.4U AS=0.142P AD=0.176P PS=1.14U
+ PD=1.68U
* device instance $284 r0 *1 16.22,14.93 nfet
M$284 ph[10] \$338 VSS VSS nfet L=0.6U W=0.82U AS=0.3608P AD=0.3608P PS=2.52U
+ PD=2.52U
* device instance $285 r0 *1 19.4,14.76 nfet
M$285 \_046_ ph[11] VSS VSS nfet L=0.6U W=0.48U AS=0.2112P AD=0.2112P PS=1.84U
+ PD=1.84U
* device instance $286 r0 *1 23.5,16.43 nfet
M$286 q2 \$416 VSS VSS nfet L=0.6U W=0.82U AS=0.3608P AD=0.3608P PS=2.52U
+ PD=2.52U
* device instance $287 r0 *1 33.4,14.93 nfet
M$287 \$402 \_048_ VSS VSS nfet L=0.6U W=0.82U AS=0.3608P AD=0.1312P PS=2.52U
+ PD=1.14U
* device instance $288 r0 *1 34.32,14.93 nfet
M$288 \_003_ \_036_ \$402 VSS nfet L=0.6U W=0.82U AS=0.1312P AD=0.2569P
+ PS=1.14U PD=1.56U
* device instance $289 r0 *1 35.66,15.085 nfet
M$289 VSS ph[13] \_003_ VSS nfet L=0.6U W=0.51U AS=0.2569P AD=0.2244P PS=1.56U
+ PD=1.9U
* device instance $290 r0 *1 37.88,14.93 nfet
M$290 \$403 \_046_ VSS VSS nfet L=0.6U W=0.82U AS=0.3608P AD=0.1312P PS=2.52U
+ PD=1.14U
* device instance $291 r0 *1 38.8,14.93 nfet
M$291 \_001_ \_042_ \$403 VSS nfet L=0.6U W=0.82U AS=0.1312P AD=0.2569P
+ PS=1.14U PD=1.56U
* device instance $292 r0 *1 40.14,15.085 nfet
M$292 VSS ph[13] \_001_ VSS nfet L=0.6U W=0.51U AS=0.2569P AD=0.2244P PS=1.56U
+ PD=1.9U
* device instance $293 r0 *1 42.36,14.93 nfet
M$293 \$343 clknet_0_clk VSS VSS nfet L=0.6U W=0.82U AS=0.3608P AD=0.2132P
+ PS=2.52U PD=1.34U
* device instance $294 r0 *1 43.48,14.93 nfet
M$294 VSS clknet_0_clk \$343 VSS nfet L=0.6U W=0.82U AS=0.2132P AD=0.2132P
+ PS=1.34U PD=1.34U
* device instance $295 r0 *1 44.6,14.93 nfet
M$295 clknet_2_0__leaf_clk \$343 VSS VSS nfet L=0.6U W=0.82U AS=0.2132P
+ AD=0.2132P PS=1.34U PD=1.34U
* device instance $296 r0 *1 45.72,14.93 nfet
M$296 VSS \$343 clknet_2_0__leaf_clk VSS nfet L=0.6U W=0.82U AS=0.2132P
+ AD=0.2132P PS=1.34U PD=1.34U
* device instance $297 r0 *1 46.84,14.93 nfet
M$297 clknet_2_0__leaf_clk \$343 VSS VSS nfet L=0.6U W=0.82U AS=0.2132P
+ AD=0.2132P PS=1.34U PD=1.34U
* device instance $298 r0 *1 47.96,14.93 nfet
M$298 VSS \$343 clknet_2_0__leaf_clk VSS nfet L=0.6U W=0.82U AS=0.2132P
+ AD=0.3608P PS=1.34U PD=2.52U
* device instance $299 r0 *1 49.26,16.43 nfet
M$299 eng1 \$420 VSS VSS nfet L=0.6U W=0.82U AS=0.3608P AD=0.3608P PS=2.52U
+ PD=2.52U
* device instance $300 r0 *1 50.76,14.76 nfet
M$300 \_044_ eng1 VSS VSS nfet L=0.6U W=0.48U AS=0.2112P AD=0.2112P PS=1.84U
+ PD=1.84U
* device instance $301 r0 *1 54.68,14.8725 nfet
M$301 sel_lo_n_8p \_036_ VSS VSS nfet L=0.6U W=0.565U AS=0.2486P AD=0.1469P
+ PS=2.01U PD=1.085U
* device instance $302 r0 *1 55.8,14.8725 nfet
M$302 VSS q4 sel_lo_n_8p VSS nfet L=0.6U W=0.565U AS=0.1469P AD=0.2486P
+ PS=1.085U PD=2.01U
* device instance $303 r0 *1 57.66,16.38 nfet
M$303 \$470 q0 VSS VSS nfet L=0.6U W=0.36U AS=0.218P AD=0.0432P PS=1.52U PD=0.6U
* device instance $304 r0 *1 58.5,16.38 nfet
M$304 \$422 ph[14] \$470 VSS nfet L=0.6U W=0.36U AS=0.0432P AD=0.0936P PS=0.6U
+ PD=0.88U
* device instance $305 r0 *1 59.62,16.38 nfet
M$305 \$471 \$389 \$422 VSS nfet L=0.6U W=0.36U AS=0.0936P AD=0.0432P PS=0.88U
+ PD=0.6U
* device instance $306 r0 *1 60.46,16.38 nfet
M$306 VSS c0_r \$471 VSS nfet L=0.6U W=0.36U AS=0.0432P AD=0.0936P PS=0.6U
+ PD=0.88U
* device instance $307 r0 *1 61.58,16.38 nfet
M$307 \$389 ph[14] VSS VSS nfet L=0.6U W=0.36U AS=0.0936P AD=0.1584P PS=0.88U
+ PD=1.6U
* device instance $308 r0 *1 56.36,16.43 nfet
M$308 VSS \$422 \_013_ VSS nfet L=0.6U W=0.82U AS=0.3608P AD=0.218P PS=2.52U
+ PD=1.52U
* device instance $309 r0 *1 58.04,14.9225 nfet
M$309 sel_hi_n_4n q3 VSS VSS nfet L=0.6U W=0.465U AS=0.2046P AD=0.1209P
+ PS=1.81U PD=0.985U
* device instance $310 r0 *1 59.16,14.9225 nfet
M$310 VSS \_031_ sel_hi_n_4n VSS nfet L=0.6U W=0.465U AS=0.1209P AD=0.1209P
+ PS=0.985U PD=0.985U
* device instance $311 r0 *1 60.28,14.9225 nfet
M$311 sel_hi_n_4n \_030_ VSS VSS nfet L=0.6U W=0.465U AS=0.1209P AD=0.2046P
+ PS=0.985U PD=1.81U
* device instance $312 r0 *1 62.52,14.7025 nfet
M$312 \$407 mode \$344 VSS nfet L=0.6U W=0.365U AS=0.1606P AD=0.0584P PS=1.61U
+ PD=0.685U
* device instance $313 r0 *1 63.44,14.7025 nfet
M$313 VSS sel_hi_n_256p \$407 VSS nfet L=0.6U W=0.365U AS=0.0584P AD=0.23405P
+ PS=0.685U PD=1.555U
* device instance $314 r0 *1 64.78,14.9275 nfet
M$314 sel_lo_n_256n \$344 VSS VSS nfet L=0.6U W=0.815U AS=0.23405P AD=0.3586P
+ PS=1.555U PD=2.51U
* device instance $315 r0 *1 73.72,14.7025 nfet
M$315 \$408 q8 \$346 VSS nfet L=0.6U W=0.365U AS=0.1606P AD=0.0584P PS=1.61U
+ PD=0.685U
* device instance $316 r0 *1 74.64,14.7025 nfet
M$316 VSS eng8 \$408 VSS nfet L=0.6U W=0.365U AS=0.0584P AD=0.23405P PS=0.685U
+ PD=1.555U
* device instance $317 r0 *1 75.98,14.9275 nfet
M$317 sel_hi_n_128p \$346 VSS VSS nfet L=0.6U W=0.815U AS=0.23405P AD=0.3586P
+ PS=1.555U PD=2.51U
* device instance $318 r0 *1 82.86,16.38 nfet
M$318 \$476 q9 VSS VSS nfet L=0.6U W=0.36U AS=0.218P AD=0.0432P PS=1.52U PD=0.6U
* device instance $319 r0 *1 83.7,16.38 nfet
M$319 \$426 ph[14] \$476 VSS nfet L=0.6U W=0.36U AS=0.0432P AD=0.0936P PS=0.6U
+ PD=0.88U
* device instance $320 r0 *1 84.82,16.38 nfet
M$320 \$477 \$392 \$426 VSS nfet L=0.6U W=0.36U AS=0.0936P AD=0.0432P PS=0.88U
+ PD=0.6U
* device instance $321 r0 *1 85.66,16.38 nfet
M$321 VSS c9_r \$477 VSS nfet L=0.6U W=0.36U AS=0.0432P AD=0.0936P PS=0.6U
+ PD=0.88U
* device instance $322 r0 *1 86.78,16.38 nfet
M$322 \$392 ph[14] VSS VSS nfet L=0.6U W=0.36U AS=0.0936P AD=0.1584P PS=0.88U
+ PD=1.6U
* device instance $323 r0 *1 81.56,16.43 nfet
M$323 VSS \$426 \_011_ VSS nfet L=0.6U W=0.82U AS=0.3608P AD=0.218P PS=2.52U
+ PD=1.52U
* device instance $324 r0 *1 82.68,14.7025 nfet
M$324 \$409 q9 \$348 VSS nfet L=0.6U W=0.365U AS=0.1606P AD=0.0584P PS=1.61U
+ PD=0.685U
* device instance $325 r0 *1 83.6,14.7025 nfet
M$325 VSS eng9 \$409 VSS nfet L=0.6U W=0.365U AS=0.0584P AD=0.23405P PS=0.685U
+ PD=1.555U
* device instance $326 r0 *1 84.94,14.9275 nfet
M$326 sel_hi_n_256p \$348 VSS VSS nfet L=0.6U W=0.815U AS=0.23405P AD=0.3586P
+ PS=1.555U PD=2.51U
* device instance $327 r0 *1 87.72,14.7225 nfet
M$327 VSS clknet_2_0__leaf_clk \$309 VSS nfet L=0.6U W=0.405U AS=0.1782P
+ AD=0.1053P PS=1.69U PD=0.925U
* device instance $328 r0 *1 88.84,14.7225 nfet
M$328 \$310 \$309 VSS VSS nfet L=0.6U W=0.405U AS=0.1053P AD=0.1782P PS=0.925U
+ PD=1.69U
* device instance $329 r0 *1 90.14,16.38 nfet
M$329 \$478 q2 VSS VSS nfet L=0.6U W=0.36U AS=0.218P AD=0.0432P PS=1.52U PD=0.6U
* device instance $330 r0 *1 90.98,16.38 nfet
M$330 \$428 ph[14] \$478 VSS nfet L=0.6U W=0.36U AS=0.0432P AD=0.0936P PS=0.6U
+ PD=0.88U
* device instance $331 r0 *1 92.1,16.38 nfet
M$331 \$480 \$393 \$428 VSS nfet L=0.6U W=0.36U AS=0.0936P AD=0.0432P PS=0.88U
+ PD=0.6U
* device instance $332 r0 *1 92.94,16.38 nfet
M$332 VSS c2_r \$480 VSS nfet L=0.6U W=0.36U AS=0.0432P AD=0.0936P PS=0.6U
+ PD=0.88U
* device instance $333 r0 *1 94.06,16.38 nfet
M$333 \$393 ph[14] VSS VSS nfet L=0.6U W=0.36U AS=0.0936P AD=0.1584P PS=0.88U
+ PD=1.6U
* device instance $334 r0 *1 88.84,16.43 nfet
M$334 VSS \$428 \_016_ VSS nfet L=0.6U W=0.82U AS=0.3608P AD=0.218P PS=2.52U
+ PD=1.52U
* device instance $335 r0 *1 90.68,14.705 nfet
M$335 \$410 \$309 VSS VSS nfet L=0.6U W=0.36U AS=0.1584P AD=0.0432P PS=1.6U
+ PD=0.6U
* device instance $336 r0 *1 91.52,14.705 nfet
M$336 \$410 \_024_ \$349 VSS nfet L=0.6U W=0.36U AS=0.207P AD=0.0432P PS=1.51U
+ PD=0.6U
* device instance $337 r0 *1 93.14,14.705 nfet
M$337 \$411 \$310 \$349 VSS nfet L=0.6U W=0.36U AS=0.207P AD=0.0432P PS=1.51U
+ PD=0.6U
* device instance $338 r0 *1 93.98,14.705 nfet
M$338 VSS \$350 \$411 VSS nfet L=0.6U W=0.36U AS=0.0432P AD=0.2637P PS=0.6U
+ PD=1.825U
* device instance $339 r0 *1 95.54,14.705 nfet
M$339 \$350 \$349 VSS VSS nfet L=0.6U W=0.36U AS=0.2637P AD=0.0936P PS=1.825U
+ PD=0.88U
* device instance $340 r0 *1 96.66,14.705 nfet
M$340 \$351 \$310 \$350 VSS nfet L=0.6U W=0.36U AS=0.0936P AD=0.0936P PS=0.88U
+ PD=0.88U
* device instance $341 r0 *1 97.78,14.705 nfet
M$341 \$412 \$309 \$351 VSS nfet L=0.6U W=0.36U AS=0.0936P AD=0.0432P PS=0.88U
+ PD=0.6U
* device instance $342 r0 *1 98.62,14.705 nfet
M$342 VSS \$352 \$412 VSS nfet L=0.6U W=0.36U AS=0.0432P AD=0.142P PS=0.6U
+ PD=1.14U
* device instance $343 r0 *1 99.96,14.725 nfet
M$343 \$352 \$351 VSS VSS nfet L=0.6U W=0.4U AS=0.142P AD=0.176P PS=1.14U
+ PD=1.68U
* device instance $344 r0 *1 101.9,14.93 nfet
M$344 c5_r \$352 VSS VSS nfet L=0.6U W=0.82U AS=0.3608P AD=0.3608P PS=2.52U
+ PD=2.52U
* device instance $345 r0 *1 112.92,14.9225 nfet
M$345 sel_hi_n_256n \_041_ VSS VSS nfet L=0.6U W=0.465U AS=0.2046P AD=0.1209P
+ PS=1.81U PD=0.985U
* device instance $346 r0 *1 114.04,14.9225 nfet
M$346 VSS q9 sel_hi_n_256n VSS nfet L=0.6U W=0.465U AS=0.1209P AD=0.1209P
+ PS=0.985U PD=0.985U
* device instance $347 r0 *1 115.16,14.9225 nfet
M$347 sel_hi_n_256n \_031_ VSS VSS nfet L=0.6U W=0.465U AS=0.1209P AD=0.2046P
+ PS=0.985U PD=1.81U
* device instance $348 r0 *1 117.4,14.8725 nfet
M$348 sel_lo_n_256p \_041_ VSS VSS nfet L=0.6U W=0.565U AS=0.2486P AD=0.1469P
+ PS=2.01U PD=1.085U
* device instance $349 r0 *1 118.52,14.8725 nfet
M$349 VSS q9 sel_lo_n_256p VSS nfet L=0.6U W=0.565U AS=0.1469P AD=0.2486P
+ PS=1.085U PD=2.01U
* device instance $350 r0 *1 118.14,16.43 nfet
M$350 c1_r \$431 VSS VSS nfet L=0.6U W=0.82U AS=0.3608P AD=0.3608P PS=2.52U
+ PD=2.52U
* device instance $351 r0 *1 131.4,14.8725 nfet
M$351 sel_lo_n_64p \_039_ VSS VSS nfet L=0.6U W=0.565U AS=0.2486P AD=0.1469P
+ PS=2.01U PD=1.085U
* device instance $352 r0 *1 132.52,14.8725 nfet
M$352 VSS q7 sel_lo_n_64p VSS nfet L=0.6U W=0.565U AS=0.1469P AD=0.2486P
+ PS=1.085U PD=2.01U
* device instance $353 r0 *1 134.76,14.8725 nfet
M$353 sel_lo_n_32p \_038_ VSS VSS nfet L=0.6U W=0.565U AS=0.2486P AD=0.1469P
+ PS=2.01U PD=1.085U
* device instance $354 r0 *1 135.88,14.8725 nfet
M$354 VSS q6 sel_lo_n_32p VSS nfet L=0.6U W=0.565U AS=0.1469P AD=0.2486P
+ PS=1.085U PD=2.01U
* device instance $355 r0 *1 142.04,14.93 nfet
M$355 \$413 \_050_ VSS VSS nfet L=0.6U W=0.82U AS=0.3608P AD=0.1312P PS=2.52U
+ PD=1.14U
* device instance $356 r0 *1 142.96,14.93 nfet
M$356 \_005_ \_038_ \$413 VSS nfet L=0.6U W=0.82U AS=0.1312P AD=0.2569P
+ PS=1.14U PD=1.56U
* device instance $357 r0 *1 144.3,15.085 nfet
M$357 VSS ph[13] \_005_ VSS nfet L=0.6U W=0.51U AS=0.2569P AD=0.2244P PS=1.56U
+ PD=1.9U
* device instance $358 r0 *1 142.22,16.43 nfet
M$358 eng5 \$434 VSS VSS nfet L=0.6U W=0.82U AS=0.3608P AD=0.3608P PS=2.52U
+ PD=2.52U
* device instance $359 r0 *1 147.64,14.8725 nfet
M$359 \_009_[6] start VSS VSS nfet L=0.6U W=0.565U AS=0.2486P AD=0.1469P
+ PS=2.01U PD=1.085U
* device instance $360 r0 *1 148.76,14.8725 nfet
M$360 VSS \_052_ \_009_[6] VSS nfet L=0.6U W=0.565U AS=0.1469P AD=0.2486P
+ PS=1.085U PD=2.01U
* device instance $361 r0 *1 152.68,14.8725 nfet
M$361 \_009_[7] start VSS VSS nfet L=0.6U W=0.565U AS=0.2486P AD=0.1469P
+ PS=2.01U PD=1.085U
* device instance $362 r0 *1 153.8,14.8725 nfet
M$362 VSS \_051_ \_009_[7] VSS nfet L=0.6U W=0.565U AS=0.1469P AD=0.2486P
+ PS=1.085U PD=2.01U
* device instance $363 r0 *1 158.28,14.76 nfet
M$363 \_050_ ph[7] VSS VSS nfet L=0.6U W=0.48U AS=0.2112P AD=0.2112P PS=1.84U
+ PD=1.84U
* device instance $364 r0 *1 159.02,16.43 nfet
M$364 ph[6] \$438 VSS VSS nfet L=0.6U W=0.82U AS=0.3608P AD=0.3608P PS=2.52U
+ PD=2.52U
* device instance $365 r0 *1 164.46,16.275 nfet
M$365 VSS \_056_ \_014_ VSS nfet L=0.6U W=0.51U AS=0.2569P AD=0.2244P PS=1.56U
+ PD=1.9U
* device instance $366 r0 *1 162.2,16.43 nfet
M$366 \$472 cmp VSS VSS nfet L=0.6U W=0.82U AS=0.3608P AD=0.1312P PS=2.52U
+ PD=1.14U
* device instance $367 r0 *1 163.12,16.43 nfet
M$367 \_014_ ph[7] \$472 VSS nfet L=0.6U W=0.82U AS=0.1312P AD=0.2569P PS=1.14U
+ PD=1.56U
* device instance $368 r0 *1 163.88,14.8725 nfet
M$368 \_056_ ph[7] VSS VSS nfet L=0.6U W=0.565U AS=0.2486P AD=0.1469P PS=2.01U
+ PD=1.085U
* device instance $369 r0 *1 165,14.8725 nfet
M$369 VSS q6 \_056_ VSS nfet L=0.6U W=0.565U AS=0.1469P AD=0.2486P PS=1.085U
+ PD=2.01U
* device instance $370 r0 *1 176.2,14.7225 nfet
M$370 VSS clknet_2_2__leaf_clk \$312 VSS nfet L=0.6U W=0.405U AS=0.1782P
+ AD=0.1053P PS=1.69U PD=0.925U
* device instance $371 r0 *1 177.32,14.7225 nfet
M$371 \$313 \$312 VSS VSS nfet L=0.6U W=0.405U AS=0.1053P AD=0.1782P PS=0.925U
+ PD=1.69U
* device instance $372 r0 *1 179.16,14.705 nfet
M$372 \$406 \$312 VSS VSS nfet L=0.6U W=0.36U AS=0.1584P AD=0.0432P PS=1.6U
+ PD=0.6U
* device instance $373 r0 *1 180,14.705 nfet
M$373 \$406 \_026_ \$358 VSS nfet L=0.6U W=0.36U AS=0.207P AD=0.0432P PS=1.51U
+ PD=0.6U
* device instance $374 r0 *1 181.62,14.705 nfet
M$374 \$405 \$313 \$358 VSS nfet L=0.6U W=0.36U AS=0.207P AD=0.0432P PS=1.51U
+ PD=0.6U
* device instance $375 r0 *1 182.46,14.705 nfet
M$375 VSS \$359 \$405 VSS nfet L=0.6U W=0.36U AS=0.0432P AD=0.2637P PS=0.6U
+ PD=1.825U
* device instance $376 r0 *1 184.02,14.705 nfet
M$376 \$359 \$358 VSS VSS nfet L=0.6U W=0.36U AS=0.2637P AD=0.0936P PS=1.825U
+ PD=0.88U
* device instance $377 r0 *1 185.14,14.705 nfet
M$377 \$360 \$313 \$359 VSS nfet L=0.6U W=0.36U AS=0.0936P AD=0.0936P PS=0.88U
+ PD=0.88U
* device instance $378 r0 *1 186.26,14.705 nfet
M$378 \$404 \$312 \$360 VSS nfet L=0.6U W=0.36U AS=0.0936P AD=0.0432P PS=0.88U
+ PD=0.6U
* device instance $379 r0 *1 187.1,14.705 nfet
M$379 VSS \$361 \$404 VSS nfet L=0.6U W=0.36U AS=0.0432P AD=0.142P PS=0.6U
+ PD=1.14U
* device instance $380 r0 *1 188.44,14.725 nfet
M$380 \$361 \$360 VSS VSS nfet L=0.6U W=0.4U AS=0.142P AD=0.176P PS=1.14U
+ PD=1.68U
* device instance $381 r0 *1 188.14,16.43 nfet
M$381 q8 \$441 VSS VSS nfet L=0.6U W=0.82U AS=0.3608P AD=0.3608P PS=2.52U
+ PD=2.52U
* device instance $382 r0 *1 190.38,14.93 nfet
M$382 q9 \$361 VSS VSS nfet L=0.6U W=0.82U AS=0.3608P AD=0.3608P PS=2.52U
+ PD=2.52U
* device instance $383 r0 *1 72.6,16.4875 nfet
M$383 sel_lo_n_128p \_040_ VSS VSS nfet L=0.6U W=0.565U AS=0.2486P AD=0.1469P
+ PS=2.01U PD=1.085U
* device instance $384 r0 *1 73.72,16.4875 nfet
M$384 VSS q8 sel_lo_n_128p VSS nfet L=0.6U W=0.565U AS=0.1469P AD=0.2486P
+ PS=1.085U PD=2.01U
* device instance $385 r0 *1 190.2,16.4875 nfet
M$385 \_009_[4] start VSS VSS nfet L=0.6U W=0.565U AS=0.2486P AD=0.1469P
+ PS=2.01U PD=1.085U
* device instance $386 r0 *1 191.32,16.4875 nfet
M$386 VSS \_035_ \_009_[4] VSS nfet L=0.6U W=0.565U AS=0.1469P AD=0.2486P
+ PS=1.085U PD=2.01U
* device instance $387 r0 *1 9.32,16.6375 nfet
M$387 VSS clknet_2_0__leaf_clk \$444 VSS nfet L=0.6U W=0.405U AS=0.1782P
+ AD=0.1053P PS=1.69U PD=0.925U
* device instance $388 r0 *1 10.44,16.6375 nfet
M$388 \$387 \$444 VSS VSS nfet L=0.6U W=0.405U AS=0.1053P AD=0.1782P PS=0.925U
+ PD=1.69U
* device instance $389 r0 *1 12.28,16.655 nfet
M$389 \$461 \$444 VSS VSS nfet L=0.6U W=0.36U AS=0.1584P AD=0.0432P PS=1.6U
+ PD=0.6U
* device instance $390 r0 *1 13.12,16.655 nfet
M$390 \$446 \_017_ \$461 VSS nfet L=0.6U W=0.36U AS=0.0432P AD=0.207P PS=0.6U
+ PD=1.51U
* device instance $391 r0 *1 14.74,16.655 nfet
M$391 \$462 \$387 \$446 VSS nfet L=0.6U W=0.36U AS=0.207P AD=0.0432P PS=1.51U
+ PD=0.6U
* device instance $392 r0 *1 15.58,16.655 nfet
M$392 \$462 \$414 VSS VSS nfet L=0.6U W=0.36U AS=0.2637P AD=0.0432P PS=1.825U
+ PD=0.6U
* device instance $393 r0 *1 17.14,16.655 nfet
M$393 \$414 \$446 VSS VSS nfet L=0.6U W=0.36U AS=0.2637P AD=0.0936P PS=1.825U
+ PD=0.88U
* device instance $394 r0 *1 18.26,16.655 nfet
M$394 \$415 \$387 \$414 VSS nfet L=0.6U W=0.36U AS=0.0936P AD=0.0936P PS=0.88U
+ PD=0.88U
* device instance $395 r0 *1 19.38,16.655 nfet
M$395 \$463 \$444 \$415 VSS nfet L=0.6U W=0.36U AS=0.0936P AD=0.0432P PS=0.88U
+ PD=0.6U
* device instance $396 r0 *1 20.22,16.655 nfet
M$396 \$463 \$416 VSS VSS nfet L=0.6U W=0.36U AS=0.142P AD=0.0432P PS=1.14U
+ PD=0.6U
* device instance $397 r0 *1 21.56,16.635 nfet
M$397 \$416 \$415 VSS VSS nfet L=0.6U W=0.4U AS=0.142P AD=0.176P PS=1.14U
+ PD=1.68U
* device instance $398 r0 *1 31.72,16.6 nfet
M$398 \_043_ ph[12] VSS VSS nfet L=0.6U W=0.48U AS=0.2112P AD=0.2112P PS=1.84U
+ PD=1.84U
* device instance $399 r0 *1 35.08,16.6375 nfet
M$399 VSS clknet_2_0__leaf_clk \$447 VSS nfet L=0.6U W=0.405U AS=0.1782P
+ AD=0.1053P PS=1.69U PD=0.925U
* device instance $400 r0 *1 36.2,16.6375 nfet
M$400 \$388 \$447 VSS VSS nfet L=0.6U W=0.405U AS=0.1053P AD=0.1782P PS=0.925U
+ PD=1.69U
* device instance $401 r0 *1 38.04,16.655 nfet
M$401 \$466 \$447 VSS VSS nfet L=0.6U W=0.36U AS=0.1584P AD=0.0432P PS=1.6U
+ PD=0.6U
* device instance $402 r0 *1 38.88,16.655 nfet
M$402 \$448 \_000_ \$466 VSS nfet L=0.6U W=0.36U AS=0.0432P AD=0.207P PS=0.6U
+ PD=1.51U
* device instance $403 r0 *1 40.5,16.655 nfet
M$403 \$468 \$388 \$448 VSS nfet L=0.6U W=0.36U AS=0.207P AD=0.0432P PS=1.51U
+ PD=0.6U
* device instance $404 r0 *1 41.34,16.655 nfet
M$404 \$468 \$418 VSS VSS nfet L=0.6U W=0.36U AS=0.2637P AD=0.0432P PS=1.825U
+ PD=0.6U
* device instance $405 r0 *1 42.9,16.655 nfet
M$405 \$418 \$448 VSS VSS nfet L=0.6U W=0.36U AS=0.2637P AD=0.0936P PS=1.825U
+ PD=0.88U
* device instance $406 r0 *1 44.02,16.655 nfet
M$406 \$419 \$388 \$418 VSS nfet L=0.6U W=0.36U AS=0.0936P AD=0.0936P PS=0.88U
+ PD=0.88U
* device instance $407 r0 *1 45.14,16.655 nfet
M$407 \$469 \$447 \$419 VSS nfet L=0.6U W=0.36U AS=0.0936P AD=0.0432P PS=0.88U
+ PD=0.6U
* device instance $408 r0 *1 45.98,16.655 nfet
M$408 \$469 \$420 VSS VSS nfet L=0.6U W=0.36U AS=0.142P AD=0.0432P PS=1.14U
+ PD=0.6U
* device instance $409 r0 *1 47.32,16.635 nfet
M$409 \$420 \$419 VSS VSS nfet L=0.6U W=0.4U AS=0.142P AD=0.176P PS=1.14U
+ PD=1.68U
* device instance $410 r0 *1 63.64,16.6575 nfet
M$410 \$473 mode \$423 VSS nfet L=0.6U W=0.365U AS=0.1606P AD=0.0584P PS=1.61U
+ PD=0.685U
* device instance $411 r0 *1 64.56,16.6575 nfet
M$411 \$473 sel_hi_n_16p VSS VSS nfet L=0.6U W=0.365U AS=0.23405P AD=0.0584P
+ PS=1.555U PD=0.685U
* device instance $412 r0 *1 65.9,16.4325 nfet
M$412 sel_lo_n_16n \$423 VSS VSS nfet L=0.6U W=0.815U AS=0.23405P AD=0.3586P
+ PS=1.555U PD=2.51U
* device instance $413 r0 *1 79.32,16.6 nfet
M$413 \_040_ eng8 VSS VSS nfet L=0.6U W=0.48U AS=0.2112P AD=0.2112P PS=1.84U
+ PD=1.84U
* device instance $414 r0 *1 103.96,16.6375 nfet
M$414 VSS clknet_2_2__leaf_clk \$450 VSS nfet L=0.6U W=0.405U AS=0.1782P
+ AD=0.1053P PS=1.69U PD=0.925U
* device instance $415 r0 *1 105.08,16.6375 nfet
M$415 \$394 \$450 VSS VSS nfet L=0.6U W=0.405U AS=0.1053P AD=0.1782P PS=0.925U
+ PD=1.69U
* device instance $416 r0 *1 106.92,16.655 nfet
M$416 \$481 \$450 VSS VSS nfet L=0.6U W=0.36U AS=0.1584P AD=0.0432P PS=1.6U
+ PD=0.6U
* device instance $417 r0 *1 107.76,16.655 nfet
M$417 \$452 \_015_ \$481 VSS nfet L=0.6U W=0.36U AS=0.0432P AD=0.207P PS=0.6U
+ PD=1.51U
* device instance $418 r0 *1 109.38,16.655 nfet
M$418 \$483 \$394 \$452 VSS nfet L=0.6U W=0.36U AS=0.207P AD=0.0432P PS=1.51U
+ PD=0.6U
* device instance $419 r0 *1 110.22,16.655 nfet
M$419 \$483 \$429 VSS VSS nfet L=0.6U W=0.36U AS=0.2637P AD=0.0432P PS=1.825U
+ PD=0.6U
* device instance $420 r0 *1 111.78,16.655 nfet
M$420 \$429 \$452 VSS VSS nfet L=0.6U W=0.36U AS=0.2637P AD=0.0936P PS=1.825U
+ PD=0.88U
* device instance $421 r0 *1 112.9,16.655 nfet
M$421 \$430 \$394 \$429 VSS nfet L=0.6U W=0.36U AS=0.0936P AD=0.0936P PS=0.88U
+ PD=0.88U
* device instance $422 r0 *1 114.02,16.655 nfet
M$422 \$485 \$450 \$430 VSS nfet L=0.6U W=0.36U AS=0.0936P AD=0.0432P PS=0.88U
+ PD=0.6U
* device instance $423 r0 *1 114.86,16.655 nfet
M$423 \$485 \$431 VSS VSS nfet L=0.6U W=0.36U AS=0.142P AD=0.0432P PS=1.14U
+ PD=0.6U
* device instance $424 r0 *1 116.2,16.635 nfet
M$424 \$431 \$430 VSS VSS nfet L=0.6U W=0.4U AS=0.142P AD=0.176P PS=1.14U
+ PD=1.68U
* device instance $425 r0 *1 120.2,16.6 nfet
M$425 \_037_ eng5 VSS VSS nfet L=0.6U W=0.48U AS=0.2112P AD=0.2112P PS=1.84U
+ PD=1.84U
* device instance $426 r0 *1 128.04,16.6375 nfet
M$426 VSS clknet_2_2__leaf_clk \$453 VSS nfet L=0.6U W=0.405U AS=0.1782P
+ AD=0.1053P PS=1.69U PD=0.925U
* device instance $427 r0 *1 129.16,16.6375 nfet
M$427 \$395 \$453 VSS VSS nfet L=0.6U W=0.405U AS=0.1053P AD=0.1782P PS=0.925U
+ PD=1.69U
* device instance $428 r0 *1 131,16.655 nfet
M$428 \$486 \$453 VSS VSS nfet L=0.6U W=0.36U AS=0.1584P AD=0.0432P PS=1.6U
+ PD=0.6U
* device instance $429 r0 *1 131.84,16.655 nfet
M$429 \$455 \_004_ \$486 VSS nfet L=0.6U W=0.36U AS=0.0432P AD=0.207P PS=0.6U
+ PD=1.51U
* device instance $430 r0 *1 133.46,16.655 nfet
M$430 \$484 \$395 \$455 VSS nfet L=0.6U W=0.36U AS=0.207P AD=0.0432P PS=1.51U
+ PD=0.6U
* device instance $431 r0 *1 134.3,16.655 nfet
M$431 \$484 \$432 VSS VSS nfet L=0.6U W=0.36U AS=0.2637P AD=0.0432P PS=1.825U
+ PD=0.6U
* device instance $432 r0 *1 135.86,16.655 nfet
M$432 \$432 \$455 VSS VSS nfet L=0.6U W=0.36U AS=0.2637P AD=0.0936P PS=1.825U
+ PD=0.88U
* device instance $433 r0 *1 136.98,16.655 nfet
M$433 \$433 \$395 \$432 VSS nfet L=0.6U W=0.36U AS=0.0936P AD=0.0936P PS=0.88U
+ PD=0.88U
* device instance $434 r0 *1 138.1,16.655 nfet
M$434 \$482 \$453 \$433 VSS nfet L=0.6U W=0.36U AS=0.0936P AD=0.0432P PS=0.88U
+ PD=0.6U
* device instance $435 r0 *1 138.94,16.655 nfet
M$435 \$482 \$434 VSS VSS nfet L=0.6U W=0.36U AS=0.142P AD=0.0432P PS=1.14U
+ PD=0.6U
* device instance $436 r0 *1 140.28,16.635 nfet
M$436 \$434 \$433 VSS VSS nfet L=0.6U W=0.4U AS=0.142P AD=0.176P PS=1.14U
+ PD=1.68U
* device instance $437 r0 *1 144.84,16.6375 nfet
M$437 VSS clknet_2_3__leaf_clk \$456 VSS nfet L=0.6U W=0.405U AS=0.1782P
+ AD=0.1053P PS=1.69U PD=0.925U
* device instance $438 r0 *1 145.96,16.6375 nfet
M$438 \$396 \$456 VSS VSS nfet L=0.6U W=0.405U AS=0.1053P AD=0.1782P PS=0.925U
+ PD=1.69U
* device instance $439 r0 *1 147.8,16.655 nfet
M$439 \$479 \$456 VSS VSS nfet L=0.6U W=0.36U AS=0.1584P AD=0.0432P PS=1.6U
+ PD=0.6U
* device instance $440 r0 *1 148.64,16.655 nfet
M$440 \$457 \_009_[6] \$479 VSS nfet L=0.6U W=0.36U AS=0.0432P AD=0.207P
+ PS=0.6U PD=1.51U
* device instance $441 r0 *1 150.26,16.655 nfet
M$441 \$475 \$396 \$457 VSS nfet L=0.6U W=0.36U AS=0.207P AD=0.0432P PS=1.51U
+ PD=0.6U
* device instance $442 r0 *1 151.1,16.655 nfet
M$442 \$475 \$436 VSS VSS nfet L=0.6U W=0.36U AS=0.2637P AD=0.0432P PS=1.825U
+ PD=0.6U
* device instance $443 r0 *1 152.66,16.655 nfet
M$443 \$436 \$457 VSS VSS nfet L=0.6U W=0.36U AS=0.2637P AD=0.0936P PS=1.825U
+ PD=0.88U
* device instance $444 r0 *1 153.78,16.655 nfet
M$444 \$437 \$396 \$436 VSS nfet L=0.6U W=0.36U AS=0.0936P AD=0.0936P PS=0.88U
+ PD=0.88U
* device instance $445 r0 *1 154.9,16.655 nfet
M$445 \$474 \$456 \$437 VSS nfet L=0.6U W=0.36U AS=0.0936P AD=0.0432P PS=0.88U
+ PD=0.6U
* device instance $446 r0 *1 155.74,16.655 nfet
M$446 \$474 \$438 VSS VSS nfet L=0.6U W=0.36U AS=0.142P AD=0.0432P PS=1.14U
+ PD=0.6U
* device instance $447 r0 *1 157.08,16.635 nfet
M$447 \$438 \$437 VSS VSS nfet L=0.6U W=0.4U AS=0.142P AD=0.176P PS=1.14U
+ PD=1.68U
* device instance $448 r0 *1 173.96,16.6375 nfet
M$448 VSS clknet_2_2__leaf_clk \$458 VSS nfet L=0.6U W=0.405U AS=0.1782P
+ AD=0.1053P PS=1.69U PD=0.925U
* device instance $449 r0 *1 175.08,16.6375 nfet
M$449 \$397 \$458 VSS VSS nfet L=0.6U W=0.405U AS=0.1053P AD=0.1782P PS=0.925U
+ PD=1.69U
* device instance $450 r0 *1 176.92,16.655 nfet
M$450 \$467 \$458 VSS VSS nfet L=0.6U W=0.36U AS=0.1584P AD=0.0432P PS=1.6U
+ PD=0.6U
* device instance $451 r0 *1 177.76,16.655 nfet
M$451 \$460 \_022_ \$467 VSS nfet L=0.6U W=0.36U AS=0.0432P AD=0.207P PS=0.6U
+ PD=1.51U
* device instance $452 r0 *1 179.38,16.655 nfet
M$452 \$465 \$397 \$460 VSS nfet L=0.6U W=0.36U AS=0.207P AD=0.0432P PS=1.51U
+ PD=0.6U
* device instance $453 r0 *1 180.22,16.655 nfet
M$453 \$465 \$439 VSS VSS nfet L=0.6U W=0.36U AS=0.2637P AD=0.0432P PS=1.825U
+ PD=0.6U
* device instance $454 r0 *1 181.78,16.655 nfet
M$454 \$439 \$460 VSS VSS nfet L=0.6U W=0.36U AS=0.2637P AD=0.0936P PS=1.825U
+ PD=0.88U
* device instance $455 r0 *1 182.9,16.655 nfet
M$455 \$440 \$397 \$439 VSS nfet L=0.6U W=0.36U AS=0.0936P AD=0.0936P PS=0.88U
+ PD=0.88U
* device instance $456 r0 *1 184.02,16.655 nfet
M$456 \$464 \$458 \$440 VSS nfet L=0.6U W=0.36U AS=0.0936P AD=0.0432P PS=0.88U
+ PD=0.6U
* device instance $457 r0 *1 184.86,16.655 nfet
M$457 \$464 \$441 VSS VSS nfet L=0.6U W=0.36U AS=0.142P AD=0.0432P PS=1.14U
+ PD=0.6U
* device instance $458 r0 *1 186.2,16.635 nfet
M$458 \$441 \$440 VSS VSS nfet L=0.6U W=0.4U AS=0.142P AD=0.176P PS=1.14U
+ PD=1.68U
* device instance $459 r0 *1 9.88,22.77 nfet
M$459 \$588 cmp VSS VSS nfet L=0.6U W=0.82U AS=0.3608P AD=0.1312P PS=2.52U
+ PD=1.14U
* device instance $460 r0 *1 10.8,22.77 nfet
M$460 \_025_ ph[9] \$588 VSS nfet L=0.6U W=0.82U AS=0.1312P AD=0.2569P PS=1.14U
+ PD=1.56U
* device instance $461 r0 *1 12.14,22.925 nfet
M$461 VSS \_062_ \_025_ VSS nfet L=0.6U W=0.51U AS=0.2569P AD=0.2244P PS=1.56U
+ PD=1.9U
* device instance $462 r0 *1 14.36,22.6 nfet
M$462 \_048_ ph[9] VSS VSS nfet L=0.6U W=0.48U AS=0.2112P AD=0.2112P PS=1.84U
+ PD=1.84U
* device instance $463 r0 *1 16.6,22.7125 nfet
M$463 \_009_[12] start VSS VSS nfet L=0.6U W=0.565U AS=0.2486P AD=0.1469P
+ PS=2.01U PD=1.085U
* device instance $464 r0 *1 17.72,22.7125 nfet
M$464 VSS \_046_ \_009_[12] VSS nfet L=0.6U W=0.565U AS=0.1469P AD=0.2486P
+ PS=1.085U PD=2.01U
* device instance $465 r0 *1 26.3,24.27 nfet
M$465 ph[12] \$617 VSS VSS nfet L=0.6U W=0.82U AS=0.3608P AD=0.3608P PS=2.52U
+ PD=2.52U
* device instance $466 r0 *1 30.04,22.5625 nfet
M$466 VSS clknet_2_0__leaf_clk \$492 VSS nfet L=0.6U W=0.405U AS=0.1782P
+ AD=0.1053P PS=1.69U PD=0.925U
* device instance $467 r0 *1 31.16,22.5625 nfet
M$467 \$493 \$492 VSS VSS nfet L=0.6U W=0.405U AS=0.1053P AD=0.1782P PS=0.925U
+ PD=1.69U
* device instance $468 r0 *1 33,22.545 nfet
M$468 \$591 \$492 VSS VSS nfet L=0.6U W=0.36U AS=0.1584P AD=0.0432P PS=1.6U
+ PD=0.6U
* device instance $469 r0 *1 33.84,22.545 nfet
M$469 \$591 \_003_ \$537 VSS nfet L=0.6U W=0.36U AS=0.207P AD=0.0432P PS=1.51U
+ PD=0.6U
* device instance $470 r0 *1 35.46,22.545 nfet
M$470 \$592 \$493 \$537 VSS nfet L=0.6U W=0.36U AS=0.207P AD=0.0432P PS=1.51U
+ PD=0.6U
* device instance $471 r0 *1 36.3,22.545 nfet
M$471 VSS \$538 \$592 VSS nfet L=0.6U W=0.36U AS=0.0432P AD=0.2637P PS=0.6U
+ PD=1.825U
* device instance $472 r0 *1 37.86,22.545 nfet
M$472 \$538 \$537 VSS VSS nfet L=0.6U W=0.36U AS=0.2637P AD=0.0936P PS=1.825U
+ PD=0.88U
* device instance $473 r0 *1 38.98,22.545 nfet
M$473 \$539 \$493 \$538 VSS nfet L=0.6U W=0.36U AS=0.0936P AD=0.0936P PS=0.88U
+ PD=0.88U
* device instance $474 r0 *1 40.1,22.545 nfet
M$474 \$593 \$492 \$539 VSS nfet L=0.6U W=0.36U AS=0.0936P AD=0.0432P PS=0.88U
+ PD=0.6U
* device instance $475 r0 *1 40.94,22.545 nfet
M$475 VSS \$540 \$593 VSS nfet L=0.6U W=0.36U AS=0.0432P AD=0.142P PS=0.6U
+ PD=1.14U
* device instance $476 r0 *1 42.28,22.565 nfet
M$476 \$540 \$539 VSS VSS nfet L=0.6U W=0.4U AS=0.142P AD=0.176P PS=1.14U
+ PD=1.68U
* device instance $477 r0 *1 44.22,22.77 nfet
M$477 eng4 \$540 VSS VSS nfet L=0.6U W=0.82U AS=0.3608P AD=0.3608P PS=2.52U
+ PD=2.52U
* device instance $478 r0 *1 46.28,22.77 nfet
M$478 \$494 clknet_0_clk VSS VSS nfet L=0.6U W=0.82U AS=0.3608P AD=0.2132P
+ PS=2.52U PD=1.34U
* device instance $479 r0 *1 47.4,22.77 nfet
M$479 VSS clknet_0_clk \$494 VSS nfet L=0.6U W=0.82U AS=0.2132P AD=0.2132P
+ PS=1.34U PD=1.34U
* device instance $480 r0 *1 48.52,22.77 nfet
M$480 clknet_2_1__leaf_clk \$494 VSS VSS nfet L=0.6U W=0.82U AS=0.2132P
+ AD=0.2132P PS=1.34U PD=1.34U
* device instance $481 r0 *1 49.64,22.77 nfet
M$481 VSS \$494 clknet_2_1__leaf_clk VSS nfet L=0.6U W=0.82U AS=0.2132P
+ AD=0.2132P PS=1.34U PD=1.34U
* device instance $482 r0 *1 50.76,22.77 nfet
M$482 clknet_2_1__leaf_clk \$494 VSS VSS nfet L=0.6U W=0.82U AS=0.2132P
+ AD=0.2132P PS=1.34U PD=1.34U
* device instance $483 r0 *1 51.88,22.77 nfet
M$483 VSS \$494 clknet_2_1__leaf_clk VSS nfet L=0.6U W=0.82U AS=0.2132P
+ AD=0.3608P PS=1.34U PD=2.52U
* device instance $484 r0 *1 48.14,24.27 nfet
M$484 q0 \$624 VSS VSS nfet L=0.6U W=0.82U AS=0.3608P AD=0.3608P PS=2.52U
+ PD=2.52U
* device instance $485 r0 *1 56.36,22.5625 nfet
M$485 VSS clknet_2_1__leaf_clk \$496 VSS nfet L=0.6U W=0.405U AS=0.1782P
+ AD=0.1053P PS=1.69U PD=0.925U
* device instance $486 r0 *1 57.48,22.5625 nfet
M$486 \$497 \$496 VSS VSS nfet L=0.6U W=0.405U AS=0.1053P AD=0.1782P PS=0.925U
+ PD=1.69U
* device instance $487 r0 *1 59.32,22.545 nfet
M$487 \$595 \$496 VSS VSS nfet L=0.6U W=0.36U AS=0.1584P AD=0.0432P PS=1.6U
+ PD=0.6U
* device instance $488 r0 *1 60.16,22.545 nfet
M$488 \$595 \_023_ \$541 VSS nfet L=0.6U W=0.36U AS=0.207P AD=0.0432P PS=1.51U
+ PD=0.6U
* device instance $489 r0 *1 61.78,22.545 nfet
M$489 \$596 \$497 \$541 VSS nfet L=0.6U W=0.36U AS=0.207P AD=0.0432P PS=1.51U
+ PD=0.6U
* device instance $490 r0 *1 62.62,22.545 nfet
M$490 VSS \$542 \$596 VSS nfet L=0.6U W=0.36U AS=0.0432P AD=0.2637P PS=0.6U
+ PD=1.825U
* device instance $491 r0 *1 64.18,22.545 nfet
M$491 \$542 \$541 VSS VSS nfet L=0.6U W=0.36U AS=0.2637P AD=0.0936P PS=1.825U
+ PD=0.88U
* device instance $492 r0 *1 65.3,22.545 nfet
M$492 \$543 \$497 \$542 VSS nfet L=0.6U W=0.36U AS=0.0936P AD=0.0936P PS=0.88U
+ PD=0.88U
* device instance $493 r0 *1 66.42,22.545 nfet
M$493 \$597 \$496 \$543 VSS nfet L=0.6U W=0.36U AS=0.0936P AD=0.0432P PS=0.88U
+ PD=0.6U
* device instance $494 r0 *1 67.26,22.545 nfet
M$494 VSS \$544 \$597 VSS nfet L=0.6U W=0.36U AS=0.0432P AD=0.142P PS=0.6U
+ PD=1.14U
* device instance $495 r0 *1 68.6,22.565 nfet
M$495 \$544 \$543 VSS VSS nfet L=0.6U W=0.4U AS=0.142P AD=0.176P PS=1.14U
+ PD=1.68U
* device instance $496 r0 *1 69.98,24.27 nfet
M$496 c3_r \$630 VSS VSS nfet L=0.6U W=0.82U AS=0.3608P AD=0.3608P PS=2.52U
+ PD=2.52U
* device instance $497 r0 *1 70.54,22.77 nfet
M$497 c4_r \$544 VSS VSS nfet L=0.6U W=0.82U AS=0.3608P AD=0.3608P PS=2.52U
+ PD=2.52U
* device instance $498 r0 *1 84.92,22.5625 nfet
M$498 VSS clknet_2_0__leaf_clk \$498 VSS nfet L=0.6U W=0.405U AS=0.1782P
+ AD=0.1053P PS=1.69U PD=0.925U
* device instance $499 r0 *1 86.04,22.5625 nfet
M$499 \$500 \$498 VSS VSS nfet L=0.6U W=0.405U AS=0.1053P AD=0.1782P PS=0.925U
+ PD=1.69U
* device instance $500 r0 *1 87.88,22.545 nfet
M$500 \$598 \$498 VSS VSS nfet L=0.6U W=0.36U AS=0.1584P AD=0.0432P PS=1.6U
+ PD=0.6U
* device instance $501 r0 *1 88.72,22.545 nfet
M$501 \$598 \_007_ \$546 VSS nfet L=0.6U W=0.36U AS=0.207P AD=0.0432P PS=1.51U
+ PD=0.6U
* device instance $502 r0 *1 90.34,22.545 nfet
M$502 \$599 \$500 \$546 VSS nfet L=0.6U W=0.36U AS=0.207P AD=0.0432P PS=1.51U
+ PD=0.6U
* device instance $503 r0 *1 91.18,22.545 nfet
M$503 VSS \$547 \$599 VSS nfet L=0.6U W=0.36U AS=0.0432P AD=0.2637P PS=0.6U
+ PD=1.825U
* device instance $504 r0 *1 92.74,22.545 nfet
M$504 \$547 \$546 VSS VSS nfet L=0.6U W=0.36U AS=0.2637P AD=0.0936P PS=1.825U
+ PD=0.88U
* device instance $505 r0 *1 93.86,22.545 nfet
M$505 \$548 \$500 \$547 VSS nfet L=0.6U W=0.36U AS=0.0936P AD=0.0936P PS=0.88U
+ PD=0.88U
* device instance $506 r0 *1 94.98,22.545 nfet
M$506 \$600 \$498 \$548 VSS nfet L=0.6U W=0.36U AS=0.0936P AD=0.0432P PS=0.88U
+ PD=0.6U
* device instance $507 r0 *1 95.82,22.545 nfet
M$507 VSS \$549 \$600 VSS nfet L=0.6U W=0.36U AS=0.0432P AD=0.142P PS=0.6U
+ PD=1.14U
* device instance $508 r0 *1 97.16,22.565 nfet
M$508 \$549 \$548 VSS VSS nfet L=0.6U W=0.4U AS=0.142P AD=0.176P PS=1.14U
+ PD=1.68U
* device instance $509 r0 *1 97.98,24.27 nfet
M$509 c2_r \$635 VSS VSS nfet L=0.6U W=0.82U AS=0.3608P AD=0.3608P PS=2.52U
+ PD=2.52U
* device instance $510 r0 *1 99.1,22.77 nfet
M$510 eng8 \$549 VSS VSS nfet L=0.6U W=0.82U AS=0.3608P AD=0.3608P PS=2.52U
+ PD=2.52U
* device instance $511 r0 *1 109,22.5625 nfet
M$511 VSS clknet_2_3__leaf_clk \$501 VSS nfet L=0.6U W=0.405U AS=0.1782P
+ AD=0.1053P PS=1.69U PD=0.925U
* device instance $512 r0 *1 110.12,22.5625 nfet
M$512 \$502 \$501 VSS VSS nfet L=0.6U W=0.405U AS=0.1053P AD=0.1782P PS=0.925U
+ PD=1.69U
* device instance $513 r0 *1 111.96,22.545 nfet
M$513 \$602 \$501 VSS VSS nfet L=0.6U W=0.36U AS=0.1584P AD=0.0432P PS=1.6U
+ PD=0.6U
* device instance $514 r0 *1 112.8,22.545 nfet
M$514 \$602 \_027_ \$550 VSS nfet L=0.6U W=0.36U AS=0.207P AD=0.0432P PS=1.51U
+ PD=0.6U
* device instance $515 r0 *1 114.42,22.545 nfet
M$515 \$603 \$502 \$550 VSS nfet L=0.6U W=0.36U AS=0.207P AD=0.0432P PS=1.51U
+ PD=0.6U
* device instance $516 r0 *1 115.26,22.545 nfet
M$516 VSS \$551 \$603 VSS nfet L=0.6U W=0.36U AS=0.0432P AD=0.2637P PS=0.6U
+ PD=1.825U
* device instance $517 r0 *1 116.82,22.545 nfet
M$517 \$551 \$550 VSS VSS nfet L=0.6U W=0.36U AS=0.2637P AD=0.0936P PS=1.825U
+ PD=0.88U
* device instance $518 r0 *1 117.94,22.545 nfet
M$518 \$552 \$502 \$551 VSS nfet L=0.6U W=0.36U AS=0.0936P AD=0.0936P PS=0.88U
+ PD=0.88U
* device instance $519 r0 *1 119.06,22.545 nfet
M$519 \$604 \$501 \$552 VSS nfet L=0.6U W=0.36U AS=0.0936P AD=0.0432P PS=0.88U
+ PD=0.6U
* device instance $520 r0 *1 119.9,22.545 nfet
M$520 VSS \$553 \$604 VSS nfet L=0.6U W=0.36U AS=0.0432P AD=0.142P PS=0.6U
+ PD=1.14U
* device instance $521 r0 *1 121.24,22.565 nfet
M$521 \$553 \$552 VSS VSS nfet L=0.6U W=0.4U AS=0.142P AD=0.176P PS=1.14U
+ PD=1.68U
* device instance $522 r0 *1 113.66,24.22 nfet
M$522 \$646 q6 VSS VSS nfet L=0.6U W=0.36U AS=0.218P AD=0.0432P PS=1.52U PD=0.6U
* device instance $523 r0 *1 114.5,24.22 nfet
M$523 \$636 ph[14] \$646 VSS nfet L=0.6U W=0.36U AS=0.0432P AD=0.0936P PS=0.6U
+ PD=0.88U
* device instance $524 r0 *1 115.62,24.22 nfet
M$524 \$645 \$609 \$636 VSS nfet L=0.6U W=0.36U AS=0.0936P AD=0.0432P PS=0.88U
+ PD=0.6U
* device instance $525 r0 *1 116.46,24.22 nfet
M$525 VSS c6_r \$645 VSS nfet L=0.6U W=0.36U AS=0.0432P AD=0.0936P PS=0.6U
+ PD=0.88U
* device instance $526 r0 *1 117.58,24.22 nfet
M$526 \$609 ph[14] VSS VSS nfet L=0.6U W=0.36U AS=0.0936P AD=0.1584P PS=0.88U
+ PD=1.6U
* device instance $527 r0 *1 112.36,24.27 nfet
M$527 VSS \$636 \_027_ VSS nfet L=0.6U W=0.82U AS=0.3608P AD=0.218P PS=2.52U
+ PD=1.52U
* device instance $528 r0 *1 123.18,22.77 nfet
M$528 c6_r \$553 VSS VSS nfet L=0.6U W=0.82U AS=0.3608P AD=0.3608P PS=2.52U
+ PD=2.52U
* device instance $529 r0 *1 131.42,24.115 nfet
M$529 VSS ph[13] \_004_ VSS nfet L=0.6U W=0.51U AS=0.2569P AD=0.2244P PS=1.56U
+ PD=1.9U
* device instance $530 r0 *1 129.16,24.27 nfet
M$530 \$676 \_049_ VSS VSS nfet L=0.6U W=0.82U AS=0.3608P AD=0.1312P PS=2.52U
+ PD=1.14U
* device instance $531 r0 *1 130.08,24.27 nfet
M$531 \_004_ \_037_ \$676 VSS nfet L=0.6U W=0.82U AS=0.1312P AD=0.2569P
+ PS=1.14U PD=1.56U
* device instance $532 r0 *1 130.84,22.77 nfet
M$532 \$607 \_052_ VSS VSS nfet L=0.6U W=0.82U AS=0.3608P AD=0.1312P PS=2.52U
+ PD=1.14U
* device instance $533 r0 *1 131.76,22.77 nfet
M$533 \_007_ \_040_ \$607 VSS nfet L=0.6U W=0.82U AS=0.1312P AD=0.2569P
+ PS=1.14U PD=1.56U
* device instance $534 r0 *1 133.1,22.925 nfet
M$534 VSS ph[13] \_007_ VSS nfet L=0.6U W=0.51U AS=0.2569P AD=0.2244P PS=1.56U
+ PD=1.9U
* device instance $535 r0 *1 136.46,24.115 nfet
M$535 VSS ph[13] \_008_ VSS nfet L=0.6U W=0.51U AS=0.2569P AD=0.2244P PS=1.56U
+ PD=1.9U
* device instance $536 r0 *1 134.2,24.27 nfet
M$536 \$673 \_053_ VSS VSS nfet L=0.6U W=0.82U AS=0.3608P AD=0.1312P PS=2.52U
+ PD=1.14U
* device instance $537 r0 *1 135.12,24.27 nfet
M$537 \_008_ \_041_ \$673 VSS nfet L=0.6U W=0.82U AS=0.1312P AD=0.2569P
+ PS=1.14U PD=1.56U
* device instance $538 r0 *1 135.32,22.6 nfet
M$538 \_041_ eng9 VSS VSS nfet L=0.6U W=0.48U AS=0.2112P AD=0.2112P PS=1.84U
+ PD=1.84U
* device instance $539 r0 *1 143.16,22.77 nfet
M$539 \$504 clknet_0_clk VSS VSS nfet L=0.6U W=0.82U AS=0.3608P AD=0.2132P
+ PS=2.52U PD=1.34U
* device instance $540 r0 *1 144.28,22.77 nfet
M$540 VSS clknet_0_clk \$504 VSS nfet L=0.6U W=0.82U AS=0.2132P AD=0.2132P
+ PS=1.34U PD=1.34U
* device instance $541 r0 *1 145.4,22.77 nfet
M$541 clknet_2_2__leaf_clk \$504 VSS VSS nfet L=0.6U W=0.82U AS=0.2132P
+ AD=0.2132P PS=1.34U PD=1.34U
* device instance $542 r0 *1 146.52,22.77 nfet
M$542 VSS \$504 clknet_2_2__leaf_clk VSS nfet L=0.6U W=0.82U AS=0.2132P
+ AD=0.2132P PS=1.34U PD=1.34U
* device instance $543 r0 *1 147.64,22.77 nfet
M$543 clknet_2_2__leaf_clk \$504 VSS VSS nfet L=0.6U W=0.82U AS=0.2132P
+ AD=0.2132P PS=1.34U PD=1.34U
* device instance $544 r0 *1 148.76,22.77 nfet
M$544 VSS \$504 clknet_2_2__leaf_clk VSS nfet L=0.6U W=0.82U AS=0.2132P
+ AD=0.3608P PS=1.34U PD=2.52U
* device instance $545 r0 *1 151,22.7125 nfet
M$545 \_009_[8] start VSS VSS nfet L=0.6U W=0.565U AS=0.2486P AD=0.1469P
+ PS=2.01U PD=1.085U
* device instance $546 r0 *1 152.12,22.7125 nfet
M$546 VSS \_050_ \_009_[8] VSS nfet L=0.6U W=0.565U AS=0.1469P AD=0.2486P
+ PS=1.085U PD=2.01U
* device instance $547 r0 *1 154.36,22.6 nfet
M$547 \_051_ ph[6] VSS VSS nfet L=0.6U W=0.48U AS=0.2112P AD=0.2112P PS=1.84U
+ PD=1.84U
* device instance $548 r0 *1 155.1,24.27 nfet
M$548 eng7 \$643 VSS VSS nfet L=0.6U W=0.82U AS=0.3608P AD=0.3608P PS=2.52U
+ PD=2.52U
* device instance $549 r0 *1 156.6,22.5625 nfet
M$549 VSS clknet_2_3__leaf_clk \$506 VSS nfet L=0.6U W=0.405U AS=0.1782P
+ AD=0.1053P PS=1.69U PD=0.925U
* device instance $550 r0 *1 157.72,22.5625 nfet
M$550 \$507 \$506 VSS VSS nfet L=0.6U W=0.405U AS=0.1053P AD=0.1782P PS=0.925U
+ PD=1.69U
* device instance $551 r0 *1 159.56,22.545 nfet
M$551 \$606 \$506 VSS VSS nfet L=0.6U W=0.36U AS=0.1584P AD=0.0432P PS=1.6U
+ PD=0.6U
* device instance $552 r0 *1 160.4,22.545 nfet
M$552 \$606 \_019_ \$555 VSS nfet L=0.6U W=0.36U AS=0.207P AD=0.0432P PS=1.51U
+ PD=0.6U
* device instance $553 r0 *1 162.02,22.545 nfet
M$553 \$605 \$507 \$555 VSS nfet L=0.6U W=0.36U AS=0.207P AD=0.0432P PS=1.51U
+ PD=0.6U
* device instance $554 r0 *1 162.86,22.545 nfet
M$554 VSS \$556 \$605 VSS nfet L=0.6U W=0.36U AS=0.0432P AD=0.2637P PS=0.6U
+ PD=1.825U
* device instance $555 r0 *1 164.42,22.545 nfet
M$555 \$556 \$555 VSS VSS nfet L=0.6U W=0.36U AS=0.2637P AD=0.0936P PS=1.825U
+ PD=0.88U
* device instance $556 r0 *1 165.54,22.545 nfet
M$556 \$557 \$507 \$556 VSS nfet L=0.6U W=0.36U AS=0.0936P AD=0.0936P PS=0.88U
+ PD=0.88U
* device instance $557 r0 *1 166.66,22.545 nfet
M$557 \$601 \$506 \$557 VSS nfet L=0.6U W=0.36U AS=0.0936P AD=0.0432P PS=0.88U
+ PD=0.6U
* device instance $558 r0 *1 167.5,22.545 nfet
M$558 VSS \$558 \$601 VSS nfet L=0.6U W=0.36U AS=0.0432P AD=0.142P PS=0.6U
+ PD=1.14U
* device instance $559 r0 *1 168.84,22.565 nfet
M$559 \$558 \$557 VSS VSS nfet L=0.6U W=0.4U AS=0.142P AD=0.176P PS=1.14U
+ PD=1.68U
* device instance $560 r0 *1 162.78,24.115 nfet
M$560 VSS \_059_ \_019_ VSS nfet L=0.6U W=0.51U AS=0.2569P AD=0.2244P PS=1.56U
+ PD=1.9U
* device instance $561 r0 *1 160.52,24.27 nfet
M$561 \$662 cmp VSS VSS nfet L=0.6U W=0.82U AS=0.3608P AD=0.1312P PS=2.52U
+ PD=1.14U
* device instance $562 r0 *1 161.44,24.27 nfet
M$562 \_019_ ph[8] \$662 VSS nfet L=0.6U W=0.82U AS=0.1312P AD=0.2569P PS=1.14U
+ PD=1.56U
* device instance $563 r0 *1 170.78,22.77 nfet
M$563 q5 \$558 VSS VSS nfet L=0.6U W=0.82U AS=0.3608P AD=0.3608P PS=2.52U
+ PD=2.52U
* device instance $564 r0 *1 175.64,22.7125 nfet
M$564 \_009_[1] start VSS VSS nfet L=0.6U W=0.565U AS=0.2486P AD=0.1469P
+ PS=2.01U PD=1.085U
* device instance $565 r0 *1 176.76,22.7125 nfet
M$565 VSS \_033_ \_009_[1] VSS nfet L=0.6U W=0.565U AS=0.1469P AD=0.2486P
+ PS=1.085U PD=2.01U
* device instance $566 r0 *1 177.9,24.115 nfet
M$566 VSS \_061_ \_022_ VSS nfet L=0.6U W=0.51U AS=0.2569P AD=0.2244P PS=1.56U
+ PD=1.9U
* device instance $567 r0 *1 175.64,24.27 nfet
M$567 \$661 cmp VSS VSS nfet L=0.6U W=0.82U AS=0.3608P AD=0.1312P PS=2.52U
+ PD=1.14U
* device instance $568 r0 *1 176.56,24.27 nfet
M$568 \_022_ ph[5] \$661 VSS nfet L=0.6U W=0.82U AS=0.1312P AD=0.2569P PS=1.14U
+ PD=1.56U
* device instance $569 r0 *1 179,22.5625 nfet
M$569 VSS clknet_2_3__leaf_clk \$508 VSS nfet L=0.6U W=0.405U AS=0.1782P
+ AD=0.1053P PS=1.69U PD=0.925U
* device instance $570 r0 *1 180.12,22.5625 nfet
M$570 \$509 \$508 VSS VSS nfet L=0.6U W=0.405U AS=0.1053P AD=0.1782P PS=0.925U
+ PD=1.69U
* device instance $571 r0 *1 182.38,24.115 nfet
M$571 VSS \_063_ \_026_ VSS nfet L=0.6U W=0.51U AS=0.2569P AD=0.2244P PS=1.56U
+ PD=1.9U
* device instance $572 r0 *1 180.12,24.27 nfet
M$572 \$659 cmp VSS VSS nfet L=0.6U W=0.82U AS=0.3608P AD=0.1312P PS=2.52U
+ PD=1.14U
* device instance $573 r0 *1 181.04,24.27 nfet
M$573 \_026_ ph[4] \$659 VSS nfet L=0.6U W=0.82U AS=0.1312P AD=0.2569P PS=1.14U
+ PD=1.56U
* device instance $574 r0 *1 181.96,22.545 nfet
M$574 \$594 \$508 VSS VSS nfet L=0.6U W=0.36U AS=0.1584P AD=0.0432P PS=1.6U
+ PD=0.6U
* device instance $575 r0 *1 182.8,22.545 nfet
M$575 \$594 \_009_[4] \$559 VSS nfet L=0.6U W=0.36U AS=0.207P AD=0.0432P
+ PS=1.51U PD=0.6U
* device instance $576 r0 *1 184.42,22.545 nfet
M$576 \$590 \$509 \$559 VSS nfet L=0.6U W=0.36U AS=0.207P AD=0.0432P PS=1.51U
+ PD=0.6U
* device instance $577 r0 *1 185.26,22.545 nfet
M$577 VSS \$560 \$590 VSS nfet L=0.6U W=0.36U AS=0.0432P AD=0.2637P PS=0.6U
+ PD=1.825U
* device instance $578 r0 *1 186.82,22.545 nfet
M$578 \$560 \$559 VSS VSS nfet L=0.6U W=0.36U AS=0.2637P AD=0.0936P PS=1.825U
+ PD=0.88U
* device instance $579 r0 *1 187.94,22.545 nfet
M$579 \$561 \$509 \$560 VSS nfet L=0.6U W=0.36U AS=0.0936P AD=0.0936P PS=0.88U
+ PD=0.88U
* device instance $580 r0 *1 189.06,22.545 nfet
M$580 \$589 \$508 \$561 VSS nfet L=0.6U W=0.36U AS=0.0936P AD=0.0432P PS=0.88U
+ PD=0.6U
* device instance $581 r0 *1 189.9,22.545 nfet
M$581 VSS \$562 \$589 VSS nfet L=0.6U W=0.36U AS=0.0432P AD=0.142P PS=0.6U
+ PD=1.14U
* device instance $582 r0 *1 191.24,22.565 nfet
M$582 \$562 \$561 VSS VSS nfet L=0.6U W=0.4U AS=0.142P AD=0.176P PS=1.14U
+ PD=1.68U
* device instance $583 r0 *1 193.18,22.77 nfet
M$583 ph[4] \$562 VSS VSS nfet L=0.6U W=0.82U AS=0.3608P AD=0.3608P PS=2.52U
+ PD=2.52U
* device instance $584 r0 *1 8.76,24.3275 nfet
M$584 \_009_[10] start VSS VSS nfet L=0.6U W=0.565U AS=0.2486P AD=0.1469P
+ PS=2.01U PD=1.085U
* device instance $585 r0 *1 9.88,24.3275 nfet
M$585 VSS \_048_ \_009_[10] VSS nfet L=0.6U W=0.565U AS=0.1469P AD=0.2486P
+ PS=1.085U PD=2.01U
* device instance $586 r0 *1 12.12,24.4775 nfet
M$586 VSS clknet_2_1__leaf_clk \$613 VSS nfet L=0.6U W=0.405U AS=0.1782P
+ AD=0.1053P PS=1.69U PD=0.925U
* device instance $587 r0 *1 13.24,24.4775 nfet
M$587 \$614 \$613 VSS VSS nfet L=0.6U W=0.405U AS=0.1053P AD=0.1782P PS=0.925U
+ PD=1.69U
* device instance $588 r0 *1 30.6,24.3275 nfet
M$588 \_009_[13] start VSS VSS nfet L=0.6U W=0.565U AS=0.2486P AD=0.1469P
+ PS=2.01U PD=1.085U
* device instance $589 r0 *1 31.72,24.3275 nfet
M$589 VSS \_043_ \_009_[13] VSS nfet L=0.6U W=0.565U AS=0.1469P AD=0.2486P
+ PS=1.085U PD=2.01U
* device instance $590 r0 *1 33.96,24.4775 nfet
M$590 VSS clknet_2_1__leaf_clk \$619 VSS nfet L=0.6U W=0.405U AS=0.1782P
+ AD=0.1053P PS=1.69U PD=0.925U
* device instance $591 r0 *1 35.08,24.4775 nfet
M$591 \$620 \$619 VSS VSS nfet L=0.6U W=0.405U AS=0.1053P AD=0.1782P PS=0.925U
+ PD=1.69U
* device instance $592 r0 *1 55.8,24.4775 nfet
M$592 VSS clknet_2_1__leaf_clk \$625 VSS nfet L=0.6U W=0.405U AS=0.1782P
+ AD=0.1053P PS=1.69U PD=0.925U
* device instance $593 r0 *1 56.92,24.4775 nfet
M$593 \$626 \$625 VSS VSS nfet L=0.6U W=0.405U AS=0.1053P AD=0.1782P PS=0.925U
+ PD=1.69U
* device instance $594 r0 *1 83.8,24.4775 nfet
M$594 VSS clknet_2_1__leaf_clk \$631 VSS nfet L=0.6U W=0.405U AS=0.1782P
+ AD=0.1053P PS=1.69U PD=0.925U
* device instance $595 r0 *1 84.92,24.4775 nfet
M$595 \$632 \$631 VSS VSS nfet L=0.6U W=0.405U AS=0.1053P AD=0.1782P PS=0.925U
+ PD=1.69U
* device instance $596 r0 *1 119.64,24.44 nfet
M$596 \_054_ ph[14] VSS VSS nfet L=0.6U W=0.48U AS=0.2112P AD=0.2112P PS=1.84U
+ PD=1.84U
* device instance $597 r0 *1 140.92,24.4775 nfet
M$597 VSS clknet_2_3__leaf_clk \$639 VSS nfet L=0.6U W=0.405U AS=0.1782P
+ AD=0.1053P PS=1.69U PD=0.925U
* device instance $598 r0 *1 142.04,24.4775 nfet
M$598 \$640 \$639 VSS VSS nfet L=0.6U W=0.405U AS=0.1053P AD=0.1782P PS=0.925U
+ PD=1.69U
* device instance $599 r0 *1 157.16,24.3275 nfet
M$599 \_058_ ph[6] VSS VSS nfet L=0.6U W=0.565U AS=0.2486P AD=0.1469P PS=2.01U
+ PD=1.085U
* device instance $600 r0 *1 158.28,24.3275 nfet
M$600 VSS q7 \_058_ VSS nfet L=0.6U W=0.565U AS=0.1469P AD=0.2486P PS=1.085U
+ PD=2.01U
* device instance $601 r0 *1 184.6,24.3275 nfet
M$601 \_063_ ph[4] VSS VSS nfet L=0.6U W=0.565U AS=0.2486P AD=0.1469P PS=2.01U
+ PD=1.085U
* device instance $602 r0 *1 185.72,24.3275 nfet
M$602 VSS q9 \_063_ VSS nfet L=0.6U W=0.565U AS=0.1469P AD=0.2486P PS=1.085U
+ PD=2.01U
* device instance $603 r0 *1 187.96,24.44 nfet
M$603 \_035_ ph[3] VSS VSS nfet L=0.6U W=0.48U AS=0.2112P AD=0.2112P PS=1.84U
+ PD=1.84U
* device instance $604 r0 *1 15.08,24.495 nfet
M$604 \$657 \$613 VSS VSS nfet L=0.6U W=0.36U AS=0.1584P AD=0.0432P PS=1.6U
+ PD=0.6U
* device instance $605 r0 *1 15.92,24.495 nfet
M$605 \$648 \_009_[12] \$657 VSS nfet L=0.6U W=0.36U AS=0.0432P AD=0.207P
+ PS=0.6U PD=1.51U
* device instance $606 r0 *1 17.54,24.495 nfet
M$606 \$658 \$614 \$648 VSS nfet L=0.6U W=0.36U AS=0.207P AD=0.0432P PS=1.51U
+ PD=0.6U
* device instance $607 r0 *1 18.38,24.495 nfet
M$607 \$658 \$615 VSS VSS nfet L=0.6U W=0.36U AS=0.2637P AD=0.0432P PS=1.825U
+ PD=0.6U
* device instance $608 r0 *1 19.94,24.495 nfet
M$608 \$615 \$648 VSS VSS nfet L=0.6U W=0.36U AS=0.2637P AD=0.0936P PS=1.825U
+ PD=0.88U
* device instance $609 r0 *1 21.06,24.495 nfet
M$609 \$616 \$614 \$615 VSS nfet L=0.6U W=0.36U AS=0.0936P AD=0.0936P PS=0.88U
+ PD=0.88U
* device instance $610 r0 *1 22.18,24.495 nfet
M$610 \$660 \$613 \$616 VSS nfet L=0.6U W=0.36U AS=0.0936P AD=0.0432P PS=0.88U
+ PD=0.6U
* device instance $611 r0 *1 23.02,24.495 nfet
M$611 \$660 \$617 VSS VSS nfet L=0.6U W=0.36U AS=0.142P AD=0.0432P PS=1.14U
+ PD=0.6U
* device instance $612 r0 *1 24.36,24.475 nfet
M$612 \$617 \$616 VSS VSS nfet L=0.6U W=0.4U AS=0.142P AD=0.176P PS=1.14U
+ PD=1.68U
* device instance $613 r0 *1 15.48,30.61 nfet
M$613 \$763 cmp VSS VSS nfet L=0.6U W=0.82U AS=0.3608P AD=0.1312P PS=2.52U
+ PD=1.14U
* device instance $614 r0 *1 16.4,30.61 nfet
M$614 \_017_ ph[11] \$763 VSS nfet L=0.6U W=0.82U AS=0.1312P AD=0.2569P
+ PS=1.14U PD=1.56U
* device instance $615 r0 *1 17.74,30.765 nfet
M$615 VSS \_057_ \_017_ VSS nfet L=0.6U W=0.51U AS=0.2569P AD=0.2244P PS=1.56U
+ PD=1.9U
* device instance $616 r0 *1 25,30.61 nfet
M$616 \$764 cmp VSS VSS nfet L=0.6U W=0.82U AS=0.3608P AD=0.1312P PS=2.52U
+ PD=1.14U
* device instance $617 r0 *1 25.92,30.61 nfet
M$617 \_020_ ph[12] \$764 VSS nfet L=0.6U W=0.82U AS=0.1312P AD=0.2569P
+ PS=1.14U PD=1.56U
* device instance $618 r0 *1 27.26,30.765 nfet
M$618 VSS \_060_ \_020_ VSS nfet L=0.6U W=0.51U AS=0.2569P AD=0.2244P PS=1.56U
+ PD=1.9U
* device instance $619 r0 *1 35.64,30.61 nfet
M$619 \$766 cmp VSS VSS nfet L=0.6U W=0.82U AS=0.3608P AD=0.1312P PS=2.52U
+ PD=1.14U
* device instance $620 r0 *1 36.56,30.61 nfet
M$620 \_012_ ph[13] \$766 VSS nfet L=0.6U W=0.82U AS=0.1312P AD=0.2569P
+ PS=1.14U PD=1.56U
* device instance $621 r0 *1 37.9,30.765 nfet
M$621 VSS \_055_ \_012_ VSS nfet L=0.6U W=0.51U AS=0.2569P AD=0.2244P PS=1.56U
+ PD=1.9U
* device instance $622 r0 *1 36.92,24.495 nfet
M$622 \$663 \$619 VSS VSS nfet L=0.6U W=0.36U AS=0.1584P AD=0.0432P PS=1.6U
+ PD=0.6U
* device instance $623 r0 *1 37.76,24.495 nfet
M$623 \$649 \_012_ \$663 VSS nfet L=0.6U W=0.36U AS=0.0432P AD=0.207P PS=0.6U
+ PD=1.51U
* device instance $624 r0 *1 39.38,24.495 nfet
M$624 \$664 \$620 \$649 VSS nfet L=0.6U W=0.36U AS=0.207P AD=0.0432P PS=1.51U
+ PD=0.6U
* device instance $625 r0 *1 40.22,24.495 nfet
M$625 \$664 \$622 VSS VSS nfet L=0.6U W=0.36U AS=0.2637P AD=0.0432P PS=1.825U
+ PD=0.6U
* device instance $626 r0 *1 41.78,24.495 nfet
M$626 \$622 \$649 VSS VSS nfet L=0.6U W=0.36U AS=0.2637P AD=0.0936P PS=1.825U
+ PD=0.88U
* device instance $627 r0 *1 42.9,24.495 nfet
M$627 \$623 \$620 \$622 VSS nfet L=0.6U W=0.36U AS=0.0936P AD=0.0936P PS=0.88U
+ PD=0.88U
* device instance $628 r0 *1 44.02,24.495 nfet
M$628 \$665 \$619 \$623 VSS nfet L=0.6U W=0.36U AS=0.0936P AD=0.0432P PS=0.88U
+ PD=0.6U
* device instance $629 r0 *1 44.86,24.495 nfet
M$629 \$665 \$624 VSS VSS nfet L=0.6U W=0.36U AS=0.142P AD=0.0432P PS=1.14U
+ PD=0.6U
* device instance $630 r0 *1 46.2,24.475 nfet
M$630 \$624 \$623 VSS VSS nfet L=0.6U W=0.4U AS=0.142P AD=0.176P PS=1.14U
+ PD=1.68U
* device instance $631 r0 *1 49.08,30.44 nfet
M$631 \_045_ ph[13] VSS VSS nfet L=0.6U W=0.48U AS=0.2112P AD=0.2112P PS=1.84U
+ PD=1.84U
* device instance $632 r0 *1 58.76,24.495 nfet
M$632 \$667 \$625 VSS VSS nfet L=0.6U W=0.36U AS=0.1584P AD=0.0432P PS=1.6U
+ PD=0.6U
* device instance $633 r0 *1 59.6,24.495 nfet
M$633 \$651 \_021_ \$667 VSS nfet L=0.6U W=0.36U AS=0.0432P AD=0.207P PS=0.6U
+ PD=1.51U
* device instance $634 r0 *1 61.22,24.495 nfet
M$634 \$668 \$626 \$651 VSS nfet L=0.6U W=0.36U AS=0.207P AD=0.0432P PS=1.51U
+ PD=0.6U
* device instance $635 r0 *1 62.06,24.495 nfet
M$635 \$668 \$628 VSS VSS nfet L=0.6U W=0.36U AS=0.2637P AD=0.0432P PS=1.825U
+ PD=0.6U
* device instance $636 r0 *1 63.62,24.495 nfet
M$636 \$628 \$651 VSS VSS nfet L=0.6U W=0.36U AS=0.2637P AD=0.0936P PS=1.825U
+ PD=0.88U
* device instance $637 r0 *1 64.74,24.495 nfet
M$637 \$629 \$626 \$628 VSS nfet L=0.6U W=0.36U AS=0.0936P AD=0.0936P PS=0.88U
+ PD=0.88U
* device instance $638 r0 *1 65.86,24.495 nfet
M$638 \$670 \$625 \$629 VSS nfet L=0.6U W=0.36U AS=0.0936P AD=0.0432P PS=0.88U
+ PD=0.6U
* device instance $639 r0 *1 66.7,24.495 nfet
M$639 \$670 \$630 VSS VSS nfet L=0.6U W=0.36U AS=0.142P AD=0.0432P PS=1.14U
+ PD=0.6U
* device instance $640 r0 *1 68.04,24.475 nfet
M$640 \$630 \$629 VSS VSS nfet L=0.6U W=0.4U AS=0.142P AD=0.176P PS=1.14U
+ PD=1.68U
* device instance $641 r0 *1 61.58,30.66 nfet
M$641 \$769 q4 VSS VSS nfet L=0.6U W=0.36U AS=0.218P AD=0.0432P PS=1.52U PD=0.6U
* device instance $642 r0 *1 62.42,30.66 nfet
M$642 \$716 ph[14] \$769 VSS nfet L=0.6U W=0.36U AS=0.0432P AD=0.0936P PS=0.6U
+ PD=0.88U
* device instance $643 r0 *1 63.54,30.66 nfet
M$643 \$770 \$685 \$716 VSS nfet L=0.6U W=0.36U AS=0.0936P AD=0.0432P PS=0.88U
+ PD=0.6U
* device instance $644 r0 *1 64.38,30.66 nfet
M$644 VSS c4_r \$770 VSS nfet L=0.6U W=0.36U AS=0.0432P AD=0.0936P PS=0.6U
+ PD=0.88U
* device instance $645 r0 *1 65.5,30.66 nfet
M$645 \$685 ph[14] VSS VSS nfet L=0.6U W=0.36U AS=0.0936P AD=0.1584P PS=0.88U
+ PD=1.6U
* device instance $646 r0 *1 60.28,30.61 nfet
M$646 VSS \$716 \_023_ VSS nfet L=0.6U W=0.82U AS=0.3608P AD=0.218P PS=2.52U
+ PD=1.52U
* device instance $647 r0 *1 78.94,30.66 nfet
M$647 \$771 q8 VSS VSS nfet L=0.6U W=0.36U AS=0.218P AD=0.0432P PS=1.52U PD=0.6U
* device instance $648 r0 *1 79.78,30.66 nfet
M$648 \$718 ph[14] \$771 VSS nfet L=0.6U W=0.36U AS=0.0432P AD=0.0936P PS=0.6U
+ PD=0.88U
* device instance $649 r0 *1 80.9,30.66 nfet
M$649 \$772 \$686 \$718 VSS nfet L=0.6U W=0.36U AS=0.0936P AD=0.0432P PS=0.88U
+ PD=0.6U
* device instance $650 r0 *1 81.74,30.66 nfet
M$650 VSS c8_r \$772 VSS nfet L=0.6U W=0.36U AS=0.0432P AD=0.0936P PS=0.6U
+ PD=0.88U
* device instance $651 r0 *1 82.86,30.66 nfet
M$651 \$686 ph[14] VSS VSS nfet L=0.6U W=0.36U AS=0.0936P AD=0.1584P PS=0.88U
+ PD=1.6U
* device instance $652 r0 *1 77.64,30.61 nfet
M$652 VSS \$718 \_010_ VSS nfet L=0.6U W=0.82U AS=0.3608P AD=0.218P PS=2.52U
+ PD=1.52U
* device instance $653 r0 *1 86.76,24.495 nfet
M$653 \$672 \$631 VSS VSS nfet L=0.6U W=0.36U AS=0.1584P AD=0.0432P PS=1.6U
+ PD=0.6U
* device instance $654 r0 *1 87.6,24.495 nfet
M$654 \$653 \_016_ \$672 VSS nfet L=0.6U W=0.36U AS=0.0432P AD=0.207P PS=0.6U
+ PD=1.51U
* device instance $655 r0 *1 89.22,24.495 nfet
M$655 \$674 \$632 \$653 VSS nfet L=0.6U W=0.36U AS=0.207P AD=0.0432P PS=1.51U
+ PD=0.6U
* device instance $656 r0 *1 90.06,24.495 nfet
M$656 \$674 \$633 VSS VSS nfet L=0.6U W=0.36U AS=0.2637P AD=0.0432P PS=1.825U
+ PD=0.6U
* device instance $657 r0 *1 91.62,24.495 nfet
M$657 \$633 \$653 VSS VSS nfet L=0.6U W=0.36U AS=0.2637P AD=0.0936P PS=1.825U
+ PD=0.88U
* device instance $658 r0 *1 92.74,24.495 nfet
M$658 \$634 \$632 \$633 VSS nfet L=0.6U W=0.36U AS=0.0936P AD=0.0936P PS=0.88U
+ PD=0.88U
* device instance $659 r0 *1 93.86,24.495 nfet
M$659 \$675 \$631 \$634 VSS nfet L=0.6U W=0.36U AS=0.0936P AD=0.0432P PS=0.88U
+ PD=0.6U
* device instance $660 r0 *1 94.7,24.495 nfet
M$660 \$675 \$635 VSS VSS nfet L=0.6U W=0.36U AS=0.142P AD=0.0432P PS=1.14U
+ PD=0.6U
* device instance $661 r0 *1 96.04,24.475 nfet
M$661 \$635 \$634 VSS VSS nfet L=0.6U W=0.4U AS=0.142P AD=0.176P PS=1.14U
+ PD=1.68U
* device instance $662 r0 *1 93.5,30.66 nfet
M$662 \$773 q5 VSS VSS nfet L=0.6U W=0.36U AS=0.218P AD=0.0432P PS=1.52U PD=0.6U
* device instance $663 r0 *1 94.34,30.66 nfet
M$663 \$719 ph[14] \$773 VSS nfet L=0.6U W=0.36U AS=0.0432P AD=0.0936P PS=0.6U
+ PD=0.88U
* device instance $664 r0 *1 95.46,30.66 nfet
M$664 \$774 \$687 \$719 VSS nfet L=0.6U W=0.36U AS=0.0936P AD=0.0432P PS=0.88U
+ PD=0.6U
* device instance $665 r0 *1 96.3,30.66 nfet
M$665 VSS c5_r \$774 VSS nfet L=0.6U W=0.36U AS=0.0432P AD=0.0936P PS=0.6U
+ PD=0.88U
* device instance $666 r0 *1 97.42,30.66 nfet
M$666 \$687 ph[14] VSS VSS nfet L=0.6U W=0.36U AS=0.0936P AD=0.1584P PS=0.88U
+ PD=1.6U
* device instance $667 r0 *1 92.2,30.61 nfet
M$667 VSS \$719 \_024_ VSS nfet L=0.6U W=0.82U AS=0.3608P AD=0.218P PS=2.52U
+ PD=1.52U
* device instance $668 r0 *1 111.42,30.66 nfet
M$668 \$775 q1 VSS VSS nfet L=0.6U W=0.36U AS=0.218P AD=0.0432P PS=1.52U PD=0.6U
* device instance $669 r0 *1 112.26,30.66 nfet
M$669 \$720 ph[14] \$775 VSS nfet L=0.6U W=0.36U AS=0.0432P AD=0.0936P PS=0.6U
+ PD=0.88U
* device instance $670 r0 *1 113.38,30.66 nfet
M$670 \$776 \$688 \$720 VSS nfet L=0.6U W=0.36U AS=0.0936P AD=0.0432P PS=0.88U
+ PD=0.6U
* device instance $671 r0 *1 114.22,30.66 nfet
M$671 VSS c1_r \$776 VSS nfet L=0.6U W=0.36U AS=0.0432P AD=0.0936P PS=0.6U
+ PD=0.88U
* device instance $672 r0 *1 115.34,30.66 nfet
M$672 \$688 ph[14] VSS VSS nfet L=0.6U W=0.36U AS=0.0936P AD=0.1584P PS=0.88U
+ PD=1.6U
* device instance $673 r0 *1 110.12,30.61 nfet
M$673 VSS \$720 \_015_ VSS nfet L=0.6U W=0.82U AS=0.3608P AD=0.218P PS=2.52U
+ PD=1.52U
* device instance $674 r0 *1 128.04,30.4025 nfet
M$674 VSS clknet_2_3__leaf_clk \$722 VSS nfet L=0.6U W=0.405U AS=0.1782P
+ AD=0.1053P PS=1.69U PD=0.925U
* device instance $675 r0 *1 129.16,30.4025 nfet
M$675 \$725 \$722 VSS VSS nfet L=0.6U W=0.405U AS=0.1053P AD=0.1782P PS=0.925U
+ PD=1.69U
* device instance $676 r0 *1 142.22,30.61 nfet
M$676 eng9 \$727 VSS VSS nfet L=0.6U W=0.82U AS=0.3608P AD=0.3608P PS=2.52U
+ PD=2.52U
* device instance $677 r0 *1 143.88,24.495 nfet
M$677 \$671 \$639 VSS VSS nfet L=0.6U W=0.36U AS=0.1584P AD=0.0432P PS=1.6U
+ PD=0.6U
* device instance $678 r0 *1 144.72,24.495 nfet
M$678 \$655 \_006_ \$671 VSS nfet L=0.6U W=0.36U AS=0.0432P AD=0.207P PS=0.6U
+ PD=1.51U
* device instance $679 r0 *1 146.34,24.495 nfet
M$679 \$669 \$640 \$655 VSS nfet L=0.6U W=0.36U AS=0.207P AD=0.0432P PS=1.51U
+ PD=0.6U
* device instance $680 r0 *1 147.18,24.495 nfet
M$680 \$669 \$641 VSS VSS nfet L=0.6U W=0.36U AS=0.2637P AD=0.0432P PS=1.825U
+ PD=0.6U
* device instance $681 r0 *1 148.74,24.495 nfet
M$681 \$641 \$655 VSS VSS nfet L=0.6U W=0.36U AS=0.2637P AD=0.0936P PS=1.825U
+ PD=0.88U
* device instance $682 r0 *1 149.86,24.495 nfet
M$682 \$642 \$640 \$641 VSS nfet L=0.6U W=0.36U AS=0.0936P AD=0.0936P PS=0.88U
+ PD=0.88U
* device instance $683 r0 *1 150.98,24.495 nfet
M$683 \$666 \$639 \$642 VSS nfet L=0.6U W=0.36U AS=0.0936P AD=0.0432P PS=0.88U
+ PD=0.6U
* device instance $684 r0 *1 151.82,24.495 nfet
M$684 \$666 \$643 VSS VSS nfet L=0.6U W=0.36U AS=0.142P AD=0.0432P PS=1.14U
+ PD=0.6U
* device instance $685 r0 *1 153.16,24.475 nfet
M$685 \$643 \$642 VSS VSS nfet L=0.6U W=0.4U AS=0.142P AD=0.176P PS=1.14U
+ PD=1.68U
* device instance $686 r0 *1 144.28,30.61 nfet
M$686 \$728 clknet_0_clk VSS VSS nfet L=0.6U W=0.82U AS=0.3608P AD=0.2132P
+ PS=2.52U PD=1.34U
* device instance $687 r0 *1 145.4,30.61 nfet
M$687 VSS clknet_0_clk \$728 VSS nfet L=0.6U W=0.82U AS=0.2132P AD=0.2132P
+ PS=1.34U PD=1.34U
* device instance $688 r0 *1 146.52,30.61 nfet
M$688 clknet_2_3__leaf_clk \$728 VSS VSS nfet L=0.6U W=0.82U AS=0.2132P
+ AD=0.2132P PS=1.34U PD=1.34U
* device instance $689 r0 *1 147.64,30.61 nfet
M$689 VSS \$728 clknet_2_3__leaf_clk VSS nfet L=0.6U W=0.82U AS=0.2132P
+ AD=0.2132P PS=1.34U PD=1.34U
* device instance $690 r0 *1 148.76,30.61 nfet
M$690 clknet_2_3__leaf_clk \$728 VSS VSS nfet L=0.6U W=0.82U AS=0.2132P
+ AD=0.2132P PS=1.34U PD=1.34U
* device instance $691 r0 *1 149.88,30.61 nfet
M$691 VSS \$728 clknet_2_3__leaf_clk VSS nfet L=0.6U W=0.82U AS=0.2132P
+ AD=0.3608P PS=1.34U PD=2.52U
* device instance $692 r0 *1 152.68,30.44 nfet
M$692 \_049_ ph[8] VSS VSS nfet L=0.6U W=0.48U AS=0.2112P AD=0.2112P PS=1.84U
+ PD=1.84U
* device instance $693 r0 *1 154.92,30.61 nfet
M$693 \$779 cmp VSS VSS nfet L=0.6U W=0.82U AS=0.3608P AD=0.1312P PS=2.52U
+ PD=1.14U
* device instance $694 r0 *1 155.84,30.61 nfet
M$694 \_018_ ph[6] \$779 VSS nfet L=0.6U W=0.82U AS=0.1312P AD=0.2569P PS=1.14U
+ PD=1.56U
* device instance $695 r0 *1 157.18,30.765 nfet
M$695 VSS \_058_ \_018_ VSS nfet L=0.6U W=0.51U AS=0.2569P AD=0.2244P PS=1.56U
+ PD=1.9U
* device instance $696 r0 *1 173.4,30.44 nfet
M$696 \_052_ ph[5] VSS VSS nfet L=0.6U W=0.48U AS=0.2112P AD=0.2112P PS=1.84U
+ PD=1.84U
* device instance $697 r0 *1 179.56,30.44 nfet
M$697 \_053_ ph[4] VSS VSS nfet L=0.6U W=0.48U AS=0.2112P AD=0.2112P PS=1.84U
+ PD=1.84U
* device instance $698 r0 *1 181.8,30.4025 nfet
M$698 VSS clknet_2_3__leaf_clk \$732 VSS nfet L=0.6U W=0.405U AS=0.1782P
+ AD=0.1053P PS=1.69U PD=0.925U
* device instance $699 r0 *1 182.92,30.4025 nfet
M$699 \$735 \$732 VSS VSS nfet L=0.6U W=0.405U AS=0.1053P AD=0.1782P PS=0.925U
+ PD=1.69U
* device instance $700 r0 *1 195.98,30.61 nfet
M$700 ph[5] \$737 VSS VSS nfet L=0.6U W=0.82U AS=0.3608P AD=0.3608P PS=2.52U
+ PD=2.52U
* device instance $701 r0 *1 8.76,30.5525 nfet
M$701 \_009_[9] start VSS VSS nfet L=0.6U W=0.565U AS=0.2486P AD=0.1469P
+ PS=2.01U PD=1.085U
* device instance $702 r0 *1 9.88,30.5525 nfet
M$702 VSS \_049_ \_009_[9] VSS nfet L=0.6U W=0.565U AS=0.1469P AD=0.2486P
+ PS=1.085U PD=2.01U
* device instance $703 r0 *1 12.12,30.5525 nfet
M$703 \_062_ ph[9] VSS VSS nfet L=0.6U W=0.565U AS=0.2486P AD=0.1469P PS=2.01U
+ PD=1.085U
* device instance $704 r0 *1 13.24,30.5525 nfet
M$704 VSS q4 \_062_ VSS nfet L=0.6U W=0.565U AS=0.1469P AD=0.2486P PS=1.085U
+ PD=2.01U
* device instance $705 r0 *1 29.48,30.5525 nfet
M$705 \_060_ q1 VSS VSS nfet L=0.6U W=0.565U AS=0.2486P AD=0.1469P PS=2.01U
+ PD=1.085U
* device instance $706 r0 *1 30.6,30.5525 nfet
M$706 VSS ph[12] \_060_ VSS nfet L=0.6U W=0.565U AS=0.1469P AD=0.2486P
+ PS=1.085U PD=2.01U
* device instance $707 r0 *1 40.12,30.5525 nfet
M$707 \_055_ q0 VSS VSS nfet L=0.6U W=0.565U AS=0.2486P AD=0.1469P PS=2.01U
+ PD=1.085U
* device instance $708 r0 *1 41.24,30.5525 nfet
M$708 VSS ph[13] \_055_ VSS nfet L=0.6U W=0.565U AS=0.1469P AD=0.2486P
+ PS=1.085U PD=2.01U
* device instance $709 r0 *1 117.96,30.5525 nfet
M$709 \_009_[15] start VSS VSS nfet L=0.6U W=0.565U AS=0.2486P AD=0.1469P
+ PS=2.01U PD=1.085U
* device instance $710 r0 *1 119.08,30.5525 nfet
M$710 VSS \_054_ \_009_[15] VSS nfet L=0.6U W=0.565U AS=0.1469P AD=0.2486P
+ PS=1.085U PD=2.01U
* device instance $711 r0 *1 131,30.385 nfet
M$711 \$777 \$722 VSS VSS nfet L=0.6U W=0.36U AS=0.1584P AD=0.0432P PS=1.6U
+ PD=0.6U
* device instance $712 r0 *1 131.84,30.385 nfet
M$712 \$777 \_008_ \$723 VSS nfet L=0.6U W=0.36U AS=0.207P AD=0.0432P PS=1.51U
+ PD=0.6U
* device instance $713 r0 *1 133.46,30.385 nfet
M$713 \$778 \$725 \$723 VSS nfet L=0.6U W=0.36U AS=0.207P AD=0.0432P PS=1.51U
+ PD=0.6U
* device instance $714 r0 *1 134.3,30.385 nfet
M$714 VSS \$724 \$778 VSS nfet L=0.6U W=0.36U AS=0.0432P AD=0.2637P PS=0.6U
+ PD=1.825U
* device instance $715 r0 *1 135.86,30.385 nfet
M$715 \$724 \$723 VSS VSS nfet L=0.6U W=0.36U AS=0.2637P AD=0.0936P PS=1.825U
+ PD=0.88U
* device instance $716 r0 *1 136.98,30.385 nfet
M$716 \$726 \$725 \$724 VSS nfet L=0.6U W=0.36U AS=0.0936P AD=0.0936P PS=0.88U
+ PD=0.88U
* device instance $717 r0 *1 138.1,30.385 nfet
M$717 \$780 \$722 \$726 VSS nfet L=0.6U W=0.36U AS=0.0936P AD=0.0432P PS=0.88U
+ PD=0.6U
* device instance $718 r0 *1 138.94,30.385 nfet
M$718 VSS \$727 \$780 VSS nfet L=0.6U W=0.36U AS=0.0432P AD=0.142P PS=0.6U
+ PD=1.14U
* device instance $719 r0 *1 140.28,30.405 nfet
M$719 \$727 \$726 VSS VSS nfet L=0.6U W=0.4U AS=0.142P AD=0.176P PS=1.14U
+ PD=1.68U
* device instance $720 r0 *1 160.52,30.5525 nfet
M$720 \_059_ ph[8] VSS VSS nfet L=0.6U W=0.565U AS=0.2486P AD=0.1469P PS=2.01U
+ PD=1.085U
* device instance $721 r0 *1 161.64,30.5525 nfet
M$721 VSS q5 \_059_ VSS nfet L=0.6U W=0.565U AS=0.1469P AD=0.2486P PS=1.085U
+ PD=2.01U
* device instance $722 r0 *1 176.2,30.5525 nfet
M$722 \_009_[5] start VSS VSS nfet L=0.6U W=0.565U AS=0.2486P AD=0.1469P
+ PS=2.01U PD=1.085U
* device instance $723 r0 *1 177.32,30.5525 nfet
M$723 VSS \_053_ \_009_[5] VSS nfet L=0.6U W=0.565U AS=0.1469P AD=0.2486P
+ PS=1.085U PD=2.01U
* device instance $724 r0 *1 184.76,30.385 nfet
M$724 \$768 \$732 VSS VSS nfet L=0.6U W=0.36U AS=0.1584P AD=0.0432P PS=1.6U
+ PD=0.6U
* device instance $725 r0 *1 185.6,30.385 nfet
M$725 \$768 \_009_[5] \$733 VSS nfet L=0.6U W=0.36U AS=0.207P AD=0.0432P
+ PS=1.51U PD=0.6U
* device instance $726 r0 *1 187.22,30.385 nfet
M$726 \$767 \$735 \$733 VSS nfet L=0.6U W=0.36U AS=0.207P AD=0.0432P PS=1.51U
+ PD=0.6U
* device instance $727 r0 *1 188.06,30.385 nfet
M$727 VSS \$734 \$767 VSS nfet L=0.6U W=0.36U AS=0.0432P AD=0.2637P PS=0.6U
+ PD=1.825U
* device instance $728 r0 *1 189.62,30.385 nfet
M$728 \$734 \$733 VSS VSS nfet L=0.6U W=0.36U AS=0.2637P AD=0.0936P PS=1.825U
+ PD=0.88U
* device instance $729 r0 *1 190.74,30.385 nfet
M$729 \$736 \$735 \$734 VSS nfet L=0.6U W=0.36U AS=0.0936P AD=0.0936P PS=0.88U
+ PD=0.88U
* device instance $730 r0 *1 191.86,30.385 nfet
M$730 \$765 \$732 \$736 VSS nfet L=0.6U W=0.36U AS=0.0936P AD=0.0432P PS=0.88U
+ PD=0.6U
* device instance $731 r0 *1 192.7,30.385 nfet
M$731 VSS \$737 \$765 VSS nfet L=0.6U W=0.36U AS=0.0432P AD=0.142P PS=0.6U
+ PD=1.14U
* device instance $732 r0 *1 194.04,30.405 nfet
M$732 \$737 \$736 VSS VSS nfet L=0.6U W=0.4U AS=0.142P AD=0.176P PS=1.14U
+ PD=1.68U
* device instance $733 r0 *1 4.84,32.3175 nfet
M$733 VSS clknet_2_1__leaf_clk \$805 VSS nfet L=0.6U W=0.405U AS=0.1782P
+ AD=0.1053P PS=1.69U PD=0.925U
* device instance $734 r0 *1 5.96,32.3175 nfet
M$734 \$781 \$805 VSS VSS nfet L=0.6U W=0.405U AS=0.1053P AD=0.1782P PS=0.925U
+ PD=1.69U
* device instance $735 r0 *1 7.8,32.335 nfet
M$735 \$827 \$805 VSS VSS nfet L=0.6U W=0.36U AS=0.1584P AD=0.0432P PS=1.6U
+ PD=0.6U
* device instance $736 r0 *1 8.64,32.335 nfet
M$736 \$806 \_025_ \$827 VSS nfet L=0.6U W=0.36U AS=0.0432P AD=0.207P PS=0.6U
+ PD=1.51U
* device instance $737 r0 *1 10.26,32.335 nfet
M$737 \$829 \$781 \$806 VSS nfet L=0.6U W=0.36U AS=0.207P AD=0.0432P PS=1.51U
+ PD=0.6U
* device instance $738 r0 *1 11.1,32.335 nfet
M$738 \$829 \$782 VSS VSS nfet L=0.6U W=0.36U AS=0.2637P AD=0.0432P PS=1.825U
+ PD=0.6U
* device instance $739 r0 *1 12.66,32.335 nfet
M$739 \$782 \$806 VSS VSS nfet L=0.6U W=0.36U AS=0.2637P AD=0.0936P PS=1.825U
+ PD=0.88U
* device instance $740 r0 *1 13.78,32.335 nfet
M$740 \$807 \$781 \$782 VSS nfet L=0.6U W=0.36U AS=0.0936P AD=0.0936P PS=0.88U
+ PD=0.88U
* device instance $741 r0 *1 14.9,32.335 nfet
M$741 \$830 \$805 \$807 VSS nfet L=0.6U W=0.36U AS=0.0936P AD=0.0432P PS=0.88U
+ PD=0.6U
* device instance $742 r0 *1 15.74,32.335 nfet
M$742 \$830 \$783 VSS VSS nfet L=0.6U W=0.36U AS=0.142P AD=0.0432P PS=1.14U
+ PD=0.6U
* device instance $743 r0 *1 17.08,32.315 nfet
M$743 \$783 \$807 VSS VSS nfet L=0.6U W=0.4U AS=0.142P AD=0.176P PS=1.14U
+ PD=1.68U
* device instance $744 r0 *1 19.02,32.11 nfet
M$744 q4 \$783 VSS VSS nfet L=0.6U W=0.82U AS=0.3608P AD=0.3608P PS=2.52U
+ PD=2.52U
* device instance $745 r0 *1 27.24,32.3175 nfet
M$745 VSS clknet_2_1__leaf_clk \$808 VSS nfet L=0.6U W=0.405U AS=0.1782P
+ AD=0.1053P PS=1.69U PD=0.925U
* device instance $746 r0 *1 28.36,32.3175 nfet
M$746 \$784 \$808 VSS VSS nfet L=0.6U W=0.405U AS=0.1053P AD=0.1782P PS=0.925U
+ PD=1.69U
* device instance $747 r0 *1 30.2,32.335 nfet
M$747 \$833 \$808 VSS VSS nfet L=0.6U W=0.36U AS=0.1584P AD=0.0432P PS=1.6U
+ PD=0.6U
* device instance $748 r0 *1 31.04,32.335 nfet
M$748 \$809 \_009_[13] \$833 VSS nfet L=0.6U W=0.36U AS=0.0432P AD=0.207P
+ PS=0.6U PD=1.51U
* device instance $749 r0 *1 32.66,32.335 nfet
M$749 \$834 \$784 \$809 VSS nfet L=0.6U W=0.36U AS=0.207P AD=0.0432P PS=1.51U
+ PD=0.6U
* device instance $750 r0 *1 33.5,32.335 nfet
M$750 \$834 \$785 VSS VSS nfet L=0.6U W=0.36U AS=0.2637P AD=0.0432P PS=1.825U
+ PD=0.6U
* device instance $751 r0 *1 35.06,32.335 nfet
M$751 \$785 \$809 VSS VSS nfet L=0.6U W=0.36U AS=0.2637P AD=0.0936P PS=1.825U
+ PD=0.88U
* device instance $752 r0 *1 36.18,32.335 nfet
M$752 \$810 \$784 \$785 VSS nfet L=0.6U W=0.36U AS=0.0936P AD=0.0936P PS=0.88U
+ PD=0.88U
* device instance $753 r0 *1 37.3,32.335 nfet
M$753 \$835 \$808 \$810 VSS nfet L=0.6U W=0.36U AS=0.0936P AD=0.0432P PS=0.88U
+ PD=0.6U
* device instance $754 r0 *1 38.14,32.335 nfet
M$754 \$835 \$786 VSS VSS nfet L=0.6U W=0.36U AS=0.142P AD=0.0432P PS=1.14U
+ PD=0.6U
* device instance $755 r0 *1 39.48,32.315 nfet
M$755 \$786 \$810 VSS VSS nfet L=0.6U W=0.4U AS=0.142P AD=0.176P PS=1.14U
+ PD=1.68U
* device instance $756 r0 *1 41.42,32.11 nfet
M$756 ph[13] \$786 VSS VSS nfet L=0.6U W=0.82U AS=0.3608P AD=0.3608P PS=2.52U
+ PD=2.52U
* device instance $757 r0 *1 47.96,32.1675 nfet
M$757 \_009_[14] start VSS VSS nfet L=0.6U W=0.565U AS=0.2486P AD=0.1469P
+ PS=2.01U PD=1.085U
* device instance $758 r0 *1 49.08,32.1675 nfet
M$758 VSS \_045_ \_009_[14] VSS nfet L=0.6U W=0.565U AS=0.1469P AD=0.2486P
+ PS=1.085U PD=2.01U
* device instance $759 r0 *1 51.32,32.3175 nfet
M$759 VSS clknet_2_1__leaf_clk \$811 VSS nfet L=0.6U W=0.405U AS=0.1782P
+ AD=0.1053P PS=1.69U PD=0.925U
* device instance $760 r0 *1 52.44,32.3175 nfet
M$760 \$788 \$811 VSS VSS nfet L=0.6U W=0.405U AS=0.1053P AD=0.1782P PS=0.925U
+ PD=1.69U
* device instance $761 r0 *1 54.28,32.335 nfet
M$761 \$838 \$811 VSS VSS nfet L=0.6U W=0.36U AS=0.1584P AD=0.0432P PS=1.6U
+ PD=0.6U
* device instance $762 r0 *1 55.12,32.335 nfet
M$762 \$812 \_013_ \$838 VSS nfet L=0.6U W=0.36U AS=0.0432P AD=0.207P PS=0.6U
+ PD=1.51U
* device instance $763 r0 *1 56.74,32.335 nfet
M$763 \$839 \$788 \$812 VSS nfet L=0.6U W=0.36U AS=0.207P AD=0.0432P PS=1.51U
+ PD=0.6U
* device instance $764 r0 *1 57.58,32.335 nfet
M$764 \$839 \$789 VSS VSS nfet L=0.6U W=0.36U AS=0.2637P AD=0.0432P PS=1.825U
+ PD=0.6U
* device instance $765 r0 *1 59.14,32.335 nfet
M$765 \$789 \$812 VSS VSS nfet L=0.6U W=0.36U AS=0.2637P AD=0.0936P PS=1.825U
+ PD=0.88U
* device instance $766 r0 *1 60.26,32.335 nfet
M$766 \$813 \$788 \$789 VSS nfet L=0.6U W=0.36U AS=0.0936P AD=0.0936P PS=0.88U
+ PD=0.88U
* device instance $767 r0 *1 61.38,32.335 nfet
M$767 \$841 \$811 \$813 VSS nfet L=0.6U W=0.36U AS=0.0936P AD=0.0432P PS=0.88U
+ PD=0.6U
* device instance $768 r0 *1 62.22,32.335 nfet
M$768 \$841 \$790 VSS VSS nfet L=0.6U W=0.36U AS=0.142P AD=0.0432P PS=1.14U
+ PD=0.6U
* device instance $769 r0 *1 63.56,32.315 nfet
M$769 \$790 \$813 VSS VSS nfet L=0.6U W=0.4U AS=0.142P AD=0.176P PS=1.14U
+ PD=1.68U
* device instance $770 r0 *1 65.5,32.11 nfet
M$770 c0_r \$790 VSS VSS nfet L=0.6U W=0.82U AS=0.3608P AD=0.3608P PS=2.52U
+ PD=2.52U
* device instance $771 r0 *1 76.52,32.3175 nfet
M$771 VSS clknet_2_1__leaf_clk \$814 VSS nfet L=0.6U W=0.405U AS=0.1782P
+ AD=0.1053P PS=1.69U PD=0.925U
* device instance $772 r0 *1 77.64,32.3175 nfet
M$772 \$791 \$814 VSS VSS nfet L=0.6U W=0.405U AS=0.1053P AD=0.1782P PS=0.925U
+ PD=1.69U
* device instance $773 r0 *1 79.48,32.335 nfet
M$773 \$842 \$814 VSS VSS nfet L=0.6U W=0.36U AS=0.1584P AD=0.0432P PS=1.6U
+ PD=0.6U
* device instance $774 r0 *1 80.32,32.335 nfet
M$774 \$815 \_011_ \$842 VSS nfet L=0.6U W=0.36U AS=0.0432P AD=0.207P PS=0.6U
+ PD=1.51U
* device instance $775 r0 *1 81.94,32.335 nfet
M$775 \$844 \$791 \$815 VSS nfet L=0.6U W=0.36U AS=0.207P AD=0.0432P PS=1.51U
+ PD=0.6U
* device instance $776 r0 *1 82.78,32.335 nfet
M$776 \$844 \$792 VSS VSS nfet L=0.6U W=0.36U AS=0.2637P AD=0.0432P PS=1.825U
+ PD=0.6U
* device instance $777 r0 *1 84.34,32.335 nfet
M$777 \$792 \$815 VSS VSS nfet L=0.6U W=0.36U AS=0.2637P AD=0.0936P PS=1.825U
+ PD=0.88U
* device instance $778 r0 *1 85.46,32.335 nfet
M$778 \$816 \$791 \$792 VSS nfet L=0.6U W=0.36U AS=0.0936P AD=0.0936P PS=0.88U
+ PD=0.88U
* device instance $779 r0 *1 86.58,32.335 nfet
M$779 \$845 \$814 \$816 VSS nfet L=0.6U W=0.36U AS=0.0936P AD=0.0432P PS=0.88U
+ PD=0.6U
* device instance $780 r0 *1 87.42,32.335 nfet
M$780 \$845 \$793 VSS VSS nfet L=0.6U W=0.36U AS=0.142P AD=0.0432P PS=1.14U
+ PD=0.6U
* device instance $781 r0 *1 88.76,32.315 nfet
M$781 \$793 \$816 VSS VSS nfet L=0.6U W=0.4U AS=0.142P AD=0.176P PS=1.14U
+ PD=1.68U
* device instance $782 r0 *1 90.7,32.11 nfet
M$782 c9_r \$793 VSS VSS nfet L=0.6U W=0.82U AS=0.3608P AD=0.3608P PS=2.52U
+ PD=2.52U
* device instance $783 r0 *1 92.76,32.11 nfet
M$783 \$760 clk VSS VSS nfet L=0.6U W=0.82U AS=0.3608P AD=0.2132P PS=2.52U
+ PD=1.34U
* device instance $784 r0 *1 93.88,32.11 nfet
M$784 VSS clk \$760 VSS nfet L=0.6U W=0.82U AS=0.2132P AD=0.2132P PS=1.34U
+ PD=1.34U
* device instance $785 r0 *1 95,32.11 nfet
M$785 clknet_0_clk \$760 VSS VSS nfet L=0.6U W=0.82U AS=0.2132P AD=0.2132P
+ PS=1.34U PD=1.34U
* device instance $786 r0 *1 96.12,32.11 nfet
M$786 VSS \$760 clknet_0_clk VSS nfet L=0.6U W=0.82U AS=0.2132P AD=0.2132P
+ PS=1.34U PD=1.34U
* device instance $787 r0 *1 97.24,32.11 nfet
M$787 clknet_0_clk \$760 VSS VSS nfet L=0.6U W=0.82U AS=0.2132P AD=0.2132P
+ PS=1.34U PD=1.34U
* device instance $788 r0 *1 98.36,32.11 nfet
M$788 VSS \$760 clknet_0_clk VSS nfet L=0.6U W=0.82U AS=0.2132P AD=0.3608P
+ PS=1.34U PD=2.52U
* device instance $789 r0 *1 111.42,32.06 nfet
M$789 \$848 q7 VSS VSS nfet L=0.6U W=0.36U AS=0.218P AD=0.0432P PS=1.52U PD=0.6U
* device instance $790 r0 *1 112.26,32.06 nfet
M$790 \$761 ph[14] \$848 VSS nfet L=0.6U W=0.36U AS=0.0432P AD=0.0936P PS=0.6U
+ PD=0.88U
* device instance $791 r0 *1 113.38,32.06 nfet
M$791 \$849 \$762 \$761 VSS nfet L=0.6U W=0.36U AS=0.0936P AD=0.0432P PS=0.88U
+ PD=0.6U
* device instance $792 r0 *1 114.22,32.06 nfet
M$792 VSS c7_r \$849 VSS nfet L=0.6U W=0.36U AS=0.0432P AD=0.0936P PS=0.6U
+ PD=0.88U
* device instance $793 r0 *1 115.34,32.06 nfet
M$793 \$762 ph[14] VSS VSS nfet L=0.6U W=0.36U AS=0.0936P AD=0.1584P PS=0.88U
+ PD=1.6U
* device instance $794 r0 *1 110.12,32.11 nfet
M$794 VSS \$761 \_028_ VSS nfet L=0.6U W=0.82U AS=0.3608P AD=0.218P PS=2.52U
+ PD=1.52U
* device instance $795 r0 *1 118.52,32.3175 nfet
M$795 VSS clknet_2_3__leaf_clk \$818 VSS nfet L=0.6U W=0.405U AS=0.1782P
+ AD=0.1053P PS=1.69U PD=0.925U
* device instance $796 r0 *1 119.64,32.3175 nfet
M$796 \$795 \$818 VSS VSS nfet L=0.6U W=0.405U AS=0.1053P AD=0.1782P PS=0.925U
+ PD=1.69U
* device instance $797 r0 *1 121.48,32.335 nfet
M$797 \$847 \$818 VSS VSS nfet L=0.6U W=0.36U AS=0.1584P AD=0.0432P PS=1.6U
+ PD=0.6U
* device instance $798 r0 *1 122.32,32.335 nfet
M$798 \$819 \_009_[15] \$847 VSS nfet L=0.6U W=0.36U AS=0.0432P AD=0.207P
+ PS=0.6U PD=1.51U
* device instance $799 r0 *1 123.94,32.335 nfet
M$799 \$846 \$795 \$819 VSS nfet L=0.6U W=0.36U AS=0.207P AD=0.0432P PS=1.51U
+ PD=0.6U
* device instance $800 r0 *1 124.78,32.335 nfet
M$800 \$846 \$796 VSS VSS nfet L=0.6U W=0.36U AS=0.2637P AD=0.0432P PS=1.825U
+ PD=0.6U
* device instance $801 r0 *1 126.34,32.335 nfet
M$801 \$796 \$819 VSS VSS nfet L=0.6U W=0.36U AS=0.2637P AD=0.0936P PS=1.825U
+ PD=0.88U
* device instance $802 r0 *1 127.46,32.335 nfet
M$802 \$820 \$795 \$796 VSS nfet L=0.6U W=0.36U AS=0.0936P AD=0.0936P PS=0.88U
+ PD=0.88U
* device instance $803 r0 *1 128.58,32.335 nfet
M$803 \$843 \$818 \$820 VSS nfet L=0.6U W=0.36U AS=0.0936P AD=0.0432P PS=0.88U
+ PD=0.6U
* device instance $804 r0 *1 129.42,32.335 nfet
M$804 \$843 \$797 VSS VSS nfet L=0.6U W=0.36U AS=0.142P AD=0.0432P PS=1.14U
+ PD=0.6U
* device instance $805 r0 *1 130.76,32.315 nfet
M$805 \$797 \$820 VSS VSS nfet L=0.6U W=0.4U AS=0.142P AD=0.176P PS=1.14U
+ PD=1.68U
* device instance $806 r0 *1 132.7,32.11 nfet
M$806 ph[15] \$797 VSS VSS nfet L=0.6U W=0.82U AS=0.3608P AD=0.3608P PS=2.52U
+ PD=2.52U
* device instance $807 r0 *1 148.2,32.3175 nfet
M$807 VSS clknet_2_3__leaf_clk \$821 VSS nfet L=0.6U W=0.405U AS=0.1782P
+ AD=0.1053P PS=1.69U PD=0.925U
* device instance $808 r0 *1 149.32,32.3175 nfet
M$808 \$798 \$821 VSS VSS nfet L=0.6U W=0.405U AS=0.1053P AD=0.1782P PS=0.925U
+ PD=1.69U
* device instance $809 r0 *1 151.16,32.335 nfet
M$809 \$840 \$821 VSS VSS nfet L=0.6U W=0.36U AS=0.1584P AD=0.0432P PS=1.6U
+ PD=0.6U
* device instance $810 r0 *1 152,32.335 nfet
M$810 \$822 \_009_[8] \$840 VSS nfet L=0.6U W=0.36U AS=0.0432P AD=0.207P
+ PS=0.6U PD=1.51U
* device instance $811 r0 *1 153.62,32.335 nfet
M$811 \$837 \$798 \$822 VSS nfet L=0.6U W=0.36U AS=0.207P AD=0.0432P PS=1.51U
+ PD=0.6U
* device instance $812 r0 *1 154.46,32.335 nfet
M$812 \$837 \$799 VSS VSS nfet L=0.6U W=0.36U AS=0.2637P AD=0.0432P PS=1.825U
+ PD=0.6U
* device instance $813 r0 *1 156.02,32.335 nfet
M$813 \$799 \$822 VSS VSS nfet L=0.6U W=0.36U AS=0.2637P AD=0.0936P PS=1.825U
+ PD=0.88U
* device instance $814 r0 *1 157.14,32.335 nfet
M$814 \$823 \$798 \$799 VSS nfet L=0.6U W=0.36U AS=0.0936P AD=0.0936P PS=0.88U
+ PD=0.88U
* device instance $815 r0 *1 158.26,32.335 nfet
M$815 \$836 \$821 \$823 VSS nfet L=0.6U W=0.36U AS=0.0936P AD=0.0432P PS=0.88U
+ PD=0.6U
* device instance $816 r0 *1 159.1,32.335 nfet
M$816 \$836 \$800 VSS VSS nfet L=0.6U W=0.36U AS=0.142P AD=0.0432P PS=1.14U
+ PD=0.6U
* device instance $817 r0 *1 160.44,32.315 nfet
M$817 \$800 \$823 VSS VSS nfet L=0.6U W=0.4U AS=0.142P AD=0.176P PS=1.14U
+ PD=1.68U
* device instance $818 r0 *1 162.38,32.11 nfet
M$818 ph[8] \$800 VSS VSS nfet L=0.6U W=0.82U AS=0.3608P AD=0.3608P PS=2.52U
+ PD=2.52U
* device instance $819 r0 *1 177.32,32.3175 nfet
M$819 VSS clknet_2_3__leaf_clk \$824 VSS nfet L=0.6U W=0.405U AS=0.1782P
+ AD=0.1053P PS=1.69U PD=0.925U
* device instance $820 r0 *1 178.44,32.3175 nfet
M$820 \$801 \$824 VSS VSS nfet L=0.6U W=0.405U AS=0.1053P AD=0.1782P PS=0.925U
+ PD=1.69U
* device instance $821 r0 *1 180.28,32.335 nfet
M$821 \$832 \$824 VSS VSS nfet L=0.6U W=0.36U AS=0.1584P AD=0.0432P PS=1.6U
+ PD=0.6U
* device instance $822 r0 *1 181.12,32.335 nfet
M$822 \$825 \_009_[2] \$832 VSS nfet L=0.6U W=0.36U AS=0.0432P AD=0.207P
+ PS=0.6U PD=1.51U
* device instance $823 r0 *1 182.74,32.335 nfet
M$823 \$831 \$801 \$825 VSS nfet L=0.6U W=0.36U AS=0.207P AD=0.0432P PS=1.51U
+ PD=0.6U
* device instance $824 r0 *1 183.58,32.335 nfet
M$824 \$831 \$802 VSS VSS nfet L=0.6U W=0.36U AS=0.2637P AD=0.0432P PS=1.825U
+ PD=0.6U
* device instance $825 r0 *1 185.14,32.335 nfet
M$825 \$802 \$825 VSS VSS nfet L=0.6U W=0.36U AS=0.2637P AD=0.0936P PS=1.825U
+ PD=0.88U
* device instance $826 r0 *1 186.26,32.335 nfet
M$826 \$826 \$801 \$802 VSS nfet L=0.6U W=0.36U AS=0.0936P AD=0.0936P PS=0.88U
+ PD=0.88U
* device instance $827 r0 *1 187.38,32.335 nfet
M$827 \$828 \$824 \$826 VSS nfet L=0.6U W=0.36U AS=0.0936P AD=0.0432P PS=0.88U
+ PD=0.6U
* device instance $828 r0 *1 188.22,32.335 nfet
M$828 \$828 \$803 VSS VSS nfet L=0.6U W=0.36U AS=0.142P AD=0.0432P PS=1.14U
+ PD=0.6U
* device instance $829 r0 *1 189.56,32.315 nfet
M$829 \$803 \$826 VSS VSS nfet L=0.6U W=0.4U AS=0.142P AD=0.176P PS=1.14U
+ PD=1.68U
* device instance $830 r0 *1 191.5,32.11 nfet
M$830 ph[2] \$803 VSS VSS nfet L=0.6U W=0.82U AS=0.3608P AD=0.3608P PS=2.52U
+ PD=2.52U
* device instance $831 r0 *1 2.04,38.2425 nfet
M$831 VSS clknet_2_1__leaf_clk \$875 VSS nfet L=0.6U W=0.405U AS=0.1782P
+ AD=0.1053P PS=1.69U PD=0.925U
* device instance $832 r0 *1 3.16,38.2425 nfet
M$832 \$877 \$875 VSS VSS nfet L=0.6U W=0.405U AS=0.1053P AD=0.1782P PS=0.925U
+ PD=1.69U
* device instance $833 r0 *1 5,38.225 nfet
M$833 \$943 \$875 VSS VSS nfet L=0.6U W=0.36U AS=0.1584P AD=0.0432P PS=1.6U
+ PD=0.6U
* device instance $834 r0 *1 5.84,38.225 nfet
M$834 \$943 \_009_[9] \$906 VSS nfet L=0.6U W=0.36U AS=0.207P AD=0.0432P
+ PS=1.51U PD=0.6U
* device instance $835 r0 *1 7.46,38.225 nfet
M$835 \$944 \$877 \$906 VSS nfet L=0.6U W=0.36U AS=0.207P AD=0.0432P PS=1.51U
+ PD=0.6U
* device instance $836 r0 *1 8.3,38.225 nfet
M$836 VSS \$876 \$944 VSS nfet L=0.6U W=0.36U AS=0.0432P AD=0.2637P PS=0.6U
+ PD=1.825U
* device instance $837 r0 *1 9.86,38.225 nfet
M$837 \$876 \$906 VSS VSS nfet L=0.6U W=0.36U AS=0.2637P AD=0.0936P PS=1.825U
+ PD=0.88U
* device instance $838 r0 *1 10.98,38.225 nfet
M$838 \$907 \$877 \$876 VSS nfet L=0.6U W=0.36U AS=0.0936P AD=0.0936P PS=0.88U
+ PD=0.88U
* device instance $839 r0 *1 12.1,38.225 nfet
M$839 \$945 \$875 \$907 VSS nfet L=0.6U W=0.36U AS=0.0936P AD=0.0432P PS=0.88U
+ PD=0.6U
* device instance $840 r0 *1 12.94,38.225 nfet
M$840 VSS \$878 \$945 VSS nfet L=0.6U W=0.36U AS=0.0432P AD=0.142P PS=0.6U
+ PD=1.14U
* device instance $841 r0 *1 14.28,38.245 nfet
M$841 \$878 \$907 VSS VSS nfet L=0.6U W=0.4U AS=0.142P AD=0.176P PS=1.14U
+ PD=1.68U
* device instance $842 r0 *1 16.22,38.45 nfet
M$842 ph[9] \$878 VSS VSS nfet L=0.6U W=0.82U AS=0.3608P AD=0.3608P PS=2.52U
+ PD=2.52U
* device instance $843 r0 *1 21.64,38.2425 nfet
M$843 VSS clknet_2_1__leaf_clk \$879 VSS nfet L=0.6U W=0.405U AS=0.1782P
+ AD=0.1053P PS=1.69U PD=0.925U
* device instance $844 r0 *1 22.76,38.2425 nfet
M$844 \$881 \$879 VSS VSS nfet L=0.6U W=0.405U AS=0.1053P AD=0.1782P PS=0.925U
+ PD=1.69U
* device instance $845 r0 *1 24.6,38.225 nfet
M$845 \$946 \$879 VSS VSS nfet L=0.6U W=0.36U AS=0.1584P AD=0.0432P PS=1.6U
+ PD=0.6U
* device instance $846 r0 *1 25.44,38.225 nfet
M$846 \$946 \_020_ \$908 VSS nfet L=0.6U W=0.36U AS=0.207P AD=0.0432P PS=1.51U
+ PD=0.6U
* device instance $847 r0 *1 27.06,38.225 nfet
M$847 \$947 \$881 \$908 VSS nfet L=0.6U W=0.36U AS=0.207P AD=0.0432P PS=1.51U
+ PD=0.6U
* device instance $848 r0 *1 27.9,38.225 nfet
M$848 VSS \$880 \$947 VSS nfet L=0.6U W=0.36U AS=0.0432P AD=0.2637P PS=0.6U
+ PD=1.825U
* device instance $849 r0 *1 29.46,38.225 nfet
M$849 \$880 \$908 VSS VSS nfet L=0.6U W=0.36U AS=0.2637P AD=0.0936P PS=1.825U
+ PD=0.88U
* device instance $850 r0 *1 30.58,38.225 nfet
M$850 \$909 \$881 \$880 VSS nfet L=0.6U W=0.36U AS=0.0936P AD=0.0936P PS=0.88U
+ PD=0.88U
* device instance $851 r0 *1 31.7,38.225 nfet
M$851 \$948 \$879 \$909 VSS nfet L=0.6U W=0.36U AS=0.0936P AD=0.0432P PS=0.88U
+ PD=0.6U
* device instance $852 r0 *1 32.54,38.225 nfet
M$852 VSS \$882 \$948 VSS nfet L=0.6U W=0.36U AS=0.0432P AD=0.142P PS=0.6U
+ PD=1.14U
* device instance $853 r0 *1 33.88,38.245 nfet
M$853 \$882 \$909 VSS VSS nfet L=0.6U W=0.4U AS=0.142P AD=0.176P PS=1.14U
+ PD=1.68U
* device instance $854 r0 *1 35.82,38.45 nfet
M$854 q1 \$882 VSS VSS nfet L=0.6U W=0.82U AS=0.3608P AD=0.3608P PS=2.52U
+ PD=2.52U
* device instance $855 r0 *1 40.12,38.45 nfet
M$855 \$883 clknet_2_0__leaf_clk VSS VSS nfet L=0.6U W=0.82U AS=0.3608P
+ AD=0.2132P PS=2.52U PD=1.34U
* device instance $856 r0 *1 41.24,38.45 nfet
M$856 VSS clknet_2_0__leaf_clk \$883 VSS nfet L=0.6U W=0.82U AS=0.2132P
+ AD=0.2132P PS=1.34U PD=1.34U
* device instance $857 r0 *1 42.36,38.45 nfet
M$857 Z \$883 VSS VSS nfet L=0.6U W=0.82U AS=0.2132P AD=0.2132P PS=1.34U
+ PD=1.34U
* device instance $858 r0 *1 43.48,38.45 nfet
M$858 VSS \$883 Z VSS nfet L=0.6U W=0.82U AS=0.2132P AD=0.2132P PS=1.34U
+ PD=1.34U
* device instance $859 r0 *1 44.6,38.45 nfet
M$859 Z \$883 VSS VSS nfet L=0.6U W=0.82U AS=0.2132P AD=0.2132P PS=1.34U
+ PD=1.34U
* device instance $860 r0 *1 45.72,38.45 nfet
M$860 VSS \$883 Z VSS nfet L=0.6U W=0.82U AS=0.2132P AD=0.3608P PS=1.34U
+ PD=2.52U
* device instance $861 r0 *1 47.96,38.2425 nfet
M$861 VSS clknet_2_1__leaf_clk \$885 VSS nfet L=0.6U W=0.405U AS=0.1782P
+ AD=0.1053P PS=1.69U PD=0.925U
* device instance $862 r0 *1 49.08,38.2425 nfet
M$862 \$887 \$885 VSS VSS nfet L=0.6U W=0.405U AS=0.1053P AD=0.1782P PS=0.925U
+ PD=1.69U
* device instance $863 r0 *1 50.92,38.225 nfet
M$863 \$949 \$885 VSS VSS nfet L=0.6U W=0.36U AS=0.1584P AD=0.0432P PS=1.6U
+ PD=0.6U
* device instance $864 r0 *1 51.76,38.225 nfet
M$864 \$949 \_009_[14] \$910 VSS nfet L=0.6U W=0.36U AS=0.207P AD=0.0432P
+ PS=1.51U PD=0.6U
* device instance $865 r0 *1 53.38,38.225 nfet
M$865 \$950 \$887 \$910 VSS nfet L=0.6U W=0.36U AS=0.207P AD=0.0432P PS=1.51U
+ PD=0.6U
* device instance $866 r0 *1 54.22,38.225 nfet
M$866 VSS \$886 \$950 VSS nfet L=0.6U W=0.36U AS=0.0432P AD=0.2637P PS=0.6U
+ PD=1.825U
* device instance $867 r0 *1 55.78,38.225 nfet
M$867 \$886 \$910 VSS VSS nfet L=0.6U W=0.36U AS=0.2637P AD=0.0936P PS=1.825U
+ PD=0.88U
* device instance $868 r0 *1 56.9,38.225 nfet
M$868 \$911 \$887 \$886 VSS nfet L=0.6U W=0.36U AS=0.0936P AD=0.0936P PS=0.88U
+ PD=0.88U
* device instance $869 r0 *1 58.02,38.225 nfet
M$869 \$951 \$885 \$911 VSS nfet L=0.6U W=0.36U AS=0.0936P AD=0.0432P PS=0.88U
+ PD=0.6U
* device instance $870 r0 *1 58.86,38.225 nfet
M$870 VSS \$888 \$951 VSS nfet L=0.6U W=0.36U AS=0.0432P AD=0.142P PS=0.6U
+ PD=1.14U
* device instance $871 r0 *1 60.2,38.245 nfet
M$871 \$888 \$911 VSS VSS nfet L=0.6U W=0.4U AS=0.142P AD=0.176P PS=1.14U
+ PD=1.68U
* device instance $872 r0 *1 62.14,38.45 nfet
M$872 ph[14] \$888 VSS VSS nfet L=0.6U W=0.82U AS=0.3608P AD=0.3608P PS=2.52U
+ PD=2.52U
* device instance $873 r0 *1 65.5,38.5 nfet
M$873 \$952 q3 VSS VSS nfet L=0.6U W=0.36U AS=0.218P AD=0.0432P PS=1.52U PD=0.6U
* device instance $874 r0 *1 66.34,38.5 nfet
M$874 \$889 ph[14] \$952 VSS nfet L=0.6U W=0.36U AS=0.0432P AD=0.0936P PS=0.6U
+ PD=0.88U
* device instance $875 r0 *1 67.46,38.5 nfet
M$875 \$953 \$850 \$889 VSS nfet L=0.6U W=0.36U AS=0.0936P AD=0.0432P PS=0.88U
+ PD=0.6U
* device instance $876 r0 *1 68.3,38.5 nfet
M$876 VSS c3_r \$953 VSS nfet L=0.6U W=0.36U AS=0.0432P AD=0.0936P PS=0.6U
+ PD=0.88U
* device instance $877 r0 *1 69.42,38.5 nfet
M$877 \$850 ph[14] VSS VSS nfet L=0.6U W=0.36U AS=0.0936P AD=0.1584P PS=0.88U
+ PD=1.6U
* device instance $878 r0 *1 64.2,38.45 nfet
M$878 VSS \$889 \_021_ VSS nfet L=0.6U W=0.82U AS=0.3608P AD=0.218P PS=2.52U
+ PD=1.52U
* device instance $879 r0 *1 73.16,38.2425 nfet
M$879 VSS clknet_2_1__leaf_clk \$890 VSS nfet L=0.6U W=0.405U AS=0.1782P
+ AD=0.1053P PS=1.69U PD=0.925U
* device instance $880 r0 *1 74.28,38.2425 nfet
M$880 \$892 \$890 VSS VSS nfet L=0.6U W=0.405U AS=0.1053P AD=0.1782P PS=0.925U
+ PD=1.69U
* device instance $881 r0 *1 76.12,38.225 nfet
M$881 \$954 \$890 VSS VSS nfet L=0.6U W=0.36U AS=0.1584P AD=0.0432P PS=1.6U
+ PD=0.6U
* device instance $882 r0 *1 76.96,38.225 nfet
M$882 \$954 \_010_ \$912 VSS nfet L=0.6U W=0.36U AS=0.207P AD=0.0432P PS=1.51U
+ PD=0.6U
* device instance $883 r0 *1 78.58,38.225 nfet
M$883 \$955 \$892 \$912 VSS nfet L=0.6U W=0.36U AS=0.207P AD=0.0432P PS=1.51U
+ PD=0.6U
* device instance $884 r0 *1 79.42,38.225 nfet
M$884 VSS \$891 \$955 VSS nfet L=0.6U W=0.36U AS=0.0432P AD=0.2637P PS=0.6U
+ PD=1.825U
* device instance $885 r0 *1 80.98,38.225 nfet
M$885 \$891 \$912 VSS VSS nfet L=0.6U W=0.36U AS=0.2637P AD=0.0936P PS=1.825U
+ PD=0.88U
* device instance $886 r0 *1 82.1,38.225 nfet
M$886 \$913 \$892 \$891 VSS nfet L=0.6U W=0.36U AS=0.0936P AD=0.0936P PS=0.88U
+ PD=0.88U
* device instance $887 r0 *1 83.22,38.225 nfet
M$887 \$956 \$890 \$913 VSS nfet L=0.6U W=0.36U AS=0.0936P AD=0.0432P PS=0.88U
+ PD=0.6U
* device instance $888 r0 *1 84.06,38.225 nfet
M$888 VSS \$893 \$956 VSS nfet L=0.6U W=0.36U AS=0.0432P AD=0.142P PS=0.6U
+ PD=1.14U
* device instance $889 r0 *1 85.4,38.245 nfet
M$889 \$893 \$913 VSS VSS nfet L=0.6U W=0.4U AS=0.142P AD=0.176P PS=1.14U
+ PD=1.68U
* device instance $890 r0 *1 87.34,38.45 nfet
M$890 c8_r \$893 VSS VSS nfet L=0.6U W=0.82U AS=0.3608P AD=0.3608P PS=2.52U
+ PD=2.52U
* device instance $891 r0 *1 107.88,38.2425 nfet
M$891 VSS clknet_2_3__leaf_clk \$894 VSS nfet L=0.6U W=0.405U AS=0.1782P
+ AD=0.1053P PS=1.69U PD=0.925U
* device instance $892 r0 *1 109,38.2425 nfet
M$892 \$896 \$894 VSS VSS nfet L=0.6U W=0.405U AS=0.1053P AD=0.1782P PS=0.925U
+ PD=1.69U
* device instance $893 r0 *1 110.84,38.225 nfet
M$893 \$957 \$894 VSS VSS nfet L=0.6U W=0.36U AS=0.1584P AD=0.0432P PS=1.6U
+ PD=0.6U
* device instance $894 r0 *1 111.68,38.225 nfet
M$894 \$957 \_028_ \$914 VSS nfet L=0.6U W=0.36U AS=0.207P AD=0.0432P PS=1.51U
+ PD=0.6U
* device instance $895 r0 *1 113.3,38.225 nfet
M$895 \$958 \$896 \$914 VSS nfet L=0.6U W=0.36U AS=0.207P AD=0.0432P PS=1.51U
+ PD=0.6U
* device instance $896 r0 *1 114.14,38.225 nfet
M$896 VSS \$895 \$958 VSS nfet L=0.6U W=0.36U AS=0.0432P AD=0.2637P PS=0.6U
+ PD=1.825U
* device instance $897 r0 *1 115.7,38.225 nfet
M$897 \$895 \$914 VSS VSS nfet L=0.6U W=0.36U AS=0.2637P AD=0.0936P PS=1.825U
+ PD=0.88U
* device instance $898 r0 *1 116.82,38.225 nfet
M$898 \$915 \$896 \$895 VSS nfet L=0.6U W=0.36U AS=0.0936P AD=0.0936P PS=0.88U
+ PD=0.88U
* device instance $899 r0 *1 117.94,38.225 nfet
M$899 \$959 \$894 \$915 VSS nfet L=0.6U W=0.36U AS=0.0936P AD=0.0432P PS=0.88U
+ PD=0.6U
* device instance $900 r0 *1 118.78,38.225 nfet
M$900 VSS \$897 \$959 VSS nfet L=0.6U W=0.36U AS=0.0432P AD=0.142P PS=0.6U
+ PD=1.14U
* device instance $901 r0 *1 120.12,38.245 nfet
M$901 \$897 \$915 VSS VSS nfet L=0.6U W=0.4U AS=0.142P AD=0.176P PS=1.14U
+ PD=1.68U
* device instance $902 r0 *1 122.06,38.45 nfet
M$902 c7_r \$897 VSS VSS nfet L=0.6U W=0.82U AS=0.3608P AD=0.3608P PS=2.52U
+ PD=2.52U
* device instance $903 r0 *1 149.32,38.2425 nfet
M$903 VSS clknet_2_3__leaf_clk \$898 VSS nfet L=0.6U W=0.405U AS=0.1782P
+ AD=0.1053P PS=1.69U PD=0.925U
* device instance $904 r0 *1 150.44,38.2425 nfet
M$904 \$900 \$898 VSS VSS nfet L=0.6U W=0.405U AS=0.1053P AD=0.1782P PS=0.925U
+ PD=1.69U
* device instance $905 r0 *1 152.28,38.225 nfet
M$905 \$960 \$898 VSS VSS nfet L=0.6U W=0.36U AS=0.1584P AD=0.0432P PS=1.6U
+ PD=0.6U
* device instance $906 r0 *1 153.12,38.225 nfet
M$906 \$960 \_018_ \$916 VSS nfet L=0.6U W=0.36U AS=0.207P AD=0.0432P PS=1.51U
+ PD=0.6U
* device instance $907 r0 *1 154.74,38.225 nfet
M$907 \$961 \$900 \$916 VSS nfet L=0.6U W=0.36U AS=0.207P AD=0.0432P PS=1.51U
+ PD=0.6U
* device instance $908 r0 *1 155.58,38.225 nfet
M$908 VSS \$899 \$961 VSS nfet L=0.6U W=0.36U AS=0.0432P AD=0.2637P PS=0.6U
+ PD=1.825U
* device instance $909 r0 *1 157.14,38.225 nfet
M$909 \$899 \$916 VSS VSS nfet L=0.6U W=0.36U AS=0.2637P AD=0.0936P PS=1.825U
+ PD=0.88U
* device instance $910 r0 *1 158.26,38.225 nfet
M$910 \$917 \$900 \$899 VSS nfet L=0.6U W=0.36U AS=0.0936P AD=0.0936P PS=0.88U
+ PD=0.88U
* device instance $911 r0 *1 159.38,38.225 nfet
M$911 \$962 \$898 \$917 VSS nfet L=0.6U W=0.36U AS=0.0936P AD=0.0432P PS=0.88U
+ PD=0.6U
* device instance $912 r0 *1 160.22,38.225 nfet
M$912 VSS \$901 \$962 VSS nfet L=0.6U W=0.36U AS=0.0432P AD=0.142P PS=0.6U
+ PD=1.14U
* device instance $913 r0 *1 161.56,38.245 nfet
M$913 \$901 \$917 VSS VSS nfet L=0.6U W=0.4U AS=0.142P AD=0.176P PS=1.14U
+ PD=1.68U
* device instance $914 r0 *1 163.5,38.45 nfet
M$914 q7 \$901 VSS VSS nfet L=0.6U W=0.82U AS=0.3608P AD=0.3608P PS=2.52U
+ PD=2.52U
* device instance $915 r0 *1 179,38.2425 nfet
M$915 VSS clknet_2_3__leaf_clk \$902 VSS nfet L=0.6U W=0.405U AS=0.1782P
+ AD=0.1053P PS=1.69U PD=0.925U
* device instance $916 r0 *1 180.12,38.2425 nfet
M$916 \$904 \$902 VSS VSS nfet L=0.6U W=0.405U AS=0.1053P AD=0.1782P PS=0.925U
+ PD=1.69U
* device instance $917 r0 *1 181.96,38.225 nfet
M$917 \$963 \$902 VSS VSS nfet L=0.6U W=0.36U AS=0.1584P AD=0.0432P PS=1.6U
+ PD=0.6U
* device instance $918 r0 *1 182.8,38.225 nfet
M$918 \$963 \_009_[3] \$918 VSS nfet L=0.6U W=0.36U AS=0.207P AD=0.0432P
+ PS=1.51U PD=0.6U
* device instance $919 r0 *1 184.42,38.225 nfet
M$919 \$964 \$904 \$918 VSS nfet L=0.6U W=0.36U AS=0.207P AD=0.0432P PS=1.51U
+ PD=0.6U
* device instance $920 r0 *1 185.26,38.225 nfet
M$920 VSS \$903 \$964 VSS nfet L=0.6U W=0.36U AS=0.0432P AD=0.2637P PS=0.6U
+ PD=1.825U
* device instance $921 r0 *1 186.82,38.225 nfet
M$921 \$903 \$918 VSS VSS nfet L=0.6U W=0.36U AS=0.2637P AD=0.0936P PS=1.825U
+ PD=0.88U
* device instance $922 r0 *1 187.94,38.225 nfet
M$922 \$919 \$904 \$903 VSS nfet L=0.6U W=0.36U AS=0.0936P AD=0.0936P PS=0.88U
+ PD=0.88U
* device instance $923 r0 *1 189.06,38.225 nfet
M$923 \$965 \$902 \$919 VSS nfet L=0.6U W=0.36U AS=0.0936P AD=0.0432P PS=0.88U
+ PD=0.6U
* device instance $924 r0 *1 189.9,38.225 nfet
M$924 VSS \$905 \$965 VSS nfet L=0.6U W=0.36U AS=0.0432P AD=0.142P PS=0.6U
+ PD=1.14U
* device instance $925 r0 *1 191.24,38.245 nfet
M$925 \$905 \$919 VSS VSS nfet L=0.6U W=0.4U AS=0.142P AD=0.176P PS=1.14U
+ PD=1.68U
* device instance $926 r0 *1 193.18,38.45 nfet
M$926 ph[3] \$905 VSS VSS nfet L=0.6U W=0.82U AS=0.3608P AD=0.3608P PS=2.52U
+ PD=2.52U
* device instance $927 r0 *1 3.21,2.7925 pfet
M$927 VDD clknet_2_0__leaf_clk \$37 VDD pfet L=0.5U W=0.865U AS=0.3806P
+ AD=0.2249P PS=2.61U PD=1.385U
* device instance $928 r0 *1 4.23,2.7925 pfet
M$928 \$39 \$37 VDD VDD pfet L=0.5U W=0.865U AS=0.2249P AD=0.3806P PS=1.385U
+ PD=2.61U
* device instance $929 r0 *1 17.23,2.97 pfet
M$929 ph[11] \$44 VDD VDD pfet L=0.5U W=1.22U AS=0.5368P AD=0.5368P PS=3.32U
+ PD=3.32U
* device instance $930 r0 *1 19.35,2.97 pfet
M$930 \_047_ ph[10] VDD VDD pfet L=0.5U W=1.22U AS=0.5368P AD=0.5368P PS=3.32U
+ PD=3.32U
* device instance $931 r0 *1 31.77,2.7925 pfet
M$931 VDD clknet_2_0__leaf_clk \$46 VDD pfet L=0.5U W=0.865U AS=0.3806P
+ AD=0.2249P PS=2.61U PD=1.385U
* device instance $932 r0 *1 32.79,2.7925 pfet
M$932 \$47 \$46 VDD VDD pfet L=0.5U W=0.865U AS=0.2249P AD=0.3806P PS=1.385U
+ PD=2.61U
* device instance $933 r0 *1 45.79,2.97 pfet
M$933 eng2 \$52 VDD VDD pfet L=0.5U W=1.22U AS=0.5368P AD=0.5368P PS=3.32U
+ PD=3.32U
* device instance $934 r0 *1 54.63,2.97 pfet
M$934 \$118 q2 VDD VDD pfet L=0.5U W=1.22U AS=0.5368P AD=0.4087P PS=3.32U
+ PD=1.89U
* device instance $935 r0 *1 55.8,2.97 pfet
M$935 sel_lo_n_2p \_042_ \$118 VDD pfet L=0.5U W=1.22U AS=0.4087P AD=0.5368P
+ PS=1.89U PD=3.32U
* device instance $936 r0 *1 57.99,2.97 pfet
M$936 \$120 q3 VDD VDD pfet L=0.5U W=1.22U AS=0.5368P AD=0.4087P PS=3.32U
+ PD=1.89U
* device instance $937 r0 *1 59.16,2.97 pfet
M$937 sel_lo_n_4p \_030_ \$120 VDD pfet L=0.5U W=1.22U AS=0.4087P AD=0.5368P
+ PS=1.89U PD=3.32U
* device instance $938 r0 *1 76.47,2.9675 pfet
M$938 rel_n_8n eng4 \$106 VDD pfet L=0.5U W=1.215U AS=0.5346P AD=0.3159P
+ PS=3.31U PD=1.735U
* device instance $939 r0 *1 77.49,2.9675 pfet
M$939 \$106 mode rel_n_8n VDD pfet L=0.5U W=1.215U AS=0.3159P AD=0.44955P
+ PS=1.735U PD=1.955U
* device instance $940 r0 *1 78.73,2.9675 pfet
M$940 VDD sel_in_n \$106 VDD pfet L=0.5U W=1.215U AS=0.44955P AD=0.5346P
+ PS=1.955U PD=3.31U
* device instance $941 r0 *1 84.31,2.97 pfet
M$941 \$122 sel_in_n VDD VDD pfet L=0.5U W=1.22U AS=0.5368P AD=0.4087P PS=3.32U
+ PD=1.89U
* device instance $942 r0 *1 85.48,2.97 pfet
M$942 rel_n_32p eng6 \$122 VDD pfet L=0.5U W=1.22U AS=0.4087P AD=0.5368P
+ PS=1.89U PD=3.32U
* device instance $943 r0 *1 87.67,2.9675 pfet
M$943 rel_n_128n eng8 \$107 VDD pfet L=0.5U W=1.215U AS=0.5346P AD=0.3159P
+ PS=3.31U PD=1.735U
* device instance $944 r0 *1 88.69,2.9675 pfet
M$944 \$107 mode rel_n_128n VDD pfet L=0.5U W=1.215U AS=0.3159P AD=0.44955P
+ PS=1.735U PD=1.955U
* device instance $945 r0 *1 89.93,2.9675 pfet
M$945 VDD sel_in_n \$107 VDD pfet L=0.5U W=1.215U AS=0.44955P AD=0.5346P
+ PS=1.955U PD=3.31U
* device instance $946 r0 *1 93.27,2.97 pfet
M$946 \_031_ mode VDD VDD pfet L=0.5U W=1.22U AS=0.5368P AD=0.5368P PS=3.32U
+ PD=3.32U
* device instance $947 r0 *1 97.19,2.97 pfet
M$947 \$126 sel_in_n VDD VDD pfet L=0.5U W=1.22U AS=0.5368P AD=0.4087P PS=3.32U
+ PD=1.89U
* device instance $948 r0 *1 98.36,2.97 pfet
M$948 rel_n_128p eng8 \$126 VDD pfet L=0.5U W=1.22U AS=0.4087P AD=0.5368P
+ PS=1.89U PD=3.32U
* device instance $949 r0 *1 113.53,2.97 pfet
M$949 \$128 q1 VDD VDD pfet L=0.5U W=1.22U AS=0.5368P AD=0.3172P PS=3.32U
+ PD=1.74U
* device instance $950 r0 *1 114.55,2.97 pfet
M$950 \$127 \_044_ \$128 VDD pfet L=0.5U W=1.22U AS=0.3172P AD=0.3782P PS=1.74U
+ PD=1.84U
* device instance $951 r0 *1 115.67,2.97 pfet
M$951 sel_hi_n_1n \_031_ \$127 VDD pfet L=0.5U W=1.22U AS=0.3782P AD=0.5368P
+ PS=1.84U PD=3.32U
* device instance $952 r0 *1 122.39,2.9675 pfet
M$952 rel_n_1n eng1 \$108 VDD pfet L=0.5U W=1.215U AS=0.5346P AD=0.3159P
+ PS=3.31U PD=1.735U
* device instance $953 r0 *1 123.41,2.9675 pfet
M$953 \$108 mode rel_n_1n VDD pfet L=0.5U W=1.215U AS=0.3159P AD=0.44955P
+ PS=1.735U PD=1.955U
* device instance $954 r0 *1 124.65,2.9675 pfet
M$954 VDD sel_in_n \$108 VDD pfet L=0.5U W=1.215U AS=0.44955P AD=0.5346P
+ PS=1.955U PD=3.31U
* device instance $955 r0 *1 134.25,2.97 pfet
M$955 \$130 \_038_ VDD VDD pfet L=0.5U W=1.22U AS=0.5368P AD=0.3172P PS=3.32U
+ PD=1.74U
* device instance $956 r0 *1 135.27,2.97 pfet
M$956 \$129 q6 \$130 VDD pfet L=0.5U W=1.22U AS=0.3172P AD=0.3782P PS=1.74U
+ PD=1.84U
* device instance $957 r0 *1 136.39,2.97 pfet
M$957 sel_hi_n_32n \_031_ \$129 VDD pfet L=0.5U W=1.22U AS=0.3782P AD=0.5368P
+ PS=1.84U PD=3.32U
* device instance $958 r0 *1 140.87,2.97 pfet
M$958 \_038_ eng6 VDD VDD pfet L=0.5U W=1.22U AS=0.5368P AD=0.5368P PS=3.32U
+ PD=3.32U
* device instance $959 r0 *1 144.23,2.97 pfet
M$959 ZN clknet_2_2__leaf_clk VDD VDD pfet L=0.5U W=1.22U AS=0.5368P AD=0.4392P
+ PS=3.32U PD=1.94U
* device instance $960 r0 *1 145.45,2.97 pfet
M$960 VDD clknet_2_2__leaf_clk ZN VDD pfet L=0.5U W=1.22U AS=0.4392P AD=0.3172P
+ PS=1.94U PD=1.74U
* device instance $961 r0 *1 146.47,2.97 pfet
M$961 ZN clknet_2_2__leaf_clk VDD VDD pfet L=0.5U W=1.22U AS=0.3172P AD=0.5368P
+ PS=1.74U PD=3.32U
* device instance $962 r0 *1 152.17,2.7925 pfet
M$962 VDD clknet_2_2__leaf_clk \$66 VDD pfet L=0.5U W=0.865U AS=0.3806P
+ AD=0.2249P PS=2.61U PD=1.385U
* device instance $963 r0 *1 153.19,2.7925 pfet
M$963 \$67 \$66 VDD VDD pfet L=0.5U W=0.865U AS=0.2249P AD=0.3806P PS=1.385U
+ PD=2.61U
* device instance $964 r0 *1 166.19,2.97 pfet
M$964 ph[7] \$72 VDD VDD pfet L=0.5U W=1.22U AS=0.5368P AD=0.5368P PS=3.32U
+ PD=3.32U
* device instance $965 r0 *1 177.37,2.7925 pfet
M$965 VDD clknet_2_2__leaf_clk \$73 VDD pfet L=0.5U W=0.865U AS=0.3806P
+ AD=0.2249P PS=2.61U PD=1.385U
* device instance $966 r0 *1 178.39,2.7925 pfet
M$966 \$74 \$73 VDD VDD pfet L=0.5U W=0.865U AS=0.2249P AD=0.3806P PS=1.385U
+ PD=2.61U
* device instance $967 r0 *1 191.39,2.97 pfet
M$967 ph[1] \$79 VDD VDD pfet L=0.5U W=1.22U AS=0.5368P AD=0.5368P PS=3.32U
+ PD=3.32U
* device instance $968 r0 *1 6.39,2.815 pfet
M$968 \$111 \$39 VDD VDD pfet L=0.5U W=0.36U AS=0.4554P AD=0.054P PS=3.25U
+ PD=0.66U
* device instance $969 r0 *1 7.19,2.815 pfet
M$969 \$41 \_009_[11] \$111 VDD pfet L=0.5U W=0.36U AS=0.054P AD=0.1872P
+ PS=0.66U PD=1.4U
* device instance $970 r0 *1 8.73,2.815 pfet
M$970 \$112 \$37 \$41 VDD pfet L=0.5U W=0.36U AS=0.1872P AD=0.0432P PS=1.4U
+ PD=0.6U
* device instance $971 r0 *1 9.47,2.815 pfet
M$971 VDD \$42 \$112 VDD pfet L=0.5U W=0.36U AS=0.0432P AD=0.1044P PS=0.6U
+ PD=0.94U
* device instance $972 r0 *1 10.55,2.815 pfet
M$972 \$42 \$41 VDD VDD pfet L=0.5U W=0.36U AS=0.1044P AD=0.1791P PS=0.94U
+ PD=1.355U
* device instance $973 r0 *1 12.045,2.815 pfet
M$973 \$43 \$37 \$42 VDD pfet L=0.5U W=0.36U AS=0.1791P AD=0.1665P PS=1.355U
+ PD=1.285U
* device instance $974 r0 *1 13.47,2.815 pfet
M$974 \$113 \$39 \$43 VDD pfet L=0.5U W=0.36U AS=0.1665P AD=0.0504P PS=1.285U
+ PD=0.64U
* device instance $975 r0 *1 14.25,2.815 pfet
M$975 VDD \$44 \$113 VDD pfet L=0.5U W=0.36U AS=0.0504P AD=0.23P PS=0.64U
+ PD=1.54U
* device instance $976 r0 *1 15.49,3.035 pfet
M$976 \$44 \$43 VDD VDD pfet L=0.5U W=0.8U AS=0.23P AD=0.352P PS=1.54U PD=2.48U
* device instance $977 r0 *1 22.27,4.87 pfet
M$977 q3 \$134 VDD VDD pfet L=0.5U W=1.22U AS=0.5368P AD=0.5368P PS=3.32U
+ PD=3.32U
* device instance $978 r0 *1 34.95,2.815 pfet
M$978 \$114 \$47 VDD VDD pfet L=0.5U W=0.36U AS=0.4554P AD=0.054P PS=3.25U
+ PD=0.66U
* device instance $979 r0 *1 35.75,2.815 pfet
M$979 \$49 \_001_ \$114 VDD pfet L=0.5U W=0.36U AS=0.054P AD=0.1872P PS=0.66U
+ PD=1.4U
* device instance $980 r0 *1 37.29,2.815 pfet
M$980 \$115 \$46 \$49 VDD pfet L=0.5U W=0.36U AS=0.1872P AD=0.0432P PS=1.4U
+ PD=0.6U
* device instance $981 r0 *1 38.03,2.815 pfet
M$981 VDD \$50 \$115 VDD pfet L=0.5U W=0.36U AS=0.0432P AD=0.1044P PS=0.6U
+ PD=0.94U
* device instance $982 r0 *1 39.11,2.815 pfet
M$982 \$50 \$49 VDD VDD pfet L=0.5U W=0.36U AS=0.1044P AD=0.1791P PS=0.94U
+ PD=1.355U
* device instance $983 r0 *1 40.605,2.815 pfet
M$983 \$51 \$46 \$50 VDD pfet L=0.5U W=0.36U AS=0.1791P AD=0.1665P PS=1.355U
+ PD=1.285U
* device instance $984 r0 *1 42.03,2.815 pfet
M$984 \$116 \$47 \$51 VDD pfet L=0.5U W=0.36U AS=0.1665P AD=0.0504P PS=1.285U
+ PD=0.64U
* device instance $985 r0 *1 42.81,2.815 pfet
M$985 VDD \$52 \$116 VDD pfet L=0.5U W=0.36U AS=0.0504P AD=0.23P PS=0.64U
+ PD=1.54U
* device instance $986 r0 *1 44.05,3.035 pfet
M$986 \$52 \$51 VDD VDD pfet L=0.5U W=0.8U AS=0.23P AD=0.352P PS=1.54U PD=2.48U
* device instance $987 r0 *1 43.55,4.87 pfet
M$987 eng3 \$138 VDD VDD pfet L=0.5U W=1.22U AS=0.5368P AD=0.5368P PS=3.32U
+ PD=3.32U
* device instance $988 r0 *1 45.67,4.87 pfet
M$988 \_030_ eng3 VDD VDD pfet L=0.5U W=1.22U AS=0.5368P AD=0.5368P PS=3.32U
+ PD=3.32U
* device instance $989 r0 *1 56.97,4.87 pfet
M$989 \$186 q2 VDD VDD pfet L=0.5U W=1.22U AS=0.5368P AD=0.3172P PS=3.32U
+ PD=1.74U
* device instance $990 r0 *1 57.99,4.87 pfet
M$990 \$187 \_042_ \$186 VDD pfet L=0.5U W=1.22U AS=0.3172P AD=0.3782P PS=1.74U
+ PD=1.84U
* device instance $991 r0 *1 59.11,4.87 pfet
M$991 sel_hi_n_2n \_031_ \$187 VDD pfet L=0.5U W=1.22U AS=0.3782P AD=0.5368P
+ PS=1.84U PD=3.32U
* device instance $992 r0 *1 61.35,3.275 pfet
M$992 \$55 mode VDD VDD pfet L=0.5U W=0.6U AS=0.264P AD=0.156P PS=2.08U PD=1.12U
* device instance $993 r0 *1 62.37,3.275 pfet
M$993 \$55 sel_hi_n_64p VDD VDD pfet L=0.5U W=0.6U AS=0.40575P AD=0.156P
+ PS=2.055U PD=1.12U
* device instance $994 r0 *1 63.71,2.9675 pfet
M$994 sel_lo_n_64n \$55 VDD VDD pfet L=0.5U W=1.215U AS=0.40575P AD=0.5346P
+ PS=2.055U PD=3.31U
* device instance $995 r0 *1 92.15,4.87 pfet
M$995 \$193 sel_in_n VDD VDD pfet L=0.5U W=1.22U AS=0.5368P AD=0.4087P PS=3.32U
+ PD=1.89U
* device instance $996 r0 *1 93.32,4.87 pfet
M$996 rel_n_64p eng7 \$193 VDD pfet L=0.5U W=1.22U AS=0.4087P AD=0.5368P
+ PS=1.89U PD=3.32U
* device instance $997 r0 *1 97.19,4.87 pfet
M$997 \$196 sel_in_n VDD VDD pfet L=0.5U W=1.22U AS=0.5368P AD=0.4087P PS=3.32U
+ PD=1.89U
* device instance $998 r0 *1 98.36,4.87 pfet
M$998 rel_n_2p eng2 \$196 VDD pfet L=0.5U W=1.22U AS=0.4087P AD=0.5368P
+ PS=1.89U PD=3.32U
* device instance $999 r0 *1 101.67,3.275 pfet
M$999 \$59 mode VDD VDD pfet L=0.5U W=0.6U AS=0.264P AD=0.156P PS=2.08U PD=1.12U
* device instance $1000 r0 *1 102.69,3.275 pfet
M$1000 \$59 sel_hi_n_2p VDD VDD pfet L=0.5U W=0.6U AS=0.40575P AD=0.156P
+ PS=2.055U PD=1.12U
* device instance $1001 r0 *1 104.03,2.9675 pfet
M$1001 sel_lo_n_2n \$59 VDD VDD pfet L=0.5U W=1.215U AS=0.40575P AD=0.5346P
+ PS=2.055U PD=3.31U
* device instance $1002 r0 *1 102.23,4.87 pfet
M$1002 \$198 sel_in_n VDD VDD pfet L=0.5U W=1.22U AS=0.5368P AD=0.4087P
+ PS=3.32U PD=1.89U
* device instance $1003 r0 *1 103.4,4.87 pfet
M$1003 rel_n_1p eng1 \$198 VDD pfet L=0.5U W=1.22U AS=0.4087P AD=0.5368P
+ PS=1.89U PD=3.32U
* device instance $1004 r0 *1 105.59,4.87 pfet
M$1004 \$199 sel_in_n VDD VDD pfet L=0.5U W=1.22U AS=0.5368P AD=0.4087P
+ PS=3.32U PD=1.89U
* device instance $1005 r0 *1 106.76,4.87 pfet
M$1005 rel_n_4p eng3 \$199 VDD pfet L=0.5U W=1.22U AS=0.4087P AD=0.5368P
+ PS=1.89U PD=3.32U
* device instance $1006 r0 *1 108.95,3.275 pfet
M$1006 \$60 q6 VDD VDD pfet L=0.5U W=0.6U AS=0.264P AD=0.156P PS=2.08U PD=1.12U
* device instance $1007 r0 *1 109.97,3.275 pfet
M$1007 \$60 eng6 VDD VDD pfet L=0.5U W=0.6U AS=0.40575P AD=0.156P PS=2.055U
+ PD=1.12U
* device instance $1008 r0 *1 111.31,2.9675 pfet
M$1008 sel_hi_n_32p \$60 VDD VDD pfet L=0.5U W=1.215U AS=0.40575P AD=0.5346P
+ PS=2.055U PD=3.31U
* device instance $1009 r0 *1 124.07,4.87 pfet
M$1009 \$197 sel_in_n VDD VDD pfet L=0.5U W=1.22U AS=0.5368P AD=0.4087P
+ PS=3.32U PD=1.89U
* device instance $1010 r0 *1 125.24,4.87 pfet
M$1010 rel_n_256p eng9 \$197 VDD pfet L=0.5U W=1.22U AS=0.4087P AD=0.5368P
+ PS=1.89U PD=3.32U
* device instance $1011 r0 *1 128.55,4.87 pfet
M$1011 \$195 sel_in_n VDD VDD pfet L=0.5U W=1.22U AS=0.5368P AD=0.4087P
+ PS=3.32U PD=1.89U
* device instance $1012 r0 *1 129.72,4.87 pfet
M$1012 rel_n_8p eng4 \$195 VDD pfet L=0.5U W=1.22U AS=0.4087P AD=0.5368P
+ PS=1.89U PD=3.32U
* device instance $1013 r0 *1 132.57,4.87 pfet
M$1013 \$194 \_039_ VDD VDD pfet L=0.5U W=1.22U AS=0.5368P AD=0.3172P PS=3.32U
+ PD=1.74U
* device instance $1014 r0 *1 133.59,4.87 pfet
M$1014 \$192 q7 \$194 VDD pfet L=0.5U W=1.22U AS=0.3172P AD=0.3782P PS=1.74U
+ PD=1.84U
* device instance $1015 r0 *1 134.71,4.87 pfet
M$1015 sel_hi_n_64n \_031_ \$192 VDD pfet L=0.5U W=1.22U AS=0.3782P AD=0.5368P
+ PS=1.84U PD=3.32U
* device instance $1016 r0 *1 136.95,4.87 pfet
M$1016 \$191 sel_in_n VDD VDD pfet L=0.5U W=1.22U AS=0.5368P AD=0.4087P
+ PS=3.32U PD=1.89U
* device instance $1017 r0 *1 138.12,4.87 pfet
M$1017 rel_n_16p eng5 \$191 VDD pfet L=0.5U W=1.22U AS=0.4087P AD=0.5368P
+ PS=1.89U PD=3.32U
* device instance $1018 r0 *1 155.35,2.815 pfet
M$1018 \$125 \$67 VDD VDD pfet L=0.5U W=0.36U AS=0.4554P AD=0.054P PS=3.25U
+ PD=0.66U
* device instance $1019 r0 *1 156.15,2.815 pfet
M$1019 \$69 \_009_[7] \$125 VDD pfet L=0.5U W=0.36U AS=0.054P AD=0.1872P
+ PS=0.66U PD=1.4U
* device instance $1020 r0 *1 157.69,2.815 pfet
M$1020 \$124 \$66 \$69 VDD pfet L=0.5U W=0.36U AS=0.1872P AD=0.0432P PS=1.4U
+ PD=0.6U
* device instance $1021 r0 *1 158.43,2.815 pfet
M$1021 VDD \$70 \$124 VDD pfet L=0.5U W=0.36U AS=0.0432P AD=0.1044P PS=0.6U
+ PD=0.94U
* device instance $1022 r0 *1 159.51,2.815 pfet
M$1022 \$70 \$69 VDD VDD pfet L=0.5U W=0.36U AS=0.1044P AD=0.1791P PS=0.94U
+ PD=1.355U
* device instance $1023 r0 *1 161.005,2.815 pfet
M$1023 \$71 \$66 \$70 VDD pfet L=0.5U W=0.36U AS=0.1791P AD=0.1665P PS=1.355U
+ PD=1.285U
* device instance $1024 r0 *1 162.43,2.815 pfet
M$1024 \$123 \$67 \$71 VDD pfet L=0.5U W=0.36U AS=0.1665P AD=0.0504P PS=1.285U
+ PD=0.64U
* device instance $1025 r0 *1 163.21,2.815 pfet
M$1025 VDD \$72 \$123 VDD pfet L=0.5U W=0.36U AS=0.0504P AD=0.23P PS=0.64U
+ PD=1.54U
* device instance $1026 r0 *1 164.45,3.035 pfet
M$1026 \$72 \$71 VDD VDD pfet L=0.5U W=0.8U AS=0.23P AD=0.352P PS=1.54U PD=2.48U
* device instance $1027 r0 *1 155.55,4.87 pfet
M$1027 eng6 \$155 VDD VDD pfet L=0.5U W=1.22U AS=0.5368P AD=0.5368P PS=3.32U
+ PD=3.32U
* device instance $1028 r0 *1 175.15,4.87 pfet
M$1028 ph[0] \$159 VDD VDD pfet L=0.5U W=1.22U AS=0.5368P AD=0.5368P PS=3.32U
+ PD=3.32U
* device instance $1029 r0 *1 177.83,4.87 pfet
M$1029 \_033_ ph[0] VDD VDD pfet L=0.5U W=1.22U AS=0.5368P AD=0.5368P PS=3.32U
+ PD=3.32U
* device instance $1030 r0 *1 180.55,2.815 pfet
M$1030 \$121 \$74 VDD VDD pfet L=0.5U W=0.36U AS=0.4554P AD=0.054P PS=3.25U
+ PD=0.66U
* device instance $1031 r0 *1 181.35,2.815 pfet
M$1031 \$76 \_009_[1] \$121 VDD pfet L=0.5U W=0.36U AS=0.054P AD=0.1872P
+ PS=0.66U PD=1.4U
* device instance $1032 r0 *1 182.89,2.815 pfet
M$1032 \$119 \$73 \$76 VDD pfet L=0.5U W=0.36U AS=0.1872P AD=0.0432P PS=1.4U
+ PD=0.6U
* device instance $1033 r0 *1 183.63,2.815 pfet
M$1033 VDD \$77 \$119 VDD pfet L=0.5U W=0.36U AS=0.0432P AD=0.1044P PS=0.6U
+ PD=0.94U
* device instance $1034 r0 *1 184.71,2.815 pfet
M$1034 \$77 \$76 VDD VDD pfet L=0.5U W=0.36U AS=0.1044P AD=0.1791P PS=0.94U
+ PD=1.355U
* device instance $1035 r0 *1 186.205,2.815 pfet
M$1035 \$78 \$73 \$77 VDD pfet L=0.5U W=0.36U AS=0.1791P AD=0.1665P PS=1.355U
+ PD=1.285U
* device instance $1036 r0 *1 187.63,2.815 pfet
M$1036 \$117 \$74 \$78 VDD pfet L=0.5U W=0.36U AS=0.1665P AD=0.0504P PS=1.285U
+ PD=0.64U
* device instance $1037 r0 *1 188.41,2.815 pfet
M$1037 VDD \$79 \$117 VDD pfet L=0.5U W=0.36U AS=0.0504P AD=0.23P PS=0.64U
+ PD=1.54U
* device instance $1038 r0 *1 189.65,3.035 pfet
M$1038 \$79 \$78 VDD VDD pfet L=0.5U W=0.8U AS=0.23P AD=0.352P PS=1.54U PD=2.48U
* device instance $1039 r0 *1 185.67,4.87 pfet
M$1039 \_034_ ph[1] VDD VDD pfet L=0.5U W=1.22U AS=0.5368P AD=0.5368P PS=3.32U
+ PD=3.32U
* device instance $1040 r0 *1 187.91,4.87 pfet
M$1040 \_032_ ph[2] VDD VDD pfet L=0.5U W=1.22U AS=0.5368P AD=0.5368P PS=3.32U
+ PD=3.32U
* device instance $1041 r0 *1 8.25,5.0475 pfet
M$1041 VDD clknet_2_0__leaf_clk \$131 VDD pfet L=0.5U W=0.865U AS=0.3806P
+ AD=0.2249P PS=2.61U PD=1.385U
* device instance $1042 r0 *1 9.27,5.0475 pfet
M$1042 \$133 \$131 VDD VDD pfet L=0.5U W=0.865U AS=0.2249P AD=0.3806P PS=1.385U
+ PD=2.61U
* device instance $1043 r0 *1 29.53,5.0475 pfet
M$1043 VDD clknet_2_0__leaf_clk \$135 VDD pfet L=0.5U W=0.865U AS=0.3806P
+ AD=0.2249P PS=2.61U PD=1.385U
* device instance $1044 r0 *1 30.55,5.0475 pfet
M$1044 \$137 \$135 VDD VDD pfet L=0.5U W=0.865U AS=0.2249P AD=0.3806P PS=1.385U
+ PD=2.61U
* device instance $1045 r0 *1 61.35,4.565 pfet
M$1045 \$140 q4 VDD VDD pfet L=0.5U W=0.6U AS=0.264P AD=0.156P PS=2.08U PD=1.12U
* device instance $1046 r0 *1 62.37,4.565 pfet
M$1046 VDD eng4 \$140 VDD pfet L=0.5U W=0.6U AS=0.156P AD=0.40575P PS=1.12U
+ PD=2.055U
* device instance $1047 r0 *1 63.71,4.8725 pfet
M$1047 sel_hi_n_8p \$140 VDD VDD pfet L=0.5U W=1.215U AS=0.40575P AD=0.5346P
+ PS=2.055U PD=3.31U
* device instance $1048 r0 *1 68.07,4.565 pfet
M$1048 \$142 mode VDD VDD pfet L=0.5U W=0.6U AS=0.264P AD=0.156P PS=2.08U
+ PD=1.12U
* device instance $1049 r0 *1 69.09,4.565 pfet
M$1049 VDD sel_hi_n_8p \$142 VDD pfet L=0.5U W=0.6U AS=0.156P AD=0.40575P
+ PS=1.12U PD=2.055U
* device instance $1050 r0 *1 70.43,4.8725 pfet
M$1050 sel_lo_n_8n \$142 VDD VDD pfet L=0.5U W=1.215U AS=0.40575P AD=0.5346P
+ PS=2.055U PD=3.31U
* device instance $1051 r0 *1 73.11,4.565 pfet
M$1051 \$144 mode VDD VDD pfet L=0.5U W=0.6U AS=0.264P AD=0.156P PS=2.08U
+ PD=1.12U
* device instance $1052 r0 *1 74.13,4.565 pfet
M$1052 VDD sel_hi_n_1p \$144 VDD pfet L=0.5U W=0.6U AS=0.156P AD=0.40575P
+ PS=1.12U PD=2.055U
* device instance $1053 r0 *1 75.47,4.8725 pfet
M$1053 sel_lo_n_1n \$144 VDD VDD pfet L=0.5U W=1.215U AS=0.40575P AD=0.5346P
+ PS=2.055U PD=3.31U
* device instance $1054 r0 *1 80.39,4.8725 pfet
M$1054 rel_n_2n eng2 \$145 VDD pfet L=0.5U W=1.215U AS=0.5346P AD=0.3159P
+ PS=3.31U PD=1.735U
* device instance $1055 r0 *1 81.41,4.8725 pfet
M$1055 \$145 mode rel_n_2n VDD pfet L=0.5U W=1.215U AS=0.3159P AD=0.44955P
+ PS=1.735U PD=1.955U
* device instance $1056 r0 *1 82.65,4.8725 pfet
M$1056 VDD sel_in_n \$145 VDD pfet L=0.5U W=1.215U AS=0.44955P AD=0.5346P
+ PS=1.955U PD=3.31U
* device instance $1057 r0 *1 86.55,4.565 pfet
M$1057 \$146 mode VDD VDD pfet L=0.5U W=0.6U AS=0.264P AD=0.156P PS=2.08U
+ PD=1.12U
* device instance $1058 r0 *1 87.57,4.565 pfet
M$1058 VDD sel_hi_n_4p \$146 VDD pfet L=0.5U W=0.6U AS=0.156P AD=0.40575P
+ PS=1.12U PD=2.055U
* device instance $1059 r0 *1 88.91,4.8725 pfet
M$1059 sel_lo_n_4n \$146 VDD VDD pfet L=0.5U W=1.215U AS=0.40575P AD=0.5346P
+ PS=2.055U PD=3.31U
* device instance $1060 r0 *1 110.07,4.8725 pfet
M$1060 rel_n_64n eng7 \$149 VDD pfet L=0.5U W=1.215U AS=0.5346P AD=0.3159P
+ PS=3.31U PD=1.735U
* device instance $1061 r0 *1 111.09,4.8725 pfet
M$1061 \$149 mode rel_n_64n VDD pfet L=0.5U W=1.215U AS=0.3159P AD=0.44955P
+ PS=1.735U PD=1.955U
* device instance $1062 r0 *1 112.33,4.8725 pfet
M$1062 VDD sel_in_n \$149 VDD pfet L=0.5U W=1.215U AS=0.44955P AD=0.5346P
+ PS=1.955U PD=3.31U
* device instance $1063 r0 *1 114.55,4.565 pfet
M$1063 \$150 mode VDD VDD pfet L=0.5U W=0.6U AS=0.264P AD=0.156P PS=2.08U
+ PD=1.12U
* device instance $1064 r0 *1 115.57,4.565 pfet
M$1064 VDD sel_hi_n_32p \$150 VDD pfet L=0.5U W=0.6U AS=0.156P AD=0.40575P
+ PS=1.12U PD=2.055U
* device instance $1065 r0 *1 116.91,4.8725 pfet
M$1065 sel_lo_n_32n \$150 VDD VDD pfet L=0.5U W=1.215U AS=0.40575P AD=0.5346P
+ PS=2.055U PD=3.31U
* device instance $1066 r0 *1 119.59,4.8725 pfet
M$1066 rel_n_4n mode \$151 VDD pfet L=0.5U W=1.215U AS=0.5346P AD=0.3159P
+ PS=3.31U PD=1.735U
* device instance $1067 r0 *1 120.61,4.8725 pfet
M$1067 \$151 eng3 rel_n_4n VDD pfet L=0.5U W=1.215U AS=0.3159P AD=0.44955P
+ PS=1.735U PD=1.955U
* device instance $1068 r0 *1 121.85,4.8725 pfet
M$1068 VDD sel_in_n \$151 VDD pfet L=0.5U W=1.215U AS=0.44955P AD=0.5346P
+ PS=1.955U PD=3.31U
* device instance $1069 r0 *1 141.53,5.0475 pfet
M$1069 VDD clknet_2_2__leaf_clk \$152 VDD pfet L=0.5U W=0.865U AS=0.3806P
+ AD=0.2249P PS=2.61U PD=1.385U
* device instance $1070 r0 *1 142.55,5.0475 pfet
M$1070 \$154 \$152 VDD VDD pfet L=0.5U W=0.865U AS=0.2249P AD=0.3806P PS=1.385U
+ PD=2.61U
* device instance $1071 r0 *1 161.13,5.0475 pfet
M$1071 VDD clknet_2_2__leaf_clk \$156 VDD pfet L=0.5U W=0.865U AS=0.3806P
+ AD=0.2249P PS=2.61U PD=1.385U
* device instance $1072 r0 *1 162.15,5.0475 pfet
M$1072 \$158 \$156 VDD VDD pfet L=0.5U W=0.865U AS=0.2249P AD=0.3806P PS=1.385U
+ PD=2.61U
* device instance $1073 r0 *1 181.885,4.9075 pfet
M$1073 samp_tp_n \_034_ VDD VDD pfet L=0.5U W=0.985U AS=0.4334P AD=0.2561P
+ PS=2.85U PD=1.505U
* device instance $1074 r0 *1 182.905,4.9075 pfet
M$1074 VDD \_033_ samp_tp_n VDD pfet L=0.5U W=0.985U AS=0.2561P AD=0.2561P
+ PS=1.505U PD=1.505U
* device instance $1075 r0 *1 183.925,4.9075 pfet
M$1075 samp_tp_n \_032_ VDD VDD pfet L=0.5U W=0.985U AS=0.2561P AD=0.4334P
+ PS=1.505U PD=2.85U
* device instance $1076 r0 *1 8.71,10.81 pfet
M$1076 \$314 start VDD$1 VDD$1 pfet L=0.5U W=1.22U AS=0.5368P AD=0.4087P
+ PS=3.32U PD=1.89U
* device instance $1077 r0 *1 9.88,10.81 pfet
M$1077 \_009_[11] \_047_ \$314 VDD$1 pfet L=0.5U W=1.22U AS=0.4087P AD=0.5368P
+ PS=1.89U PD=3.32U
* device instance $1078 r0 *1 11.43,5.025 pfet
M$1078 \$177 \$133 VDD VDD pfet L=0.5U W=0.36U AS=0.4554P AD=0.054P PS=3.25U
+ PD=0.66U
* device instance $1079 r0 *1 12.23,5.025 pfet
M$1079 \$160 \_029_ \$177 VDD pfet L=0.5U W=0.36U AS=0.054P AD=0.1872P PS=0.66U
+ PD=1.4U
* device instance $1080 r0 *1 13.77,5.025 pfet
M$1080 \$178 \$131 \$160 VDD pfet L=0.5U W=0.36U AS=0.1872P AD=0.0432P PS=1.4U
+ PD=0.6U
* device instance $1081 r0 *1 14.51,5.025 pfet
M$1081 VDD \$132 \$178 VDD pfet L=0.5U W=0.36U AS=0.0432P AD=0.1044P PS=0.6U
+ PD=0.94U
* device instance $1082 r0 *1 15.59,5.025 pfet
M$1082 \$132 \$160 VDD VDD pfet L=0.5U W=0.36U AS=0.1044P AD=0.1791P PS=0.94U
+ PD=1.355U
* device instance $1083 r0 *1 17.085,5.025 pfet
M$1083 \$161 \$131 \$132 VDD pfet L=0.5U W=0.36U AS=0.1791P AD=0.1665P
+ PS=1.355U PD=1.285U
* device instance $1084 r0 *1 18.51,5.025 pfet
M$1084 \$179 \$133 \$161 VDD pfet L=0.5U W=0.36U AS=0.1665P AD=0.0504P
+ PS=1.285U PD=0.64U
* device instance $1085 r0 *1 19.29,5.025 pfet
M$1085 \$179 \$134 VDD VDD pfet L=0.5U W=0.36U AS=0.23P AD=0.0504P PS=1.54U
+ PD=0.64U
* device instance $1086 r0 *1 20.53,4.805 pfet
M$1086 \$134 \$161 VDD VDD pfet L=0.5U W=0.8U AS=0.23P AD=0.352P PS=1.54U
+ PD=2.48U
* device instance $1087 r0 *1 12.07,10.8075 pfet
M$1087 \_029_ cmp \$298 VDD$1 pfet L=0.5U W=1.215U AS=0.5346P AD=0.3159P
+ PS=3.31U PD=1.735U
* device instance $1088 r0 *1 13.09,10.8075 pfet
M$1088 \$298 ph[10] \_029_ VDD$1 pfet L=0.5U W=1.215U AS=0.3159P AD=0.44955P
+ PS=1.735U PD=1.955U
* device instance $1089 r0 *1 14.33,10.8075 pfet
M$1089 VDD$1 \_064_ \$298 VDD$1 pfet L=0.5U W=1.215U AS=0.44955P AD=0.5346P
+ PS=1.955U PD=3.31U
* device instance $1090 r0 *1 16.55,10.81 pfet
M$1090 \$316 ph[10] VDD$1 VDD$1 pfet L=0.5U W=1.22U AS=0.5368P AD=0.4087P
+ PS=3.32U PD=1.89U
* device instance $1091 r0 *1 17.72,10.81 pfet
M$1091 \_064_ q3 \$316 VDD$1 pfet L=0.5U W=1.22U AS=0.4087P AD=0.5368P PS=1.89U
+ PD=3.32U
* device instance $1092 r0 *1 19.91,10.81 pfet
M$1092 \$317 ph[11] VDD$1 VDD$1 pfet L=0.5U W=1.22U AS=0.5368P AD=0.4087P
+ PS=3.32U PD=1.89U
* device instance $1093 r0 *1 21.08,10.81 pfet
M$1093 \_057_ q2 \$317 VDD$1 pfet L=0.5U W=1.22U AS=0.4087P AD=0.5368P PS=1.89U
+ PD=3.32U
* device instance $1094 r0 *1 32.71,5.025 pfet
M$1094 \$180 \$137 VDD VDD pfet L=0.5U W=0.36U AS=0.4554P AD=0.054P PS=3.25U
+ PD=0.66U
* device instance $1095 r0 *1 33.51,5.025 pfet
M$1095 \$162 \_002_ \$180 VDD pfet L=0.5U W=0.36U AS=0.054P AD=0.1872P PS=0.66U
+ PD=1.4U
* device instance $1096 r0 *1 35.05,5.025 pfet
M$1096 \$181 \$135 \$162 VDD pfet L=0.5U W=0.36U AS=0.1872P AD=0.0432P PS=1.4U
+ PD=0.6U
* device instance $1097 r0 *1 35.79,5.025 pfet
M$1097 VDD \$136 \$181 VDD pfet L=0.5U W=0.36U AS=0.0432P AD=0.1044P PS=0.6U
+ PD=0.94U
* device instance $1098 r0 *1 36.87,5.025 pfet
M$1098 \$136 \$162 VDD VDD pfet L=0.5U W=0.36U AS=0.1044P AD=0.1791P PS=0.94U
+ PD=1.355U
* device instance $1099 r0 *1 38.365,5.025 pfet
M$1099 \$163 \$135 \$136 VDD pfet L=0.5U W=0.36U AS=0.1791P AD=0.1665P
+ PS=1.355U PD=1.285U
* device instance $1100 r0 *1 39.79,5.025 pfet
M$1100 \$183 \$137 \$163 VDD pfet L=0.5U W=0.36U AS=0.1665P AD=0.0504P
+ PS=1.285U PD=0.64U
* device instance $1101 r0 *1 40.57,5.025 pfet
M$1101 \$183 \$138 VDD VDD pfet L=0.5U W=0.36U AS=0.23P AD=0.0504P PS=1.54U
+ PD=0.64U
* device instance $1102 r0 *1 41.81,4.805 pfet
M$1102 \$138 \$163 VDD VDD pfet L=0.5U W=0.8U AS=0.23P AD=0.352P PS=1.54U
+ PD=2.48U
* device instance $1103 r0 *1 32.79,10.8075 pfet
M$1103 \_002_ \_047_ \$299 VDD$1 pfet L=0.5U W=1.215U AS=0.5346P AD=0.3159P
+ PS=3.31U PD=1.735U
* device instance $1104 r0 *1 33.81,10.8075 pfet
M$1104 \$299 \_030_ \_002_ VDD$1 pfet L=0.5U W=1.215U AS=0.3159P AD=0.44955P
+ PS=1.735U PD=1.955U
* device instance $1105 r0 *1 35.05,10.8075 pfet
M$1105 VDD$1 ph[13] \$299 VDD$1 pfet L=0.5U W=1.215U AS=0.44955P AD=0.5346P
+ PS=1.955U PD=3.31U
* device instance $1106 r0 *1 37.27,10.8075 pfet
M$1106 \_000_ \_044_ \$300 VDD$1 pfet L=0.5U W=1.215U AS=0.5346P AD=0.3159P
+ PS=3.31U PD=1.735U
* device instance $1107 r0 *1 38.29,10.8075 pfet
M$1107 \$300 \_043_ \_000_ VDD$1 pfet L=0.5U W=1.215U AS=0.3159P AD=0.44955P
+ PS=1.735U PD=1.955U
* device instance $1108 r0 *1 39.53,10.8075 pfet
M$1108 VDD$1 ph[13] \$300 VDD$1 pfet L=0.5U W=1.215U AS=0.44955P AD=0.5346P
+ PS=1.955U PD=3.31U
* device instance $1109 r0 *1 45.67,10.81 pfet
M$1109 \_036_ eng4 VDD$1 VDD$1 pfet L=0.5U W=1.22U AS=0.5368P AD=0.5368P
+ PS=3.32U PD=3.32U
* device instance $1110 r0 *1 47.91,10.81 pfet
M$1110 \_042_ eng2 VDD$1 VDD$1 pfet L=0.5U W=1.22U AS=0.5368P AD=0.5368P
+ PS=3.32U PD=3.32U
* device instance $1111 r0 *1 56.41,10.81 pfet
M$1111 \$323 \_036_ VDD$1 VDD$1 pfet L=0.5U W=1.22U AS=0.5368P AD=0.3172P
+ PS=3.32U PD=1.74U
* device instance $1112 r0 *1 57.43,10.81 pfet
M$1112 \$324 q4 \$323 VDD$1 pfet L=0.5U W=1.22U AS=0.3172P AD=0.3782P PS=1.74U
+ PD=1.84U
* device instance $1113 r0 *1 58.55,10.81 pfet
M$1113 sel_hi_n_8n \_031_ \$324 VDD$1 pfet L=0.5U W=1.22U AS=0.3782P AD=0.5368P
+ PS=1.84U PD=3.32U
* device instance $1114 r0 *1 79.83,10.8075 pfet
M$1114 rel_n_32n eng6 \$301 VDD$1 pfet L=0.5U W=1.215U AS=0.5346P AD=0.3159P
+ PS=3.31U PD=1.735U
* device instance $1115 r0 *1 80.85,10.8075 pfet
M$1115 \$301 mode rel_n_32n VDD$1 pfet L=0.5U W=1.215U AS=0.3159P AD=0.44955P
+ PS=1.735U PD=1.955U
* device instance $1116 r0 *1 82.09,10.8075 pfet
M$1116 VDD$1 sel_in_n \$301 VDD$1 pfet L=0.5U W=1.215U AS=0.44955P AD=0.5346P
+ PS=1.955U PD=3.31U
* device instance $1117 r0 *1 84.31,10.8075 pfet
M$1117 rel_n_256n eng9 \$302 VDD$1 pfet L=0.5U W=1.215U AS=0.5346P AD=0.3159P
+ PS=3.31U PD=1.735U
* device instance $1118 r0 *1 85.33,10.8075 pfet
M$1118 \$302 mode rel_n_256n VDD$1 pfet L=0.5U W=1.215U AS=0.3159P AD=0.44955P
+ PS=1.735U PD=1.955U
* device instance $1119 r0 *1 86.57,10.8075 pfet
M$1119 VDD$1 sel_in_n \$302 VDD$1 pfet L=0.5U W=1.215U AS=0.44955P AD=0.5346P
+ PS=1.955U PD=3.31U
* device instance $1120 r0 *1 111.75,10.81 pfet
M$1120 \$329 q1 VDD$1 VDD$1 pfet L=0.5U W=1.22U AS=0.5368P AD=0.4087P PS=3.32U
+ PD=1.89U
* device instance $1121 r0 *1 112.92,10.81 pfet
M$1121 sel_lo_n_1p \_044_ \$329 VDD$1 pfet L=0.5U W=1.22U AS=0.4087P AD=0.5368P
+ PS=1.89U PD=3.32U
* device instance $1122 r0 *1 115.21,10.81 pfet
M$1122 \$330 \_037_ VDD$1 VDD$1 pfet L=0.5U W=1.22U AS=0.5368P AD=0.3172P
+ PS=3.32U PD=1.74U
* device instance $1123 r0 *1 116.23,10.81 pfet
M$1123 \$331 q5 \$330 VDD$1 pfet L=0.5U W=1.22U AS=0.3172P AD=0.3782P PS=1.74U
+ PD=1.84U
* device instance $1124 r0 *1 117.35,10.81 pfet
M$1124 sel_hi_n_16n \_031_ \$331 VDD$1 pfet L=0.5U W=1.22U AS=0.3782P
+ AD=0.5368P PS=1.84U PD=3.32U
* device instance $1125 r0 *1 120.71,10.8075 pfet
M$1125 rel_n_16n eng5 \$303 VDD$1 pfet L=0.5U W=1.215U AS=0.5346P AD=0.3159P
+ PS=3.31U PD=1.735U
* device instance $1126 r0 *1 121.73,10.8075 pfet
M$1126 \$303 mode rel_n_16n VDD$1 pfet L=0.5U W=1.215U AS=0.3159P AD=0.44955P
+ PS=1.735U PD=1.955U
* device instance $1127 r0 *1 122.97,10.8075 pfet
M$1127 VDD$1 sel_in_n \$303 VDD$1 pfet L=0.5U W=1.215U AS=0.44955P AD=0.5346P
+ PS=1.955U PD=3.31U
* device instance $1128 r0 *1 127.43,10.81 pfet
M$1128 \$332 \_037_ VDD$1 VDD$1 pfet L=0.5U W=1.22U AS=0.5368P AD=0.4087P
+ PS=3.32U PD=1.89U
* device instance $1129 r0 *1 128.6,10.81 pfet
M$1129 sel_lo_n_16p q5 \$332 VDD$1 pfet L=0.5U W=1.22U AS=0.4087P AD=0.5368P
+ PS=1.89U PD=3.32U
* device instance $1130 r0 *1 132.57,10.81 pfet
M$1130 \$334 \_040_ VDD$1 VDD$1 pfet L=0.5U W=1.22U AS=0.5368P AD=0.3172P
+ PS=3.32U PD=1.74U
* device instance $1131 r0 *1 133.59,10.81 pfet
M$1131 \$333 q8 \$334 VDD$1 pfet L=0.5U W=1.22U AS=0.3172P AD=0.3782P PS=1.74U
+ PD=1.84U
* device instance $1132 r0 *1 134.71,10.81 pfet
M$1132 sel_hi_n_128n \_031_ \$333 VDD$1 pfet L=0.5U W=1.22U AS=0.3782P
+ AD=0.5368P PS=1.84U PD=3.32U
* device instance $1133 r0 *1 140.87,10.81 pfet
M$1133 \_039_ eng7 VDD$1 VDD$1 pfet L=0.5U W=1.22U AS=0.5368P AD=0.5368P
+ PS=3.32U PD=3.32U
* device instance $1134 r0 *1 143.11,10.8075 pfet
M$1134 \_006_ \_051_ \$304 VDD$1 pfet L=0.5U W=1.215U AS=0.5346P AD=0.3159P
+ PS=3.31U PD=1.735U
* device instance $1135 r0 *1 144.13,10.8075 pfet
M$1135 \$304 \_039_ \_006_ VDD$1 pfet L=0.5U W=1.215U AS=0.3159P AD=0.44955P
+ PS=1.735U PD=1.955U
* device instance $1136 r0 *1 145.37,10.8075 pfet
M$1136 VDD$1 ph[13] \$304 VDD$1 pfet L=0.5U W=1.215U AS=0.44955P AD=0.5346P
+ PS=1.955U PD=3.31U
* device instance $1137 r0 *1 144.71,5.025 pfet
M$1137 \$190 \$154 VDD VDD pfet L=0.5U W=0.36U AS=0.4554P AD=0.054P PS=3.25U
+ PD=0.66U
* device instance $1138 r0 *1 145.51,5.025 pfet
M$1138 \$170 \_005_ \$190 VDD pfet L=0.5U W=0.36U AS=0.054P AD=0.1872P PS=0.66U
+ PD=1.4U
* device instance $1139 r0 *1 147.05,5.025 pfet
M$1139 \$189 \$152 \$170 VDD pfet L=0.5U W=0.36U AS=0.1872P AD=0.0432P PS=1.4U
+ PD=0.6U
* device instance $1140 r0 *1 147.79,5.025 pfet
M$1140 VDD \$153 \$189 VDD pfet L=0.5U W=0.36U AS=0.0432P AD=0.1044P PS=0.6U
+ PD=0.94U
* device instance $1141 r0 *1 148.87,5.025 pfet
M$1141 \$153 \$170 VDD VDD pfet L=0.5U W=0.36U AS=0.1044P AD=0.1791P PS=0.94U
+ PD=1.355U
* device instance $1142 r0 *1 150.365,5.025 pfet
M$1142 \$171 \$152 \$153 VDD pfet L=0.5U W=0.36U AS=0.1791P AD=0.1665P
+ PS=1.355U PD=1.285U
* device instance $1143 r0 *1 151.79,5.025 pfet
M$1143 \$188 \$154 \$171 VDD pfet L=0.5U W=0.36U AS=0.1665P AD=0.0504P
+ PS=1.285U PD=0.64U
* device instance $1144 r0 *1 152.57,5.025 pfet
M$1144 \$188 \$155 VDD VDD pfet L=0.5U W=0.36U AS=0.23P AD=0.0504P PS=1.54U
+ PD=0.64U
* device instance $1145 r0 *1 153.81,4.805 pfet
M$1145 \$155 \$171 VDD VDD pfet L=0.5U W=0.8U AS=0.23P AD=0.352P PS=1.54U
+ PD=2.48U
* device instance $1146 r0 *1 158.33,10.6325 pfet
M$1146 VDD$1 clknet_2_2__leaf_clk \$265 VDD$1 pfet L=0.5U W=0.865U AS=0.3806P
+ AD=0.2249P PS=2.61U PD=1.385U
* device instance $1147 r0 *1 159.35,10.6325 pfet
M$1147 \$266 \$265 VDD$1 VDD$1 pfet L=0.5U W=0.865U AS=0.2249P AD=0.3806P
+ PS=1.385U PD=2.61U
* device instance $1148 r0 *1 164.31,5.025 pfet
M$1148 \$185 \$158 VDD VDD pfet L=0.5U W=0.36U AS=0.4554P AD=0.054P PS=3.25U
+ PD=0.66U
* device instance $1149 r0 *1 165.11,5.025 pfet
M$1149 \$172 \_009_[0] \$185 VDD pfet L=0.5U W=0.36U AS=0.054P AD=0.1872P
+ PS=0.66U PD=1.4U
* device instance $1150 r0 *1 166.65,5.025 pfet
M$1150 \$184 \$156 \$172 VDD pfet L=0.5U W=0.36U AS=0.1872P AD=0.0432P PS=1.4U
+ PD=0.6U
* device instance $1151 r0 *1 167.39,5.025 pfet
M$1151 VDD \$157 \$184 VDD pfet L=0.5U W=0.36U AS=0.0432P AD=0.1044P PS=0.6U
+ PD=0.94U
* device instance $1152 r0 *1 168.47,5.025 pfet
M$1152 \$157 \$172 VDD VDD pfet L=0.5U W=0.36U AS=0.1044P AD=0.1791P PS=0.94U
+ PD=1.355U
* device instance $1153 r0 *1 169.965,5.025 pfet
M$1153 \$173 \$156 \$157 VDD pfet L=0.5U W=0.36U AS=0.1791P AD=0.1665P
+ PS=1.355U PD=1.285U
* device instance $1154 r0 *1 171.39,5.025 pfet
M$1154 \$182 \$158 \$173 VDD pfet L=0.5U W=0.36U AS=0.1665P AD=0.0504P
+ PS=1.285U PD=0.64U
* device instance $1155 r0 *1 172.17,5.025 pfet
M$1155 \$182 \$159 VDD VDD pfet L=0.5U W=0.36U AS=0.23P AD=0.0504P PS=1.54U
+ PD=0.64U
* device instance $1156 r0 *1 173.41,4.805 pfet
M$1156 \$159 \$173 VDD VDD pfet L=0.5U W=0.8U AS=0.23P AD=0.352P PS=1.54U
+ PD=2.48U
* device instance $1157 r0 *1 172.35,10.81 pfet
M$1157 q6 \$271 VDD$1 VDD$1 pfet L=0.5U W=1.22U AS=0.5368P AD=0.5368P PS=3.32U
+ PD=3.32U
* device instance $1158 r0 *1 175.59,10.81 pfet
M$1158 \$322 start VDD$1 VDD$1 pfet L=0.5U W=1.22U AS=0.5368P AD=0.4087P
+ PS=3.32U PD=1.89U
* device instance $1159 r0 *1 176.76,10.81 pfet
M$1159 \_009_[2] \_034_ \$322 VDD$1 pfet L=0.5U W=1.22U AS=0.4087P AD=0.5368P
+ PS=1.89U PD=3.32U
* device instance $1160 r0 *1 178.95,10.81 pfet
M$1160 \$321 ph[5] VDD$1 VDD$1 pfet L=0.5U W=1.22U AS=0.5368P AD=0.4087P
+ PS=3.32U PD=1.89U
* device instance $1161 r0 *1 180.12,10.81 pfet
M$1161 \_061_ q8 \$321 VDD$1 pfet L=0.5U W=1.22U AS=0.4087P AD=0.5368P PS=1.89U
+ PD=3.32U
* device instance $1162 r0 *1 182.31,10.81 pfet
M$1162 \$320 start VDD$1 VDD$1 pfet L=0.5U W=1.22U AS=0.5368P AD=0.4087P
+ PS=3.32U PD=1.89U
* device instance $1163 r0 *1 183.48,10.81 pfet
M$1163 \_009_[3] \_032_ \$320 VDD$1 pfet L=0.5U W=1.22U AS=0.4087P AD=0.5368P
+ PS=1.89U PD=3.32U
* device instance $1164 r0 *1 16.11,12.71 pfet
M$1164 ph[10] \$338 VDD$1 VDD$1 pfet L=0.5U W=1.22U AS=0.5368P AD=0.5368P
+ PS=3.32U PD=3.32U
* device instance $1165 r0 *1 19.35,12.71 pfet
M$1165 \_046_ ph[11] VDD$1 VDD$1 pfet L=0.5U W=1.22U AS=0.5368P AD=0.5368P
+ PS=3.32U PD=3.32U
* device instance $1166 r0 *1 33.35,12.7125 pfet
M$1166 \_003_ \_048_ \$340 VDD$1 pfet L=0.5U W=1.215U AS=0.5346P AD=0.3159P
+ PS=3.31U PD=1.735U
* device instance $1167 r0 *1 34.37,12.7125 pfet
M$1167 \$340 \_036_ \_003_ VDD$1 pfet L=0.5U W=1.215U AS=0.3159P AD=0.44955P
+ PS=1.735U PD=1.955U
* device instance $1168 r0 *1 35.61,12.7125 pfet
M$1168 VDD$1 ph[13] \$340 VDD$1 pfet L=0.5U W=1.215U AS=0.44955P AD=0.5346P
+ PS=1.955U PD=3.31U
* device instance $1169 r0 *1 37.83,12.7125 pfet
M$1169 \_001_ \_046_ \$342 VDD$1 pfet L=0.5U W=1.215U AS=0.5346P AD=0.3159P
+ PS=3.31U PD=1.735U
* device instance $1170 r0 *1 38.85,12.7125 pfet
M$1170 \$342 \_042_ \_001_ VDD$1 pfet L=0.5U W=1.215U AS=0.3159P AD=0.44955P
+ PS=1.735U PD=1.955U
* device instance $1171 r0 *1 40.09,12.7125 pfet
M$1171 VDD$1 ph[13] \$342 VDD$1 pfet L=0.5U W=1.215U AS=0.44955P AD=0.5346P
+ PS=1.955U PD=3.31U
* device instance $1172 r0 *1 42.31,12.71 pfet
M$1172 \$343 clknet_0_clk VDD$1 VDD$1 pfet L=0.5U W=1.22U AS=0.5368P AD=0.3782P
+ PS=3.32U PD=1.84U
* device instance $1173 r0 *1 43.43,12.71 pfet
M$1173 VDD$1 clknet_0_clk \$343 VDD$1 pfet L=0.5U W=1.22U AS=0.3782P AD=0.3782P
+ PS=1.84U PD=1.84U
* device instance $1174 r0 *1 44.55,12.71 pfet
M$1174 clknet_2_0__leaf_clk \$343 VDD$1 VDD$1 pfet L=0.5U W=1.22U AS=0.3782P
+ AD=0.3782P PS=1.84U PD=1.84U
* device instance $1175 r0 *1 45.67,12.71 pfet
M$1175 VDD$1 \$343 clknet_2_0__leaf_clk VDD$1 pfet L=0.5U W=1.22U AS=0.3782P
+ AD=0.3782P PS=1.84U PD=1.84U
* device instance $1176 r0 *1 46.79,12.71 pfet
M$1176 clknet_2_0__leaf_clk \$343 VDD$1 VDD$1 pfet L=0.5U W=1.22U AS=0.3782P
+ AD=0.3782P PS=1.84U PD=1.84U
* device instance $1177 r0 *1 47.91,12.71 pfet
M$1177 VDD$1 \$343 clknet_2_0__leaf_clk VDD$1 pfet L=0.5U W=1.22U AS=0.3782P
+ AD=0.5368P PS=1.84U PD=3.32U
* device instance $1178 r0 *1 50.71,12.71 pfet
M$1178 \_044_ eng1 VDD$1 VDD$1 pfet L=0.5U W=1.22U AS=0.5368P AD=0.5368P
+ PS=3.32U PD=3.32U
* device instance $1179 r0 *1 54.63,12.71 pfet
M$1179 \$369 \_036_ VDD$1 VDD$1 pfet L=0.5U W=1.22U AS=0.5368P AD=0.4087P
+ PS=3.32U PD=1.89U
* device instance $1180 r0 *1 55.8,12.71 pfet
M$1180 sel_lo_n_8p q4 \$369 VDD$1 pfet L=0.5U W=1.22U AS=0.4087P AD=0.5368P
+ PS=1.89U PD=3.32U
* device instance $1181 r0 *1 58.09,12.71 pfet
M$1181 \$370 q3 VDD$1 VDD$1 pfet L=0.5U W=1.22U AS=0.5368P AD=0.3172P PS=3.32U
+ PD=1.74U
* device instance $1182 r0 *1 59.11,12.71 pfet
M$1182 \$371 \_031_ \$370 VDD$1 pfet L=0.5U W=1.22U AS=0.3172P AD=0.3782P
+ PS=1.74U PD=1.84U
* device instance $1183 r0 *1 60.23,12.71 pfet
M$1183 sel_hi_n_4n \_030_ \$371 VDD$1 pfet L=0.5U W=1.22U AS=0.3782P AD=0.5368P
+ PS=1.84U PD=3.32U
* device instance $1184 r0 *1 60.79,11.115 pfet
M$1184 \$250 eng3 VDD$1 VDD$1 pfet L=0.5U W=0.6U AS=0.264P AD=0.156P PS=2.08U
+ PD=1.12U
* device instance $1185 r0 *1 61.81,11.115 pfet
M$1185 \$250 q3 VDD$1 VDD$1 pfet L=0.5U W=0.6U AS=0.40575P AD=0.156P PS=2.055U
+ PD=1.12U
* device instance $1186 r0 *1 63.15,10.8075 pfet
M$1186 sel_hi_n_4p \$250 VDD$1 VDD$1 pfet L=0.5U W=1.215U AS=0.40575P
+ AD=0.5346P PS=2.055U PD=3.31U
* device instance $1187 r0 *1 62.47,12.405 pfet
M$1187 \$344 mode VDD$1 VDD$1 pfet L=0.5U W=0.6U AS=0.264P AD=0.156P PS=2.08U
+ PD=1.12U
* device instance $1188 r0 *1 63.49,12.405 pfet
M$1188 VDD$1 sel_hi_n_256p \$344 VDD$1 pfet L=0.5U W=0.6U AS=0.156P AD=0.40575P
+ PS=1.12U PD=2.055U
* device instance $1189 r0 *1 64.83,12.7125 pfet
M$1189 sel_lo_n_256n \$344 VDD$1 VDD$1 pfet L=0.5U W=1.215U AS=0.40575P
+ AD=0.5346P PS=2.055U PD=3.31U
* device instance $1190 r0 *1 65.27,11.115 pfet
M$1190 \$251 mode VDD$1 VDD$1 pfet L=0.5U W=0.6U AS=0.264P AD=0.156P PS=2.08U
+ PD=1.12U
* device instance $1191 r0 *1 66.29,11.115 pfet
M$1191 \$251 sel_hi_n_128p VDD$1 VDD$1 pfet L=0.5U W=0.6U AS=0.40575P AD=0.156P
+ PS=2.055U PD=1.12U
* device instance $1192 r0 *1 67.63,10.8075 pfet
M$1192 sel_lo_n_128n \$251 VDD$1 VDD$1 pfet L=0.5U W=1.215U AS=0.40575P
+ AD=0.5346P PS=2.055U PD=3.31U
* device instance $1193 r0 *1 73.67,12.405 pfet
M$1193 \$346 q8 VDD$1 VDD$1 pfet L=0.5U W=0.6U AS=0.264P AD=0.156P PS=2.08U
+ PD=1.12U
* device instance $1194 r0 *1 74.69,12.405 pfet
M$1194 VDD$1 eng8 \$346 VDD$1 pfet L=0.5U W=0.6U AS=0.156P AD=0.40575P PS=1.12U
+ PD=2.055U
* device instance $1195 r0 *1 76.03,12.7125 pfet
M$1195 sel_hi_n_128p \$346 VDD$1 VDD$1 pfet L=0.5U W=1.215U AS=0.40575P
+ AD=0.5346P PS=2.055U PD=3.31U
* device instance $1196 r0 *1 74.23,11.115 pfet
M$1196 \$252 eng1 VDD$1 VDD$1 pfet L=0.5U W=0.6U AS=0.264P AD=0.156P PS=2.08U
+ PD=1.12U
* device instance $1197 r0 *1 75.25,11.115 pfet
M$1197 \$252 q1 VDD$1 VDD$1 pfet L=0.5U W=0.6U AS=0.40575P AD=0.156P PS=2.055U
+ PD=1.12U
* device instance $1198 r0 *1 76.59,10.8075 pfet
M$1198 sel_hi_n_1p \$252 VDD$1 VDD$1 pfet L=0.5U W=1.215U AS=0.40575P
+ AD=0.5346P PS=2.055U PD=3.31U
* device instance $1199 r0 *1 82.63,12.405 pfet
M$1199 \$348 q9 VDD$1 VDD$1 pfet L=0.5U W=0.6U AS=0.264P AD=0.156P PS=2.08U
+ PD=1.12U
* device instance $1200 r0 *1 83.65,12.405 pfet
M$1200 VDD$1 eng9 \$348 VDD$1 pfet L=0.5U W=0.6U AS=0.156P AD=0.40575P PS=1.12U
+ PD=2.055U
* device instance $1201 r0 *1 84.99,12.7125 pfet
M$1201 sel_hi_n_256p \$348 VDD$1 VDD$1 pfet L=0.5U W=1.215U AS=0.40575P
+ AD=0.5346P PS=2.055U PD=3.31U
* device instance $1202 r0 *1 93.27,11.115 pfet
M$1202 \$253 eng2 VDD$1 VDD$1 pfet L=0.5U W=0.6U AS=0.264P AD=0.156P PS=2.08U
+ PD=1.12U
* device instance $1203 r0 *1 94.29,11.115 pfet
M$1203 \$253 q2 VDD$1 VDD$1 pfet L=0.5U W=0.6U AS=0.40575P AD=0.156P PS=2.055U
+ PD=1.12U
* device instance $1204 r0 *1 95.63,10.8075 pfet
M$1204 sel_hi_n_2p \$253 VDD$1 VDD$1 pfet L=0.5U W=1.215U AS=0.40575P
+ AD=0.5346P PS=2.055U PD=3.31U
* device instance $1205 r0 *1 101.67,11.115 pfet
M$1205 \$254 q7 VDD$1 VDD$1 pfet L=0.5U W=0.6U AS=0.264P AD=0.156P PS=2.08U
+ PD=1.12U
* device instance $1206 r0 *1 102.69,11.115 pfet
M$1206 \$254 eng7 VDD$1 VDD$1 pfet L=0.5U W=0.6U AS=0.40575P AD=0.156P
+ PS=2.055U PD=1.12U
* device instance $1207 r0 *1 104.03,10.8075 pfet
M$1207 sel_hi_n_64p \$254 VDD$1 VDD$1 pfet L=0.5U W=1.215U AS=0.40575P
+ AD=0.5346P PS=2.055U PD=3.31U
* device instance $1208 r0 *1 101.79,12.71 pfet
M$1208 c5_r \$352 VDD$1 VDD$1 pfet L=0.5U W=1.22U AS=0.5368P AD=0.5368P
+ PS=3.32U PD=3.32U
* device instance $1209 r0 *1 107.27,11.115 pfet
M$1209 \$256 q5 VDD$1 VDD$1 pfet L=0.5U W=0.6U AS=0.264P AD=0.156P PS=2.08U
+ PD=1.12U
* device instance $1210 r0 *1 108.29,11.115 pfet
M$1210 \$256 eng5 VDD$1 VDD$1 pfet L=0.5U W=0.6U AS=0.40575P AD=0.156P
+ PS=2.055U PD=1.12U
* device instance $1211 r0 *1 109.63,10.8075 pfet
M$1211 sel_hi_n_16p \$256 VDD$1 VDD$1 pfet L=0.5U W=1.215U AS=0.40575P
+ AD=0.5346P PS=2.055U PD=3.31U
* device instance $1212 r0 *1 112.97,12.71 pfet
M$1212 \$379 \_041_ VDD$1 VDD$1 pfet L=0.5U W=1.22U AS=0.5368P AD=0.3172P
+ PS=3.32U PD=1.74U
* device instance $1213 r0 *1 113.99,12.71 pfet
M$1213 \$380 q9 \$379 VDD$1 pfet L=0.5U W=1.22U AS=0.3172P AD=0.3782P PS=1.74U
+ PD=1.84U
* device instance $1214 r0 *1 115.11,12.71 pfet
M$1214 sel_hi_n_256n \_031_ \$380 VDD$1 pfet L=0.5U W=1.22U AS=0.3782P
+ AD=0.5368P PS=1.84U PD=3.32U
* device instance $1215 r0 *1 117.35,12.71 pfet
M$1215 \$381 \_041_ VDD$1 VDD$1 pfet L=0.5U W=1.22U AS=0.5368P AD=0.4087P
+ PS=3.32U PD=1.89U
* device instance $1216 r0 *1 118.52,12.71 pfet
M$1216 sel_lo_n_256p q9 \$381 VDD$1 pfet L=0.5U W=1.22U AS=0.4087P AD=0.5368P
+ PS=1.89U PD=3.32U
* device instance $1217 r0 *1 131.35,12.71 pfet
M$1217 \$378 \_039_ VDD$1 VDD$1 pfet L=0.5U W=1.22U AS=0.5368P AD=0.4087P
+ PS=3.32U PD=1.89U
* device instance $1218 r0 *1 132.52,12.71 pfet
M$1218 sel_lo_n_64p q7 \$378 VDD$1 pfet L=0.5U W=1.22U AS=0.4087P AD=0.5368P
+ PS=1.89U PD=3.32U
* device instance $1219 r0 *1 134.71,12.71 pfet
M$1219 \$375 \_038_ VDD$1 VDD$1 pfet L=0.5U W=1.22U AS=0.5368P AD=0.4087P
+ PS=3.32U PD=1.89U
* device instance $1220 r0 *1 135.88,12.71 pfet
M$1220 sel_lo_n_32p q6 \$375 VDD$1 pfet L=0.5U W=1.22U AS=0.4087P AD=0.5368P
+ PS=1.89U PD=3.32U
* device instance $1221 r0 *1 141.99,12.7125 pfet
M$1221 \_005_ \_050_ \$354 VDD$1 pfet L=0.5U W=1.215U AS=0.5346P AD=0.3159P
+ PS=3.31U PD=1.735U
* device instance $1222 r0 *1 143.01,12.7125 pfet
M$1222 \$354 \_038_ \_005_ VDD$1 pfet L=0.5U W=1.215U AS=0.3159P AD=0.44955P
+ PS=1.735U PD=1.955U
* device instance $1223 r0 *1 144.25,12.7125 pfet
M$1223 VDD$1 ph[13] \$354 VDD$1 pfet L=0.5U W=1.215U AS=0.44955P AD=0.5346P
+ PS=1.955U PD=3.31U
* device instance $1224 r0 *1 147.59,12.71 pfet
M$1224 \$373 start VDD$1 VDD$1 pfet L=0.5U W=1.22U AS=0.5368P AD=0.4087P
+ PS=3.32U PD=1.89U
* device instance $1225 r0 *1 148.76,12.71 pfet
M$1225 \_009_[6] \_052_ \$373 VDD$1 pfet L=0.5U W=1.22U AS=0.4087P AD=0.5368P
+ PS=1.89U PD=3.32U
* device instance $1226 r0 *1 152.63,12.71 pfet
M$1226 \$372 start VDD$1 VDD$1 pfet L=0.5U W=1.22U AS=0.5368P AD=0.4087P
+ PS=3.32U PD=1.89U
* device instance $1227 r0 *1 153.8,12.71 pfet
M$1227 \_009_[7] \_051_ \$372 VDD$1 pfet L=0.5U W=1.22U AS=0.4087P AD=0.5368P
+ PS=1.89U PD=3.32U
* device instance $1228 r0 *1 153.905,11.1375 pfet
M$1228 \$328 start \$264 VDD$1 pfet L=0.5U W=0.565U AS=0.2486P AD=0.1469P
+ PS=2.01U PD=1.085U
* device instance $1229 r0 *1 154.925,11.1375 pfet
M$1229 \$328 ph[15] VDD$1 VDD$1 pfet L=0.5U W=0.565U AS=0.38705P AD=0.1469P
+ PS=2.08U PD=1.085U
* device instance $1230 r0 *1 156.285,10.81 pfet
M$1230 \_009_[0] \$264 VDD$1 VDD$1 pfet L=0.5U W=1.22U AS=0.38705P AD=0.5368P
+ PS=2.08U PD=3.32U
* device instance $1231 r0 *1 158.23,12.71 pfet
M$1231 \_050_ ph[7] VDD$1 VDD$1 pfet L=0.5U W=1.22U AS=0.5368P AD=0.5368P
+ PS=3.32U PD=3.32U
* device instance $1232 r0 *1 161.51,10.655 pfet
M$1232 \$327 \$266 VDD$1 VDD$1 pfet L=0.5U W=0.36U AS=0.4554P AD=0.054P
+ PS=3.25U PD=0.66U
* device instance $1233 r0 *1 162.31,10.655 pfet
M$1233 \$268 \_014_ \$327 VDD$1 pfet L=0.5U W=0.36U AS=0.054P AD=0.1872P
+ PS=0.66U PD=1.4U
* device instance $1234 r0 *1 163.85,10.655 pfet
M$1234 \$326 \$265 \$268 VDD$1 pfet L=0.5U W=0.36U AS=0.1872P AD=0.0432P
+ PS=1.4U PD=0.6U
* device instance $1235 r0 *1 164.59,10.655 pfet
M$1235 VDD$1 \$269 \$326 VDD$1 pfet L=0.5U W=0.36U AS=0.0432P AD=0.1044P
+ PS=0.6U PD=0.94U
* device instance $1236 r0 *1 165.67,10.655 pfet
M$1236 \$269 \$268 VDD$1 VDD$1 pfet L=0.5U W=0.36U AS=0.1044P AD=0.1791P
+ PS=0.94U PD=1.355U
* device instance $1237 r0 *1 167.165,10.655 pfet
M$1237 \$270 \$265 \$269 VDD$1 pfet L=0.5U W=0.36U AS=0.1791P AD=0.1665P
+ PS=1.355U PD=1.285U
* device instance $1238 r0 *1 168.59,10.655 pfet
M$1238 \$325 \$266 \$270 VDD$1 pfet L=0.5U W=0.36U AS=0.1665P AD=0.0504P
+ PS=1.285U PD=0.64U
* device instance $1239 r0 *1 169.37,10.655 pfet
M$1239 VDD$1 \$271 \$325 VDD$1 pfet L=0.5U W=0.36U AS=0.0504P AD=0.23P PS=0.64U
+ PD=1.54U
* device instance $1240 r0 *1 170.61,10.875 pfet
M$1240 \$271 \$270 VDD$1 VDD$1 pfet L=0.5U W=0.8U AS=0.23P AD=0.352P PS=1.54U
+ PD=2.48U
* device instance $1241 r0 *1 163.83,12.71 pfet
M$1241 \$368 ph[7] VDD$1 VDD$1 pfet L=0.5U W=1.22U AS=0.5368P AD=0.4087P
+ PS=3.32U PD=1.89U
* device instance $1242 r0 *1 165,12.71 pfet
M$1242 \_056_ q6 \$368 VDD$1 pfet L=0.5U W=1.22U AS=0.4087P AD=0.5368P PS=1.89U
+ PD=3.32U
* device instance $1243 r0 *1 185.77,11.14 pfet
M$1243 \$318 ph[2] \$275 VDD$1 pfet L=0.5U W=0.56U AS=0.2464P AD=0.196P PS=2U
+ PD=1.26U
* device instance $1244 r0 *1 186.97,11.14 pfet
M$1244 \$319 ph[0] \$318 VDD$1 pfet L=0.5U W=0.56U AS=0.196P AD=0.1736P
+ PS=1.26U PD=1.18U
* device instance $1245 r0 *1 188.09,11.14 pfet
M$1245 \$315 ph[1] \$319 VDD$1 pfet L=0.5U W=0.56U AS=0.1736P AD=0.1736P
+ PS=1.18U PD=1.18U
* device instance $1246 r0 *1 189.21,11.14 pfet
M$1246 \$315 ph[3] VDD$1 VDD$1 pfet L=0.5U W=0.56U AS=0.389P AD=0.1736P
+ PS=2.02U PD=1.18U
* device instance $1247 r0 *1 190.51,10.81 pfet
M$1247 sel_in_n \$275 VDD$1 VDD$1 pfet L=0.5U W=1.22U AS=0.389P AD=0.5368P
+ PS=2.02U PD=3.32U
* device instance $1248 r0 *1 190.27,12.71 pfet
M$1248 q9 \$361 VDD$1 VDD$1 pfet L=0.5U W=1.22U AS=0.5368P AD=0.5368P PS=3.32U
+ PD=3.32U
* device instance $1249 r0 *1 2.09,12.8875 pfet
M$1249 VDD$1 clknet_2_0__leaf_clk \$305 VDD$1 pfet L=0.5U W=0.865U AS=0.3806P
+ AD=0.2249P PS=2.61U PD=1.385U
* device instance $1250 r0 *1 3.11,12.8875 pfet
M$1250 \$306 \$305 VDD$1 VDD$1 pfet L=0.5U W=0.865U AS=0.2249P AD=0.3806P
+ PS=1.385U PD=2.61U
* device instance $1251 r0 *1 5.27,12.865 pfet
M$1251 \$362 \$306 VDD$1 VDD$1 pfet L=0.5U W=0.36U AS=0.4554P AD=0.054P
+ PS=3.25U PD=0.66U
* device instance $1252 r0 *1 6.07,12.865 pfet
M$1252 \$335 \_009_[10] \$362 VDD$1 pfet L=0.5U W=0.36U AS=0.054P AD=0.1872P
+ PS=0.66U PD=1.4U
* device instance $1253 r0 *1 7.61,12.865 pfet
M$1253 \$363 \$305 \$335 VDD$1 pfet L=0.5U W=0.36U AS=0.1872P AD=0.0432P
+ PS=1.4U PD=0.6U
* device instance $1254 r0 *1 8.35,12.865 pfet
M$1254 VDD$1 \$336 \$363 VDD$1 pfet L=0.5U W=0.36U AS=0.0432P AD=0.1044P
+ PS=0.6U PD=0.94U
* device instance $1255 r0 *1 9.43,12.865 pfet
M$1255 \$336 \$335 VDD$1 VDD$1 pfet L=0.5U W=0.36U AS=0.1044P AD=0.1791P
+ PS=0.94U PD=1.355U
* device instance $1256 r0 *1 10.925,12.865 pfet
M$1256 \$337 \$305 \$336 VDD$1 pfet L=0.5U W=0.36U AS=0.1791P AD=0.1665P
+ PS=1.355U PD=1.285U
* device instance $1257 r0 *1 12.35,12.865 pfet
M$1257 \$365 \$306 \$337 VDD$1 pfet L=0.5U W=0.36U AS=0.1665P AD=0.0504P
+ PS=1.285U PD=0.64U
* device instance $1258 r0 *1 13.13,12.865 pfet
M$1258 \$365 \$338 VDD$1 VDD$1 pfet L=0.5U W=0.36U AS=0.23P AD=0.0504P PS=1.54U
+ PD=0.64U
* device instance $1259 r0 *1 14.37,12.645 pfet
M$1259 \$338 \$337 VDD$1 VDD$1 pfet L=0.5U W=0.8U AS=0.23P AD=0.352P PS=1.54U
+ PD=2.48U
* device instance $1260 r0 *1 9.37,18.4725 pfet
M$1260 VDD$2 clknet_2_0__leaf_clk \$444 VDD$2 pfet L=0.5U W=0.865U AS=0.3806P
+ AD=0.2249P PS=2.61U PD=1.385U
* device instance $1261 r0 *1 10.39,18.4725 pfet
M$1261 \$387 \$444 VDD$2 VDD$2 pfet L=0.5U W=0.865U AS=0.2249P AD=0.3806P
+ PS=1.385U PD=2.61U
* device instance $1262 r0 *1 23.39,18.65 pfet
M$1262 q2 \$416 VDD$2 VDD$2 pfet L=0.5U W=1.22U AS=0.5368P AD=0.5368P PS=3.32U
+ PD=3.32U
* device instance $1263 r0 *1 31.67,18.65 pfet
M$1263 \_043_ ph[12] VDD$2 VDD$2 pfet L=0.5U W=1.22U AS=0.5368P AD=0.5368P
+ PS=3.32U PD=3.32U
* device instance $1264 r0 *1 35.13,18.4725 pfet
M$1264 VDD$2 clknet_2_0__leaf_clk \$447 VDD$2 pfet L=0.5U W=0.865U AS=0.3806P
+ AD=0.2249P PS=2.61U PD=1.385U
* device instance $1265 r0 *1 36.15,18.4725 pfet
M$1265 \$388 \$447 VDD$2 VDD$2 pfet L=0.5U W=0.865U AS=0.2249P AD=0.3806P
+ PS=1.385U PD=2.61U
* device instance $1266 r0 *1 49.15,18.65 pfet
M$1266 eng1 \$420 VDD$2 VDD$2 pfet L=0.5U W=1.22U AS=0.5368P AD=0.5368P
+ PS=3.32U PD=3.32U
* device instance $1267 r0 *1 56.41,18.65 pfet
M$1267 VDD$2 \$422 \_013_ VDD$2 pfet L=0.5U W=1.22U AS=0.5368P AD=0.4298375P
+ PS=3.32U PD=2.185U
* device instance $1268 r0 *1 57.875,18.9525 pfet
M$1268 \$520 q0 VDD$2 VDD$2 pfet L=0.5U W=0.615U AS=0.4298375P AD=0.0845625P
+ PS=2.185U PD=0.89U
* device instance $1269 r0 *1 58.65,18.9525 pfet
M$1269 \$422 \$389 \$520 VDD$2 pfet L=0.5U W=0.615U AS=0.0845625P AD=0.1599P
+ PS=0.89U PD=1.135U
* device instance $1270 r0 *1 59.67,18.9525 pfet
M$1270 \$521 ph[14] \$422 VDD$2 pfet L=0.5U W=0.615U AS=0.1599P AD=0.0738P
+ PS=1.135U PD=0.855U
* device instance $1271 r0 *1 60.41,18.9525 pfet
M$1271 VDD$2 c0_r \$521 VDD$2 pfet L=0.5U W=0.615U AS=0.0738P AD=0.1599P
+ PS=0.855U PD=1.135U
* device instance $1272 r0 *1 61.43,18.9525 pfet
M$1272 \$389 ph[14] VDD$2 VDD$2 pfet L=0.5U W=0.615U AS=0.1599P AD=0.2706P
+ PS=1.135U PD=2.11U
* device instance $1273 r0 *1 72.55,18.65 pfet
M$1273 \$522 \_040_ VDD$2 VDD$2 pfet L=0.5U W=1.22U AS=0.5368P AD=0.4087P
+ PS=3.32U PD=1.89U
* device instance $1274 r0 *1 73.72,18.65 pfet
M$1274 sel_lo_n_128p q8 \$522 VDD$2 pfet L=0.5U W=1.22U AS=0.4087P AD=0.5368P
+ PS=1.89U PD=3.32U
* device instance $1275 r0 *1 79.27,18.65 pfet
M$1275 \_040_ eng8 VDD$2 VDD$2 pfet L=0.5U W=1.22U AS=0.5368P AD=0.5368P
+ PS=3.32U PD=3.32U
* device instance $1276 r0 *1 81.61,18.65 pfet
M$1276 VDD$2 \$426 \_011_ VDD$2 pfet L=0.5U W=1.22U AS=0.5368P AD=0.4298375P
+ PS=3.32U PD=2.185U
* device instance $1277 r0 *1 83.075,18.9525 pfet
M$1277 \$523 q9 VDD$2 VDD$2 pfet L=0.5U W=0.615U AS=0.4298375P AD=0.0845625P
+ PS=2.185U PD=0.89U
* device instance $1278 r0 *1 83.85,18.9525 pfet
M$1278 \$426 \$392 \$523 VDD$2 pfet L=0.5U W=0.615U AS=0.0845625P AD=0.1599P
+ PS=0.89U PD=1.135U
* device instance $1279 r0 *1 84.87,18.9525 pfet
M$1279 \$524 ph[14] \$426 VDD$2 pfet L=0.5U W=0.615U AS=0.1599P AD=0.0738P
+ PS=1.135U PD=0.855U
* device instance $1280 r0 *1 85.61,18.9525 pfet
M$1280 VDD$2 c9_r \$524 VDD$2 pfet L=0.5U W=0.615U AS=0.0738P AD=0.1599P
+ PS=0.855U PD=1.135U
* device instance $1281 r0 *1 86.63,18.9525 pfet
M$1281 \$392 ph[14] VDD$2 VDD$2 pfet L=0.5U W=0.615U AS=0.1599P AD=0.2706P
+ PS=1.135U PD=2.11U
* device instance $1282 r0 *1 87.77,12.8875 pfet
M$1282 VDD$1 clknet_2_0__leaf_clk \$309 VDD$1 pfet L=0.5U W=0.865U AS=0.3806P
+ AD=0.2249P PS=2.61U PD=1.385U
* device instance $1283 r0 *1 88.79,12.8875 pfet
M$1283 \$310 \$309 VDD$1 VDD$1 pfet L=0.5U W=0.865U AS=0.2249P AD=0.3806P
+ PS=1.385U PD=2.61U
* device instance $1284 r0 *1 88.89,18.65 pfet
M$1284 VDD$2 \$428 \_016_ VDD$2 pfet L=0.5U W=1.22U AS=0.5368P AD=0.4298375P
+ PS=3.32U PD=2.185U
* device instance $1285 r0 *1 90.355,18.9525 pfet
M$1285 \$526 q2 VDD$2 VDD$2 pfet L=0.5U W=0.615U AS=0.4298375P AD=0.0845625P
+ PS=2.185U PD=0.89U
* device instance $1286 r0 *1 91.13,18.9525 pfet
M$1286 \$428 \$393 \$526 VDD$2 pfet L=0.5U W=0.615U AS=0.0845625P AD=0.1599P
+ PS=0.89U PD=1.135U
* device instance $1287 r0 *1 92.15,18.9525 pfet
M$1287 \$527 ph[14] \$428 VDD$2 pfet L=0.5U W=0.615U AS=0.1599P AD=0.0738P
+ PS=1.135U PD=0.855U
* device instance $1288 r0 *1 92.89,18.9525 pfet
M$1288 VDD$2 c2_r \$527 VDD$2 pfet L=0.5U W=0.615U AS=0.0738P AD=0.1599P
+ PS=0.855U PD=1.135U
* device instance $1289 r0 *1 93.91,18.9525 pfet
M$1289 \$393 ph[14] VDD$2 VDD$2 pfet L=0.5U W=0.615U AS=0.1599P AD=0.2706P
+ PS=1.135U PD=2.11U
* device instance $1290 r0 *1 90.95,12.865 pfet
M$1290 \$374 \$310 VDD$1 VDD$1 pfet L=0.5U W=0.36U AS=0.4554P AD=0.054P
+ PS=3.25U PD=0.66U
* device instance $1291 r0 *1 91.75,12.865 pfet
M$1291 \$349 \_024_ \$374 VDD$1 pfet L=0.5U W=0.36U AS=0.054P AD=0.1872P
+ PS=0.66U PD=1.4U
* device instance $1292 r0 *1 93.29,12.865 pfet
M$1292 \$376 \$309 \$349 VDD$1 pfet L=0.5U W=0.36U AS=0.1872P AD=0.0432P
+ PS=1.4U PD=0.6U
* device instance $1293 r0 *1 94.03,12.865 pfet
M$1293 VDD$1 \$350 \$376 VDD$1 pfet L=0.5U W=0.36U AS=0.0432P AD=0.1044P
+ PS=0.6U PD=0.94U
* device instance $1294 r0 *1 95.11,12.865 pfet
M$1294 \$350 \$349 VDD$1 VDD$1 pfet L=0.5U W=0.36U AS=0.1044P AD=0.1791P
+ PS=0.94U PD=1.355U
* device instance $1295 r0 *1 96.605,12.865 pfet
M$1295 \$351 \$309 \$350 VDD$1 pfet L=0.5U W=0.36U AS=0.1791P AD=0.1665P
+ PS=1.355U PD=1.285U
* device instance $1296 r0 *1 98.03,12.865 pfet
M$1296 \$377 \$310 \$351 VDD$1 pfet L=0.5U W=0.36U AS=0.1665P AD=0.0504P
+ PS=1.285U PD=0.64U
* device instance $1297 r0 *1 98.81,12.865 pfet
M$1297 \$377 \$352 VDD$1 VDD$1 pfet L=0.5U W=0.36U AS=0.23P AD=0.0504P PS=1.54U
+ PD=0.64U
* device instance $1298 r0 *1 100.05,12.645 pfet
M$1298 \$352 \$351 VDD$1 VDD$1 pfet L=0.5U W=0.8U AS=0.23P AD=0.352P PS=1.54U
+ PD=2.48U
* device instance $1299 r0 *1 104.01,18.4725 pfet
M$1299 VDD$2 clknet_2_2__leaf_clk \$450 VDD$2 pfet L=0.5U W=0.865U AS=0.3806P
+ AD=0.2249P PS=2.61U PD=1.385U
* device instance $1300 r0 *1 105.03,18.4725 pfet
M$1300 \$394 \$450 VDD$2 VDD$2 pfet L=0.5U W=0.865U AS=0.2249P AD=0.3806P
+ PS=1.385U PD=2.61U
* device instance $1301 r0 *1 118.03,18.65 pfet
M$1301 c1_r \$431 VDD$2 VDD$2 pfet L=0.5U W=1.22U AS=0.5368P AD=0.5368P
+ PS=3.32U PD=3.32U
* device instance $1302 r0 *1 120.15,18.65 pfet
M$1302 \_037_ eng5 VDD$2 VDD$2 pfet L=0.5U W=1.22U AS=0.5368P AD=0.5368P
+ PS=3.32U PD=3.32U
* device instance $1303 r0 *1 128.09,18.4725 pfet
M$1303 VDD$2 clknet_2_2__leaf_clk \$453 VDD$2 pfet L=0.5U W=0.865U AS=0.3806P
+ AD=0.2249P PS=2.61U PD=1.385U
* device instance $1304 r0 *1 129.11,18.4725 pfet
M$1304 \$395 \$453 VDD$2 VDD$2 pfet L=0.5U W=0.865U AS=0.2249P AD=0.3806P
+ PS=1.385U PD=2.61U
* device instance $1305 r0 *1 142.11,18.65 pfet
M$1305 eng5 \$434 VDD$2 VDD$2 pfet L=0.5U W=1.22U AS=0.5368P AD=0.5368P
+ PS=3.32U PD=3.32U
* device instance $1306 r0 *1 144.89,18.4725 pfet
M$1306 VDD$2 clknet_2_3__leaf_clk \$456 VDD$2 pfet L=0.5U W=0.865U AS=0.3806P
+ AD=0.2249P PS=2.61U PD=1.385U
* device instance $1307 r0 *1 145.91,18.4725 pfet
M$1307 \$396 \$456 VDD$2 VDD$2 pfet L=0.5U W=0.865U AS=0.2249P AD=0.3806P
+ PS=1.385U PD=2.61U
* device instance $1308 r0 *1 158.91,18.65 pfet
M$1308 ph[6] \$438 VDD$2 VDD$2 pfet L=0.5U W=1.22U AS=0.5368P AD=0.5368P
+ PS=3.32U PD=3.32U
* device instance $1309 r0 *1 162.15,18.6475 pfet
M$1309 \_014_ cmp \$487 VDD$2 pfet L=0.5U W=1.215U AS=0.5346P AD=0.3159P
+ PS=3.31U PD=1.735U
* device instance $1310 r0 *1 163.17,18.6475 pfet
M$1310 \$487 ph[7] \_014_ VDD$2 pfet L=0.5U W=1.215U AS=0.3159P AD=0.44955P
+ PS=1.735U PD=1.955U
* device instance $1311 r0 *1 164.41,18.6475 pfet
M$1311 VDD$2 \_056_ \$487 VDD$2 pfet L=0.5U W=1.215U AS=0.44955P AD=0.5346P
+ PS=1.955U PD=3.31U
* device instance $1312 r0 *1 174.01,18.4725 pfet
M$1312 VDD$2 clknet_2_2__leaf_clk \$458 VDD$2 pfet L=0.5U W=0.865U AS=0.3806P
+ AD=0.2249P PS=2.61U PD=1.385U
* device instance $1313 r0 *1 175.03,18.4725 pfet
M$1313 \$397 \$458 VDD$2 VDD$2 pfet L=0.5U W=0.865U AS=0.2249P AD=0.3806P
+ PS=1.385U PD=2.61U
* device instance $1314 r0 *1 176.25,12.8875 pfet
M$1314 VDD$1 clknet_2_2__leaf_clk \$312 VDD$1 pfet L=0.5U W=0.865U AS=0.3806P
+ AD=0.2249P PS=2.61U PD=1.385U
* device instance $1315 r0 *1 177.27,12.8875 pfet
M$1315 \$313 \$312 VDD$1 VDD$1 pfet L=0.5U W=0.865U AS=0.2249P AD=0.3806P
+ PS=1.385U PD=2.61U
* device instance $1316 r0 *1 179.43,12.865 pfet
M$1316 \$367 \$313 VDD$1 VDD$1 pfet L=0.5U W=0.36U AS=0.4554P AD=0.054P
+ PS=3.25U PD=0.66U
* device instance $1317 r0 *1 180.23,12.865 pfet
M$1317 \$358 \_026_ \$367 VDD$1 pfet L=0.5U W=0.36U AS=0.054P AD=0.1872P
+ PS=0.66U PD=1.4U
* device instance $1318 r0 *1 181.77,12.865 pfet
M$1318 \$366 \$312 \$358 VDD$1 pfet L=0.5U W=0.36U AS=0.1872P AD=0.0432P
+ PS=1.4U PD=0.6U
* device instance $1319 r0 *1 182.51,12.865 pfet
M$1319 VDD$1 \$359 \$366 VDD$1 pfet L=0.5U W=0.36U AS=0.0432P AD=0.1044P
+ PS=0.6U PD=0.94U
* device instance $1320 r0 *1 183.59,12.865 pfet
M$1320 \$359 \$358 VDD$1 VDD$1 pfet L=0.5U W=0.36U AS=0.1044P AD=0.1791P
+ PS=0.94U PD=1.355U
* device instance $1321 r0 *1 185.085,12.865 pfet
M$1321 \$360 \$312 \$359 VDD$1 pfet L=0.5U W=0.36U AS=0.1791P AD=0.1665P
+ PS=1.355U PD=1.285U
* device instance $1322 r0 *1 186.51,12.865 pfet
M$1322 \$364 \$313 \$360 VDD$1 pfet L=0.5U W=0.36U AS=0.1665P AD=0.0504P
+ PS=1.285U PD=0.64U
* device instance $1323 r0 *1 187.29,12.865 pfet
M$1323 \$364 \$361 VDD$1 VDD$1 pfet L=0.5U W=0.36U AS=0.23P AD=0.0504P PS=1.54U
+ PD=0.64U
* device instance $1324 r0 *1 188.53,12.645 pfet
M$1324 \$361 \$360 VDD$1 VDD$1 pfet L=0.5U W=0.8U AS=0.23P AD=0.352P PS=1.54U
+ PD=2.48U
* device instance $1325 r0 *1 188.03,18.65 pfet
M$1325 q8 \$441 VDD$2 VDD$2 pfet L=0.5U W=1.22U AS=0.5368P AD=0.5368P PS=3.32U
+ PD=3.32U
* device instance $1326 r0 *1 190.15,18.65 pfet
M$1326 \$511 start VDD$2 VDD$2 pfet L=0.5U W=1.22U AS=0.5368P AD=0.4087P
+ PS=3.32U PD=1.89U
* device instance $1327 r0 *1 191.32,18.65 pfet
M$1327 \_009_[4] \_035_ \$511 VDD$2 pfet L=0.5U W=1.22U AS=0.4087P AD=0.5368P
+ PS=1.89U PD=3.32U
* device instance $1328 r0 *1 12.55,18.495 pfet
M$1328 \$510 \$387 VDD$2 VDD$2 pfet L=0.5U W=0.36U AS=0.4554P AD=0.054P
+ PS=3.25U PD=0.66U
* device instance $1329 r0 *1 13.35,18.495 pfet
M$1329 \$446 \_017_ \$510 VDD$2 pfet L=0.5U W=0.36U AS=0.054P AD=0.1872P
+ PS=0.66U PD=1.4U
* device instance $1330 r0 *1 14.89,18.495 pfet
M$1330 \$512 \$444 \$446 VDD$2 pfet L=0.5U W=0.36U AS=0.1872P AD=0.0432P
+ PS=1.4U PD=0.6U
* device instance $1331 r0 *1 15.63,18.495 pfet
M$1331 VDD$2 \$414 \$512 VDD$2 pfet L=0.5U W=0.36U AS=0.0432P AD=0.1044P
+ PS=0.6U PD=0.94U
* device instance $1332 r0 *1 16.71,18.495 pfet
M$1332 \$414 \$446 VDD$2 VDD$2 pfet L=0.5U W=0.36U AS=0.1044P AD=0.1791P
+ PS=0.94U PD=1.355U
* device instance $1333 r0 *1 18.205,18.495 pfet
M$1333 \$415 \$444 \$414 VDD$2 pfet L=0.5U W=0.36U AS=0.1791P AD=0.1665P
+ PS=1.355U PD=1.285U
* device instance $1334 r0 *1 19.63,18.495 pfet
M$1334 \$513 \$387 \$415 VDD$2 pfet L=0.5U W=0.36U AS=0.1665P AD=0.0504P
+ PS=1.285U PD=0.64U
* device instance $1335 r0 *1 20.41,18.495 pfet
M$1335 VDD$2 \$416 \$513 VDD$2 pfet L=0.5U W=0.36U AS=0.0504P AD=0.23P PS=0.64U
+ PD=1.54U
* device instance $1336 r0 *1 21.65,18.715 pfet
M$1336 \$416 \$415 VDD$2 VDD$2 pfet L=0.5U W=0.8U AS=0.23P AD=0.352P PS=1.54U
+ PD=2.48U
* device instance $1337 r0 *1 38.31,18.495 pfet
M$1337 \$516 \$388 VDD$2 VDD$2 pfet L=0.5U W=0.36U AS=0.4554P AD=0.054P
+ PS=3.25U PD=0.66U
* device instance $1338 r0 *1 39.11,18.495 pfet
M$1338 \$448 \_000_ \$516 VDD$2 pfet L=0.5U W=0.36U AS=0.054P AD=0.1872P
+ PS=0.66U PD=1.4U
* device instance $1339 r0 *1 40.65,18.495 pfet
M$1339 \$517 \$447 \$448 VDD$2 pfet L=0.5U W=0.36U AS=0.1872P AD=0.0432P
+ PS=1.4U PD=0.6U
* device instance $1340 r0 *1 41.39,18.495 pfet
M$1340 VDD$2 \$418 \$517 VDD$2 pfet L=0.5U W=0.36U AS=0.0432P AD=0.1044P
+ PS=0.6U PD=0.94U
* device instance $1341 r0 *1 42.47,18.495 pfet
M$1341 \$418 \$448 VDD$2 VDD$2 pfet L=0.5U W=0.36U AS=0.1044P AD=0.1791P
+ PS=0.94U PD=1.355U
* device instance $1342 r0 *1 43.965,18.495 pfet
M$1342 \$419 \$447 \$418 VDD$2 pfet L=0.5U W=0.36U AS=0.1791P AD=0.1665P
+ PS=1.355U PD=1.285U
* device instance $1343 r0 *1 45.39,18.495 pfet
M$1343 \$518 \$388 \$419 VDD$2 pfet L=0.5U W=0.36U AS=0.1665P AD=0.0504P
+ PS=1.285U PD=0.64U
* device instance $1344 r0 *1 46.17,18.495 pfet
M$1344 VDD$2 \$420 \$518 VDD$2 pfet L=0.5U W=0.36U AS=0.0504P AD=0.23P PS=0.64U
+ PD=1.54U
* device instance $1345 r0 *1 47.41,18.715 pfet
M$1345 \$420 \$419 VDD$2 VDD$2 pfet L=0.5U W=0.8U AS=0.23P AD=0.352P PS=1.54U
+ PD=2.48U
* device instance $1346 r0 *1 107.19,18.495 pfet
M$1346 \$529 \$394 VDD$2 VDD$2 pfet L=0.5U W=0.36U AS=0.4554P AD=0.054P
+ PS=3.25U PD=0.66U
* device instance $1347 r0 *1 107.99,18.495 pfet
M$1347 \$452 \_015_ \$529 VDD$2 pfet L=0.5U W=0.36U AS=0.054P AD=0.1872P
+ PS=0.66U PD=1.4U
* device instance $1348 r0 *1 109.53,18.495 pfet
M$1348 \$531 \$450 \$452 VDD$2 pfet L=0.5U W=0.36U AS=0.1872P AD=0.0432P
+ PS=1.4U PD=0.6U
* device instance $1349 r0 *1 110.27,18.495 pfet
M$1349 VDD$2 \$429 \$531 VDD$2 pfet L=0.5U W=0.36U AS=0.0432P AD=0.1044P
+ PS=0.6U PD=0.94U
* device instance $1350 r0 *1 111.35,18.495 pfet
M$1350 \$429 \$452 VDD$2 VDD$2 pfet L=0.5U W=0.36U AS=0.1044P AD=0.1791P
+ PS=0.94U PD=1.355U
* device instance $1351 r0 *1 112.845,18.495 pfet
M$1351 \$430 \$450 \$429 VDD$2 pfet L=0.5U W=0.36U AS=0.1791P AD=0.1665P
+ PS=1.355U PD=1.285U
* device instance $1352 r0 *1 114.27,18.495 pfet
M$1352 \$532 \$394 \$430 VDD$2 pfet L=0.5U W=0.36U AS=0.1665P AD=0.0504P
+ PS=1.285U PD=0.64U
* device instance $1353 r0 *1 115.05,18.495 pfet
M$1353 VDD$2 \$431 \$532 VDD$2 pfet L=0.5U W=0.36U AS=0.0504P AD=0.23P PS=0.64U
+ PD=1.54U
* device instance $1354 r0 *1 116.29,18.715 pfet
M$1354 \$431 \$430 VDD$2 VDD$2 pfet L=0.5U W=0.8U AS=0.23P AD=0.352P PS=1.54U
+ PD=2.48U
* device instance $1355 r0 *1 131.27,18.495 pfet
M$1355 \$534 \$395 VDD$2 VDD$2 pfet L=0.5U W=0.36U AS=0.4554P AD=0.054P
+ PS=3.25U PD=0.66U
* device instance $1356 r0 *1 132.07,18.495 pfet
M$1356 \$455 \_004_ \$534 VDD$2 pfet L=0.5U W=0.36U AS=0.054P AD=0.1872P
+ PS=0.66U PD=1.4U
* device instance $1357 r0 *1 133.61,18.495 pfet
M$1357 \$535 \$453 \$455 VDD$2 pfet L=0.5U W=0.36U AS=0.1872P AD=0.0432P
+ PS=1.4U PD=0.6U
* device instance $1358 r0 *1 134.35,18.495 pfet
M$1358 VDD$2 \$432 \$535 VDD$2 pfet L=0.5U W=0.36U AS=0.0432P AD=0.1044P
+ PS=0.6U PD=0.94U
* device instance $1359 r0 *1 135.43,18.495 pfet
M$1359 \$432 \$455 VDD$2 VDD$2 pfet L=0.5U W=0.36U AS=0.1044P AD=0.1791P
+ PS=0.94U PD=1.355U
* device instance $1360 r0 *1 136.925,18.495 pfet
M$1360 \$433 \$453 \$432 VDD$2 pfet L=0.5U W=0.36U AS=0.1791P AD=0.1665P
+ PS=1.355U PD=1.285U
* device instance $1361 r0 *1 138.35,18.495 pfet
M$1361 \$533 \$395 \$433 VDD$2 pfet L=0.5U W=0.36U AS=0.1665P AD=0.0504P
+ PS=1.285U PD=0.64U
* device instance $1362 r0 *1 139.13,18.495 pfet
M$1362 VDD$2 \$434 \$533 VDD$2 pfet L=0.5U W=0.36U AS=0.0504P AD=0.23P PS=0.64U
+ PD=1.54U
* device instance $1363 r0 *1 140.37,18.715 pfet
M$1363 \$434 \$433 VDD$2 VDD$2 pfet L=0.5U W=0.8U AS=0.23P AD=0.352P PS=1.54U
+ PD=2.48U
* device instance $1364 r0 *1 148.07,18.495 pfet
M$1364 \$530 \$396 VDD$2 VDD$2 pfet L=0.5U W=0.36U AS=0.4554P AD=0.054P
+ PS=3.25U PD=0.66U
* device instance $1365 r0 *1 148.87,18.495 pfet
M$1365 \$457 \_009_[6] \$530 VDD$2 pfet L=0.5U W=0.36U AS=0.054P AD=0.1872P
+ PS=0.66U PD=1.4U
* device instance $1366 r0 *1 150.41,18.495 pfet
M$1366 \$528 \$456 \$457 VDD$2 pfet L=0.5U W=0.36U AS=0.1872P AD=0.0432P
+ PS=1.4U PD=0.6U
* device instance $1367 r0 *1 151.15,18.495 pfet
M$1367 VDD$2 \$436 \$528 VDD$2 pfet L=0.5U W=0.36U AS=0.0432P AD=0.1044P
+ PS=0.6U PD=0.94U
* device instance $1368 r0 *1 152.23,18.495 pfet
M$1368 \$436 \$457 VDD$2 VDD$2 pfet L=0.5U W=0.36U AS=0.1044P AD=0.1791P
+ PS=0.94U PD=1.355U
* device instance $1369 r0 *1 153.725,18.495 pfet
M$1369 \$437 \$456 \$436 VDD$2 pfet L=0.5U W=0.36U AS=0.1791P AD=0.1665P
+ PS=1.355U PD=1.285U
* device instance $1370 r0 *1 155.15,18.495 pfet
M$1370 \$525 \$396 \$437 VDD$2 pfet L=0.5U W=0.36U AS=0.1665P AD=0.0504P
+ PS=1.285U PD=0.64U
* device instance $1371 r0 *1 155.93,18.495 pfet
M$1371 VDD$2 \$438 \$525 VDD$2 pfet L=0.5U W=0.36U AS=0.0504P AD=0.23P PS=0.64U
+ PD=1.54U
* device instance $1372 r0 *1 157.17,18.715 pfet
M$1372 \$438 \$437 VDD$2 VDD$2 pfet L=0.5U W=0.8U AS=0.23P AD=0.352P PS=1.54U
+ PD=2.48U
* device instance $1373 r0 *1 177.19,18.495 pfet
M$1373 \$519 \$397 VDD$2 VDD$2 pfet L=0.5U W=0.36U AS=0.4554P AD=0.054P
+ PS=3.25U PD=0.66U
* device instance $1374 r0 *1 177.99,18.495 pfet
M$1374 \$460 \_022_ \$519 VDD$2 pfet L=0.5U W=0.36U AS=0.054P AD=0.1872P
+ PS=0.66U PD=1.4U
* device instance $1375 r0 *1 179.53,18.495 pfet
M$1375 \$515 \$458 \$460 VDD$2 pfet L=0.5U W=0.36U AS=0.1872P AD=0.0432P
+ PS=1.4U PD=0.6U
* device instance $1376 r0 *1 180.27,18.495 pfet
M$1376 VDD$2 \$439 \$515 VDD$2 pfet L=0.5U W=0.36U AS=0.0432P AD=0.1044P
+ PS=0.6U PD=0.94U
* device instance $1377 r0 *1 181.35,18.495 pfet
M$1377 \$439 \$460 VDD$2 VDD$2 pfet L=0.5U W=0.36U AS=0.1044P AD=0.1791P
+ PS=0.94U PD=1.355U
* device instance $1378 r0 *1 182.845,18.495 pfet
M$1378 \$440 \$458 \$439 VDD$2 pfet L=0.5U W=0.36U AS=0.1791P AD=0.1665P
+ PS=1.355U PD=1.285U
* device instance $1379 r0 *1 184.27,18.495 pfet
M$1379 \$514 \$397 \$440 VDD$2 pfet L=0.5U W=0.36U AS=0.1665P AD=0.0504P
+ PS=1.285U PD=0.64U
* device instance $1380 r0 *1 185.05,18.495 pfet
M$1380 VDD$2 \$441 \$514 VDD$2 pfet L=0.5U W=0.36U AS=0.0504P AD=0.23P PS=0.64U
+ PD=1.54U
* device instance $1381 r0 *1 186.29,18.715 pfet
M$1381 \$441 \$440 VDD$2 VDD$2 pfet L=0.5U W=0.8U AS=0.23P AD=0.352P PS=1.54U
+ PD=2.48U
* device instance $1382 r0 *1 9.83,20.5525 pfet
M$1382 \_025_ cmp \$488 VDD$2 pfet L=0.5U W=1.215U AS=0.5346P AD=0.3159P
+ PS=3.31U PD=1.735U
* device instance $1383 r0 *1 10.85,20.5525 pfet
M$1383 \$488 ph[9] \_025_ VDD$2 pfet L=0.5U W=1.215U AS=0.3159P AD=0.44955P
+ PS=1.735U PD=1.955U
* device instance $1384 r0 *1 12.09,20.5525 pfet
M$1384 VDD$2 \_062_ \$488 VDD$2 pfet L=0.5U W=1.215U AS=0.44955P AD=0.5346P
+ PS=1.955U PD=3.31U
* device instance $1385 r0 *1 14.31,20.55 pfet
M$1385 \_048_ ph[9] VDD$2 VDD$2 pfet L=0.5U W=1.22U AS=0.5368P AD=0.5368P
+ PS=3.32U PD=3.32U
* device instance $1386 r0 *1 16.55,20.55 pfet
M$1386 \$565 start VDD$2 VDD$2 pfet L=0.5U W=1.22U AS=0.5368P AD=0.4087P
+ PS=3.32U PD=1.89U
* device instance $1387 r0 *1 17.72,20.55 pfet
M$1387 \_009_[12] \_046_ \$565 VDD$2 pfet L=0.5U W=1.22U AS=0.4087P AD=0.5368P
+ PS=1.89U PD=3.32U
* device instance $1388 r0 *1 30.09,20.7275 pfet
M$1388 VDD$2 clknet_2_0__leaf_clk \$492 VDD$2 pfet L=0.5U W=0.865U AS=0.3806P
+ AD=0.2249P PS=2.61U PD=1.385U
* device instance $1389 r0 *1 31.11,20.7275 pfet
M$1389 \$493 \$492 VDD$2 VDD$2 pfet L=0.5U W=0.865U AS=0.2249P AD=0.3806P
+ PS=1.385U PD=2.61U
* device instance $1390 r0 *1 33.27,20.705 pfet
M$1390 \$567 \$493 VDD$2 VDD$2 pfet L=0.5U W=0.36U AS=0.4554P AD=0.054P
+ PS=3.25U PD=0.66U
* device instance $1391 r0 *1 34.07,20.705 pfet
M$1391 \$537 \_003_ \$567 VDD$2 pfet L=0.5U W=0.36U AS=0.054P AD=0.1872P
+ PS=0.66U PD=1.4U
* device instance $1392 r0 *1 35.61,20.705 pfet
M$1392 \$569 \$492 \$537 VDD$2 pfet L=0.5U W=0.36U AS=0.1872P AD=0.0432P
+ PS=1.4U PD=0.6U
* device instance $1393 r0 *1 36.35,20.705 pfet
M$1393 VDD$2 \$538 \$569 VDD$2 pfet L=0.5U W=0.36U AS=0.0432P AD=0.1044P
+ PS=0.6U PD=0.94U
* device instance $1394 r0 *1 37.43,20.705 pfet
M$1394 \$538 \$537 VDD$2 VDD$2 pfet L=0.5U W=0.36U AS=0.1044P AD=0.1791P
+ PS=0.94U PD=1.355U
* device instance $1395 r0 *1 38.925,20.705 pfet
M$1395 \$539 \$492 \$538 VDD$2 pfet L=0.5U W=0.36U AS=0.1791P AD=0.1665P
+ PS=1.355U PD=1.285U
* device instance $1396 r0 *1 40.35,20.705 pfet
M$1396 \$570 \$493 \$539 VDD$2 pfet L=0.5U W=0.36U AS=0.1665P AD=0.0504P
+ PS=1.285U PD=0.64U
* device instance $1397 r0 *1 41.13,20.705 pfet
M$1397 \$570 \$540 VDD$2 VDD$2 pfet L=0.5U W=0.36U AS=0.23P AD=0.0504P PS=1.54U
+ PD=0.64U
* device instance $1398 r0 *1 42.37,20.485 pfet
M$1398 \$540 \$539 VDD$2 VDD$2 pfet L=0.5U W=0.8U AS=0.23P AD=0.352P PS=1.54U
+ PD=2.48U
* device instance $1399 r0 *1 44.11,20.55 pfet
M$1399 eng4 \$540 VDD$2 VDD$2 pfet L=0.5U W=1.22U AS=0.5368P AD=0.5368P
+ PS=3.32U PD=3.32U
* device instance $1400 r0 *1 46.23,20.55 pfet
M$1400 \$494 clknet_0_clk VDD$2 VDD$2 pfet L=0.5U W=1.22U AS=0.5368P AD=0.3782P
+ PS=3.32U PD=1.84U
* device instance $1401 r0 *1 47.35,20.55 pfet
M$1401 VDD$2 clknet_0_clk \$494 VDD$2 pfet L=0.5U W=1.22U AS=0.3782P AD=0.3782P
+ PS=1.84U PD=1.84U
* device instance $1402 r0 *1 48.47,20.55 pfet
M$1402 clknet_2_1__leaf_clk \$494 VDD$2 VDD$2 pfet L=0.5U W=1.22U AS=0.3782P
+ AD=0.3782P PS=1.84U PD=1.84U
* device instance $1403 r0 *1 49.59,20.55 pfet
M$1403 VDD$2 \$494 clknet_2_1__leaf_clk VDD$2 pfet L=0.5U W=1.22U AS=0.3782P
+ AD=0.3782P PS=1.84U PD=1.84U
* device instance $1404 r0 *1 50.71,20.55 pfet
M$1404 clknet_2_1__leaf_clk \$494 VDD$2 VDD$2 pfet L=0.5U W=1.22U AS=0.3782P
+ AD=0.3782P PS=1.84U PD=1.84U
* device instance $1405 r0 *1 51.83,20.55 pfet
M$1405 VDD$2 \$494 clknet_2_1__leaf_clk VDD$2 pfet L=0.5U W=1.22U AS=0.3782P
+ AD=0.5368P PS=1.84U PD=3.32U
* device instance $1406 r0 *1 56.41,20.7275 pfet
M$1406 VDD$2 clknet_2_1__leaf_clk \$496 VDD$2 pfet L=0.5U W=0.865U AS=0.3806P
+ AD=0.2249P PS=2.61U PD=1.385U
* device instance $1407 r0 *1 57.43,20.7275 pfet
M$1407 \$497 \$496 VDD$2 VDD$2 pfet L=0.5U W=0.865U AS=0.2249P AD=0.3806P
+ PS=1.385U PD=2.61U
* device instance $1408 r0 *1 59.59,20.705 pfet
M$1408 \$574 \$497 VDD$2 VDD$2 pfet L=0.5U W=0.36U AS=0.4554P AD=0.054P
+ PS=3.25U PD=0.66U
* device instance $1409 r0 *1 60.39,20.705 pfet
M$1409 \$541 \_023_ \$574 VDD$2 pfet L=0.5U W=0.36U AS=0.054P AD=0.1872P
+ PS=0.66U PD=1.4U
* device instance $1410 r0 *1 61.93,20.705 pfet
M$1410 \$575 \$496 \$541 VDD$2 pfet L=0.5U W=0.36U AS=0.1872P AD=0.0432P
+ PS=1.4U PD=0.6U
* device instance $1411 r0 *1 62.67,20.705 pfet
M$1411 VDD$2 \$542 \$575 VDD$2 pfet L=0.5U W=0.36U AS=0.0432P AD=0.1044P
+ PS=0.6U PD=0.94U
* device instance $1412 r0 *1 63.75,20.705 pfet
M$1412 \$542 \$541 VDD$2 VDD$2 pfet L=0.5U W=0.36U AS=0.1044P AD=0.1791P
+ PS=0.94U PD=1.355U
* device instance $1413 r0 *1 65.245,20.705 pfet
M$1413 \$543 \$496 \$542 VDD$2 pfet L=0.5U W=0.36U AS=0.1791P AD=0.1665P
+ PS=1.355U PD=1.285U
* device instance $1414 r0 *1 66.67,20.705 pfet
M$1414 \$576 \$497 \$543 VDD$2 pfet L=0.5U W=0.36U AS=0.1665P AD=0.0504P
+ PS=1.285U PD=0.64U
* device instance $1415 r0 *1 67.45,20.705 pfet
M$1415 \$576 \$544 VDD$2 VDD$2 pfet L=0.5U W=0.36U AS=0.23P AD=0.0504P PS=1.54U
+ PD=0.64U
* device instance $1416 r0 *1 68.69,20.485 pfet
M$1416 \$544 \$543 VDD$2 VDD$2 pfet L=0.5U W=0.8U AS=0.23P AD=0.352P PS=1.54U
+ PD=2.48U
* device instance $1417 r0 *1 63.59,18.955 pfet
M$1417 \$423 mode VDD$2 VDD$2 pfet L=0.5U W=0.6U AS=0.264P AD=0.156P PS=2.08U
+ PD=1.12U
* device instance $1418 r0 *1 64.61,18.955 pfet
M$1418 \$423 sel_hi_n_16p VDD$2 VDD$2 pfet L=0.5U W=0.6U AS=0.40575P AD=0.156P
+ PS=2.055U PD=1.12U
* device instance $1419 r0 *1 65.95,18.6475 pfet
M$1419 sel_lo_n_16n \$423 VDD$2 VDD$2 pfet L=0.5U W=1.215U AS=0.40575P
+ AD=0.5346P PS=2.055U PD=3.31U
* device instance $1420 r0 *1 70.43,20.55 pfet
M$1420 c4_r \$544 VDD$2 VDD$2 pfet L=0.5U W=1.22U AS=0.5368P AD=0.5368P
+ PS=3.32U PD=3.32U
* device instance $1421 r0 *1 84.97,20.7275 pfet
M$1421 VDD$2 clknet_2_0__leaf_clk \$498 VDD$2 pfet L=0.5U W=0.865U AS=0.3806P
+ AD=0.2249P PS=2.61U PD=1.385U
* device instance $1422 r0 *1 85.99,20.7275 pfet
M$1422 \$500 \$498 VDD$2 VDD$2 pfet L=0.5U W=0.865U AS=0.2249P AD=0.3806P
+ PS=1.385U PD=2.61U
* device instance $1423 r0 *1 88.15,20.705 pfet
M$1423 \$578 \$500 VDD$2 VDD$2 pfet L=0.5U W=0.36U AS=0.4554P AD=0.054P
+ PS=3.25U PD=0.66U
* device instance $1424 r0 *1 88.95,20.705 pfet
M$1424 \$546 \_007_ \$578 VDD$2 pfet L=0.5U W=0.36U AS=0.054P AD=0.1872P
+ PS=0.66U PD=1.4U
* device instance $1425 r0 *1 90.49,20.705 pfet
M$1425 \$579 \$498 \$546 VDD$2 pfet L=0.5U W=0.36U AS=0.1872P AD=0.0432P
+ PS=1.4U PD=0.6U
* device instance $1426 r0 *1 91.23,20.705 pfet
M$1426 VDD$2 \$547 \$579 VDD$2 pfet L=0.5U W=0.36U AS=0.0432P AD=0.1044P
+ PS=0.6U PD=0.94U
* device instance $1427 r0 *1 92.31,20.705 pfet
M$1427 \$547 \$546 VDD$2 VDD$2 pfet L=0.5U W=0.36U AS=0.1044P AD=0.1791P
+ PS=0.94U PD=1.355U
* device instance $1428 r0 *1 93.805,20.705 pfet
M$1428 \$548 \$498 \$547 VDD$2 pfet L=0.5U W=0.36U AS=0.1791P AD=0.1665P
+ PS=1.355U PD=1.285U
* device instance $1429 r0 *1 95.23,20.705 pfet
M$1429 \$580 \$500 \$548 VDD$2 pfet L=0.5U W=0.36U AS=0.1665P AD=0.0504P
+ PS=1.285U PD=0.64U
* device instance $1430 r0 *1 96.01,20.705 pfet
M$1430 \$580 \$549 VDD$2 VDD$2 pfet L=0.5U W=0.36U AS=0.23P AD=0.0504P PS=1.54U
+ PD=0.64U
* device instance $1431 r0 *1 97.25,20.485 pfet
M$1431 \$549 \$548 VDD$2 VDD$2 pfet L=0.5U W=0.8U AS=0.23P AD=0.352P PS=1.54U
+ PD=2.48U
* device instance $1432 r0 *1 98.99,20.55 pfet
M$1432 eng8 \$549 VDD$2 VDD$2 pfet L=0.5U W=1.22U AS=0.5368P AD=0.5368P
+ PS=3.32U PD=3.32U
* device instance $1433 r0 *1 109.05,20.7275 pfet
M$1433 VDD$2 clknet_2_3__leaf_clk \$501 VDD$2 pfet L=0.5U W=0.865U AS=0.3806P
+ AD=0.2249P PS=2.61U PD=1.385U
* device instance $1434 r0 *1 110.07,20.7275 pfet
M$1434 \$502 \$501 VDD$2 VDD$2 pfet L=0.5U W=0.865U AS=0.2249P AD=0.3806P
+ PS=1.385U PD=2.61U
* device instance $1435 r0 *1 112.23,20.705 pfet
M$1435 \$581 \$502 VDD$2 VDD$2 pfet L=0.5U W=0.36U AS=0.4554P AD=0.054P
+ PS=3.25U PD=0.66U
* device instance $1436 r0 *1 113.03,20.705 pfet
M$1436 \$550 \_027_ \$581 VDD$2 pfet L=0.5U W=0.36U AS=0.054P AD=0.1872P
+ PS=0.66U PD=1.4U
* device instance $1437 r0 *1 114.57,20.705 pfet
M$1437 \$582 \$501 \$550 VDD$2 pfet L=0.5U W=0.36U AS=0.1872P AD=0.0432P
+ PS=1.4U PD=0.6U
* device instance $1438 r0 *1 115.31,20.705 pfet
M$1438 VDD$2 \$551 \$582 VDD$2 pfet L=0.5U W=0.36U AS=0.0432P AD=0.1044P
+ PS=0.6U PD=0.94U
* device instance $1439 r0 *1 116.39,20.705 pfet
M$1439 \$551 \$550 VDD$2 VDD$2 pfet L=0.5U W=0.36U AS=0.1044P AD=0.1791P
+ PS=0.94U PD=1.355U
* device instance $1440 r0 *1 117.885,20.705 pfet
M$1440 \$552 \$501 \$551 VDD$2 pfet L=0.5U W=0.36U AS=0.1791P AD=0.1665P
+ PS=1.355U PD=1.285U
* device instance $1441 r0 *1 119.31,20.705 pfet
M$1441 \$583 \$502 \$552 VDD$2 pfet L=0.5U W=0.36U AS=0.1665P AD=0.0504P
+ PS=1.285U PD=0.64U
* device instance $1442 r0 *1 120.09,20.705 pfet
M$1442 \$583 \$553 VDD$2 VDD$2 pfet L=0.5U W=0.36U AS=0.23P AD=0.0504P PS=1.54U
+ PD=0.64U
* device instance $1443 r0 *1 121.33,20.485 pfet
M$1443 \$553 \$552 VDD$2 VDD$2 pfet L=0.5U W=0.8U AS=0.23P AD=0.352P PS=1.54U
+ PD=2.48U
* device instance $1444 r0 *1 123.07,20.55 pfet
M$1444 c6_r \$553 VDD$2 VDD$2 pfet L=0.5U W=1.22U AS=0.5368P AD=0.5368P
+ PS=3.32U PD=3.32U
* device instance $1445 r0 *1 130.79,20.5525 pfet
M$1445 \_007_ \_052_ \$503 VDD$2 pfet L=0.5U W=1.215U AS=0.5346P AD=0.3159P
+ PS=3.31U PD=1.735U
* device instance $1446 r0 *1 131.81,20.5525 pfet
M$1446 \$503 \_040_ \_007_ VDD$2 pfet L=0.5U W=1.215U AS=0.3159P AD=0.44955P
+ PS=1.735U PD=1.955U
* device instance $1447 r0 *1 133.05,20.5525 pfet
M$1447 VDD$2 ph[13] \$503 VDD$2 pfet L=0.5U W=1.215U AS=0.44955P AD=0.5346P
+ PS=1.955U PD=3.31U
* device instance $1448 r0 *1 135.27,20.55 pfet
M$1448 \_041_ eng9 VDD$2 VDD$2 pfet L=0.5U W=1.22U AS=0.5368P AD=0.5368P
+ PS=3.32U PD=3.32U
* device instance $1449 r0 *1 143.11,20.55 pfet
M$1449 \$504 clknet_0_clk VDD$2 VDD$2 pfet L=0.5U W=1.22U AS=0.5368P AD=0.3782P
+ PS=3.32U PD=1.84U
* device instance $1450 r0 *1 144.23,20.55 pfet
M$1450 VDD$2 clknet_0_clk \$504 VDD$2 pfet L=0.5U W=1.22U AS=0.3782P AD=0.3782P
+ PS=1.84U PD=1.84U
* device instance $1451 r0 *1 145.35,20.55 pfet
M$1451 clknet_2_2__leaf_clk \$504 VDD$2 VDD$2 pfet L=0.5U W=1.22U AS=0.3782P
+ AD=0.3782P PS=1.84U PD=1.84U
* device instance $1452 r0 *1 146.47,20.55 pfet
M$1452 VDD$2 \$504 clknet_2_2__leaf_clk VDD$2 pfet L=0.5U W=1.22U AS=0.3782P
+ AD=0.3782P PS=1.84U PD=1.84U
* device instance $1453 r0 *1 147.59,20.55 pfet
M$1453 clknet_2_2__leaf_clk \$504 VDD$2 VDD$2 pfet L=0.5U W=1.22U AS=0.3782P
+ AD=0.3782P PS=1.84U PD=1.84U
* device instance $1454 r0 *1 148.71,20.55 pfet
M$1454 VDD$2 \$504 clknet_2_2__leaf_clk VDD$2 pfet L=0.5U W=1.22U AS=0.3782P
+ AD=0.5368P PS=1.84U PD=3.32U
* device instance $1455 r0 *1 150.95,20.55 pfet
M$1455 \$577 start VDD$2 VDD$2 pfet L=0.5U W=1.22U AS=0.5368P AD=0.4087P
+ PS=3.32U PD=1.89U
* device instance $1456 r0 *1 152.12,20.55 pfet
M$1456 \_009_[8] \_050_ \$577 VDD$2 pfet L=0.5U W=1.22U AS=0.4087P AD=0.5368P
+ PS=1.89U PD=3.32U
* device instance $1457 r0 *1 154.31,20.55 pfet
M$1457 \_051_ ph[6] VDD$2 VDD$2 pfet L=0.5U W=1.22U AS=0.5368P AD=0.5368P
+ PS=3.32U PD=3.32U
* device instance $1458 r0 *1 156.65,20.7275 pfet
M$1458 VDD$2 clknet_2_3__leaf_clk \$506 VDD$2 pfet L=0.5U W=0.865U AS=0.3806P
+ AD=0.2249P PS=2.61U PD=1.385U
* device instance $1459 r0 *1 157.67,20.7275 pfet
M$1459 \$507 \$506 VDD$2 VDD$2 pfet L=0.5U W=0.865U AS=0.2249P AD=0.3806P
+ PS=1.385U PD=2.61U
* device instance $1460 r0 *1 159.83,20.705 pfet
M$1460 \$573 \$507 VDD$2 VDD$2 pfet L=0.5U W=0.36U AS=0.4554P AD=0.054P
+ PS=3.25U PD=0.66U
* device instance $1461 r0 *1 160.63,20.705 pfet
M$1461 \$555 \_019_ \$573 VDD$2 pfet L=0.5U W=0.36U AS=0.054P AD=0.1872P
+ PS=0.66U PD=1.4U
* device instance $1462 r0 *1 162.17,20.705 pfet
M$1462 \$572 \$506 \$555 VDD$2 pfet L=0.5U W=0.36U AS=0.1872P AD=0.0432P
+ PS=1.4U PD=0.6U
* device instance $1463 r0 *1 162.91,20.705 pfet
M$1463 VDD$2 \$556 \$572 VDD$2 pfet L=0.5U W=0.36U AS=0.0432P AD=0.1044P
+ PS=0.6U PD=0.94U
* device instance $1464 r0 *1 163.99,20.705 pfet
M$1464 \$556 \$555 VDD$2 VDD$2 pfet L=0.5U W=0.36U AS=0.1044P AD=0.1791P
+ PS=0.94U PD=1.355U
* device instance $1465 r0 *1 165.485,20.705 pfet
M$1465 \$557 \$506 \$556 VDD$2 pfet L=0.5U W=0.36U AS=0.1791P AD=0.1665P
+ PS=1.355U PD=1.285U
* device instance $1466 r0 *1 166.91,20.705 pfet
M$1466 \$571 \$507 \$557 VDD$2 pfet L=0.5U W=0.36U AS=0.1665P AD=0.0504P
+ PS=1.285U PD=0.64U
* device instance $1467 r0 *1 167.69,20.705 pfet
M$1467 \$571 \$558 VDD$2 VDD$2 pfet L=0.5U W=0.36U AS=0.23P AD=0.0504P PS=1.54U
+ PD=0.64U
* device instance $1468 r0 *1 168.93,20.485 pfet
M$1468 \$558 \$557 VDD$2 VDD$2 pfet L=0.5U W=0.8U AS=0.23P AD=0.352P PS=1.54U
+ PD=2.48U
* device instance $1469 r0 *1 170.67,20.55 pfet
M$1469 q5 \$558 VDD$2 VDD$2 pfet L=0.5U W=1.22U AS=0.5368P AD=0.5368P PS=3.32U
+ PD=3.32U
* device instance $1470 r0 *1 175.59,20.55 pfet
M$1470 \$568 start VDD$2 VDD$2 pfet L=0.5U W=1.22U AS=0.5368P AD=0.4087P
+ PS=3.32U PD=1.89U
* device instance $1471 r0 *1 176.76,20.55 pfet
M$1471 \_009_[1] \_033_ \$568 VDD$2 pfet L=0.5U W=1.22U AS=0.4087P AD=0.5368P
+ PS=1.89U PD=3.32U
* device instance $1472 r0 *1 179.05,20.7275 pfet
M$1472 VDD$2 clknet_2_3__leaf_clk \$508 VDD$2 pfet L=0.5U W=0.865U AS=0.3806P
+ AD=0.2249P PS=2.61U PD=1.385U
* device instance $1473 r0 *1 180.07,20.7275 pfet
M$1473 \$509 \$508 VDD$2 VDD$2 pfet L=0.5U W=0.865U AS=0.2249P AD=0.3806P
+ PS=1.385U PD=2.61U
* device instance $1474 r0 *1 182.23,20.705 pfet
M$1474 \$566 \$509 VDD$2 VDD$2 pfet L=0.5U W=0.36U AS=0.4554P AD=0.054P
+ PS=3.25U PD=0.66U
* device instance $1475 r0 *1 183.03,20.705 pfet
M$1475 \$559 \_009_[4] \$566 VDD$2 pfet L=0.5U W=0.36U AS=0.054P AD=0.1872P
+ PS=0.66U PD=1.4U
* device instance $1476 r0 *1 184.57,20.705 pfet
M$1476 \$564 \$508 \$559 VDD$2 pfet L=0.5U W=0.36U AS=0.1872P AD=0.0432P
+ PS=1.4U PD=0.6U
* device instance $1477 r0 *1 185.31,20.705 pfet
M$1477 VDD$2 \$560 \$564 VDD$2 pfet L=0.5U W=0.36U AS=0.0432P AD=0.1044P
+ PS=0.6U PD=0.94U
* device instance $1478 r0 *1 186.39,20.705 pfet
M$1478 \$560 \$559 VDD$2 VDD$2 pfet L=0.5U W=0.36U AS=0.1044P AD=0.1791P
+ PS=0.94U PD=1.355U
* device instance $1479 r0 *1 187.885,20.705 pfet
M$1479 \$561 \$508 \$560 VDD$2 pfet L=0.5U W=0.36U AS=0.1791P AD=0.1665P
+ PS=1.355U PD=1.285U
* device instance $1480 r0 *1 189.31,20.705 pfet
M$1480 \$563 \$509 \$561 VDD$2 pfet L=0.5U W=0.36U AS=0.1665P AD=0.0504P
+ PS=1.285U PD=0.64U
* device instance $1481 r0 *1 190.09,20.705 pfet
M$1481 \$563 \$562 VDD$2 VDD$2 pfet L=0.5U W=0.36U AS=0.23P AD=0.0504P PS=1.54U
+ PD=0.64U
* device instance $1482 r0 *1 191.33,20.485 pfet
M$1482 \$562 \$561 VDD$2 VDD$2 pfet L=0.5U W=0.8U AS=0.23P AD=0.352P PS=1.54U
+ PD=2.48U
* device instance $1483 r0 *1 193.07,20.55 pfet
M$1483 ph[4] \$562 VDD$2 VDD$2 pfet L=0.5U W=1.22U AS=0.5368P AD=0.5368P
+ PS=3.32U PD=3.32U
* device instance $1484 r0 *1 8.71,28.39 pfet
M$1484 \$753 start VDD$3 VDD$3 pfet L=0.5U W=1.22U AS=0.5368P AD=0.4087P
+ PS=3.32U PD=1.89U
* device instance $1485 r0 *1 9.88,28.39 pfet
M$1485 \_009_[9] \_049_ \$753 VDD$3 pfet L=0.5U W=1.22U AS=0.4087P AD=0.5368P
+ PS=1.89U PD=3.32U
* device instance $1486 r0 *1 8.71,26.49 pfet
M$1486 \$689 start VDD$3 VDD$3 pfet L=0.5U W=1.22U AS=0.5368P AD=0.4087P
+ PS=3.32U PD=1.89U
* device instance $1487 r0 *1 9.88,26.49 pfet
M$1487 \_009_[10] \_048_ \$689 VDD$3 pfet L=0.5U W=1.22U AS=0.4087P AD=0.5368P
+ PS=1.89U PD=3.32U
* device instance $1488 r0 *1 12.07,28.39 pfet
M$1488 \$754 ph[9] VDD$3 VDD$3 pfet L=0.5U W=1.22U AS=0.5368P AD=0.4087P
+ PS=3.32U PD=1.89U
* device instance $1489 r0 *1 13.24,28.39 pfet
M$1489 \_062_ q4 \$754 VDD$3 pfet L=0.5U W=1.22U AS=0.4087P AD=0.5368P PS=1.89U
+ PD=3.32U
* device instance $1490 r0 *1 12.17,26.3125 pfet
M$1490 VDD$3 clknet_2_1__leaf_clk \$613 VDD$3 pfet L=0.5U W=0.865U AS=0.3806P
+ AD=0.2249P PS=2.61U PD=1.385U
* device instance $1491 r0 *1 13.19,26.3125 pfet
M$1491 \$614 \$613 VDD$3 VDD$3 pfet L=0.5U W=0.865U AS=0.2249P AD=0.3806P
+ PS=1.385U PD=2.61U
* device instance $1492 r0 *1 15.35,26.335 pfet
M$1492 \$690 \$614 VDD$3 VDD$3 pfet L=0.5U W=0.36U AS=0.4554P AD=0.054P
+ PS=3.25U PD=0.66U
* device instance $1493 r0 *1 16.15,26.335 pfet
M$1493 \$648 \_009_[12] \$690 VDD$3 pfet L=0.5U W=0.36U AS=0.054P AD=0.1872P
+ PS=0.66U PD=1.4U
* device instance $1494 r0 *1 17.69,26.335 pfet
M$1494 \$691 \$613 \$648 VDD$3 pfet L=0.5U W=0.36U AS=0.1872P AD=0.0432P
+ PS=1.4U PD=0.6U
* device instance $1495 r0 *1 18.43,26.335 pfet
M$1495 VDD$3 \$615 \$691 VDD$3 pfet L=0.5U W=0.36U AS=0.0432P AD=0.1044P
+ PS=0.6U PD=0.94U
* device instance $1496 r0 *1 19.51,26.335 pfet
M$1496 \$615 \$648 VDD$3 VDD$3 pfet L=0.5U W=0.36U AS=0.1044P AD=0.1791P
+ PS=0.94U PD=1.355U
* device instance $1497 r0 *1 21.005,26.335 pfet
M$1497 \$616 \$613 \$615 VDD$3 pfet L=0.5U W=0.36U AS=0.1791P AD=0.1665P
+ PS=1.355U PD=1.285U
* device instance $1498 r0 *1 22.43,26.335 pfet
M$1498 \$692 \$614 \$616 VDD$3 pfet L=0.5U W=0.36U AS=0.1665P AD=0.0504P
+ PS=1.285U PD=0.64U
* device instance $1499 r0 *1 23.21,26.335 pfet
M$1499 VDD$3 \$617 \$692 VDD$3 pfet L=0.5U W=0.36U AS=0.0504P AD=0.23P PS=0.64U
+ PD=1.54U
* device instance $1500 r0 *1 24.45,26.555 pfet
M$1500 \$617 \$616 VDD$3 VDD$3 pfet L=0.5U W=0.8U AS=0.23P AD=0.352P PS=1.54U
+ PD=2.48U
* device instance $1501 r0 *1 26.19,26.49 pfet
M$1501 ph[12] \$617 VDD$3 VDD$3 pfet L=0.5U W=1.22U AS=0.5368P AD=0.5368P
+ PS=3.32U PD=3.32U
* device instance $1502 r0 *1 29.43,28.39 pfet
M$1502 \$755 q1 VDD$3 VDD$3 pfet L=0.5U W=1.22U AS=0.5368P AD=0.4087P PS=3.32U
+ PD=1.89U
* device instance $1503 r0 *1 30.6,28.39 pfet
M$1503 \_060_ ph[12] \$755 VDD$3 pfet L=0.5U W=1.22U AS=0.4087P AD=0.5368P
+ PS=1.89U PD=3.32U
* device instance $1504 r0 *1 30.55,26.49 pfet
M$1504 \$694 start VDD$3 VDD$3 pfet L=0.5U W=1.22U AS=0.5368P AD=0.4087P
+ PS=3.32U PD=1.89U
* device instance $1505 r0 *1 31.72,26.49 pfet
M$1505 \_009_[13] \_043_ \$694 VDD$3 pfet L=0.5U W=1.22U AS=0.4087P AD=0.5368P
+ PS=1.89U PD=3.32U
* device instance $1506 r0 *1 34.01,26.3125 pfet
M$1506 VDD$3 clknet_2_1__leaf_clk \$619 VDD$3 pfet L=0.5U W=0.865U AS=0.3806P
+ AD=0.2249P PS=2.61U PD=1.385U
* device instance $1507 r0 *1 35.03,26.3125 pfet
M$1507 \$620 \$619 VDD$3 VDD$3 pfet L=0.5U W=0.865U AS=0.2249P AD=0.3806P
+ PS=1.385U PD=2.61U
* device instance $1508 r0 *1 37.19,26.335 pfet
M$1508 \$695 \$620 VDD$3 VDD$3 pfet L=0.5U W=0.36U AS=0.4554P AD=0.054P
+ PS=3.25U PD=0.66U
* device instance $1509 r0 *1 37.99,26.335 pfet
M$1509 \$649 \_012_ \$695 VDD$3 pfet L=0.5U W=0.36U AS=0.054P AD=0.1872P
+ PS=0.66U PD=1.4U
* device instance $1510 r0 *1 39.53,26.335 pfet
M$1510 \$696 \$619 \$649 VDD$3 pfet L=0.5U W=0.36U AS=0.1872P AD=0.0432P
+ PS=1.4U PD=0.6U
* device instance $1511 r0 *1 40.27,26.335 pfet
M$1511 VDD$3 \$622 \$696 VDD$3 pfet L=0.5U W=0.36U AS=0.0432P AD=0.1044P
+ PS=0.6U PD=0.94U
* device instance $1512 r0 *1 41.35,26.335 pfet
M$1512 \$622 \$649 VDD$3 VDD$3 pfet L=0.5U W=0.36U AS=0.1044P AD=0.1791P
+ PS=0.94U PD=1.355U
* device instance $1513 r0 *1 42.845,26.335 pfet
M$1513 \$623 \$619 \$622 VDD$3 pfet L=0.5U W=0.36U AS=0.1791P AD=0.1665P
+ PS=1.355U PD=1.285U
* device instance $1514 r0 *1 44.27,26.335 pfet
M$1514 \$697 \$620 \$623 VDD$3 pfet L=0.5U W=0.36U AS=0.1665P AD=0.0504P
+ PS=1.285U PD=0.64U
* device instance $1515 r0 *1 45.05,26.335 pfet
M$1515 VDD$3 \$624 \$697 VDD$3 pfet L=0.5U W=0.36U AS=0.0504P AD=0.23P PS=0.64U
+ PD=1.54U
* device instance $1516 r0 *1 46.29,26.555 pfet
M$1516 \$624 \$623 VDD$3 VDD$3 pfet L=0.5U W=0.8U AS=0.23P AD=0.352P PS=1.54U
+ PD=2.48U
* device instance $1517 r0 *1 40.07,28.39 pfet
M$1517 \$756 q0 VDD$3 VDD$3 pfet L=0.5U W=1.22U AS=0.5368P AD=0.4087P PS=3.32U
+ PD=1.89U
* device instance $1518 r0 *1 41.24,28.39 pfet
M$1518 \_055_ ph[13] \$756 VDD$3 pfet L=0.5U W=1.22U AS=0.4087P AD=0.5368P
+ PS=1.89U PD=3.32U
* device instance $1519 r0 *1 48.03,26.49 pfet
M$1519 q0 \$624 VDD$3 VDD$3 pfet L=0.5U W=1.22U AS=0.5368P AD=0.5368P PS=3.32U
+ PD=3.32U
* device instance $1520 r0 *1 49.03,28.39 pfet
M$1520 \_045_ ph[13] VDD$3 VDD$3 pfet L=0.5U W=1.22U AS=0.5368P AD=0.5368P
+ PS=3.32U PD=3.32U
* device instance $1521 r0 *1 55.85,26.3125 pfet
M$1521 VDD$3 clknet_2_1__leaf_clk \$625 VDD$3 pfet L=0.5U W=0.865U AS=0.3806P
+ AD=0.2249P PS=2.61U PD=1.385U
* device instance $1522 r0 *1 56.87,26.3125 pfet
M$1522 \$626 \$625 VDD$3 VDD$3 pfet L=0.5U W=0.865U AS=0.2249P AD=0.3806P
+ PS=1.385U PD=2.61U
* device instance $1523 r0 *1 59.03,26.335 pfet
M$1523 \$698 \$626 VDD$3 VDD$3 pfet L=0.5U W=0.36U AS=0.4554P AD=0.054P
+ PS=3.25U PD=0.66U
* device instance $1524 r0 *1 59.83,26.335 pfet
M$1524 \$651 \_021_ \$698 VDD$3 pfet L=0.5U W=0.36U AS=0.054P AD=0.1872P
+ PS=0.66U PD=1.4U
* device instance $1525 r0 *1 61.37,26.335 pfet
M$1525 \$699 \$625 \$651 VDD$3 pfet L=0.5U W=0.36U AS=0.1872P AD=0.0432P
+ PS=1.4U PD=0.6U
* device instance $1526 r0 *1 62.11,26.335 pfet
M$1526 VDD$3 \$628 \$699 VDD$3 pfet L=0.5U W=0.36U AS=0.0432P AD=0.1044P
+ PS=0.6U PD=0.94U
* device instance $1527 r0 *1 63.19,26.335 pfet
M$1527 \$628 \$651 VDD$3 VDD$3 pfet L=0.5U W=0.36U AS=0.1044P AD=0.1791P
+ PS=0.94U PD=1.355U
* device instance $1528 r0 *1 64.685,26.335 pfet
M$1528 \$629 \$625 \$628 VDD$3 pfet L=0.5U W=0.36U AS=0.1791P AD=0.1665P
+ PS=1.355U PD=1.285U
* device instance $1529 r0 *1 66.11,26.335 pfet
M$1529 \$700 \$626 \$629 VDD$3 pfet L=0.5U W=0.36U AS=0.1665P AD=0.0504P
+ PS=1.285U PD=0.64U
* device instance $1530 r0 *1 66.89,26.335 pfet
M$1530 VDD$3 \$630 \$700 VDD$3 pfet L=0.5U W=0.36U AS=0.0504P AD=0.23P PS=0.64U
+ PD=1.54U
* device instance $1531 r0 *1 68.13,26.555 pfet
M$1531 \$630 \$629 VDD$3 VDD$3 pfet L=0.5U W=0.8U AS=0.23P AD=0.352P PS=1.54U
+ PD=2.48U
* device instance $1532 r0 *1 61.795,28.0875 pfet
M$1532 \$742 q4 VDD$3 VDD$3 pfet L=0.5U W=0.615U AS=0.4298375P AD=0.0845625P
+ PS=2.185U PD=0.89U
* device instance $1533 r0 *1 62.57,28.0875 pfet
M$1533 \$716 \$685 \$742 VDD$3 pfet L=0.5U W=0.615U AS=0.0845625P AD=0.1599P
+ PS=0.89U PD=1.135U
* device instance $1534 r0 *1 63.59,28.0875 pfet
M$1534 \$744 ph[14] \$716 VDD$3 pfet L=0.5U W=0.615U AS=0.1599P AD=0.0738P
+ PS=1.135U PD=0.855U
* device instance $1535 r0 *1 64.33,28.0875 pfet
M$1535 VDD$3 c4_r \$744 VDD$3 pfet L=0.5U W=0.615U AS=0.0738P AD=0.1599P
+ PS=0.855U PD=1.135U
* device instance $1536 r0 *1 65.35,28.0875 pfet
M$1536 \$685 ph[14] VDD$3 VDD$3 pfet L=0.5U W=0.615U AS=0.1599P AD=0.2706P
+ PS=1.135U PD=2.11U
* device instance $1537 r0 *1 60.33,28.39 pfet
M$1537 VDD$3 \$716 \_023_ VDD$3 pfet L=0.5U W=1.22U AS=0.5368P AD=0.4298375P
+ PS=3.32U PD=2.185U
* device instance $1538 r0 *1 69.87,26.49 pfet
M$1538 c3_r \$630 VDD$3 VDD$3 pfet L=0.5U W=1.22U AS=0.5368P AD=0.5368P
+ PS=3.32U PD=3.32U
* device instance $1539 r0 *1 79.155,28.0875 pfet
M$1539 \$746 q8 VDD$3 VDD$3 pfet L=0.5U W=0.615U AS=0.4298375P AD=0.0845625P
+ PS=2.185U PD=0.89U
* device instance $1540 r0 *1 79.93,28.0875 pfet
M$1540 \$718 \$686 \$746 VDD$3 pfet L=0.5U W=0.615U AS=0.0845625P AD=0.1599P
+ PS=0.89U PD=1.135U
* device instance $1541 r0 *1 80.95,28.0875 pfet
M$1541 \$747 ph[14] \$718 VDD$3 pfet L=0.5U W=0.615U AS=0.1599P AD=0.0738P
+ PS=1.135U PD=0.855U
* device instance $1542 r0 *1 81.69,28.0875 pfet
M$1542 VDD$3 c8_r \$747 VDD$3 pfet L=0.5U W=0.615U AS=0.0738P AD=0.1599P
+ PS=0.855U PD=1.135U
* device instance $1543 r0 *1 82.71,28.0875 pfet
M$1543 \$686 ph[14] VDD$3 VDD$3 pfet L=0.5U W=0.615U AS=0.1599P AD=0.2706P
+ PS=1.135U PD=2.11U
* device instance $1544 r0 *1 77.69,28.39 pfet
M$1544 VDD$3 \$718 \_010_ VDD$3 pfet L=0.5U W=1.22U AS=0.5368P AD=0.4298375P
+ PS=3.32U PD=2.185U
* device instance $1545 r0 *1 83.85,26.3125 pfet
M$1545 VDD$3 clknet_2_1__leaf_clk \$631 VDD$3 pfet L=0.5U W=0.865U AS=0.3806P
+ AD=0.2249P PS=2.61U PD=1.385U
* device instance $1546 r0 *1 84.87,26.3125 pfet
M$1546 \$632 \$631 VDD$3 VDD$3 pfet L=0.5U W=0.865U AS=0.2249P AD=0.3806P
+ PS=1.385U PD=2.61U
* device instance $1547 r0 *1 87.03,26.335 pfet
M$1547 \$701 \$632 VDD$3 VDD$3 pfet L=0.5U W=0.36U AS=0.4554P AD=0.054P
+ PS=3.25U PD=0.66U
* device instance $1548 r0 *1 87.83,26.335 pfet
M$1548 \$653 \_016_ \$701 VDD$3 pfet L=0.5U W=0.36U AS=0.054P AD=0.1872P
+ PS=0.66U PD=1.4U
* device instance $1549 r0 *1 89.37,26.335 pfet
M$1549 \$702 \$631 \$653 VDD$3 pfet L=0.5U W=0.36U AS=0.1872P AD=0.0432P
+ PS=1.4U PD=0.6U
* device instance $1550 r0 *1 90.11,26.335 pfet
M$1550 VDD$3 \$633 \$702 VDD$3 pfet L=0.5U W=0.36U AS=0.0432P AD=0.1044P
+ PS=0.6U PD=0.94U
* device instance $1551 r0 *1 91.19,26.335 pfet
M$1551 \$633 \$653 VDD$3 VDD$3 pfet L=0.5U W=0.36U AS=0.1044P AD=0.1791P
+ PS=0.94U PD=1.355U
* device instance $1552 r0 *1 92.685,26.335 pfet
M$1552 \$634 \$631 \$633 VDD$3 pfet L=0.5U W=0.36U AS=0.1791P AD=0.1665P
+ PS=1.355U PD=1.285U
* device instance $1553 r0 *1 94.11,26.335 pfet
M$1553 \$703 \$632 \$634 VDD$3 pfet L=0.5U W=0.36U AS=0.1665P AD=0.0504P
+ PS=1.285U PD=0.64U
* device instance $1554 r0 *1 94.89,26.335 pfet
M$1554 VDD$3 \$635 \$703 VDD$3 pfet L=0.5U W=0.36U AS=0.0504P AD=0.23P PS=0.64U
+ PD=1.54U
* device instance $1555 r0 *1 96.13,26.555 pfet
M$1555 \$635 \$634 VDD$3 VDD$3 pfet L=0.5U W=0.8U AS=0.23P AD=0.352P PS=1.54U
+ PD=2.48U
* device instance $1556 r0 *1 93.715,28.0875 pfet
M$1556 \$750 q5 VDD$3 VDD$3 pfet L=0.5U W=0.615U AS=0.4298375P AD=0.0845625P
+ PS=2.185U PD=0.89U
* device instance $1557 r0 *1 94.49,28.0875 pfet
M$1557 \$719 \$687 \$750 VDD$3 pfet L=0.5U W=0.615U AS=0.0845625P AD=0.1599P
+ PS=0.89U PD=1.135U
* device instance $1558 r0 *1 95.51,28.0875 pfet
M$1558 \$751 ph[14] \$719 VDD$3 pfet L=0.5U W=0.615U AS=0.1599P AD=0.0738P
+ PS=1.135U PD=0.855U
* device instance $1559 r0 *1 96.25,28.0875 pfet
M$1559 VDD$3 c5_r \$751 VDD$3 pfet L=0.5U W=0.615U AS=0.0738P AD=0.1599P
+ PS=0.855U PD=1.135U
* device instance $1560 r0 *1 97.27,28.0875 pfet
M$1560 \$687 ph[14] VDD$3 VDD$3 pfet L=0.5U W=0.615U AS=0.1599P AD=0.2706P
+ PS=1.135U PD=2.11U
* device instance $1561 r0 *1 92.25,28.39 pfet
M$1561 VDD$3 \$719 \_024_ VDD$3 pfet L=0.5U W=1.22U AS=0.5368P AD=0.4298375P
+ PS=3.32U PD=2.185U
* device instance $1562 r0 *1 97.87,26.49 pfet
M$1562 c2_r \$635 VDD$3 VDD$3 pfet L=0.5U W=1.22U AS=0.5368P AD=0.5368P
+ PS=3.32U PD=3.32U
* device instance $1563 r0 *1 111.635,28.0875 pfet
M$1563 \$749 q1 VDD$3 VDD$3 pfet L=0.5U W=0.615U AS=0.4298375P AD=0.0845625P
+ PS=2.185U PD=0.89U
* device instance $1564 r0 *1 112.41,28.0875 pfet
M$1564 \$720 \$688 \$749 VDD$3 pfet L=0.5U W=0.615U AS=0.0845625P AD=0.1599P
+ PS=0.89U PD=1.135U
* device instance $1565 r0 *1 113.43,28.0875 pfet
M$1565 \$748 ph[14] \$720 VDD$3 pfet L=0.5U W=0.615U AS=0.1599P AD=0.0738P
+ PS=1.135U PD=0.855U
* device instance $1566 r0 *1 114.17,28.0875 pfet
M$1566 VDD$3 c1_r \$748 VDD$3 pfet L=0.5U W=0.615U AS=0.0738P AD=0.1599P
+ PS=0.855U PD=1.135U
* device instance $1567 r0 *1 115.19,28.0875 pfet
M$1567 \$688 ph[14] VDD$3 VDD$3 pfet L=0.5U W=0.615U AS=0.1599P AD=0.2706P
+ PS=1.135U PD=2.11U
* device instance $1568 r0 *1 110.17,28.39 pfet
M$1568 VDD$3 \$720 \_015_ VDD$3 pfet L=0.5U W=1.22U AS=0.5368P AD=0.4298375P
+ PS=3.32U PD=2.185U
* device instance $1569 r0 *1 112.41,26.49 pfet
M$1569 VDD$3 \$636 \_027_ VDD$3 pfet L=0.5U W=1.22U AS=0.5368P AD=0.4298375P
+ PS=3.32U PD=2.185U
* device instance $1570 r0 *1 113.875,26.7925 pfet
M$1570 \$705 q6 VDD$3 VDD$3 pfet L=0.5U W=0.615U AS=0.4298375P AD=0.0845625P
+ PS=2.185U PD=0.89U
* device instance $1571 r0 *1 114.65,26.7925 pfet
M$1571 \$636 \$609 \$705 VDD$3 pfet L=0.5U W=0.615U AS=0.0845625P AD=0.1599P
+ PS=0.89U PD=1.135U
* device instance $1572 r0 *1 115.67,26.7925 pfet
M$1572 \$706 ph[14] \$636 VDD$3 pfet L=0.5U W=0.615U AS=0.1599P AD=0.0738P
+ PS=1.135U PD=0.855U
* device instance $1573 r0 *1 116.41,26.7925 pfet
M$1573 VDD$3 c6_r \$706 VDD$3 pfet L=0.5U W=0.615U AS=0.0738P AD=0.1599P
+ PS=0.855U PD=1.135U
* device instance $1574 r0 *1 117.43,26.7925 pfet
M$1574 \$609 ph[14] VDD$3 VDD$3 pfet L=0.5U W=0.615U AS=0.1599P AD=0.2706P
+ PS=1.135U PD=2.11U
* device instance $1575 r0 *1 117.91,28.39 pfet
M$1575 \$758 start VDD$3 VDD$3 pfet L=0.5U W=1.22U AS=0.5368P AD=0.4087P
+ PS=3.32U PD=1.89U
* device instance $1576 r0 *1 119.08,28.39 pfet
M$1576 \_009_[15] \_054_ \$758 VDD$3 pfet L=0.5U W=1.22U AS=0.4087P AD=0.5368P
+ PS=1.89U PD=3.32U
* device instance $1577 r0 *1 119.59,26.49 pfet
M$1577 \_054_ ph[14] VDD$3 VDD$3 pfet L=0.5U W=1.22U AS=0.5368P AD=0.5368P
+ PS=3.32U PD=3.32U
* device instance $1578 r0 *1 129.11,26.4875 pfet
M$1578 \_004_ \_049_ \$677 VDD$3 pfet L=0.5U W=1.215U AS=0.5346P AD=0.3159P
+ PS=3.31U PD=1.735U
* device instance $1579 r0 *1 130.13,26.4875 pfet
M$1579 \$677 \_037_ \_004_ VDD$3 pfet L=0.5U W=1.215U AS=0.3159P AD=0.44955P
+ PS=1.735U PD=1.955U
* device instance $1580 r0 *1 131.37,26.4875 pfet
M$1580 VDD$3 ph[13] \$677 VDD$3 pfet L=0.5U W=1.215U AS=0.44955P AD=0.5346P
+ PS=1.955U PD=3.31U
* device instance $1581 r0 *1 134.15,26.4875 pfet
M$1581 \_008_ \_053_ \$678 VDD$3 pfet L=0.5U W=1.215U AS=0.5346P AD=0.3159P
+ PS=3.31U PD=1.735U
* device instance $1582 r0 *1 135.17,26.4875 pfet
M$1582 \$678 \_041_ \_008_ VDD$3 pfet L=0.5U W=1.215U AS=0.3159P AD=0.44955P
+ PS=1.735U PD=1.955U
* device instance $1583 r0 *1 136.41,26.4875 pfet
M$1583 VDD$3 ph[13] \$678 VDD$3 pfet L=0.5U W=1.215U AS=0.44955P AD=0.5346P
+ PS=1.955U PD=3.31U
* device instance $1584 r0 *1 140.97,26.3125 pfet
M$1584 VDD$3 clknet_2_3__leaf_clk \$639 VDD$3 pfet L=0.5U W=0.865U AS=0.3806P
+ AD=0.2249P PS=2.61U PD=1.385U
* device instance $1585 r0 *1 141.99,26.3125 pfet
M$1585 \$640 \$639 VDD$3 VDD$3 pfet L=0.5U W=0.865U AS=0.2249P AD=0.3806P
+ PS=1.385U PD=2.61U
* device instance $1586 r0 *1 142.11,28.39 pfet
M$1586 eng9 \$727 VDD$3 VDD$3 pfet L=0.5U W=1.22U AS=0.5368P AD=0.5368P
+ PS=3.32U PD=3.32U
* device instance $1587 r0 *1 144.15,26.335 pfet
M$1587 \$709 \$640 VDD$3 VDD$3 pfet L=0.5U W=0.36U AS=0.4554P AD=0.054P
+ PS=3.25U PD=0.66U
* device instance $1588 r0 *1 144.95,26.335 pfet
M$1588 \$655 \_006_ \$709 VDD$3 pfet L=0.5U W=0.36U AS=0.054P AD=0.1872P
+ PS=0.66U PD=1.4U
* device instance $1589 r0 *1 146.49,26.335 pfet
M$1589 \$708 \$639 \$655 VDD$3 pfet L=0.5U W=0.36U AS=0.1872P AD=0.0432P
+ PS=1.4U PD=0.6U
* device instance $1590 r0 *1 147.23,26.335 pfet
M$1590 VDD$3 \$641 \$708 VDD$3 pfet L=0.5U W=0.36U AS=0.0432P AD=0.1044P
+ PS=0.6U PD=0.94U
* device instance $1591 r0 *1 148.31,26.335 pfet
M$1591 \$641 \$655 VDD$3 VDD$3 pfet L=0.5U W=0.36U AS=0.1044P AD=0.1791P
+ PS=0.94U PD=1.355U
* device instance $1592 r0 *1 149.805,26.335 pfet
M$1592 \$642 \$639 \$641 VDD$3 pfet L=0.5U W=0.36U AS=0.1791P AD=0.1665P
+ PS=1.355U PD=1.285U
* device instance $1593 r0 *1 151.23,26.335 pfet
M$1593 \$707 \$640 \$642 VDD$3 pfet L=0.5U W=0.36U AS=0.1665P AD=0.0504P
+ PS=1.285U PD=0.64U
* device instance $1594 r0 *1 152.01,26.335 pfet
M$1594 VDD$3 \$643 \$707 VDD$3 pfet L=0.5U W=0.36U AS=0.0504P AD=0.23P PS=0.64U
+ PD=1.54U
* device instance $1595 r0 *1 153.25,26.555 pfet
M$1595 \$643 \$642 VDD$3 VDD$3 pfet L=0.5U W=0.8U AS=0.23P AD=0.352P PS=1.54U
+ PD=2.48U
* device instance $1596 r0 *1 144.23,28.39 pfet
M$1596 \$728 clknet_0_clk VDD$3 VDD$3 pfet L=0.5U W=1.22U AS=0.5368P AD=0.3782P
+ PS=3.32U PD=1.84U
* device instance $1597 r0 *1 145.35,28.39 pfet
M$1597 VDD$3 clknet_0_clk \$728 VDD$3 pfet L=0.5U W=1.22U AS=0.3782P AD=0.3782P
+ PS=1.84U PD=1.84U
* device instance $1598 r0 *1 146.47,28.39 pfet
M$1598 clknet_2_3__leaf_clk \$728 VDD$3 VDD$3 pfet L=0.5U W=1.22U AS=0.3782P
+ AD=0.3782P PS=1.84U PD=1.84U
* device instance $1599 r0 *1 147.59,28.39 pfet
M$1599 VDD$3 \$728 clknet_2_3__leaf_clk VDD$3 pfet L=0.5U W=1.22U AS=0.3782P
+ AD=0.3782P PS=1.84U PD=1.84U
* device instance $1600 r0 *1 148.71,28.39 pfet
M$1600 clknet_2_3__leaf_clk \$728 VDD$3 VDD$3 pfet L=0.5U W=1.22U AS=0.3782P
+ AD=0.3782P PS=1.84U PD=1.84U
* device instance $1601 r0 *1 149.83,28.39 pfet
M$1601 VDD$3 \$728 clknet_2_3__leaf_clk VDD$3 pfet L=0.5U W=1.22U AS=0.3782P
+ AD=0.5368P PS=1.84U PD=3.32U
* device instance $1602 r0 *1 152.63,28.39 pfet
M$1602 \_049_ ph[8] VDD$3 VDD$3 pfet L=0.5U W=1.22U AS=0.5368P AD=0.5368P
+ PS=3.32U PD=3.32U
* device instance $1603 r0 *1 154.99,26.49 pfet
M$1603 eng7 \$643 VDD$3 VDD$3 pfet L=0.5U W=1.22U AS=0.5368P AD=0.5368P
+ PS=3.32U PD=3.32U
* device instance $1604 r0 *1 157.11,26.49 pfet
M$1604 \$704 ph[6] VDD$3 VDD$3 pfet L=0.5U W=1.22U AS=0.5368P AD=0.4087P
+ PS=3.32U PD=1.89U
* device instance $1605 r0 *1 158.28,26.49 pfet
M$1605 \_058_ q7 \$704 VDD$3 pfet L=0.5U W=1.22U AS=0.4087P AD=0.5368P PS=1.89U
+ PD=3.32U
* device instance $1606 r0 *1 160.47,28.39 pfet
M$1606 \$759 ph[8] VDD$3 VDD$3 pfet L=0.5U W=1.22U AS=0.5368P AD=0.4087P
+ PS=3.32U PD=1.89U
* device instance $1607 r0 *1 161.64,28.39 pfet
M$1607 \_059_ q5 \$759 VDD$3 pfet L=0.5U W=1.22U AS=0.4087P AD=0.5368P PS=1.89U
+ PD=3.32U
* device instance $1608 r0 *1 160.47,26.4875 pfet
M$1608 \_019_ cmp \$679 VDD$3 pfet L=0.5U W=1.215U AS=0.5346P AD=0.3159P
+ PS=3.31U PD=1.735U
* device instance $1609 r0 *1 161.49,26.4875 pfet
M$1609 \$679 ph[8] \_019_ VDD$3 pfet L=0.5U W=1.215U AS=0.3159P AD=0.44955P
+ PS=1.735U PD=1.955U
* device instance $1610 r0 *1 162.73,26.4875 pfet
M$1610 VDD$3 \_059_ \$679 VDD$3 pfet L=0.5U W=1.215U AS=0.44955P AD=0.5346P
+ PS=1.955U PD=3.31U
* device instance $1611 r0 *1 173.35,28.39 pfet
M$1611 \_052_ ph[5] VDD$3 VDD$3 pfet L=0.5U W=1.22U AS=0.5368P AD=0.5368P
+ PS=3.32U PD=3.32U
* device instance $1612 r0 *1 175.59,26.4875 pfet
M$1612 \_022_ cmp \$680 VDD$3 pfet L=0.5U W=1.215U AS=0.5346P AD=0.3159P
+ PS=3.31U PD=1.735U
* device instance $1613 r0 *1 176.61,26.4875 pfet
M$1613 \$680 ph[5] \_022_ VDD$3 pfet L=0.5U W=1.215U AS=0.3159P AD=0.44955P
+ PS=1.735U PD=1.955U
* device instance $1614 r0 *1 177.85,26.4875 pfet
M$1614 VDD$3 \_061_ \$680 VDD$3 pfet L=0.5U W=1.215U AS=0.44955P AD=0.5346P
+ PS=1.955U PD=3.31U
* device instance $1615 r0 *1 176.15,28.39 pfet
M$1615 \$757 start VDD$3 VDD$3 pfet L=0.5U W=1.22U AS=0.5368P AD=0.4087P
+ PS=3.32U PD=1.89U
* device instance $1616 r0 *1 177.32,28.39 pfet
M$1616 \_009_[5] \_053_ \$757 VDD$3 pfet L=0.5U W=1.22U AS=0.4087P AD=0.5368P
+ PS=1.89U PD=3.32U
* device instance $1617 r0 *1 179.51,28.39 pfet
M$1617 \_053_ ph[4] VDD$3 VDD$3 pfet L=0.5U W=1.22U AS=0.5368P AD=0.5368P
+ PS=3.32U PD=3.32U
* device instance $1618 r0 *1 180.07,26.4875 pfet
M$1618 \_026_ cmp \$681 VDD$3 pfet L=0.5U W=1.215U AS=0.5346P AD=0.3159P
+ PS=3.31U PD=1.735U
* device instance $1619 r0 *1 181.09,26.4875 pfet
M$1619 \$681 ph[4] \_026_ VDD$3 pfet L=0.5U W=1.215U AS=0.3159P AD=0.44955P
+ PS=1.735U PD=1.955U
* device instance $1620 r0 *1 182.33,26.4875 pfet
M$1620 VDD$3 \_063_ \$681 VDD$3 pfet L=0.5U W=1.215U AS=0.44955P AD=0.5346P
+ PS=1.955U PD=3.31U
* device instance $1621 r0 *1 184.55,26.49 pfet
M$1621 \$693 ph[4] VDD$3 VDD$3 pfet L=0.5U W=1.22U AS=0.5368P AD=0.4087P
+ PS=3.32U PD=1.89U
* device instance $1622 r0 *1 185.72,26.49 pfet
M$1622 \_063_ q9 \$693 VDD$3 pfet L=0.5U W=1.22U AS=0.4087P AD=0.5368P PS=1.89U
+ PD=3.32U
* device instance $1623 r0 *1 187.91,26.49 pfet
M$1623 \_035_ ph[3] VDD$3 VDD$3 pfet L=0.5U W=1.22U AS=0.5368P AD=0.5368P
+ PS=3.32U PD=3.32U
* device instance $1624 r0 *1 195.87,28.39 pfet
M$1624 ph[5] \$737 VDD$3 VDD$3 pfet L=0.5U W=1.22U AS=0.5368P AD=0.5368P
+ PS=3.32U PD=3.32U
* device instance $1625 r0 *1 4.89,34.1525 pfet
M$1625 VDD$4 clknet_2_1__leaf_clk \$805 VDD$4 pfet L=0.5U W=0.865U AS=0.3806P
+ AD=0.2249P PS=2.61U PD=1.385U
* device instance $1626 r0 *1 5.91,34.1525 pfet
M$1626 \$781 \$805 VDD$4 VDD$4 pfet L=0.5U W=0.865U AS=0.2249P AD=0.3806P
+ PS=1.385U PD=2.61U
* device instance $1627 r0 *1 15.43,28.3925 pfet
M$1627 \_017_ cmp \$711 VDD$3 pfet L=0.5U W=1.215U AS=0.5346P AD=0.3159P
+ PS=3.31U PD=1.735U
* device instance $1628 r0 *1 16.45,28.3925 pfet
M$1628 \$711 ph[11] \_017_ VDD$3 pfet L=0.5U W=1.215U AS=0.3159P AD=0.44955P
+ PS=1.735U PD=1.955U
* device instance $1629 r0 *1 17.69,28.3925 pfet
M$1629 VDD$3 \_057_ \$711 VDD$3 pfet L=0.5U W=1.215U AS=0.44955P AD=0.5346P
+ PS=1.955U PD=3.31U
* device instance $1630 r0 *1 18.91,34.33 pfet
M$1630 q4 \$783 VDD$4 VDD$4 pfet L=0.5U W=1.22U AS=0.5368P AD=0.5368P PS=3.32U
+ PD=3.32U
* device instance $1631 r0 *1 24.95,28.3925 pfet
M$1631 \_020_ cmp \$712 VDD$3 pfet L=0.5U W=1.215U AS=0.5346P AD=0.3159P
+ PS=3.31U PD=1.735U
* device instance $1632 r0 *1 25.97,28.3925 pfet
M$1632 \$712 ph[12] \_020_ VDD$3 pfet L=0.5U W=1.215U AS=0.3159P AD=0.44955P
+ PS=1.735U PD=1.955U
* device instance $1633 r0 *1 27.21,28.3925 pfet
M$1633 VDD$3 \_060_ \$712 VDD$3 pfet L=0.5U W=1.215U AS=0.44955P AD=0.5346P
+ PS=1.955U PD=3.31U
* device instance $1634 r0 *1 27.29,34.1525 pfet
M$1634 VDD$4 clknet_2_1__leaf_clk \$808 VDD$4 pfet L=0.5U W=0.865U AS=0.3806P
+ AD=0.2249P PS=2.61U PD=1.385U
* device instance $1635 r0 *1 28.31,34.1525 pfet
M$1635 \$784 \$808 VDD$4 VDD$4 pfet L=0.5U W=0.865U AS=0.2249P AD=0.3806P
+ PS=1.385U PD=2.61U
* device instance $1636 r0 *1 35.59,28.3925 pfet
M$1636 \_012_ cmp \$714 VDD$3 pfet L=0.5U W=1.215U AS=0.5346P AD=0.3159P
+ PS=3.31U PD=1.735U
* device instance $1637 r0 *1 36.61,28.3925 pfet
M$1637 \$714 ph[13] \_012_ VDD$3 pfet L=0.5U W=1.215U AS=0.3159P AD=0.44955P
+ PS=1.735U PD=1.955U
* device instance $1638 r0 *1 37.85,28.3925 pfet
M$1638 VDD$3 \_055_ \$714 VDD$3 pfet L=0.5U W=1.215U AS=0.44955P AD=0.5346P
+ PS=1.955U PD=3.31U
* device instance $1639 r0 *1 41.31,34.33 pfet
M$1639 ph[13] \$786 VDD$4 VDD$4 pfet L=0.5U W=1.22U AS=0.5368P AD=0.5368P
+ PS=3.32U PD=3.32U
* device instance $1640 r0 *1 47.91,34.33 pfet
M$1640 \$858 start VDD$4 VDD$4 pfet L=0.5U W=1.22U AS=0.5368P AD=0.4087P
+ PS=3.32U PD=1.89U
* device instance $1641 r0 *1 49.08,34.33 pfet
M$1641 \_009_[14] \_045_ \$858 VDD$4 pfet L=0.5U W=1.22U AS=0.4087P AD=0.5368P
+ PS=1.89U PD=3.32U
* device instance $1642 r0 *1 51.37,34.1525 pfet
M$1642 VDD$4 clknet_2_1__leaf_clk \$811 VDD$4 pfet L=0.5U W=0.865U AS=0.3806P
+ AD=0.2249P PS=2.61U PD=1.385U
* device instance $1643 r0 *1 52.39,34.1525 pfet
M$1643 \$788 \$811 VDD$4 VDD$4 pfet L=0.5U W=0.865U AS=0.2249P AD=0.3806P
+ PS=1.385U PD=2.61U
* device instance $1644 r0 *1 65.39,34.33 pfet
M$1644 c0_r \$790 VDD$4 VDD$4 pfet L=0.5U W=1.22U AS=0.5368P AD=0.5368P
+ PS=3.32U PD=3.32U
* device instance $1645 r0 *1 76.57,34.1525 pfet
M$1645 VDD$4 clknet_2_1__leaf_clk \$814 VDD$4 pfet L=0.5U W=0.865U AS=0.3806P
+ AD=0.2249P PS=2.61U PD=1.385U
* device instance $1646 r0 *1 77.59,34.1525 pfet
M$1646 \$791 \$814 VDD$4 VDD$4 pfet L=0.5U W=0.865U AS=0.2249P AD=0.3806P
+ PS=1.385U PD=2.61U
* device instance $1647 r0 *1 90.59,34.33 pfet
M$1647 c9_r \$793 VDD$4 VDD$4 pfet L=0.5U W=1.22U AS=0.5368P AD=0.5368P
+ PS=3.32U PD=3.32U
* device instance $1648 r0 *1 92.71,34.33 pfet
M$1648 \$760 clk VDD$4 VDD$4 pfet L=0.5U W=1.22U AS=0.5368P AD=0.3782P PS=3.32U
+ PD=1.84U
* device instance $1649 r0 *1 93.83,34.33 pfet
M$1649 VDD$4 clk \$760 VDD$4 pfet L=0.5U W=1.22U AS=0.3782P AD=0.3782P PS=1.84U
+ PD=1.84U
* device instance $1650 r0 *1 94.95,34.33 pfet
M$1650 clknet_0_clk \$760 VDD$4 VDD$4 pfet L=0.5U W=1.22U AS=0.3782P AD=0.3782P
+ PS=1.84U PD=1.84U
* device instance $1651 r0 *1 96.07,34.33 pfet
M$1651 VDD$4 \$760 clknet_0_clk VDD$4 pfet L=0.5U W=1.22U AS=0.3782P AD=0.3782P
+ PS=1.84U PD=1.84U
* device instance $1652 r0 *1 97.19,34.33 pfet
M$1652 clknet_0_clk \$760 VDD$4 VDD$4 pfet L=0.5U W=1.22U AS=0.3782P AD=0.3782P
+ PS=1.84U PD=1.84U
* device instance $1653 r0 *1 98.31,34.33 pfet
M$1653 VDD$4 \$760 clknet_0_clk VDD$4 pfet L=0.5U W=1.22U AS=0.3782P AD=0.5368P
+ PS=1.84U PD=3.32U
* device instance $1654 r0 *1 110.17,34.33 pfet
M$1654 VDD$4 \$761 \_028_ VDD$4 pfet L=0.5U W=1.22U AS=0.5368P AD=0.4298375P
+ PS=3.32U PD=2.185U
* device instance $1655 r0 *1 111.635,34.6325 pfet
M$1655 \$868 q7 VDD$4 VDD$4 pfet L=0.5U W=0.615U AS=0.4298375P AD=0.0845625P
+ PS=2.185U PD=0.89U
* device instance $1656 r0 *1 112.41,34.6325 pfet
M$1656 \$761 \$762 \$868 VDD$4 pfet L=0.5U W=0.615U AS=0.0845625P AD=0.1599P
+ PS=0.89U PD=1.135U
* device instance $1657 r0 *1 113.43,34.6325 pfet
M$1657 \$869 ph[14] \$761 VDD$4 pfet L=0.5U W=0.615U AS=0.1599P AD=0.0738P
+ PS=1.135U PD=0.855U
* device instance $1658 r0 *1 114.17,34.6325 pfet
M$1658 VDD$4 c7_r \$869 VDD$4 pfet L=0.5U W=0.615U AS=0.0738P AD=0.1599P
+ PS=0.855U PD=1.135U
* device instance $1659 r0 *1 115.19,34.6325 pfet
M$1659 \$762 ph[14] VDD$4 VDD$4 pfet L=0.5U W=0.615U AS=0.1599P AD=0.2706P
+ PS=1.135U PD=2.11U
* device instance $1660 r0 *1 118.57,34.1525 pfet
M$1660 VDD$4 clknet_2_3__leaf_clk \$818 VDD$4 pfet L=0.5U W=0.865U AS=0.3806P
+ AD=0.2249P PS=2.61U PD=1.385U
* device instance $1661 r0 *1 119.59,34.1525 pfet
M$1661 \$795 \$818 VDD$4 VDD$4 pfet L=0.5U W=0.865U AS=0.2249P AD=0.3806P
+ PS=1.385U PD=2.61U
* device instance $1662 r0 *1 128.09,28.5675 pfet
M$1662 VDD$3 clknet_2_3__leaf_clk \$722 VDD$3 pfet L=0.5U W=0.865U AS=0.3806P
+ AD=0.2249P PS=2.61U PD=1.385U
* device instance $1663 r0 *1 129.11,28.5675 pfet
M$1663 \$725 \$722 VDD$3 VDD$3 pfet L=0.5U W=0.865U AS=0.2249P AD=0.3806P
+ PS=1.385U PD=2.61U
* device instance $1664 r0 *1 131.27,28.545 pfet
M$1664 \$745 \$725 VDD$3 VDD$3 pfet L=0.5U W=0.36U AS=0.4554P AD=0.054P
+ PS=3.25U PD=0.66U
* device instance $1665 r0 *1 132.07,28.545 pfet
M$1665 \$723 \_008_ \$745 VDD$3 pfet L=0.5U W=0.36U AS=0.054P AD=0.1872P
+ PS=0.66U PD=1.4U
* device instance $1666 r0 *1 133.61,28.545 pfet
M$1666 \$743 \$722 \$723 VDD$3 pfet L=0.5U W=0.36U AS=0.1872P AD=0.0432P
+ PS=1.4U PD=0.6U
* device instance $1667 r0 *1 134.35,28.545 pfet
M$1667 VDD$3 \$724 \$743 VDD$3 pfet L=0.5U W=0.36U AS=0.0432P AD=0.1044P
+ PS=0.6U PD=0.94U
* device instance $1668 r0 *1 135.43,28.545 pfet
M$1668 \$724 \$723 VDD$3 VDD$3 pfet L=0.5U W=0.36U AS=0.1044P AD=0.1791P
+ PS=0.94U PD=1.355U
* device instance $1669 r0 *1 136.925,28.545 pfet
M$1669 \$726 \$722 \$724 VDD$3 pfet L=0.5U W=0.36U AS=0.1791P AD=0.1665P
+ PS=1.355U PD=1.285U
* device instance $1670 r0 *1 138.35,28.545 pfet
M$1670 \$741 \$725 \$726 VDD$3 pfet L=0.5U W=0.36U AS=0.1665P AD=0.0504P
+ PS=1.285U PD=0.64U
* device instance $1671 r0 *1 139.13,28.545 pfet
M$1671 \$741 \$727 VDD$3 VDD$3 pfet L=0.5U W=0.36U AS=0.23P AD=0.0504P PS=1.54U
+ PD=0.64U
* device instance $1672 r0 *1 140.37,28.325 pfet
M$1672 \$727 \$726 VDD$3 VDD$3 pfet L=0.5U W=0.8U AS=0.23P AD=0.352P PS=1.54U
+ PD=2.48U
* device instance $1673 r0 *1 132.59,34.33 pfet
M$1673 ph[15] \$797 VDD$4 VDD$4 pfet L=0.5U W=1.22U AS=0.5368P AD=0.5368P
+ PS=3.32U PD=3.32U
* device instance $1674 r0 *1 148.25,34.1525 pfet
M$1674 VDD$4 clknet_2_3__leaf_clk \$821 VDD$4 pfet L=0.5U W=0.865U AS=0.3806P
+ AD=0.2249P PS=2.61U PD=1.385U
* device instance $1675 r0 *1 149.27,34.1525 pfet
M$1675 \$798 \$821 VDD$4 VDD$4 pfet L=0.5U W=0.865U AS=0.2249P AD=0.3806P
+ PS=1.385U PD=2.61U
* device instance $1676 r0 *1 154.87,28.3925 pfet
M$1676 \_018_ cmp \$729 VDD$3 pfet L=0.5U W=1.215U AS=0.5346P AD=0.3159P
+ PS=3.31U PD=1.735U
* device instance $1677 r0 *1 155.89,28.3925 pfet
M$1677 \$729 ph[6] \_018_ VDD$3 pfet L=0.5U W=1.215U AS=0.3159P AD=0.44955P
+ PS=1.735U PD=1.955U
* device instance $1678 r0 *1 157.13,28.3925 pfet
M$1678 VDD$3 \_058_ \$729 VDD$3 pfet L=0.5U W=1.215U AS=0.44955P AD=0.5346P
+ PS=1.955U PD=3.31U
* device instance $1679 r0 *1 162.27,34.33 pfet
M$1679 ph[8] \$800 VDD$4 VDD$4 pfet L=0.5U W=1.22U AS=0.5368P AD=0.5368P
+ PS=3.32U PD=3.32U
* device instance $1680 r0 *1 177.37,34.1525 pfet
M$1680 VDD$4 clknet_2_3__leaf_clk \$824 VDD$4 pfet L=0.5U W=0.865U AS=0.3806P
+ AD=0.2249P PS=2.61U PD=1.385U
* device instance $1681 r0 *1 178.39,34.1525 pfet
M$1681 \$801 \$824 VDD$4 VDD$4 pfet L=0.5U W=0.865U AS=0.2249P AD=0.3806P
+ PS=1.385U PD=2.61U
* device instance $1682 r0 *1 181.85,28.5675 pfet
M$1682 VDD$3 clknet_2_3__leaf_clk \$732 VDD$3 pfet L=0.5U W=0.865U AS=0.3806P
+ AD=0.2249P PS=2.61U PD=1.385U
* device instance $1683 r0 *1 182.87,28.5675 pfet
M$1683 \$735 \$732 VDD$3 VDD$3 pfet L=0.5U W=0.865U AS=0.2249P AD=0.3806P
+ PS=1.385U PD=2.61U
* device instance $1684 r0 *1 185.03,28.545 pfet
M$1684 \$740 \$735 VDD$3 VDD$3 pfet L=0.5U W=0.36U AS=0.4554P AD=0.054P
+ PS=3.25U PD=0.66U
* device instance $1685 r0 *1 185.83,28.545 pfet
M$1685 \$733 \_009_[5] \$740 VDD$3 pfet L=0.5U W=0.36U AS=0.054P AD=0.1872P
+ PS=0.66U PD=1.4U
* device instance $1686 r0 *1 187.37,28.545 pfet
M$1686 \$739 \$732 \$733 VDD$3 pfet L=0.5U W=0.36U AS=0.1872P AD=0.0432P
+ PS=1.4U PD=0.6U
* device instance $1687 r0 *1 188.11,28.545 pfet
M$1687 VDD$3 \$734 \$739 VDD$3 pfet L=0.5U W=0.36U AS=0.0432P AD=0.1044P
+ PS=0.6U PD=0.94U
* device instance $1688 r0 *1 189.19,28.545 pfet
M$1688 \$734 \$733 VDD$3 VDD$3 pfet L=0.5U W=0.36U AS=0.1044P AD=0.1791P
+ PS=0.94U PD=1.355U
* device instance $1689 r0 *1 190.685,28.545 pfet
M$1689 \$736 \$732 \$734 VDD$3 pfet L=0.5U W=0.36U AS=0.1791P AD=0.1665P
+ PS=1.355U PD=1.285U
* device instance $1690 r0 *1 192.11,28.545 pfet
M$1690 \$738 \$735 \$736 VDD$3 pfet L=0.5U W=0.36U AS=0.1665P AD=0.0504P
+ PS=1.285U PD=0.64U
* device instance $1691 r0 *1 192.89,28.545 pfet
M$1691 \$738 \$737 VDD$3 VDD$3 pfet L=0.5U W=0.36U AS=0.23P AD=0.0504P PS=1.54U
+ PD=0.64U
* device instance $1692 r0 *1 194.13,28.325 pfet
M$1692 \$737 \$736 VDD$3 VDD$3 pfet L=0.5U W=0.8U AS=0.23P AD=0.352P PS=1.54U
+ PD=2.48U
* device instance $1693 r0 *1 191.39,34.33 pfet
M$1693 ph[2] \$803 VDD$4 VDD$4 pfet L=0.5U W=1.22U AS=0.5368P AD=0.5368P
+ PS=3.32U PD=3.32U
* device instance $1694 r0 *1 8.07,34.175 pfet
M$1694 \$851 \$781 VDD$4 VDD$4 pfet L=0.5U W=0.36U AS=0.4554P AD=0.054P
+ PS=3.25U PD=0.66U
* device instance $1695 r0 *1 8.87,34.175 pfet
M$1695 \$806 \_025_ \$851 VDD$4 pfet L=0.5U W=0.36U AS=0.054P AD=0.1872P
+ PS=0.66U PD=1.4U
* device instance $1696 r0 *1 10.41,34.175 pfet
M$1696 \$852 \$805 \$806 VDD$4 pfet L=0.5U W=0.36U AS=0.1872P AD=0.0432P
+ PS=1.4U PD=0.6U
* device instance $1697 r0 *1 11.15,34.175 pfet
M$1697 VDD$4 \$782 \$852 VDD$4 pfet L=0.5U W=0.36U AS=0.0432P AD=0.1044P
+ PS=0.6U PD=0.94U
* device instance $1698 r0 *1 12.23,34.175 pfet
M$1698 \$782 \$806 VDD$4 VDD$4 pfet L=0.5U W=0.36U AS=0.1044P AD=0.1791P
+ PS=0.94U PD=1.355U
* device instance $1699 r0 *1 13.725,34.175 pfet
M$1699 \$807 \$805 \$782 VDD$4 pfet L=0.5U W=0.36U AS=0.1791P AD=0.1665P
+ PS=1.355U PD=1.285U
* device instance $1700 r0 *1 15.15,34.175 pfet
M$1700 \$853 \$781 \$807 VDD$4 pfet L=0.5U W=0.36U AS=0.1665P AD=0.0504P
+ PS=1.285U PD=0.64U
* device instance $1701 r0 *1 15.93,34.175 pfet
M$1701 VDD$4 \$783 \$853 VDD$4 pfet L=0.5U W=0.36U AS=0.0504P AD=0.23P PS=0.64U
+ PD=1.54U
* device instance $1702 r0 *1 17.17,34.395 pfet
M$1702 \$783 \$807 VDD$4 VDD$4 pfet L=0.5U W=0.8U AS=0.23P AD=0.352P PS=1.54U
+ PD=2.48U
* device instance $1703 r0 *1 30.47,34.175 pfet
M$1703 \$854 \$784 VDD$4 VDD$4 pfet L=0.5U W=0.36U AS=0.4554P AD=0.054P
+ PS=3.25U PD=0.66U
* device instance $1704 r0 *1 31.27,34.175 pfet
M$1704 \$809 \_009_[13] \$854 VDD$4 pfet L=0.5U W=0.36U AS=0.054P AD=0.1872P
+ PS=0.66U PD=1.4U
* device instance $1705 r0 *1 32.81,34.175 pfet
M$1705 \$855 \$808 \$809 VDD$4 pfet L=0.5U W=0.36U AS=0.1872P AD=0.0432P
+ PS=1.4U PD=0.6U
* device instance $1706 r0 *1 33.55,34.175 pfet
M$1706 VDD$4 \$785 \$855 VDD$4 pfet L=0.5U W=0.36U AS=0.0432P AD=0.1044P
+ PS=0.6U PD=0.94U
* device instance $1707 r0 *1 34.63,34.175 pfet
M$1707 \$785 \$809 VDD$4 VDD$4 pfet L=0.5U W=0.36U AS=0.1044P AD=0.1791P
+ PS=0.94U PD=1.355U
* device instance $1708 r0 *1 36.125,34.175 pfet
M$1708 \$810 \$808 \$785 VDD$4 pfet L=0.5U W=0.36U AS=0.1791P AD=0.1665P
+ PS=1.355U PD=1.285U
* device instance $1709 r0 *1 37.55,34.175 pfet
M$1709 \$857 \$784 \$810 VDD$4 pfet L=0.5U W=0.36U AS=0.1665P AD=0.0504P
+ PS=1.285U PD=0.64U
* device instance $1710 r0 *1 38.33,34.175 pfet
M$1710 VDD$4 \$786 \$857 VDD$4 pfet L=0.5U W=0.36U AS=0.0504P AD=0.23P PS=0.64U
+ PD=1.54U
* device instance $1711 r0 *1 39.57,34.395 pfet
M$1711 \$786 \$810 VDD$4 VDD$4 pfet L=0.5U W=0.8U AS=0.23P AD=0.352P PS=1.54U
+ PD=2.48U
* device instance $1712 r0 *1 54.55,34.175 pfet
M$1712 \$859 \$788 VDD$4 VDD$4 pfet L=0.5U W=0.36U AS=0.4554P AD=0.054P
+ PS=3.25U PD=0.66U
* device instance $1713 r0 *1 55.35,34.175 pfet
M$1713 \$812 \_013_ \$859 VDD$4 pfet L=0.5U W=0.36U AS=0.054P AD=0.1872P
+ PS=0.66U PD=1.4U
* device instance $1714 r0 *1 56.89,34.175 pfet
M$1714 \$860 \$811 \$812 VDD$4 pfet L=0.5U W=0.36U AS=0.1872P AD=0.0432P
+ PS=1.4U PD=0.6U
* device instance $1715 r0 *1 57.63,34.175 pfet
M$1715 VDD$4 \$789 \$860 VDD$4 pfet L=0.5U W=0.36U AS=0.0432P AD=0.1044P
+ PS=0.6U PD=0.94U
* device instance $1716 r0 *1 58.71,34.175 pfet
M$1716 \$789 \$812 VDD$4 VDD$4 pfet L=0.5U W=0.36U AS=0.1044P AD=0.1791P
+ PS=0.94U PD=1.355U
* device instance $1717 r0 *1 60.205,34.175 pfet
M$1717 \$813 \$811 \$789 VDD$4 pfet L=0.5U W=0.36U AS=0.1791P AD=0.1665P
+ PS=1.355U PD=1.285U
* device instance $1718 r0 *1 61.63,34.175 pfet
M$1718 \$862 \$788 \$813 VDD$4 pfet L=0.5U W=0.36U AS=0.1665P AD=0.0504P
+ PS=1.285U PD=0.64U
* device instance $1719 r0 *1 62.41,34.175 pfet
M$1719 VDD$4 \$790 \$862 VDD$4 pfet L=0.5U W=0.36U AS=0.0504P AD=0.23P PS=0.64U
+ PD=1.54U
* device instance $1720 r0 *1 63.65,34.395 pfet
M$1720 \$790 \$813 VDD$4 VDD$4 pfet L=0.5U W=0.8U AS=0.23P AD=0.352P PS=1.54U
+ PD=2.48U
* device instance $1721 r0 *1 79.75,34.175 pfet
M$1721 \$864 \$791 VDD$4 VDD$4 pfet L=0.5U W=0.36U AS=0.4554P AD=0.054P
+ PS=3.25U PD=0.66U
* device instance $1722 r0 *1 80.55,34.175 pfet
M$1722 \$815 \_011_ \$864 VDD$4 pfet L=0.5U W=0.36U AS=0.054P AD=0.1872P
+ PS=0.66U PD=1.4U
* device instance $1723 r0 *1 82.09,34.175 pfet
M$1723 \$865 \$814 \$815 VDD$4 pfet L=0.5U W=0.36U AS=0.1872P AD=0.0432P
+ PS=1.4U PD=0.6U
* device instance $1724 r0 *1 82.83,34.175 pfet
M$1724 VDD$4 \$792 \$865 VDD$4 pfet L=0.5U W=0.36U AS=0.0432P AD=0.1044P
+ PS=0.6U PD=0.94U
* device instance $1725 r0 *1 83.91,34.175 pfet
M$1725 \$792 \$815 VDD$4 VDD$4 pfet L=0.5U W=0.36U AS=0.1044P AD=0.1791P
+ PS=0.94U PD=1.355U
* device instance $1726 r0 *1 85.405,34.175 pfet
M$1726 \$816 \$814 \$792 VDD$4 pfet L=0.5U W=0.36U AS=0.1791P AD=0.1665P
+ PS=1.355U PD=1.285U
* device instance $1727 r0 *1 86.83,34.175 pfet
M$1727 \$866 \$791 \$816 VDD$4 pfet L=0.5U W=0.36U AS=0.1665P AD=0.0504P
+ PS=1.285U PD=0.64U
* device instance $1728 r0 *1 87.61,34.175 pfet
M$1728 VDD$4 \$793 \$866 VDD$4 pfet L=0.5U W=0.36U AS=0.0504P AD=0.23P PS=0.64U
+ PD=1.54U
* device instance $1729 r0 *1 88.85,34.395 pfet
M$1729 \$793 \$816 VDD$4 VDD$4 pfet L=0.5U W=0.8U AS=0.23P AD=0.352P PS=1.54U
+ PD=2.48U
* device instance $1730 r0 *1 121.75,34.175 pfet
M$1730 \$871 \$795 VDD$4 VDD$4 pfet L=0.5U W=0.36U AS=0.4554P AD=0.054P
+ PS=3.25U PD=0.66U
* device instance $1731 r0 *1 122.55,34.175 pfet
M$1731 \$819 \_009_[15] \$871 VDD$4 pfet L=0.5U W=0.36U AS=0.054P AD=0.1872P
+ PS=0.66U PD=1.4U
* device instance $1732 r0 *1 124.09,34.175 pfet
M$1732 \$872 \$818 \$819 VDD$4 pfet L=0.5U W=0.36U AS=0.1872P AD=0.0432P
+ PS=1.4U PD=0.6U
* device instance $1733 r0 *1 124.83,34.175 pfet
M$1733 VDD$4 \$796 \$872 VDD$4 pfet L=0.5U W=0.36U AS=0.0432P AD=0.1044P
+ PS=0.6U PD=0.94U
* device instance $1734 r0 *1 125.91,34.175 pfet
M$1734 \$796 \$819 VDD$4 VDD$4 pfet L=0.5U W=0.36U AS=0.1044P AD=0.1791P
+ PS=0.94U PD=1.355U
* device instance $1735 r0 *1 127.405,34.175 pfet
M$1735 \$820 \$818 \$796 VDD$4 pfet L=0.5U W=0.36U AS=0.1791P AD=0.1665P
+ PS=1.355U PD=1.285U
* device instance $1736 r0 *1 128.83,34.175 pfet
M$1736 \$873 \$795 \$820 VDD$4 pfet L=0.5U W=0.36U AS=0.1665P AD=0.0504P
+ PS=1.285U PD=0.64U
* device instance $1737 r0 *1 129.61,34.175 pfet
M$1737 VDD$4 \$797 \$873 VDD$4 pfet L=0.5U W=0.36U AS=0.0504P AD=0.23P PS=0.64U
+ PD=1.54U
* device instance $1738 r0 *1 130.85,34.395 pfet
M$1738 \$797 \$820 VDD$4 VDD$4 pfet L=0.5U W=0.8U AS=0.23P AD=0.352P PS=1.54U
+ PD=2.48U
* device instance $1739 r0 *1 151.43,34.175 pfet
M$1739 \$874 \$798 VDD$4 VDD$4 pfet L=0.5U W=0.36U AS=0.4554P AD=0.054P
+ PS=3.25U PD=0.66U
* device instance $1740 r0 *1 152.23,34.175 pfet
M$1740 \$822 \_009_[8] \$874 VDD$4 pfet L=0.5U W=0.36U AS=0.054P AD=0.1872P
+ PS=0.66U PD=1.4U
* device instance $1741 r0 *1 153.77,34.175 pfet
M$1741 \$870 \$821 \$822 VDD$4 pfet L=0.5U W=0.36U AS=0.1872P AD=0.0432P
+ PS=1.4U PD=0.6U
* device instance $1742 r0 *1 154.51,34.175 pfet
M$1742 VDD$4 \$799 \$870 VDD$4 pfet L=0.5U W=0.36U AS=0.0432P AD=0.1044P
+ PS=0.6U PD=0.94U
* device instance $1743 r0 *1 155.59,34.175 pfet
M$1743 \$799 \$822 VDD$4 VDD$4 pfet L=0.5U W=0.36U AS=0.1044P AD=0.1791P
+ PS=0.94U PD=1.355U
* device instance $1744 r0 *1 157.085,34.175 pfet
M$1744 \$823 \$821 \$799 VDD$4 pfet L=0.5U W=0.36U AS=0.1791P AD=0.1665P
+ PS=1.355U PD=1.285U
* device instance $1745 r0 *1 158.51,34.175 pfet
M$1745 \$867 \$798 \$823 VDD$4 pfet L=0.5U W=0.36U AS=0.1665P AD=0.0504P
+ PS=1.285U PD=0.64U
* device instance $1746 r0 *1 159.29,34.175 pfet
M$1746 VDD$4 \$800 \$867 VDD$4 pfet L=0.5U W=0.36U AS=0.0504P AD=0.23P PS=0.64U
+ PD=1.54U
* device instance $1747 r0 *1 160.53,34.395 pfet
M$1747 \$800 \$823 VDD$4 VDD$4 pfet L=0.5U W=0.8U AS=0.23P AD=0.352P PS=1.54U
+ PD=2.48U
* device instance $1748 r0 *1 180.55,34.175 pfet
M$1748 \$863 \$801 VDD$4 VDD$4 pfet L=0.5U W=0.36U AS=0.4554P AD=0.054P
+ PS=3.25U PD=0.66U
* device instance $1749 r0 *1 181.35,34.175 pfet
M$1749 \$825 \_009_[2] \$863 VDD$4 pfet L=0.5U W=0.36U AS=0.054P AD=0.1872P
+ PS=0.66U PD=1.4U
* device instance $1750 r0 *1 182.89,34.175 pfet
M$1750 \$861 \$824 \$825 VDD$4 pfet L=0.5U W=0.36U AS=0.1872P AD=0.0432P
+ PS=1.4U PD=0.6U
* device instance $1751 r0 *1 183.63,34.175 pfet
M$1751 VDD$4 \$802 \$861 VDD$4 pfet L=0.5U W=0.36U AS=0.0432P AD=0.1044P
+ PS=0.6U PD=0.94U
* device instance $1752 r0 *1 184.71,34.175 pfet
M$1752 \$802 \$825 VDD$4 VDD$4 pfet L=0.5U W=0.36U AS=0.1044P AD=0.1791P
+ PS=0.94U PD=1.355U
* device instance $1753 r0 *1 186.205,34.175 pfet
M$1753 \$826 \$824 \$802 VDD$4 pfet L=0.5U W=0.36U AS=0.1791P AD=0.1665P
+ PS=1.355U PD=1.285U
* device instance $1754 r0 *1 187.63,34.175 pfet
M$1754 \$856 \$801 \$826 VDD$4 pfet L=0.5U W=0.36U AS=0.1665P AD=0.0504P
+ PS=1.285U PD=0.64U
* device instance $1755 r0 *1 188.41,34.175 pfet
M$1755 VDD$4 \$803 \$856 VDD$4 pfet L=0.5U W=0.36U AS=0.0504P AD=0.23P PS=0.64U
+ PD=1.54U
* device instance $1756 r0 *1 189.65,34.395 pfet
M$1756 \$803 \$826 VDD$4 VDD$4 pfet L=0.5U W=0.8U AS=0.23P AD=0.352P PS=1.54U
+ PD=2.48U
* device instance $1757 r0 *1 2.09,36.4075 pfet
M$1757 VDD$4 clknet_2_1__leaf_clk \$875 VDD$4 pfet L=0.5U W=0.865U AS=0.3806P
+ AD=0.2249P PS=2.61U PD=1.385U
* device instance $1758 r0 *1 3.11,36.4075 pfet
M$1758 \$877 \$875 VDD$4 VDD$4 pfet L=0.5U W=0.865U AS=0.2249P AD=0.3806P
+ PS=1.385U PD=2.61U
* device instance $1759 r0 *1 5.27,36.385 pfet
M$1759 \$920 \$877 VDD$4 VDD$4 pfet L=0.5U W=0.36U AS=0.4554P AD=0.054P
+ PS=3.25U PD=0.66U
* device instance $1760 r0 *1 6.07,36.385 pfet
M$1760 \$906 \_009_[9] \$920 VDD$4 pfet L=0.5U W=0.36U AS=0.054P AD=0.1872P
+ PS=0.66U PD=1.4U
* device instance $1761 r0 *1 7.61,36.385 pfet
M$1761 \$921 \$875 \$906 VDD$4 pfet L=0.5U W=0.36U AS=0.1872P AD=0.0432P
+ PS=1.4U PD=0.6U
* device instance $1762 r0 *1 8.35,36.385 pfet
M$1762 VDD$4 \$876 \$921 VDD$4 pfet L=0.5U W=0.36U AS=0.0432P AD=0.1044P
+ PS=0.6U PD=0.94U
* device instance $1763 r0 *1 9.43,36.385 pfet
M$1763 \$876 \$906 VDD$4 VDD$4 pfet L=0.5U W=0.36U AS=0.1044P AD=0.1791P
+ PS=0.94U PD=1.355U
* device instance $1764 r0 *1 10.925,36.385 pfet
M$1764 \$907 \$875 \$876 VDD$4 pfet L=0.5U W=0.36U AS=0.1791P AD=0.1665P
+ PS=1.355U PD=1.285U
* device instance $1765 r0 *1 12.35,36.385 pfet
M$1765 \$922 \$877 \$907 VDD$4 pfet L=0.5U W=0.36U AS=0.1665P AD=0.0504P
+ PS=1.285U PD=0.64U
* device instance $1766 r0 *1 13.13,36.385 pfet
M$1766 \$922 \$878 VDD$4 VDD$4 pfet L=0.5U W=0.36U AS=0.23P AD=0.0504P PS=1.54U
+ PD=0.64U
* device instance $1767 r0 *1 14.37,36.165 pfet
M$1767 \$878 \$907 VDD$4 VDD$4 pfet L=0.5U W=0.8U AS=0.23P AD=0.352P PS=1.54U
+ PD=2.48U
* device instance $1768 r0 *1 16.11,36.23 pfet
M$1768 ph[9] \$878 VDD$4 VDD$4 pfet L=0.5U W=1.22U AS=0.5368P AD=0.5368P
+ PS=3.32U PD=3.32U
* device instance $1769 r0 *1 21.69,36.4075 pfet
M$1769 VDD$4 clknet_2_1__leaf_clk \$879 VDD$4 pfet L=0.5U W=0.865U AS=0.3806P
+ AD=0.2249P PS=2.61U PD=1.385U
* device instance $1770 r0 *1 22.71,36.4075 pfet
M$1770 \$881 \$879 VDD$4 VDD$4 pfet L=0.5U W=0.865U AS=0.2249P AD=0.3806P
+ PS=1.385U PD=2.61U
* device instance $1771 r0 *1 24.87,36.385 pfet
M$1771 \$924 \$881 VDD$4 VDD$4 pfet L=0.5U W=0.36U AS=0.4554P AD=0.054P
+ PS=3.25U PD=0.66U
* device instance $1772 r0 *1 25.67,36.385 pfet
M$1772 \$908 \_020_ \$924 VDD$4 pfet L=0.5U W=0.36U AS=0.054P AD=0.1872P
+ PS=0.66U PD=1.4U
* device instance $1773 r0 *1 27.21,36.385 pfet
M$1773 \$925 \$879 \$908 VDD$4 pfet L=0.5U W=0.36U AS=0.1872P AD=0.0432P
+ PS=1.4U PD=0.6U
* device instance $1774 r0 *1 27.95,36.385 pfet
M$1774 VDD$4 \$880 \$925 VDD$4 pfet L=0.5U W=0.36U AS=0.0432P AD=0.1044P
+ PS=0.6U PD=0.94U
* device instance $1775 r0 *1 29.03,36.385 pfet
M$1775 \$880 \$908 VDD$4 VDD$4 pfet L=0.5U W=0.36U AS=0.1044P AD=0.1791P
+ PS=0.94U PD=1.355U
* device instance $1776 r0 *1 30.525,36.385 pfet
M$1776 \$909 \$879 \$880 VDD$4 pfet L=0.5U W=0.36U AS=0.1791P AD=0.1665P
+ PS=1.355U PD=1.285U
* device instance $1777 r0 *1 31.95,36.385 pfet
M$1777 \$927 \$881 \$909 VDD$4 pfet L=0.5U W=0.36U AS=0.1665P AD=0.0504P
+ PS=1.285U PD=0.64U
* device instance $1778 r0 *1 32.73,36.385 pfet
M$1778 \$927 \$882 VDD$4 VDD$4 pfet L=0.5U W=0.36U AS=0.23P AD=0.0504P PS=1.54U
+ PD=0.64U
* device instance $1779 r0 *1 33.97,36.165 pfet
M$1779 \$882 \$909 VDD$4 VDD$4 pfet L=0.5U W=0.8U AS=0.23P AD=0.352P PS=1.54U
+ PD=2.48U
* device instance $1780 r0 *1 35.71,36.23 pfet
M$1780 q1 \$882 VDD$4 VDD$4 pfet L=0.5U W=1.22U AS=0.5368P AD=0.5368P PS=3.32U
+ PD=3.32U
* device instance $1781 r0 *1 40.07,36.23 pfet
M$1781 \$883 clknet_2_0__leaf_clk VDD$4 VDD$4 pfet L=0.5U W=1.22U AS=0.5368P
+ AD=0.3782P PS=3.32U PD=1.84U
* device instance $1782 r0 *1 41.19,36.23 pfet
M$1782 VDD$4 clknet_2_0__leaf_clk \$883 VDD$4 pfet L=0.5U W=1.22U AS=0.3782P
+ AD=0.3782P PS=1.84U PD=1.84U
* device instance $1783 r0 *1 42.31,36.23 pfet
M$1783 Z \$883 VDD$4 VDD$4 pfet L=0.5U W=1.22U AS=0.3782P AD=0.3782P PS=1.84U
+ PD=1.84U
* device instance $1784 r0 *1 43.43,36.23 pfet
M$1784 VDD$4 \$883 Z VDD$4 pfet L=0.5U W=1.22U AS=0.3782P AD=0.3782P PS=1.84U
+ PD=1.84U
* device instance $1785 r0 *1 44.55,36.23 pfet
M$1785 Z \$883 VDD$4 VDD$4 pfet L=0.5U W=1.22U AS=0.3782P AD=0.3782P PS=1.84U
+ PD=1.84U
* device instance $1786 r0 *1 45.67,36.23 pfet
M$1786 VDD$4 \$883 Z VDD$4 pfet L=0.5U W=1.22U AS=0.3782P AD=0.5368P PS=1.84U
+ PD=3.32U
* device instance $1787 r0 *1 48.01,36.4075 pfet
M$1787 VDD$4 clknet_2_1__leaf_clk \$885 VDD$4 pfet L=0.5U W=0.865U AS=0.3806P
+ AD=0.2249P PS=2.61U PD=1.385U
* device instance $1788 r0 *1 49.03,36.4075 pfet
M$1788 \$887 \$885 VDD$4 VDD$4 pfet L=0.5U W=0.865U AS=0.2249P AD=0.3806P
+ PS=1.385U PD=2.61U
* device instance $1789 r0 *1 51.19,36.385 pfet
M$1789 \$929 \$887 VDD$4 VDD$4 pfet L=0.5U W=0.36U AS=0.4554P AD=0.054P
+ PS=3.25U PD=0.66U
* device instance $1790 r0 *1 51.99,36.385 pfet
M$1790 \$910 \_009_[14] \$929 VDD$4 pfet L=0.5U W=0.36U AS=0.054P AD=0.1872P
+ PS=0.66U PD=1.4U
* device instance $1791 r0 *1 53.53,36.385 pfet
M$1791 \$930 \$885 \$910 VDD$4 pfet L=0.5U W=0.36U AS=0.1872P AD=0.0432P
+ PS=1.4U PD=0.6U
* device instance $1792 r0 *1 54.27,36.385 pfet
M$1792 VDD$4 \$886 \$930 VDD$4 pfet L=0.5U W=0.36U AS=0.0432P AD=0.1044P
+ PS=0.6U PD=0.94U
* device instance $1793 r0 *1 55.35,36.385 pfet
M$1793 \$886 \$910 VDD$4 VDD$4 pfet L=0.5U W=0.36U AS=0.1044P AD=0.1791P
+ PS=0.94U PD=1.355U
* device instance $1794 r0 *1 56.845,36.385 pfet
M$1794 \$911 \$885 \$886 VDD$4 pfet L=0.5U W=0.36U AS=0.1791P AD=0.1665P
+ PS=1.355U PD=1.285U
* device instance $1795 r0 *1 58.27,36.385 pfet
M$1795 \$931 \$887 \$911 VDD$4 pfet L=0.5U W=0.36U AS=0.1665P AD=0.0504P
+ PS=1.285U PD=0.64U
* device instance $1796 r0 *1 59.05,36.385 pfet
M$1796 \$931 \$888 VDD$4 VDD$4 pfet L=0.5U W=0.36U AS=0.23P AD=0.0504P PS=1.54U
+ PD=0.64U
* device instance $1797 r0 *1 60.29,36.165 pfet
M$1797 \$888 \$911 VDD$4 VDD$4 pfet L=0.5U W=0.8U AS=0.23P AD=0.352P PS=1.54U
+ PD=2.48U
* device instance $1798 r0 *1 62.03,36.23 pfet
M$1798 ph[14] \$888 VDD$4 VDD$4 pfet L=0.5U W=1.22U AS=0.5368P AD=0.5368P
+ PS=3.32U PD=3.32U
* device instance $1799 r0 *1 65.715,35.9275 pfet
M$1799 \$932 q3 VDD$4 VDD$4 pfet L=0.5U W=0.615U AS=0.4298375P AD=0.0845625P
+ PS=2.185U PD=0.89U
* device instance $1800 r0 *1 66.49,35.9275 pfet
M$1800 \$889 \$850 \$932 VDD$4 pfet L=0.5U W=0.615U AS=0.0845625P AD=0.1599P
+ PS=0.89U PD=1.135U
* device instance $1801 r0 *1 67.51,35.9275 pfet
M$1801 \$933 ph[14] \$889 VDD$4 pfet L=0.5U W=0.615U AS=0.1599P AD=0.0738P
+ PS=1.135U PD=0.855U
* device instance $1802 r0 *1 68.25,35.9275 pfet
M$1802 VDD$4 c3_r \$933 VDD$4 pfet L=0.5U W=0.615U AS=0.0738P AD=0.1599P
+ PS=0.855U PD=1.135U
* device instance $1803 r0 *1 69.27,35.9275 pfet
M$1803 \$850 ph[14] VDD$4 VDD$4 pfet L=0.5U W=0.615U AS=0.1599P AD=0.2706P
+ PS=1.135U PD=2.11U
* device instance $1804 r0 *1 64.25,36.23 pfet
M$1804 VDD$4 \$889 \_021_ VDD$4 pfet L=0.5U W=1.22U AS=0.5368P AD=0.4298375P
+ PS=3.32U PD=2.185U
* device instance $1805 r0 *1 73.21,36.4075 pfet
M$1805 VDD$4 clknet_2_1__leaf_clk \$890 VDD$4 pfet L=0.5U W=0.865U AS=0.3806P
+ AD=0.2249P PS=2.61U PD=1.385U
* device instance $1806 r0 *1 74.23,36.4075 pfet
M$1806 \$892 \$890 VDD$4 VDD$4 pfet L=0.5U W=0.865U AS=0.2249P AD=0.3806P
+ PS=1.385U PD=2.61U
* device instance $1807 r0 *1 76.39,36.385 pfet
M$1807 \$935 \$892 VDD$4 VDD$4 pfet L=0.5U W=0.36U AS=0.4554P AD=0.054P
+ PS=3.25U PD=0.66U
* device instance $1808 r0 *1 77.19,36.385 pfet
M$1808 \$912 \_010_ \$935 VDD$4 pfet L=0.5U W=0.36U AS=0.054P AD=0.1872P
+ PS=0.66U PD=1.4U
* device instance $1809 r0 *1 78.73,36.385 pfet
M$1809 \$936 \$890 \$912 VDD$4 pfet L=0.5U W=0.36U AS=0.1872P AD=0.0432P
+ PS=1.4U PD=0.6U
* device instance $1810 r0 *1 79.47,36.385 pfet
M$1810 VDD$4 \$891 \$936 VDD$4 pfet L=0.5U W=0.36U AS=0.0432P AD=0.1044P
+ PS=0.6U PD=0.94U
* device instance $1811 r0 *1 80.55,36.385 pfet
M$1811 \$891 \$912 VDD$4 VDD$4 pfet L=0.5U W=0.36U AS=0.1044P AD=0.1791P
+ PS=0.94U PD=1.355U
* device instance $1812 r0 *1 82.045,36.385 pfet
M$1812 \$913 \$890 \$891 VDD$4 pfet L=0.5U W=0.36U AS=0.1791P AD=0.1665P
+ PS=1.355U PD=1.285U
* device instance $1813 r0 *1 83.47,36.385 pfet
M$1813 \$937 \$892 \$913 VDD$4 pfet L=0.5U W=0.36U AS=0.1665P AD=0.0504P
+ PS=1.285U PD=0.64U
* device instance $1814 r0 *1 84.25,36.385 pfet
M$1814 \$937 \$893 VDD$4 VDD$4 pfet L=0.5U W=0.36U AS=0.23P AD=0.0504P PS=1.54U
+ PD=0.64U
* device instance $1815 r0 *1 85.49,36.165 pfet
M$1815 \$893 \$913 VDD$4 VDD$4 pfet L=0.5U W=0.8U AS=0.23P AD=0.352P PS=1.54U
+ PD=2.48U
* device instance $1816 r0 *1 87.23,36.23 pfet
M$1816 c8_r \$893 VDD$4 VDD$4 pfet L=0.5U W=1.22U AS=0.5368P AD=0.5368P
+ PS=3.32U PD=3.32U
* device instance $1817 r0 *1 107.93,36.4075 pfet
M$1817 VDD$4 clknet_2_3__leaf_clk \$894 VDD$4 pfet L=0.5U W=0.865U AS=0.3806P
+ AD=0.2249P PS=2.61U PD=1.385U
* device instance $1818 r0 *1 108.95,36.4075 pfet
M$1818 \$896 \$894 VDD$4 VDD$4 pfet L=0.5U W=0.865U AS=0.2249P AD=0.3806P
+ PS=1.385U PD=2.61U
* device instance $1819 r0 *1 111.11,36.385 pfet
M$1819 \$938 \$896 VDD$4 VDD$4 pfet L=0.5U W=0.36U AS=0.4554P AD=0.054P
+ PS=3.25U PD=0.66U
* device instance $1820 r0 *1 111.91,36.385 pfet
M$1820 \$914 \_028_ \$938 VDD$4 pfet L=0.5U W=0.36U AS=0.054P AD=0.1872P
+ PS=0.66U PD=1.4U
* device instance $1821 r0 *1 113.45,36.385 pfet
M$1821 \$941 \$894 \$914 VDD$4 pfet L=0.5U W=0.36U AS=0.1872P AD=0.0432P
+ PS=1.4U PD=0.6U
* device instance $1822 r0 *1 114.19,36.385 pfet
M$1822 VDD$4 \$895 \$941 VDD$4 pfet L=0.5U W=0.36U AS=0.0432P AD=0.1044P
+ PS=0.6U PD=0.94U
* device instance $1823 r0 *1 115.27,36.385 pfet
M$1823 \$895 \$914 VDD$4 VDD$4 pfet L=0.5U W=0.36U AS=0.1044P AD=0.1791P
+ PS=0.94U PD=1.355U
* device instance $1824 r0 *1 116.765,36.385 pfet
M$1824 \$915 \$894 \$895 VDD$4 pfet L=0.5U W=0.36U AS=0.1791P AD=0.1665P
+ PS=1.355U PD=1.285U
* device instance $1825 r0 *1 118.19,36.385 pfet
M$1825 \$942 \$896 \$915 VDD$4 pfet L=0.5U W=0.36U AS=0.1665P AD=0.0504P
+ PS=1.285U PD=0.64U
* device instance $1826 r0 *1 118.97,36.385 pfet
M$1826 \$942 \$897 VDD$4 VDD$4 pfet L=0.5U W=0.36U AS=0.23P AD=0.0504P PS=1.54U
+ PD=0.64U
* device instance $1827 r0 *1 120.21,36.165 pfet
M$1827 \$897 \$915 VDD$4 VDD$4 pfet L=0.5U W=0.8U AS=0.23P AD=0.352P PS=1.54U
+ PD=2.48U
* device instance $1828 r0 *1 121.95,36.23 pfet
M$1828 c7_r \$897 VDD$4 VDD$4 pfet L=0.5U W=1.22U AS=0.5368P AD=0.5368P
+ PS=3.32U PD=3.32U
* device instance $1829 r0 *1 149.37,36.4075 pfet
M$1829 VDD$4 clknet_2_3__leaf_clk \$898 VDD$4 pfet L=0.5U W=0.865U AS=0.3806P
+ AD=0.2249P PS=2.61U PD=1.385U
* device instance $1830 r0 *1 150.39,36.4075 pfet
M$1830 \$900 \$898 VDD$4 VDD$4 pfet L=0.5U W=0.865U AS=0.2249P AD=0.3806P
+ PS=1.385U PD=2.61U
* device instance $1831 r0 *1 152.55,36.385 pfet
M$1831 \$940 \$900 VDD$4 VDD$4 pfet L=0.5U W=0.36U AS=0.4554P AD=0.054P
+ PS=3.25U PD=0.66U
* device instance $1832 r0 *1 153.35,36.385 pfet
M$1832 \$916 \_018_ \$940 VDD$4 pfet L=0.5U W=0.36U AS=0.054P AD=0.1872P
+ PS=0.66U PD=1.4U
* device instance $1833 r0 *1 154.89,36.385 pfet
M$1833 \$939 \$898 \$916 VDD$4 pfet L=0.5U W=0.36U AS=0.1872P AD=0.0432P
+ PS=1.4U PD=0.6U
* device instance $1834 r0 *1 155.63,36.385 pfet
M$1834 VDD$4 \$899 \$939 VDD$4 pfet L=0.5U W=0.36U AS=0.0432P AD=0.1044P
+ PS=0.6U PD=0.94U
* device instance $1835 r0 *1 156.71,36.385 pfet
M$1835 \$899 \$916 VDD$4 VDD$4 pfet L=0.5U W=0.36U AS=0.1044P AD=0.1791P
+ PS=0.94U PD=1.355U
* device instance $1836 r0 *1 158.205,36.385 pfet
M$1836 \$917 \$898 \$899 VDD$4 pfet L=0.5U W=0.36U AS=0.1791P AD=0.1665P
+ PS=1.355U PD=1.285U
* device instance $1837 r0 *1 159.63,36.385 pfet
M$1837 \$934 \$900 \$917 VDD$4 pfet L=0.5U W=0.36U AS=0.1665P AD=0.0504P
+ PS=1.285U PD=0.64U
* device instance $1838 r0 *1 160.41,36.385 pfet
M$1838 \$934 \$901 VDD$4 VDD$4 pfet L=0.5U W=0.36U AS=0.23P AD=0.0504P PS=1.54U
+ PD=0.64U
* device instance $1839 r0 *1 161.65,36.165 pfet
M$1839 \$901 \$917 VDD$4 VDD$4 pfet L=0.5U W=0.8U AS=0.23P AD=0.352P PS=1.54U
+ PD=2.48U
* device instance $1840 r0 *1 163.39,36.23 pfet
M$1840 q7 \$901 VDD$4 VDD$4 pfet L=0.5U W=1.22U AS=0.5368P AD=0.5368P PS=3.32U
+ PD=3.32U
* device instance $1841 r0 *1 179.05,36.4075 pfet
M$1841 VDD$4 clknet_2_3__leaf_clk \$902 VDD$4 pfet L=0.5U W=0.865U AS=0.3806P
+ AD=0.2249P PS=2.61U PD=1.385U
* device instance $1842 r0 *1 180.07,36.4075 pfet
M$1842 \$904 \$902 VDD$4 VDD$4 pfet L=0.5U W=0.865U AS=0.2249P AD=0.3806P
+ PS=1.385U PD=2.61U
* device instance $1843 r0 *1 182.23,36.385 pfet
M$1843 \$928 \$904 VDD$4 VDD$4 pfet L=0.5U W=0.36U AS=0.4554P AD=0.054P
+ PS=3.25U PD=0.66U
* device instance $1844 r0 *1 183.03,36.385 pfet
M$1844 \$918 \_009_[3] \$928 VDD$4 pfet L=0.5U W=0.36U AS=0.054P AD=0.1872P
+ PS=0.66U PD=1.4U
* device instance $1845 r0 *1 184.57,36.385 pfet
M$1845 \$926 \$902 \$918 VDD$4 pfet L=0.5U W=0.36U AS=0.1872P AD=0.0432P
+ PS=1.4U PD=0.6U
* device instance $1846 r0 *1 185.31,36.385 pfet
M$1846 VDD$4 \$903 \$926 VDD$4 pfet L=0.5U W=0.36U AS=0.0432P AD=0.1044P
+ PS=0.6U PD=0.94U
* device instance $1847 r0 *1 186.39,36.385 pfet
M$1847 \$903 \$918 VDD$4 VDD$4 pfet L=0.5U W=0.36U AS=0.1044P AD=0.1791P
+ PS=0.94U PD=1.355U
* device instance $1848 r0 *1 187.885,36.385 pfet
M$1848 \$919 \$902 \$903 VDD$4 pfet L=0.5U W=0.36U AS=0.1791P AD=0.1665P
+ PS=1.355U PD=1.285U
* device instance $1849 r0 *1 189.31,36.385 pfet
M$1849 \$923 \$904 \$919 VDD$4 pfet L=0.5U W=0.36U AS=0.1665P AD=0.0504P
+ PS=1.285U PD=0.64U
* device instance $1850 r0 *1 190.09,36.385 pfet
M$1850 \$923 \$905 VDD$4 VDD$4 pfet L=0.5U W=0.36U AS=0.23P AD=0.0504P PS=1.54U
+ PD=0.64U
* device instance $1851 r0 *1 191.33,36.165 pfet
M$1851 \$905 \$919 VDD$4 VDD$4 pfet L=0.5U W=0.8U AS=0.23P AD=0.352P PS=1.54U
+ PD=2.48U
* device instance $1852 r0 *1 193.07,36.23 pfet
M$1852 ph[3] \$905 VDD$4 VDD$4 pfet L=0.5U W=1.22U AS=0.5368P AD=0.5368P
+ PS=3.32U PD=3.32U
.ENDS sar_ctrl_a
