* extracted by klt extract --deck gf180mcu

* cell ADC_TGATE
* pin gn
* pin gp
* pin vin
* pin vout
* pin vsubs
.SUBCKT ADC_TGATE gn gp vin vout vsubs
* device instance $1 r0 *1 1.24,5 nfet
M$1 vin gn vout vsubs nfet L=0.28U W=10U AS=11P AD=11P PS=22.2U PD=22.2U
* device instance $2 r0 *1 6.22,10 pfet
M$2 vin gp vout \$5 pfet L=0.28U W=20U AS=22P AD=22P PS=42.2U PD=42.2U
.ENDS ADC_TGATE
