* extracted by klt extract --deck gf180mcu

* cell ADC_BLOCK
* pin XCMP_pon
* pin XCMP_pop
* pin cmpclk
* pin dout
* pin doutb
* pin hi_128_n
* pin hi_128_p
* pin hi_16_n
* pin hi_16_p
* pin hi_1_n
* pin hi_1_p
* pin hi_256_n
* pin hi_256_p
* pin hi_2_n
* pin hi_2_p
* pin hi_32_n
* pin hi_32_p
* pin hi_4_n
* pin hi_4_p
* pin hi_64_n
* pin hi_64_p
* pin hi_8_n
* pin hi_8_p
* pin ibias
* pin lo_128_n
* pin lo_128_p
* pin lo_16_n
* pin lo_16_p
* pin lo_1_n
* pin lo_1_p
* pin lo_256_n
* pin lo_256_p
* pin lo_2_n
* pin lo_2_p
* pin lo_32_n
* pin lo_32_p
* pin lo_4_n
* pin lo_4_p
* pin lo_64_n
* pin lo_64_p
* pin lo_8_n
* pin lo_8_p
* pin pinn
* pin pinp
* pin rel_128_n
* pin rel_128_p
* pin rel_16_n
* pin rel_16_p
* pin rel_1_n
* pin rel_1_p
* pin rel_256_n
* pin rel_256_p
* pin rel_2_n
* pin rel_2_p
* pin rel_32_n
* pin rel_32_p
* pin rel_4_n
* pin rel_4_p
* pin rel_64_n
* pin rel_64_p
* pin rel_8_n
* pin rel_8_p
* pin sel_in
* pin topn
* pin topp
* pin tp_gn
* pin vcm
* pin vdd
* pin vref
* pin vss
.SUBCKT ADC_BLOCK XCMP_pon XCMP_pop cmpclk dout doutb hi_128_n hi_128_p hi_16_n
+ hi_16_p hi_1_n hi_1_p hi_256_n hi_256_p hi_2_n hi_2_p hi_32_n hi_32_p hi_4_n
+ hi_4_p hi_64_n hi_64_p hi_8_n hi_8_p ibias lo_128_n lo_128_p lo_16_n lo_16_p
+ lo_1_n lo_1_p lo_256_n lo_256_p lo_2_n lo_2_p lo_32_n lo_32_p lo_4_n lo_4_p
+ lo_64_n lo_64_p lo_8_n lo_8_p pinn pinp rel_128_n rel_128_p rel_16_n rel_16_p
+ rel_1_n rel_1_p rel_256_n rel_256_p rel_2_n rel_2_p rel_32_n rel_32_p rel_4_n
+ rel_4_p rel_64_n rel_64_p rel_8_n rel_8_p sel_in topn topp tp_gn vcm vdd vref
+ vss
* device instance $1 r0 *1 1.275,2 nfet
M$1 \$5 sel_in vss vss nfet L=0.35U W=4U AS=4.4P AD=4.4P PS=10.2U PD=10.2U
* device instance $2 r0 *1 4.225,2 nfet
M$2 \$7 rel_256_p vss vss nfet L=0.35U W=4U AS=4.4P AD=4.4P PS=10.2U PD=10.2U
* device instance $3 r0 *1 7.175,2 nfet
M$3 \$9 hi_256_p vss vss nfet L=0.35U W=4U AS=4.4P AD=4.4P PS=10.2U PD=10.2U
* device instance $4 r0 *1 10.125,2 nfet
M$4 \$11 lo_256_p vss vss nfet L=0.35U W=4U AS=4.4P AD=4.4P PS=10.2U PD=10.2U
* device instance $5 r0 *1 13.04,6.25 nfet
M$5 pinp sel_in \$12 vss nfet L=0.28U W=12.5U AS=13.75P AD=13.75P PS=27.2U
+ PD=27.2U
* device instance $6 r0 *1 15.92,5 nfet
M$6 vcm rel_256_p \$12 vss nfet L=0.28U W=10U AS=11P AD=11P PS=22.2U PD=22.2U
* device instance $7 r0 *1 18.8,5 nfet
M$7 vref hi_256_p \$12 vss nfet L=0.28U W=10U AS=11P AD=11P PS=22.2U PD=22.2U
* device instance $8 r0 *1 21.68,5 nfet
M$8 vss lo_256_p \$12 vss nfet L=0.28U W=10U AS=11P AD=11P PS=22.2U PD=22.2U
* device instance $9 r0 *1 49.715,2 nfet
M$9 \$17 sel_in vss vss nfet L=0.35U W=4U AS=4.4P AD=4.4P PS=10.2U PD=10.2U
* device instance $10 r0 *1 52.665,2 nfet
M$10 \$19 rel_128_p vss vss nfet L=0.35U W=4U AS=4.4P AD=4.4P PS=10.2U PD=10.2U
* device instance $11 r0 *1 55.615,2 nfet
M$11 \$21 hi_128_p vss vss nfet L=0.35U W=4U AS=4.4P AD=4.4P PS=10.2U PD=10.2U
* device instance $12 r0 *1 58.565,2 nfet
M$12 \$23 lo_128_p vss vss nfet L=0.35U W=4U AS=4.4P AD=4.4P PS=10.2U PD=10.2U
* device instance $13 r0 *1 61.48,6.25 nfet
M$13 pinp sel_in \$24 vss nfet L=0.28U W=12.5U AS=13.75P AD=13.75P PS=27.2U
+ PD=27.2U
* device instance $14 r0 *1 64.36,5 nfet
M$14 vcm rel_128_p \$24 vss nfet L=0.28U W=10U AS=11P AD=11P PS=22.2U PD=22.2U
* device instance $15 r0 *1 67.24,5 nfet
M$15 vref hi_128_p \$24 vss nfet L=0.28U W=10U AS=11P AD=11P PS=22.2U PD=22.2U
* device instance $16 r0 *1 70.12,5 nfet
M$16 vss lo_128_p \$24 vss nfet L=0.28U W=10U AS=11P AD=11P PS=22.2U PD=22.2U
* device instance $17 r0 *1 98.155,2 nfet
M$17 \$25 sel_in vss vss nfet L=0.35U W=4U AS=4.4P AD=4.4P PS=10.2U PD=10.2U
* device instance $18 r0 *1 101.105,2 nfet
M$18 \$27 rel_64_p vss vss nfet L=0.35U W=4U AS=4.4P AD=4.4P PS=10.2U PD=10.2U
* device instance $19 r0 *1 104.055,2 nfet
M$19 \$29 hi_64_p vss vss nfet L=0.35U W=4U AS=4.4P AD=4.4P PS=10.2U PD=10.2U
* device instance $20 r0 *1 107.005,2 nfet
M$20 \$31 lo_64_p vss vss nfet L=0.35U W=4U AS=4.4P AD=4.4P PS=10.2U PD=10.2U
* device instance $21 r0 *1 109.92,6.25 nfet
M$21 pinp sel_in \$32 vss nfet L=0.28U W=12.5U AS=13.75P AD=13.75P PS=27.2U
+ PD=27.2U
* device instance $22 r0 *1 112.8,5 nfet
M$22 vcm rel_64_p \$32 vss nfet L=0.28U W=10U AS=11P AD=11P PS=22.2U PD=22.2U
* device instance $23 r0 *1 115.68,5 nfet
M$23 vref hi_64_p \$32 vss nfet L=0.28U W=10U AS=11P AD=11P PS=22.2U PD=22.2U
* device instance $24 r0 *1 118.56,5 nfet
M$24 vss lo_64_p \$32 vss nfet L=0.28U W=10U AS=11P AD=11P PS=22.2U PD=22.2U
* device instance $25 r0 *1 146.595,2 nfet
M$25 \$33 sel_in vss vss nfet L=0.35U W=4U AS=4.4P AD=4.4P PS=10.2U PD=10.2U
* device instance $26 r0 *1 149.545,2 nfet
M$26 \$35 rel_32_p vss vss nfet L=0.35U W=4U AS=4.4P AD=4.4P PS=10.2U PD=10.2U
* device instance $27 r0 *1 152.495,2 nfet
M$27 \$37 hi_32_p vss vss nfet L=0.35U W=4U AS=4.4P AD=4.4P PS=10.2U PD=10.2U
* device instance $28 r0 *1 155.445,2 nfet
M$28 \$39 lo_32_p vss vss nfet L=0.35U W=4U AS=4.4P AD=4.4P PS=10.2U PD=10.2U
* device instance $29 r0 *1 158.36,6.25 nfet
M$29 pinp sel_in \$40 vss nfet L=0.28U W=12.5U AS=13.75P AD=13.75P PS=27.2U
+ PD=27.2U
* device instance $30 r0 *1 161.24,5 nfet
M$30 vcm rel_32_p \$40 vss nfet L=0.28U W=10U AS=11P AD=11P PS=22.2U PD=22.2U
* device instance $31 r0 *1 164.12,5 nfet
M$31 vref hi_32_p \$40 vss nfet L=0.28U W=10U AS=11P AD=11P PS=22.2U PD=22.2U
* device instance $32 r0 *1 167,5 nfet
M$32 vss lo_32_p \$40 vss nfet L=0.28U W=10U AS=11P AD=11P PS=22.2U PD=22.2U
* device instance $33 r0 *1 195.035,2 nfet
M$33 \$41 sel_in vss vss nfet L=0.35U W=4U AS=4.4P AD=4.4P PS=10.2U PD=10.2U
* device instance $34 r0 *1 197.985,2 nfet
M$34 \$43 rel_16_p vss vss nfet L=0.35U W=4U AS=4.4P AD=4.4P PS=10.2U PD=10.2U
* device instance $35 r0 *1 200.935,2 nfet
M$35 \$45 hi_16_p vss vss nfet L=0.35U W=4U AS=4.4P AD=4.4P PS=10.2U PD=10.2U
* device instance $36 r0 *1 203.885,2 nfet
M$36 \$47 lo_16_p vss vss nfet L=0.35U W=4U AS=4.4P AD=4.4P PS=10.2U PD=10.2U
* device instance $37 r0 *1 206.8,6.25 nfet
M$37 pinp sel_in \$48 vss nfet L=0.28U W=12.5U AS=13.75P AD=13.75P PS=27.2U
+ PD=27.2U
* device instance $38 r0 *1 209.68,5 nfet
M$38 vcm rel_16_p \$48 vss nfet L=0.28U W=10U AS=11P AD=11P PS=22.2U PD=22.2U
* device instance $39 r0 *1 212.56,5 nfet
M$39 vref hi_16_p \$48 vss nfet L=0.28U W=10U AS=11P AD=11P PS=22.2U PD=22.2U
* device instance $40 r0 *1 215.44,5 nfet
M$40 vss lo_16_p \$48 vss nfet L=0.28U W=10U AS=11P AD=11P PS=22.2U PD=22.2U
* device instance $41 r0 *1 243.475,2 nfet
M$41 \$49 sel_in vss vss nfet L=0.35U W=4U AS=4.4P AD=4.4P PS=10.2U PD=10.2U
* device instance $42 r0 *1 246.425,2 nfet
M$42 \$51 rel_8_p vss vss nfet L=0.35U W=4U AS=4.4P AD=4.4P PS=10.2U PD=10.2U
* device instance $43 r0 *1 249.375,2 nfet
M$43 \$53 hi_8_p vss vss nfet L=0.35U W=4U AS=4.4P AD=4.4P PS=10.2U PD=10.2U
* device instance $44 r0 *1 252.325,2 nfet
M$44 \$55 lo_8_p vss vss nfet L=0.35U W=4U AS=4.4P AD=4.4P PS=10.2U PD=10.2U
* device instance $45 r0 *1 255.24,6.25 nfet
M$45 pinp sel_in \$56 vss nfet L=0.28U W=12.5U AS=13.75P AD=13.75P PS=27.2U
+ PD=27.2U
* device instance $46 r0 *1 258.12,5 nfet
M$46 vcm rel_8_p \$56 vss nfet L=0.28U W=10U AS=11P AD=11P PS=22.2U PD=22.2U
* device instance $47 r0 *1 261,5 nfet
M$47 vref hi_8_p \$56 vss nfet L=0.28U W=10U AS=11P AD=11P PS=22.2U PD=22.2U
* device instance $48 r0 *1 263.88,5 nfet
M$48 vss lo_8_p \$56 vss nfet L=0.28U W=10U AS=11P AD=11P PS=22.2U PD=22.2U
* device instance $49 r0 *1 291.915,2 nfet
M$49 \$57 sel_in vss vss nfet L=0.35U W=4U AS=4.4P AD=4.4P PS=10.2U PD=10.2U
* device instance $50 r0 *1 294.865,2 nfet
M$50 \$59 rel_4_p vss vss nfet L=0.35U W=4U AS=4.4P AD=4.4P PS=10.2U PD=10.2U
* device instance $51 r0 *1 297.815,2 nfet
M$51 \$61 hi_4_p vss vss nfet L=0.35U W=4U AS=4.4P AD=4.4P PS=10.2U PD=10.2U
* device instance $52 r0 *1 300.765,2 nfet
M$52 \$63 lo_4_p vss vss nfet L=0.35U W=4U AS=4.4P AD=4.4P PS=10.2U PD=10.2U
* device instance $53 r0 *1 303.68,6.25 nfet
M$53 pinp sel_in \$64 vss nfet L=0.28U W=12.5U AS=13.75P AD=13.75P PS=27.2U
+ PD=27.2U
* device instance $54 r0 *1 306.56,5 nfet
M$54 vcm rel_4_p \$64 vss nfet L=0.28U W=10U AS=11P AD=11P PS=22.2U PD=22.2U
* device instance $55 r0 *1 309.44,5 nfet
M$55 vref hi_4_p \$64 vss nfet L=0.28U W=10U AS=11P AD=11P PS=22.2U PD=22.2U
* device instance $56 r0 *1 312.32,5 nfet
M$56 vss lo_4_p \$64 vss nfet L=0.28U W=10U AS=11P AD=11P PS=22.2U PD=22.2U
* device instance $57 r0 *1 340.355,2 nfet
M$57 \$65 sel_in vss vss nfet L=0.35U W=4U AS=4.4P AD=4.4P PS=10.2U PD=10.2U
* device instance $58 r0 *1 343.305,2 nfet
M$58 \$67 rel_2_p vss vss nfet L=0.35U W=4U AS=4.4P AD=4.4P PS=10.2U PD=10.2U
* device instance $59 r0 *1 346.255,2 nfet
M$59 \$69 hi_2_p vss vss nfet L=0.35U W=4U AS=4.4P AD=4.4P PS=10.2U PD=10.2U
* device instance $60 r0 *1 349.205,2 nfet
M$60 \$71 lo_2_p vss vss nfet L=0.35U W=4U AS=4.4P AD=4.4P PS=10.2U PD=10.2U
* device instance $61 r0 *1 352.12,6.25 nfet
M$61 pinp sel_in \$72 vss nfet L=0.28U W=12.5U AS=13.75P AD=13.75P PS=27.2U
+ PD=27.2U
* device instance $62 r0 *1 355,5 nfet
M$62 vcm rel_2_p \$72 vss nfet L=0.28U W=10U AS=11P AD=11P PS=22.2U PD=22.2U
* device instance $63 r0 *1 357.88,5 nfet
M$63 vref hi_2_p \$72 vss nfet L=0.28U W=10U AS=11P AD=11P PS=22.2U PD=22.2U
* device instance $64 r0 *1 360.76,5 nfet
M$64 vss lo_2_p \$72 vss nfet L=0.28U W=10U AS=11P AD=11P PS=22.2U PD=22.2U
* device instance $65 r0 *1 388.795,2 nfet
M$65 \$73 sel_in vss vss nfet L=0.35U W=4U AS=4.4P AD=4.4P PS=10.2U PD=10.2U
* device instance $66 r0 *1 391.745,2 nfet
M$66 \$75 rel_1_p vss vss nfet L=0.35U W=4U AS=4.4P AD=4.4P PS=10.2U PD=10.2U
* device instance $67 r0 *1 394.695,2 nfet
M$67 \$77 hi_1_p vss vss nfet L=0.35U W=4U AS=4.4P AD=4.4P PS=10.2U PD=10.2U
* device instance $68 r0 *1 397.645,2 nfet
M$68 \$79 lo_1_p vss vss nfet L=0.35U W=4U AS=4.4P AD=4.4P PS=10.2U PD=10.2U
* device instance $69 r0 *1 400.56,6.25 nfet
M$69 pinp sel_in \$80 vss nfet L=0.28U W=12.5U AS=13.75P AD=13.75P PS=27.2U
+ PD=27.2U
* device instance $70 r0 *1 403.44,5 nfet
M$70 vcm rel_1_p \$80 vss nfet L=0.28U W=10U AS=11P AD=11P PS=22.2U PD=22.2U
* device instance $71 r0 *1 406.32,5 nfet
M$71 vref hi_1_p \$80 vss nfet L=0.28U W=10U AS=11P AD=11P PS=22.2U PD=22.2U
* device instance $72 r0 *1 409.2,5 nfet
M$72 vss lo_1_p \$80 vss nfet L=0.28U W=10U AS=11P AD=11P PS=22.2U PD=22.2U
* device instance $73 r0 *1 1.275,41 nfet
M$73 \$145 sel_in vss vss nfet L=0.35U W=4U AS=4.4P AD=4.4P PS=10.2U PD=10.2U
* device instance $74 r0 *1 4.225,41 nfet
M$74 \$110 rel_256_n vss vss nfet L=0.35U W=4U AS=4.4P AD=4.4P PS=10.2U PD=10.2U
* device instance $75 r0 *1 7.175,41 nfet
M$75 \$112 hi_256_n vss vss nfet L=0.35U W=4U AS=4.4P AD=4.4P PS=10.2U PD=10.2U
* device instance $76 r0 *1 10.125,41 nfet
M$76 \$92 lo_256_n vss vss nfet L=0.35U W=4U AS=4.4P AD=4.4P PS=10.2U PD=10.2U
* device instance $77 r0 *1 13.04,45.25 nfet
M$77 pinn sel_in \$82 vss nfet L=0.28U W=12.5U AS=13.75P AD=13.75P PS=27.2U
+ PD=27.2U
* device instance $78 r0 *1 15.92,44 nfet
M$78 vcm rel_256_n \$82 vss nfet L=0.28U W=10U AS=11P AD=11P PS=22.2U PD=22.2U
* device instance $79 r0 *1 18.8,44 nfet
M$79 vref hi_256_n \$82 vss nfet L=0.28U W=10U AS=11P AD=11P PS=22.2U PD=22.2U
* device instance $80 r0 *1 21.68,44 nfet
M$80 vss lo_256_n \$82 vss nfet L=0.28U W=10U AS=11P AD=11P PS=22.2U PD=22.2U
* device instance $81 r0 *1 49.715,41 nfet
M$81 \$146 sel_in vss vss nfet L=0.35U W=4U AS=4.4P AD=4.4P PS=10.2U PD=10.2U
* device instance $82 r0 *1 52.665,41 nfet
M$82 \$114 rel_128_n vss vss nfet L=0.35U W=4U AS=4.4P AD=4.4P PS=10.2U PD=10.2U
* device instance $83 r0 *1 55.615,41 nfet
M$83 \$116 hi_128_n vss vss nfet L=0.35U W=4U AS=4.4P AD=4.4P PS=10.2U PD=10.2U
* device instance $84 r0 *1 58.565,41 nfet
M$84 \$94 lo_128_n vss vss nfet L=0.35U W=4U AS=4.4P AD=4.4P PS=10.2U PD=10.2U
* device instance $85 r0 *1 61.48,45.25 nfet
M$85 pinn sel_in \$83 vss nfet L=0.28U W=12.5U AS=13.75P AD=13.75P PS=27.2U
+ PD=27.2U
* device instance $86 r0 *1 64.36,44 nfet
M$86 vcm rel_128_n \$83 vss nfet L=0.28U W=10U AS=11P AD=11P PS=22.2U PD=22.2U
* device instance $87 r0 *1 67.24,44 nfet
M$87 vref hi_128_n \$83 vss nfet L=0.28U W=10U AS=11P AD=11P PS=22.2U PD=22.2U
* device instance $88 r0 *1 70.12,44 nfet
M$88 vss lo_128_n \$83 vss nfet L=0.28U W=10U AS=11P AD=11P PS=22.2U PD=22.2U
* device instance $89 r0 *1 98.155,41 nfet
M$89 \$147 sel_in vss vss nfet L=0.35U W=4U AS=4.4P AD=4.4P PS=10.2U PD=10.2U
* device instance $90 r0 *1 101.105,41 nfet
M$90 \$118 rel_64_n vss vss nfet L=0.35U W=4U AS=4.4P AD=4.4P PS=10.2U PD=10.2U
* device instance $91 r0 *1 104.055,41 nfet
M$91 \$120 hi_64_n vss vss nfet L=0.35U W=4U AS=4.4P AD=4.4P PS=10.2U PD=10.2U
* device instance $92 r0 *1 107.005,41 nfet
M$92 \$96 lo_64_n vss vss nfet L=0.35U W=4U AS=4.4P AD=4.4P PS=10.2U PD=10.2U
* device instance $93 r0 *1 109.92,45.25 nfet
M$93 pinn sel_in \$84 vss nfet L=0.28U W=12.5U AS=13.75P AD=13.75P PS=27.2U
+ PD=27.2U
* device instance $94 r0 *1 112.8,44 nfet
M$94 vcm rel_64_n \$84 vss nfet L=0.28U W=10U AS=11P AD=11P PS=22.2U PD=22.2U
* device instance $95 r0 *1 115.68,44 nfet
M$95 vref hi_64_n \$84 vss nfet L=0.28U W=10U AS=11P AD=11P PS=22.2U PD=22.2U
* device instance $96 r0 *1 118.56,44 nfet
M$96 vss lo_64_n \$84 vss nfet L=0.28U W=10U AS=11P AD=11P PS=22.2U PD=22.2U
* device instance $97 r0 *1 146.595,41 nfet
M$97 \$148 sel_in vss vss nfet L=0.35U W=4U AS=4.4P AD=4.4P PS=10.2U PD=10.2U
* device instance $98 r0 *1 149.545,41 nfet
M$98 \$122 rel_32_n vss vss nfet L=0.35U W=4U AS=4.4P AD=4.4P PS=10.2U PD=10.2U
* device instance $99 r0 *1 152.495,41 nfet
M$99 \$124 hi_32_n vss vss nfet L=0.35U W=4U AS=4.4P AD=4.4P PS=10.2U PD=10.2U
* device instance $100 r0 *1 155.445,41 nfet
M$100 \$98 lo_32_n vss vss nfet L=0.35U W=4U AS=4.4P AD=4.4P PS=10.2U PD=10.2U
* device instance $101 r0 *1 158.36,45.25 nfet
M$101 pinn sel_in \$85 vss nfet L=0.28U W=12.5U AS=13.75P AD=13.75P PS=27.2U
+ PD=27.2U
* device instance $102 r0 *1 161.24,44 nfet
M$102 vcm rel_32_n \$85 vss nfet L=0.28U W=10U AS=11P AD=11P PS=22.2U PD=22.2U
* device instance $103 r0 *1 164.12,44 nfet
M$103 vref hi_32_n \$85 vss nfet L=0.28U W=10U AS=11P AD=11P PS=22.2U PD=22.2U
* device instance $104 r0 *1 167,44 nfet
M$104 vss lo_32_n \$85 vss nfet L=0.28U W=10U AS=11P AD=11P PS=22.2U PD=22.2U
* device instance $105 r0 *1 195.035,41 nfet
M$105 \$149 sel_in vss vss nfet L=0.35U W=4U AS=4.4P AD=4.4P PS=10.2U PD=10.2U
* device instance $106 r0 *1 197.985,41 nfet
M$106 \$126 rel_16_n vss vss nfet L=0.35U W=4U AS=4.4P AD=4.4P PS=10.2U PD=10.2U
* device instance $107 r0 *1 200.935,41 nfet
M$107 \$128 hi_16_n vss vss nfet L=0.35U W=4U AS=4.4P AD=4.4P PS=10.2U PD=10.2U
* device instance $108 r0 *1 203.885,41 nfet
M$108 \$100 lo_16_n vss vss nfet L=0.35U W=4U AS=4.4P AD=4.4P PS=10.2U PD=10.2U
* device instance $109 r0 *1 206.8,45.25 nfet
M$109 pinn sel_in \$86 vss nfet L=0.28U W=12.5U AS=13.75P AD=13.75P PS=27.2U
+ PD=27.2U
* device instance $110 r0 *1 209.68,44 nfet
M$110 vcm rel_16_n \$86 vss nfet L=0.28U W=10U AS=11P AD=11P PS=22.2U PD=22.2U
* device instance $111 r0 *1 212.56,44 nfet
M$111 vref hi_16_n \$86 vss nfet L=0.28U W=10U AS=11P AD=11P PS=22.2U PD=22.2U
* device instance $112 r0 *1 215.44,44 nfet
M$112 vss lo_16_n \$86 vss nfet L=0.28U W=10U AS=11P AD=11P PS=22.2U PD=22.2U
* device instance $113 r0 *1 243.475,41 nfet
M$113 \$150 sel_in vss vss nfet L=0.35U W=4U AS=4.4P AD=4.4P PS=10.2U PD=10.2U
* device instance $114 r0 *1 246.425,41 nfet
M$114 \$130 rel_8_n vss vss nfet L=0.35U W=4U AS=4.4P AD=4.4P PS=10.2U PD=10.2U
* device instance $115 r0 *1 249.375,41 nfet
M$115 \$132 hi_8_n vss vss nfet L=0.35U W=4U AS=4.4P AD=4.4P PS=10.2U PD=10.2U
* device instance $116 r0 *1 252.325,41 nfet
M$116 \$102 lo_8_n vss vss nfet L=0.35U W=4U AS=4.4P AD=4.4P PS=10.2U PD=10.2U
* device instance $117 r0 *1 255.24,45.25 nfet
M$117 pinn sel_in \$87 vss nfet L=0.28U W=12.5U AS=13.75P AD=13.75P PS=27.2U
+ PD=27.2U
* device instance $118 r0 *1 258.12,44 nfet
M$118 vcm rel_8_n \$87 vss nfet L=0.28U W=10U AS=11P AD=11P PS=22.2U PD=22.2U
* device instance $119 r0 *1 261,44 nfet
M$119 vref hi_8_n \$87 vss nfet L=0.28U W=10U AS=11P AD=11P PS=22.2U PD=22.2U
* device instance $120 r0 *1 263.88,44 nfet
M$120 vss lo_8_n \$87 vss nfet L=0.28U W=10U AS=11P AD=11P PS=22.2U PD=22.2U
* device instance $121 r0 *1 291.915,41 nfet
M$121 \$151 sel_in vss vss nfet L=0.35U W=4U AS=4.4P AD=4.4P PS=10.2U PD=10.2U
* device instance $122 r0 *1 294.865,41 nfet
M$122 \$134 rel_4_n vss vss nfet L=0.35U W=4U AS=4.4P AD=4.4P PS=10.2U PD=10.2U
* device instance $123 r0 *1 297.815,41 nfet
M$123 \$136 hi_4_n vss vss nfet L=0.35U W=4U AS=4.4P AD=4.4P PS=10.2U PD=10.2U
* device instance $124 r0 *1 300.765,41 nfet
M$124 \$104 lo_4_n vss vss nfet L=0.35U W=4U AS=4.4P AD=4.4P PS=10.2U PD=10.2U
* device instance $125 r0 *1 303.68,45.25 nfet
M$125 pinn sel_in \$88 vss nfet L=0.28U W=12.5U AS=13.75P AD=13.75P PS=27.2U
+ PD=27.2U
* device instance $126 r0 *1 306.56,44 nfet
M$126 vcm rel_4_n \$88 vss nfet L=0.28U W=10U AS=11P AD=11P PS=22.2U PD=22.2U
* device instance $127 r0 *1 309.44,44 nfet
M$127 vref hi_4_n \$88 vss nfet L=0.28U W=10U AS=11P AD=11P PS=22.2U PD=22.2U
* device instance $128 r0 *1 312.32,44 nfet
M$128 vss lo_4_n \$88 vss nfet L=0.28U W=10U AS=11P AD=11P PS=22.2U PD=22.2U
* device instance $129 r0 *1 340.355,41 nfet
M$129 \$152 sel_in vss vss nfet L=0.35U W=4U AS=4.4P AD=4.4P PS=10.2U PD=10.2U
* device instance $130 r0 *1 343.305,41 nfet
M$130 \$138 rel_2_n vss vss nfet L=0.35U W=4U AS=4.4P AD=4.4P PS=10.2U PD=10.2U
* device instance $131 r0 *1 346.255,41 nfet
M$131 \$140 hi_2_n vss vss nfet L=0.35U W=4U AS=4.4P AD=4.4P PS=10.2U PD=10.2U
* device instance $132 r0 *1 349.205,41 nfet
M$132 \$106 lo_2_n vss vss nfet L=0.35U W=4U AS=4.4P AD=4.4P PS=10.2U PD=10.2U
* device instance $133 r0 *1 352.12,45.25 nfet
M$133 pinn sel_in \$89 vss nfet L=0.28U W=12.5U AS=13.75P AD=13.75P PS=27.2U
+ PD=27.2U
* device instance $134 r0 *1 355,44 nfet
M$134 vcm rel_2_n \$89 vss nfet L=0.28U W=10U AS=11P AD=11P PS=22.2U PD=22.2U
* device instance $135 r0 *1 357.88,44 nfet
M$135 vref hi_2_n \$89 vss nfet L=0.28U W=10U AS=11P AD=11P PS=22.2U PD=22.2U
* device instance $136 r0 *1 360.76,44 nfet
M$136 vss lo_2_n \$89 vss nfet L=0.28U W=10U AS=11P AD=11P PS=22.2U PD=22.2U
* device instance $137 r0 *1 388.795,41 nfet
M$137 \$153 sel_in vss vss nfet L=0.35U W=4U AS=4.4P AD=4.4P PS=10.2U PD=10.2U
* device instance $138 r0 *1 391.745,41 nfet
M$138 \$142 rel_1_n vss vss nfet L=0.35U W=4U AS=4.4P AD=4.4P PS=10.2U PD=10.2U
* device instance $139 r0 *1 394.695,41 nfet
M$139 \$144 hi_1_n vss vss nfet L=0.35U W=4U AS=4.4P AD=4.4P PS=10.2U PD=10.2U
* device instance $140 r0 *1 397.645,41 nfet
M$140 \$108 lo_1_n vss vss nfet L=0.35U W=4U AS=4.4P AD=4.4P PS=10.2U PD=10.2U
* device instance $141 r0 *1 400.56,45.25 nfet
M$141 pinn sel_in \$90 vss nfet L=0.28U W=12.5U AS=13.75P AD=13.75P PS=27.2U
+ PD=27.2U
* device instance $142 r0 *1 403.44,44 nfet
M$142 vcm rel_1_n \$90 vss nfet L=0.28U W=10U AS=11P AD=11P PS=22.2U PD=22.2U
* device instance $143 r0 *1 406.32,44 nfet
M$143 vref hi_1_n \$90 vss nfet L=0.28U W=10U AS=11P AD=11P PS=22.2U PD=22.2U
* device instance $144 r0 *1 409.2,44 nfet
M$144 vss lo_1_n \$90 vss nfet L=0.28U W=10U AS=11P AD=11P PS=22.2U PD=22.2U
* device instance $145 r0 *1 444.075,80 nfet
M$145 \$171 tp_gn vss vss nfet L=0.35U W=4U AS=4.4P AD=4.4P PS=10.2U PD=10.2U
* device instance $146 r0 *1 446.99,83 nfet
M$146 vcm tp_gn topp vss nfet L=0.28U W=10U AS=11P AD=11P PS=22.2U PD=22.2U
* device instance $147 r0 *1 457.535,80 nfet
M$147 \$172 tp_gn vss vss nfet L=0.35U W=4U AS=4.4P AD=4.4P PS=10.2U PD=10.2U
* device instance $148 r0 *1 460.45,83 nfet
M$148 vcm tp_gn topn vss nfet L=0.28U W=10U AS=11P AD=11P PS=22.2U PD=22.2U
* device instance $149 r0 *1 480.8,83.66 nfet
M$149 ibias ibias vss vss nfet L=2U W=20U AS=22P AD=22P PS=42.2U PD=42.2U
* device instance $150 r0 *1 484.9,93.66 nfet
M$150 XCMP_pon topp \$155 vss nfet L=1U W=40U AS=44P AD=44P PS=82.2U PD=82.2U
* device instance $151 r0 *1 488.5,93.66 nfet
M$151 XCMP_pop topn \$155 vss nfet L=1U W=40U AS=44P AD=44P PS=82.2U PD=82.2U
* device instance $152 r0 *1 492.6,83.66 nfet
M$152 \$155 ibias vss vss nfet L=2U W=20U AS=22P AD=22P PS=42.2U PD=42.2U
* device instance $153 r0 *1 497.275,81.66 nfet
M$153 \$158 cmpclk vss vss nfet L=0.35U W=16U AS=17.6P AD=17.6P PS=34.2U
+ PD=34.2U
* device instance $154 r0 *1 500.3,77.66 nfet
M$154 \$159 XCMP_pop \$158 vss nfet L=0.5U W=8U AS=8.8P AD=8.8P PS=18.2U
+ PD=18.2U
* device instance $155 r0 *1 503.4,77.66 nfet
M$155 \$160 XCMP_pon \$158 vss nfet L=0.5U W=8U AS=8.8P AD=8.8P PS=18.2U
+ PD=18.2U
* device instance $156 r0 *1 506.425,76.66 nfet
M$156 \$162 \$161 \$159 vss nfet L=0.35U W=6U AS=6.6P AD=6.6P PS=14.2U PD=14.2U
* device instance $157 r0 *1 509.375,76.66 nfet
M$157 \$161 \$162 \$160 vss nfet L=0.35U W=6U AS=6.6P AD=6.6P PS=14.2U PD=14.2U
* device instance $158 r0 *1 531.825,74.16 nfet
M$158 \$163 \$162 vss vss nfet L=0.35U W=1U AS=1.1P AD=1.1P PS=4.2U PD=4.2U
* device instance $159 r0 *1 539.525,74.16 nfet
M$159 \$164 \$161 vss vss nfet L=0.35U W=1U AS=1.1P AD=1.1P PS=4.2U PD=4.2U
* device instance $160 r0 *1 547.225,75.66 nfet
M$160 dout \$164 vss vss nfet L=0.35U W=4U AS=4.4P AD=4.4P PS=10.2U PD=10.2U
* device instance $161 r0 *1 550.175,75.66 nfet
M$161 dout doutb vss vss nfet L=0.35U W=4U AS=4.4P AD=4.4P PS=10.2U PD=10.2U
* device instance $162 r0 *1 560.825,75.66 nfet
M$162 doutb \$163 vss vss nfet L=0.35U W=4U AS=4.4P AD=4.4P PS=10.2U PD=10.2U
* device instance $163 r0 *1 563.775,75.66 nfet
M$163 doutb dout vss vss nfet L=0.35U W=4U AS=4.4P AD=4.4P PS=10.2U PD=10.2U
* device instance $164 r0 *1 25.495,4 pfet
M$164 \$5 sel_in vdd vdd pfet L=0.35U W=8U AS=8.8P AD=8.8P PS=18.2U PD=18.2U
* device instance $165 r0 *1 28.445,4 pfet
M$165 \$7 rel_256_p vdd vdd pfet L=0.35U W=8U AS=8.8P AD=8.8P PS=18.2U PD=18.2U
* device instance $166 r0 *1 31.395,4 pfet
M$166 \$9 hi_256_p vdd vdd pfet L=0.35U W=8U AS=8.8P AD=8.8P PS=18.2U PD=18.2U
* device instance $167 r0 *1 34.345,4 pfet
M$167 \$11 lo_256_p vdd vdd pfet L=0.35U W=8U AS=8.8P AD=8.8P PS=18.2U PD=18.2U
* device instance $168 r0 *1 37.26,12.5 pfet
M$168 pinp \$5 \$12 vdd pfet L=0.28U W=25U AS=27.5P AD=27.5P PS=52.2U PD=52.2U
* device instance $169 r0 *1 40.14,10 pfet
M$169 vcm \$7 \$12 vdd pfet L=0.28U W=20U AS=22P AD=22P PS=42.2U PD=42.2U
* device instance $170 r0 *1 43.02,10 pfet
M$170 vref \$9 \$12 vdd pfet L=0.28U W=20U AS=22P AD=22P PS=42.2U PD=42.2U
* device instance $171 r0 *1 45.9,10 pfet
M$171 vss \$11 \$12 vdd pfet L=0.28U W=20U AS=22P AD=22P PS=42.2U PD=42.2U
* device instance $172 r0 *1 73.935,4 pfet
M$172 \$17 sel_in vdd vdd pfet L=0.35U W=8U AS=8.8P AD=8.8P PS=18.2U PD=18.2U
* device instance $173 r0 *1 76.885,4 pfet
M$173 \$19 rel_128_p vdd vdd pfet L=0.35U W=8U AS=8.8P AD=8.8P PS=18.2U PD=18.2U
* device instance $174 r0 *1 79.835,4 pfet
M$174 \$21 hi_128_p vdd vdd pfet L=0.35U W=8U AS=8.8P AD=8.8P PS=18.2U PD=18.2U
* device instance $175 r0 *1 82.785,4 pfet
M$175 \$23 lo_128_p vdd vdd pfet L=0.35U W=8U AS=8.8P AD=8.8P PS=18.2U PD=18.2U
* device instance $176 r0 *1 85.7,12.5 pfet
M$176 pinp \$17 \$24 vdd pfet L=0.28U W=25U AS=27.5P AD=27.5P PS=52.2U PD=52.2U
* device instance $177 r0 *1 88.58,10 pfet
M$177 vcm \$19 \$24 vdd pfet L=0.28U W=20U AS=22P AD=22P PS=42.2U PD=42.2U
* device instance $178 r0 *1 91.46,10 pfet
M$178 vref \$21 \$24 vdd pfet L=0.28U W=20U AS=22P AD=22P PS=42.2U PD=42.2U
* device instance $179 r0 *1 94.34,10 pfet
M$179 vss \$23 \$24 vdd pfet L=0.28U W=20U AS=22P AD=22P PS=42.2U PD=42.2U
* device instance $180 r0 *1 122.375,4 pfet
M$180 \$25 sel_in vdd vdd pfet L=0.35U W=8U AS=8.8P AD=8.8P PS=18.2U PD=18.2U
* device instance $181 r0 *1 125.325,4 pfet
M$181 \$27 rel_64_p vdd vdd pfet L=0.35U W=8U AS=8.8P AD=8.8P PS=18.2U PD=18.2U
* device instance $182 r0 *1 128.275,4 pfet
M$182 \$29 hi_64_p vdd vdd pfet L=0.35U W=8U AS=8.8P AD=8.8P PS=18.2U PD=18.2U
* device instance $183 r0 *1 131.225,4 pfet
M$183 \$31 lo_64_p vdd vdd pfet L=0.35U W=8U AS=8.8P AD=8.8P PS=18.2U PD=18.2U
* device instance $184 r0 *1 134.14,12.5 pfet
M$184 pinp \$25 \$32 vdd pfet L=0.28U W=25U AS=27.5P AD=27.5P PS=52.2U PD=52.2U
* device instance $185 r0 *1 137.02,10 pfet
M$185 vcm \$27 \$32 vdd pfet L=0.28U W=20U AS=22P AD=22P PS=42.2U PD=42.2U
* device instance $186 r0 *1 139.9,10 pfet
M$186 vref \$29 \$32 vdd pfet L=0.28U W=20U AS=22P AD=22P PS=42.2U PD=42.2U
* device instance $187 r0 *1 142.78,10 pfet
M$187 vss \$31 \$32 vdd pfet L=0.28U W=20U AS=22P AD=22P PS=42.2U PD=42.2U
* device instance $188 r0 *1 170.815,4 pfet
M$188 \$33 sel_in vdd vdd pfet L=0.35U W=8U AS=8.8P AD=8.8P PS=18.2U PD=18.2U
* device instance $189 r0 *1 173.765,4 pfet
M$189 \$35 rel_32_p vdd vdd pfet L=0.35U W=8U AS=8.8P AD=8.8P PS=18.2U PD=18.2U
* device instance $190 r0 *1 176.715,4 pfet
M$190 \$37 hi_32_p vdd vdd pfet L=0.35U W=8U AS=8.8P AD=8.8P PS=18.2U PD=18.2U
* device instance $191 r0 *1 179.665,4 pfet
M$191 \$39 lo_32_p vdd vdd pfet L=0.35U W=8U AS=8.8P AD=8.8P PS=18.2U PD=18.2U
* device instance $192 r0 *1 182.58,12.5 pfet
M$192 pinp \$33 \$40 vdd pfet L=0.28U W=25U AS=27.5P AD=27.5P PS=52.2U PD=52.2U
* device instance $193 r0 *1 185.46,10 pfet
M$193 vcm \$35 \$40 vdd pfet L=0.28U W=20U AS=22P AD=22P PS=42.2U PD=42.2U
* device instance $194 r0 *1 188.34,10 pfet
M$194 vref \$37 \$40 vdd pfet L=0.28U W=20U AS=22P AD=22P PS=42.2U PD=42.2U
* device instance $195 r0 *1 191.22,10 pfet
M$195 vss \$39 \$40 vdd pfet L=0.28U W=20U AS=22P AD=22P PS=42.2U PD=42.2U
* device instance $196 r0 *1 219.255,4 pfet
M$196 \$41 sel_in vdd vdd pfet L=0.35U W=8U AS=8.8P AD=8.8P PS=18.2U PD=18.2U
* device instance $197 r0 *1 222.205,4 pfet
M$197 \$43 rel_16_p vdd vdd pfet L=0.35U W=8U AS=8.8P AD=8.8P PS=18.2U PD=18.2U
* device instance $198 r0 *1 225.155,4 pfet
M$198 \$45 hi_16_p vdd vdd pfet L=0.35U W=8U AS=8.8P AD=8.8P PS=18.2U PD=18.2U
* device instance $199 r0 *1 228.105,4 pfet
M$199 \$47 lo_16_p vdd vdd pfet L=0.35U W=8U AS=8.8P AD=8.8P PS=18.2U PD=18.2U
* device instance $200 r0 *1 231.02,12.5 pfet
M$200 pinp \$41 \$48 vdd pfet L=0.28U W=25U AS=27.5P AD=27.5P PS=52.2U PD=52.2U
* device instance $201 r0 *1 233.9,10 pfet
M$201 vcm \$43 \$48 vdd pfet L=0.28U W=20U AS=22P AD=22P PS=42.2U PD=42.2U
* device instance $202 r0 *1 236.78,10 pfet
M$202 vref \$45 \$48 vdd pfet L=0.28U W=20U AS=22P AD=22P PS=42.2U PD=42.2U
* device instance $203 r0 *1 239.66,10 pfet
M$203 vss \$47 \$48 vdd pfet L=0.28U W=20U AS=22P AD=22P PS=42.2U PD=42.2U
* device instance $204 r0 *1 267.695,4 pfet
M$204 \$49 sel_in vdd vdd pfet L=0.35U W=8U AS=8.8P AD=8.8P PS=18.2U PD=18.2U
* device instance $205 r0 *1 270.645,4 pfet
M$205 \$51 rel_8_p vdd vdd pfet L=0.35U W=8U AS=8.8P AD=8.8P PS=18.2U PD=18.2U
* device instance $206 r0 *1 273.595,4 pfet
M$206 \$53 hi_8_p vdd vdd pfet L=0.35U W=8U AS=8.8P AD=8.8P PS=18.2U PD=18.2U
* device instance $207 r0 *1 276.545,4 pfet
M$207 \$55 lo_8_p vdd vdd pfet L=0.35U W=8U AS=8.8P AD=8.8P PS=18.2U PD=18.2U
* device instance $208 r0 *1 279.46,12.5 pfet
M$208 pinp \$49 \$56 vdd pfet L=0.28U W=25U AS=27.5P AD=27.5P PS=52.2U PD=52.2U
* device instance $209 r0 *1 282.34,10 pfet
M$209 vcm \$51 \$56 vdd pfet L=0.28U W=20U AS=22P AD=22P PS=42.2U PD=42.2U
* device instance $210 r0 *1 285.22,10 pfet
M$210 vref \$53 \$56 vdd pfet L=0.28U W=20U AS=22P AD=22P PS=42.2U PD=42.2U
* device instance $211 r0 *1 288.1,10 pfet
M$211 vss \$55 \$56 vdd pfet L=0.28U W=20U AS=22P AD=22P PS=42.2U PD=42.2U
* device instance $212 r0 *1 316.135,4 pfet
M$212 \$57 sel_in vdd vdd pfet L=0.35U W=8U AS=8.8P AD=8.8P PS=18.2U PD=18.2U
* device instance $213 r0 *1 319.085,4 pfet
M$213 \$59 rel_4_p vdd vdd pfet L=0.35U W=8U AS=8.8P AD=8.8P PS=18.2U PD=18.2U
* device instance $214 r0 *1 322.035,4 pfet
M$214 \$61 hi_4_p vdd vdd pfet L=0.35U W=8U AS=8.8P AD=8.8P PS=18.2U PD=18.2U
* device instance $215 r0 *1 324.985,4 pfet
M$215 \$63 lo_4_p vdd vdd pfet L=0.35U W=8U AS=8.8P AD=8.8P PS=18.2U PD=18.2U
* device instance $216 r0 *1 327.9,12.5 pfet
M$216 pinp \$57 \$64 vdd pfet L=0.28U W=25U AS=27.5P AD=27.5P PS=52.2U PD=52.2U
* device instance $217 r0 *1 330.78,10 pfet
M$217 vcm \$59 \$64 vdd pfet L=0.28U W=20U AS=22P AD=22P PS=42.2U PD=42.2U
* device instance $218 r0 *1 333.66,10 pfet
M$218 vref \$61 \$64 vdd pfet L=0.28U W=20U AS=22P AD=22P PS=42.2U PD=42.2U
* device instance $219 r0 *1 336.54,10 pfet
M$219 vss \$63 \$64 vdd pfet L=0.28U W=20U AS=22P AD=22P PS=42.2U PD=42.2U
* device instance $220 r0 *1 364.575,4 pfet
M$220 \$65 sel_in vdd vdd pfet L=0.35U W=8U AS=8.8P AD=8.8P PS=18.2U PD=18.2U
* device instance $221 r0 *1 367.525,4 pfet
M$221 \$67 rel_2_p vdd vdd pfet L=0.35U W=8U AS=8.8P AD=8.8P PS=18.2U PD=18.2U
* device instance $222 r0 *1 370.475,4 pfet
M$222 \$69 hi_2_p vdd vdd pfet L=0.35U W=8U AS=8.8P AD=8.8P PS=18.2U PD=18.2U
* device instance $223 r0 *1 373.425,4 pfet
M$223 \$71 lo_2_p vdd vdd pfet L=0.35U W=8U AS=8.8P AD=8.8P PS=18.2U PD=18.2U
* device instance $224 r0 *1 376.34,12.5 pfet
M$224 pinp \$65 \$72 vdd pfet L=0.28U W=25U AS=27.5P AD=27.5P PS=52.2U PD=52.2U
* device instance $225 r0 *1 379.22,10 pfet
M$225 vcm \$67 \$72 vdd pfet L=0.28U W=20U AS=22P AD=22P PS=42.2U PD=42.2U
* device instance $226 r0 *1 382.1,10 pfet
M$226 vref \$69 \$72 vdd pfet L=0.28U W=20U AS=22P AD=22P PS=42.2U PD=42.2U
* device instance $227 r0 *1 384.98,10 pfet
M$227 vss \$71 \$72 vdd pfet L=0.28U W=20U AS=22P AD=22P PS=42.2U PD=42.2U
* device instance $228 r0 *1 413.015,4 pfet
M$228 \$73 sel_in vdd vdd pfet L=0.35U W=8U AS=8.8P AD=8.8P PS=18.2U PD=18.2U
* device instance $229 r0 *1 415.965,4 pfet
M$229 \$75 rel_1_p vdd vdd pfet L=0.35U W=8U AS=8.8P AD=8.8P PS=18.2U PD=18.2U
* device instance $230 r0 *1 418.915,4 pfet
M$230 \$77 hi_1_p vdd vdd pfet L=0.35U W=8U AS=8.8P AD=8.8P PS=18.2U PD=18.2U
* device instance $231 r0 *1 421.865,4 pfet
M$231 \$79 lo_1_p vdd vdd pfet L=0.35U W=8U AS=8.8P AD=8.8P PS=18.2U PD=18.2U
* device instance $232 r0 *1 424.78,12.5 pfet
M$232 pinp \$73 \$80 vdd pfet L=0.28U W=25U AS=27.5P AD=27.5P PS=52.2U PD=52.2U
* device instance $233 r0 *1 427.66,10 pfet
M$233 vcm \$75 \$80 vdd pfet L=0.28U W=20U AS=22P AD=22P PS=42.2U PD=42.2U
* device instance $234 r0 *1 430.54,10 pfet
M$234 vref \$77 \$80 vdd pfet L=0.28U W=20U AS=22P AD=22P PS=42.2U PD=42.2U
* device instance $235 r0 *1 433.42,10 pfet
M$235 vss \$79 \$80 vdd pfet L=0.28U W=20U AS=22P AD=22P PS=42.2U PD=42.2U
* device instance $236 r0 *1 25.495,43 pfet
M$236 \$145 sel_in vdd vdd pfet L=0.35U W=8U AS=8.8P AD=8.8P PS=18.2U PD=18.2U
* device instance $237 r0 *1 28.445,43 pfet
M$237 \$110 rel_256_n vdd vdd pfet L=0.35U W=8U AS=8.8P AD=8.8P PS=18.2U
+ PD=18.2U
* device instance $238 r0 *1 31.395,43 pfet
M$238 \$112 hi_256_n vdd vdd pfet L=0.35U W=8U AS=8.8P AD=8.8P PS=18.2U PD=18.2U
* device instance $239 r0 *1 34.345,43 pfet
M$239 \$92 lo_256_n vdd vdd pfet L=0.35U W=8U AS=8.8P AD=8.8P PS=18.2U PD=18.2U
* device instance $240 r0 *1 37.26,51.5 pfet
M$240 pinn \$145 \$82 vdd pfet L=0.28U W=25U AS=27.5P AD=27.5P PS=52.2U PD=52.2U
* device instance $241 r0 *1 40.14,49 pfet
M$241 vcm \$110 \$82 vdd pfet L=0.28U W=20U AS=22P AD=22P PS=42.2U PD=42.2U
* device instance $242 r0 *1 43.02,49 pfet
M$242 vref \$112 \$82 vdd pfet L=0.28U W=20U AS=22P AD=22P PS=42.2U PD=42.2U
* device instance $243 r0 *1 45.9,49 pfet
M$243 vss \$92 \$82 vdd pfet L=0.28U W=20U AS=22P AD=22P PS=42.2U PD=42.2U
* device instance $244 r0 *1 73.935,43 pfet
M$244 \$146 sel_in vdd vdd pfet L=0.35U W=8U AS=8.8P AD=8.8P PS=18.2U PD=18.2U
* device instance $245 r0 *1 76.885,43 pfet
M$245 \$114 rel_128_n vdd vdd pfet L=0.35U W=8U AS=8.8P AD=8.8P PS=18.2U
+ PD=18.2U
* device instance $246 r0 *1 79.835,43 pfet
M$246 \$116 hi_128_n vdd vdd pfet L=0.35U W=8U AS=8.8P AD=8.8P PS=18.2U PD=18.2U
* device instance $247 r0 *1 82.785,43 pfet
M$247 \$94 lo_128_n vdd vdd pfet L=0.35U W=8U AS=8.8P AD=8.8P PS=18.2U PD=18.2U
* device instance $248 r0 *1 85.7,51.5 pfet
M$248 pinn \$146 \$83 vdd pfet L=0.28U W=25U AS=27.5P AD=27.5P PS=52.2U PD=52.2U
* device instance $249 r0 *1 88.58,49 pfet
M$249 vcm \$114 \$83 vdd pfet L=0.28U W=20U AS=22P AD=22P PS=42.2U PD=42.2U
* device instance $250 r0 *1 91.46,49 pfet
M$250 vref \$116 \$83 vdd pfet L=0.28U W=20U AS=22P AD=22P PS=42.2U PD=42.2U
* device instance $251 r0 *1 94.34,49 pfet
M$251 vss \$94 \$83 vdd pfet L=0.28U W=20U AS=22P AD=22P PS=42.2U PD=42.2U
* device instance $252 r0 *1 122.375,43 pfet
M$252 \$147 sel_in vdd vdd pfet L=0.35U W=8U AS=8.8P AD=8.8P PS=18.2U PD=18.2U
* device instance $253 r0 *1 125.325,43 pfet
M$253 \$118 rel_64_n vdd vdd pfet L=0.35U W=8U AS=8.8P AD=8.8P PS=18.2U PD=18.2U
* device instance $254 r0 *1 128.275,43 pfet
M$254 \$120 hi_64_n vdd vdd pfet L=0.35U W=8U AS=8.8P AD=8.8P PS=18.2U PD=18.2U
* device instance $255 r0 *1 131.225,43 pfet
M$255 \$96 lo_64_n vdd vdd pfet L=0.35U W=8U AS=8.8P AD=8.8P PS=18.2U PD=18.2U
* device instance $256 r0 *1 134.14,51.5 pfet
M$256 pinn \$147 \$84 vdd pfet L=0.28U W=25U AS=27.5P AD=27.5P PS=52.2U PD=52.2U
* device instance $257 r0 *1 137.02,49 pfet
M$257 vcm \$118 \$84 vdd pfet L=0.28U W=20U AS=22P AD=22P PS=42.2U PD=42.2U
* device instance $258 r0 *1 139.9,49 pfet
M$258 vref \$120 \$84 vdd pfet L=0.28U W=20U AS=22P AD=22P PS=42.2U PD=42.2U
* device instance $259 r0 *1 142.78,49 pfet
M$259 vss \$96 \$84 vdd pfet L=0.28U W=20U AS=22P AD=22P PS=42.2U PD=42.2U
* device instance $260 r0 *1 170.815,43 pfet
M$260 \$148 sel_in vdd vdd pfet L=0.35U W=8U AS=8.8P AD=8.8P PS=18.2U PD=18.2U
* device instance $261 r0 *1 173.765,43 pfet
M$261 \$122 rel_32_n vdd vdd pfet L=0.35U W=8U AS=8.8P AD=8.8P PS=18.2U PD=18.2U
* device instance $262 r0 *1 176.715,43 pfet
M$262 \$124 hi_32_n vdd vdd pfet L=0.35U W=8U AS=8.8P AD=8.8P PS=18.2U PD=18.2U
* device instance $263 r0 *1 179.665,43 pfet
M$263 \$98 lo_32_n vdd vdd pfet L=0.35U W=8U AS=8.8P AD=8.8P PS=18.2U PD=18.2U
* device instance $264 r0 *1 182.58,51.5 pfet
M$264 pinn \$148 \$85 vdd pfet L=0.28U W=25U AS=27.5P AD=27.5P PS=52.2U PD=52.2U
* device instance $265 r0 *1 185.46,49 pfet
M$265 vcm \$122 \$85 vdd pfet L=0.28U W=20U AS=22P AD=22P PS=42.2U PD=42.2U
* device instance $266 r0 *1 188.34,49 pfet
M$266 vref \$124 \$85 vdd pfet L=0.28U W=20U AS=22P AD=22P PS=42.2U PD=42.2U
* device instance $267 r0 *1 191.22,49 pfet
M$267 vss \$98 \$85 vdd pfet L=0.28U W=20U AS=22P AD=22P PS=42.2U PD=42.2U
* device instance $268 r0 *1 219.255,43 pfet
M$268 \$149 sel_in vdd vdd pfet L=0.35U W=8U AS=8.8P AD=8.8P PS=18.2U PD=18.2U
* device instance $269 r0 *1 222.205,43 pfet
M$269 \$126 rel_16_n vdd vdd pfet L=0.35U W=8U AS=8.8P AD=8.8P PS=18.2U PD=18.2U
* device instance $270 r0 *1 225.155,43 pfet
M$270 \$128 hi_16_n vdd vdd pfet L=0.35U W=8U AS=8.8P AD=8.8P PS=18.2U PD=18.2U
* device instance $271 r0 *1 228.105,43 pfet
M$271 \$100 lo_16_n vdd vdd pfet L=0.35U W=8U AS=8.8P AD=8.8P PS=18.2U PD=18.2U
* device instance $272 r0 *1 231.02,51.5 pfet
M$272 pinn \$149 \$86 vdd pfet L=0.28U W=25U AS=27.5P AD=27.5P PS=52.2U PD=52.2U
* device instance $273 r0 *1 233.9,49 pfet
M$273 vcm \$126 \$86 vdd pfet L=0.28U W=20U AS=22P AD=22P PS=42.2U PD=42.2U
* device instance $274 r0 *1 236.78,49 pfet
M$274 vref \$128 \$86 vdd pfet L=0.28U W=20U AS=22P AD=22P PS=42.2U PD=42.2U
* device instance $275 r0 *1 239.66,49 pfet
M$275 vss \$100 \$86 vdd pfet L=0.28U W=20U AS=22P AD=22P PS=42.2U PD=42.2U
* device instance $276 r0 *1 267.695,43 pfet
M$276 \$150 sel_in vdd vdd pfet L=0.35U W=8U AS=8.8P AD=8.8P PS=18.2U PD=18.2U
* device instance $277 r0 *1 270.645,43 pfet
M$277 \$130 rel_8_n vdd vdd pfet L=0.35U W=8U AS=8.8P AD=8.8P PS=18.2U PD=18.2U
* device instance $278 r0 *1 273.595,43 pfet
M$278 \$132 hi_8_n vdd vdd pfet L=0.35U W=8U AS=8.8P AD=8.8P PS=18.2U PD=18.2U
* device instance $279 r0 *1 276.545,43 pfet
M$279 \$102 lo_8_n vdd vdd pfet L=0.35U W=8U AS=8.8P AD=8.8P PS=18.2U PD=18.2U
* device instance $280 r0 *1 279.46,51.5 pfet
M$280 pinn \$150 \$87 vdd pfet L=0.28U W=25U AS=27.5P AD=27.5P PS=52.2U PD=52.2U
* device instance $281 r0 *1 282.34,49 pfet
M$281 vcm \$130 \$87 vdd pfet L=0.28U W=20U AS=22P AD=22P PS=42.2U PD=42.2U
* device instance $282 r0 *1 285.22,49 pfet
M$282 vref \$132 \$87 vdd pfet L=0.28U W=20U AS=22P AD=22P PS=42.2U PD=42.2U
* device instance $283 r0 *1 288.1,49 pfet
M$283 vss \$102 \$87 vdd pfet L=0.28U W=20U AS=22P AD=22P PS=42.2U PD=42.2U
* device instance $284 r0 *1 316.135,43 pfet
M$284 \$151 sel_in vdd vdd pfet L=0.35U W=8U AS=8.8P AD=8.8P PS=18.2U PD=18.2U
* device instance $285 r0 *1 319.085,43 pfet
M$285 \$134 rel_4_n vdd vdd pfet L=0.35U W=8U AS=8.8P AD=8.8P PS=18.2U PD=18.2U
* device instance $286 r0 *1 322.035,43 pfet
M$286 \$136 hi_4_n vdd vdd pfet L=0.35U W=8U AS=8.8P AD=8.8P PS=18.2U PD=18.2U
* device instance $287 r0 *1 324.985,43 pfet
M$287 \$104 lo_4_n vdd vdd pfet L=0.35U W=8U AS=8.8P AD=8.8P PS=18.2U PD=18.2U
* device instance $288 r0 *1 327.9,51.5 pfet
M$288 pinn \$151 \$88 vdd pfet L=0.28U W=25U AS=27.5P AD=27.5P PS=52.2U PD=52.2U
* device instance $289 r0 *1 330.78,49 pfet
M$289 vcm \$134 \$88 vdd pfet L=0.28U W=20U AS=22P AD=22P PS=42.2U PD=42.2U
* device instance $290 r0 *1 333.66,49 pfet
M$290 vref \$136 \$88 vdd pfet L=0.28U W=20U AS=22P AD=22P PS=42.2U PD=42.2U
* device instance $291 r0 *1 336.54,49 pfet
M$291 vss \$104 \$88 vdd pfet L=0.28U W=20U AS=22P AD=22P PS=42.2U PD=42.2U
* device instance $292 r0 *1 364.575,43 pfet
M$292 \$152 sel_in vdd vdd pfet L=0.35U W=8U AS=8.8P AD=8.8P PS=18.2U PD=18.2U
* device instance $293 r0 *1 367.525,43 pfet
M$293 \$138 rel_2_n vdd vdd pfet L=0.35U W=8U AS=8.8P AD=8.8P PS=18.2U PD=18.2U
* device instance $294 r0 *1 370.475,43 pfet
M$294 \$140 hi_2_n vdd vdd pfet L=0.35U W=8U AS=8.8P AD=8.8P PS=18.2U PD=18.2U
* device instance $295 r0 *1 373.425,43 pfet
M$295 \$106 lo_2_n vdd vdd pfet L=0.35U W=8U AS=8.8P AD=8.8P PS=18.2U PD=18.2U
* device instance $296 r0 *1 376.34,51.5 pfet
M$296 pinn \$152 \$89 vdd pfet L=0.28U W=25U AS=27.5P AD=27.5P PS=52.2U PD=52.2U
* device instance $297 r0 *1 379.22,49 pfet
M$297 vcm \$138 \$89 vdd pfet L=0.28U W=20U AS=22P AD=22P PS=42.2U PD=42.2U
* device instance $298 r0 *1 382.1,49 pfet
M$298 vref \$140 \$89 vdd pfet L=0.28U W=20U AS=22P AD=22P PS=42.2U PD=42.2U
* device instance $299 r0 *1 384.98,49 pfet
M$299 vss \$106 \$89 vdd pfet L=0.28U W=20U AS=22P AD=22P PS=42.2U PD=42.2U
* device instance $300 r0 *1 413.015,43 pfet
M$300 \$153 sel_in vdd vdd pfet L=0.35U W=8U AS=8.8P AD=8.8P PS=18.2U PD=18.2U
* device instance $301 r0 *1 415.965,43 pfet
M$301 \$142 rel_1_n vdd vdd pfet L=0.35U W=8U AS=8.8P AD=8.8P PS=18.2U PD=18.2U
* device instance $302 r0 *1 418.915,43 pfet
M$302 \$144 hi_1_n vdd vdd pfet L=0.35U W=8U AS=8.8P AD=8.8P PS=18.2U PD=18.2U
* device instance $303 r0 *1 421.865,43 pfet
M$303 \$108 lo_1_n vdd vdd pfet L=0.35U W=8U AS=8.8P AD=8.8P PS=18.2U PD=18.2U
* device instance $304 r0 *1 424.78,51.5 pfet
M$304 pinn \$153 \$90 vdd pfet L=0.28U W=25U AS=27.5P AD=27.5P PS=52.2U PD=52.2U
* device instance $305 r0 *1 427.66,49 pfet
M$305 vcm \$142 \$90 vdd pfet L=0.28U W=20U AS=22P AD=22P PS=42.2U PD=42.2U
* device instance $306 r0 *1 430.54,49 pfet
M$306 vref \$144 \$90 vdd pfet L=0.28U W=20U AS=22P AD=22P PS=42.2U PD=42.2U
* device instance $307 r0 *1 433.42,49 pfet
M$307 vss \$108 \$90 vdd pfet L=0.28U W=20U AS=22P AD=22P PS=42.2U PD=42.2U
* device instance $308 r0 *1 450.805,82 pfet
M$308 \$171 tp_gn vdd vdd pfet L=0.35U W=8U AS=8.8P AD=8.8P PS=18.2U PD=18.2U
* device instance $309 r0 *1 453.72,88 pfet
M$309 vcm \$171 topp vdd pfet L=0.28U W=20U AS=22P AD=22P PS=42.2U PD=42.2U
* device instance $310 r0 *1 464.265,82 pfet
M$310 \$172 tp_gn vdd vdd pfet L=0.35U W=8U AS=8.8P AD=8.8P PS=18.2U PD=18.2U
* device instance $311 r0 *1 467.18,88 pfet
M$311 vcm \$172 topn vdd pfet L=0.28U W=20U AS=22P AD=22P PS=42.2U PD=42.2U
* device instance $312 r0 *1 513.225,77.66 pfet
M$312 \$162 \$161 vdd vdd pfet L=0.35U W=8U AS=8.8P AD=8.8P PS=18.2U PD=18.2U
* device instance $313 r0 *1 516.175,77.66 pfet
M$313 \$161 \$162 vdd vdd pfet L=0.35U W=8U AS=8.8P AD=8.8P PS=18.2U PD=18.2U
* device instance $314 r0 *1 519.125,75.66 pfet
M$314 \$162 cmpclk vdd vdd pfet L=0.35U W=4U AS=4.4P AD=4.4P PS=10.2U PD=10.2U
* device instance $315 r0 *1 522.075,75.66 pfet
M$315 \$161 cmpclk vdd vdd pfet L=0.35U W=4U AS=4.4P AD=4.4P PS=10.2U PD=10.2U
* device instance $316 r0 *1 525.025,74.66 pfet
M$316 \$159 cmpclk vdd vdd pfet L=0.35U W=2U AS=2.2P AD=2.2P PS=6.2U PD=6.2U
* device instance $317 r0 *1 527.975,74.66 pfet
M$317 \$160 cmpclk vdd vdd pfet L=0.35U W=2U AS=2.2P AD=2.2P PS=6.2U PD=6.2U
* device instance $318 r0 *1 535.675,74.66 pfet
M$318 \$163 \$162 vdd vdd pfet L=0.35U W=2U AS=2.2P AD=2.2P PS=6.2U PD=6.2U
* device instance $319 r0 *1 543.375,74.66 pfet
M$319 \$164 \$161 vdd vdd pfet L=0.35U W=2U AS=2.2P AD=2.2P PS=6.2U PD=6.2U
* device instance $320 r0 *1 554.025,77.66 pfet
M$320 \$167 \$164 vdd vdd pfet L=0.35U W=8U AS=8.8P AD=8.8P PS=18.2U PD=18.2U
* device instance $321 r0 *1 556.975,77.66 pfet
M$321 dout doutb \$167 vdd pfet L=0.35U W=8U AS=8.8P AD=8.8P PS=18.2U PD=18.2U
* device instance $322 r0 *1 567.625,77.66 pfet
M$322 \$168 \$163 vdd vdd pfet L=0.35U W=8U AS=8.8P AD=8.8P PS=18.2U PD=18.2U
* device instance $323 r0 *1 570.575,77.66 pfet
M$323 doutb dout \$168 vdd pfet L=0.35U W=8U AS=8.8P AD=8.8P PS=18.2U PD=18.2U
* device instance $324 r0 *1 2.6,80.6 cap_mim_2f0_m4m5_noshield
C$324 \$12 topp 3.56528e-14
* device instance $325 r0 *1 9,80.6 cap_mim_2f0_m4m5_noshield
C$325 \$72 topp 3.56528e-14
* device instance $326 r0 *1 15.4,80.6 cap_mim_2f0_m4m5_noshield
C$326 \$12 topp 3.56528e-14
* device instance $327 r0 *1 21.8,80.6 cap_mim_2f0_m4m5_noshield
C$327 \$64 topp 3.56528e-14
* device instance $328 r0 *1 28.2,80.6 cap_mim_2f0_m4m5_noshield
C$328 \$12 topp 3.56528e-14
* device instance $329 r0 *1 34.6,80.6 cap_mim_2f0_m4m5_noshield
C$329 \$56 topp 3.56528e-14
* device instance $330 r0 *1 41,80.6 cap_mim_2f0_m4m5_noshield
C$330 \$12 topp 3.56528e-14
* device instance $331 r0 *1 47.4,80.6 cap_mim_2f0_m4m5_noshield
C$331 \$56 topp 3.56528e-14
* device instance $332 r0 *1 53.8,80.6 cap_mim_2f0_m4m5_noshield
C$332 \$12 topp 3.56528e-14
* device instance $333 r0 *1 60.2,80.6 cap_mim_2f0_m4m5_noshield
C$333 \$48 topp 3.56528e-14
* device instance $334 r0 *1 66.6,80.6 cap_mim_2f0_m4m5_noshield
C$334 \$12 topp 3.56528e-14
* device instance $335 r0 *1 73,80.6 cap_mim_2f0_m4m5_noshield
C$335 \$48 topp 3.56528e-14
* device instance $336 r0 *1 79.4,80.6 cap_mim_2f0_m4m5_noshield
C$336 \$12 topp 3.56528e-14
* device instance $337 r0 *1 85.8,80.6 cap_mim_2f0_m4m5_noshield
C$337 \$48 topp 3.56528e-14
* device instance $338 r0 *1 92.2,80.6 cap_mim_2f0_m4m5_noshield
C$338 \$12 topp 3.56528e-14
* device instance $339 r0 *1 98.6,80.6 cap_mim_2f0_m4m5_noshield
C$339 \$48 topp 3.56528e-14
* device instance $340 r0 *1 105,80.6 cap_mim_2f0_m4m5_noshield
C$340 \$12 topp 3.56528e-14
* device instance $341 r0 *1 111.4,80.6 cap_mim_2f0_m4m5_noshield
C$341 \$40 topp 3.56528e-14
* device instance $342 r0 *1 117.8,80.6 cap_mim_2f0_m4m5_noshield
C$342 \$12 topp 3.56528e-14
* device instance $343 r0 *1 124.2,80.6 cap_mim_2f0_m4m5_noshield
C$343 \$40 topp 3.56528e-14
* device instance $344 r0 *1 130.6,80.6 cap_mim_2f0_m4m5_noshield
C$344 \$12 topp 3.56528e-14
* device instance $345 r0 *1 137,80.6 cap_mim_2f0_m4m5_noshield
C$345 \$40 topp 3.56528e-14
* device instance $346 r0 *1 143.4,80.6 cap_mim_2f0_m4m5_noshield
C$346 \$12 topp 3.56528e-14
* device instance $347 r0 *1 149.8,80.6 cap_mim_2f0_m4m5_noshield
C$347 \$40 topp 3.56528e-14
* device instance $348 r0 *1 156.2,80.6 cap_mim_2f0_m4m5_noshield
C$348 \$12 topp 3.56528e-14
* device instance $349 r0 *1 162.6,80.6 cap_mim_2f0_m4m5_noshield
C$349 \$40 topp 3.56528e-14
* device instance $350 r0 *1 169,80.6 cap_mim_2f0_m4m5_noshield
C$350 \$12 topp 3.56528e-14
* device instance $351 r0 *1 175.4,80.6 cap_mim_2f0_m4m5_noshield
C$351 \$40 topp 3.56528e-14
* device instance $352 r0 *1 181.8,80.6 cap_mim_2f0_m4m5_noshield
C$352 \$12 topp 3.56528e-14
* device instance $353 r0 *1 188.2,80.6 cap_mim_2f0_m4m5_noshield
C$353 \$40 topp 3.56528e-14
* device instance $354 r0 *1 194.6,80.6 cap_mim_2f0_m4m5_noshield
C$354 \$12 topp 3.56528e-14
* device instance $355 r0 *1 201,80.6 cap_mim_2f0_m4m5_noshield
C$355 \$40 topp 3.56528e-14
* device instance $356 r0 *1 224,80.6 cap_mim_2f0_m4m5_noshield
C$356 \$82 topn 3.56528e-14
* device instance $357 r0 *1 230.4,80.6 cap_mim_2f0_m4m5_noshield
C$357 \$89 topn 3.56528e-14
* device instance $358 r0 *1 236.8,80.6 cap_mim_2f0_m4m5_noshield
C$358 \$82 topn 3.56528e-14
* device instance $359 r0 *1 243.2,80.6 cap_mim_2f0_m4m5_noshield
C$359 \$88 topn 3.56528e-14
* device instance $360 r0 *1 249.6,80.6 cap_mim_2f0_m4m5_noshield
C$360 \$82 topn 3.56528e-14
* device instance $361 r0 *1 256,80.6 cap_mim_2f0_m4m5_noshield
C$361 \$87 topn 3.56528e-14
* device instance $362 r0 *1 262.4,80.6 cap_mim_2f0_m4m5_noshield
C$362 \$82 topn 3.56528e-14
* device instance $363 r0 *1 268.8,80.6 cap_mim_2f0_m4m5_noshield
C$363 \$87 topn 3.56528e-14
* device instance $364 r0 *1 275.2,80.6 cap_mim_2f0_m4m5_noshield
C$364 \$82 topn 3.56528e-14
* device instance $365 r0 *1 281.6,80.6 cap_mim_2f0_m4m5_noshield
C$365 \$86 topn 3.56528e-14
* device instance $366 r0 *1 288,80.6 cap_mim_2f0_m4m5_noshield
C$366 \$82 topn 3.56528e-14
* device instance $367 r0 *1 294.4,80.6 cap_mim_2f0_m4m5_noshield
C$367 \$86 topn 3.56528e-14
* device instance $368 r0 *1 300.8,80.6 cap_mim_2f0_m4m5_noshield
C$368 \$82 topn 3.56528e-14
* device instance $369 r0 *1 307.2,80.6 cap_mim_2f0_m4m5_noshield
C$369 \$86 topn 3.56528e-14
* device instance $370 r0 *1 313.6,80.6 cap_mim_2f0_m4m5_noshield
C$370 \$82 topn 3.56528e-14
* device instance $371 r0 *1 320,80.6 cap_mim_2f0_m4m5_noshield
C$371 \$86 topn 3.56528e-14
* device instance $372 r0 *1 326.4,80.6 cap_mim_2f0_m4m5_noshield
C$372 \$82 topn 3.56528e-14
* device instance $373 r0 *1 332.8,80.6 cap_mim_2f0_m4m5_noshield
C$373 \$85 topn 3.56528e-14
* device instance $374 r0 *1 339.2,80.6 cap_mim_2f0_m4m5_noshield
C$374 \$82 topn 3.56528e-14
* device instance $375 r0 *1 345.6,80.6 cap_mim_2f0_m4m5_noshield
C$375 \$85 topn 3.56528e-14
* device instance $376 r0 *1 352,80.6 cap_mim_2f0_m4m5_noshield
C$376 \$82 topn 3.56528e-14
* device instance $377 r0 *1 358.4,80.6 cap_mim_2f0_m4m5_noshield
C$377 \$85 topn 3.56528e-14
* device instance $378 r0 *1 364.8,80.6 cap_mim_2f0_m4m5_noshield
C$378 \$82 topn 3.56528e-14
* device instance $379 r0 *1 371.2,80.6 cap_mim_2f0_m4m5_noshield
C$379 \$85 topn 3.56528e-14
* device instance $380 r0 *1 377.6,80.6 cap_mim_2f0_m4m5_noshield
C$380 \$82 topn 3.56528e-14
* device instance $381 r0 *1 384,80.6 cap_mim_2f0_m4m5_noshield
C$381 \$85 topn 3.56528e-14
* device instance $382 r0 *1 390.4,80.6 cap_mim_2f0_m4m5_noshield
C$382 \$82 topn 3.56528e-14
* device instance $383 r0 *1 396.8,80.6 cap_mim_2f0_m4m5_noshield
C$383 \$85 topn 3.56528e-14
* device instance $384 r0 *1 403.2,80.6 cap_mim_2f0_m4m5_noshield
C$384 \$82 topn 3.56528e-14
* device instance $385 r0 *1 409.6,80.6 cap_mim_2f0_m4m5_noshield
C$385 \$85 topn 3.56528e-14
* device instance $386 r0 *1 416,80.6 cap_mim_2f0_m4m5_noshield
C$386 \$82 topn 3.56528e-14
* device instance $387 r0 *1 422.4,80.6 cap_mim_2f0_m4m5_noshield
C$387 \$85 topn 3.56528e-14
* device instance $388 r0 *1 2.6,87 cap_mim_2f0_m4m5_noshield
C$388 \$12 topp 3.56528e-14
* device instance $389 r0 *1 9,87 cap_mim_2f0_m4m5_noshield
C$389 \$32 topp 3.56528e-14
* device instance $390 r0 *1 15.4,87 cap_mim_2f0_m4m5_noshield
C$390 \$12 topp 3.56528e-14
* device instance $391 r0 *1 21.8,87 cap_mim_2f0_m4m5_noshield
C$391 \$32 topp 3.56528e-14
* device instance $392 r0 *1 28.2,87 cap_mim_2f0_m4m5_noshield
C$392 \$12 topp 3.56528e-14
* device instance $393 r0 *1 34.6,87 cap_mim_2f0_m4m5_noshield
C$393 \$32 topp 3.56528e-14
* device instance $394 r0 *1 41,87 cap_mim_2f0_m4m5_noshield
C$394 \$12 topp 3.56528e-14
* device instance $395 r0 *1 47.4,87 cap_mim_2f0_m4m5_noshield
C$395 \$32 topp 3.56528e-14
* device instance $396 r0 *1 53.8,87 cap_mim_2f0_m4m5_noshield
C$396 \$12 topp 3.56528e-14
* device instance $397 r0 *1 60.2,87 cap_mim_2f0_m4m5_noshield
C$397 \$32 topp 3.56528e-14
* device instance $398 r0 *1 66.6,87 cap_mim_2f0_m4m5_noshield
C$398 \$12 topp 3.56528e-14
* device instance $399 r0 *1 73,87 cap_mim_2f0_m4m5_noshield
C$399 \$32 topp 3.56528e-14
* device instance $400 r0 *1 79.4,87 cap_mim_2f0_m4m5_noshield
C$400 \$12 topp 3.56528e-14
* device instance $401 r0 *1 85.8,87 cap_mim_2f0_m4m5_noshield
C$401 \$32 topp 3.56528e-14
* device instance $402 r0 *1 92.2,87 cap_mim_2f0_m4m5_noshield
C$402 \$12 topp 3.56528e-14
* device instance $403 r0 *1 98.6,87 cap_mim_2f0_m4m5_noshield
C$403 \$32 topp 3.56528e-14
* device instance $404 r0 *1 105,87 cap_mim_2f0_m4m5_noshield
C$404 \$12 topp 3.56528e-14
* device instance $405 r0 *1 111.4,87 cap_mim_2f0_m4m5_noshield
C$405 \$32 topp 3.56528e-14
* device instance $406 r0 *1 117.8,87 cap_mim_2f0_m4m5_noshield
C$406 \$12 topp 3.56528e-14
* device instance $407 r0 *1 124.2,87 cap_mim_2f0_m4m5_noshield
C$407 \$32 topp 3.56528e-14
* device instance $408 r0 *1 130.6,87 cap_mim_2f0_m4m5_noshield
C$408 \$12 topp 3.56528e-14
* device instance $409 r0 *1 137,87 cap_mim_2f0_m4m5_noshield
C$409 \$32 topp 3.56528e-14
* device instance $410 r0 *1 143.4,87 cap_mim_2f0_m4m5_noshield
C$410 \$12 topp 3.56528e-14
* device instance $411 r0 *1 149.8,87 cap_mim_2f0_m4m5_noshield
C$411 \$32 topp 3.56528e-14
* device instance $412 r0 *1 156.2,87 cap_mim_2f0_m4m5_noshield
C$412 \$12 topp 3.56528e-14
* device instance $413 r0 *1 162.6,87 cap_mim_2f0_m4m5_noshield
C$413 \$32 topp 3.56528e-14
* device instance $414 r0 *1 169,87 cap_mim_2f0_m4m5_noshield
C$414 \$12 topp 3.56528e-14
* device instance $415 r0 *1 175.4,87 cap_mim_2f0_m4m5_noshield
C$415 \$32 topp 3.56528e-14
* device instance $416 r0 *1 181.8,87 cap_mim_2f0_m4m5_noshield
C$416 \$12 topp 3.56528e-14
* device instance $417 r0 *1 188.2,87 cap_mim_2f0_m4m5_noshield
C$417 \$32 topp 3.56528e-14
* device instance $418 r0 *1 194.6,87 cap_mim_2f0_m4m5_noshield
C$418 \$12 topp 3.56528e-14
* device instance $419 r0 *1 201,87 cap_mim_2f0_m4m5_noshield
C$419 \$32 topp 3.56528e-14
* device instance $420 r0 *1 224,87 cap_mim_2f0_m4m5_noshield
C$420 \$82 topn 3.56528e-14
* device instance $421 r0 *1 230.4,87 cap_mim_2f0_m4m5_noshield
C$421 \$84 topn 3.56528e-14
* device instance $422 r0 *1 236.8,87 cap_mim_2f0_m4m5_noshield
C$422 \$82 topn 3.56528e-14
* device instance $423 r0 *1 243.2,87 cap_mim_2f0_m4m5_noshield
C$423 \$84 topn 3.56528e-14
* device instance $424 r0 *1 249.6,87 cap_mim_2f0_m4m5_noshield
C$424 \$82 topn 3.56528e-14
* device instance $425 r0 *1 256,87 cap_mim_2f0_m4m5_noshield
C$425 \$84 topn 3.56528e-14
* device instance $426 r0 *1 262.4,87 cap_mim_2f0_m4m5_noshield
C$426 \$82 topn 3.56528e-14
* device instance $427 r0 *1 268.8,87 cap_mim_2f0_m4m5_noshield
C$427 \$84 topn 3.56528e-14
* device instance $428 r0 *1 275.2,87 cap_mim_2f0_m4m5_noshield
C$428 \$82 topn 3.56528e-14
* device instance $429 r0 *1 281.6,87 cap_mim_2f0_m4m5_noshield
C$429 \$84 topn 3.56528e-14
* device instance $430 r0 *1 288,87 cap_mim_2f0_m4m5_noshield
C$430 \$82 topn 3.56528e-14
* device instance $431 r0 *1 294.4,87 cap_mim_2f0_m4m5_noshield
C$431 \$84 topn 3.56528e-14
* device instance $432 r0 *1 300.8,87 cap_mim_2f0_m4m5_noshield
C$432 \$82 topn 3.56528e-14
* device instance $433 r0 *1 307.2,87 cap_mim_2f0_m4m5_noshield
C$433 \$84 topn 3.56528e-14
* device instance $434 r0 *1 313.6,87 cap_mim_2f0_m4m5_noshield
C$434 \$82 topn 3.56528e-14
* device instance $435 r0 *1 320,87 cap_mim_2f0_m4m5_noshield
C$435 \$84 topn 3.56528e-14
* device instance $436 r0 *1 326.4,87 cap_mim_2f0_m4m5_noshield
C$436 \$82 topn 3.56528e-14
* device instance $437 r0 *1 332.8,87 cap_mim_2f0_m4m5_noshield
C$437 \$84 topn 3.56528e-14
* device instance $438 r0 *1 339.2,87 cap_mim_2f0_m4m5_noshield
C$438 \$82 topn 3.56528e-14
* device instance $439 r0 *1 345.6,87 cap_mim_2f0_m4m5_noshield
C$439 \$84 topn 3.56528e-14
* device instance $440 r0 *1 352,87 cap_mim_2f0_m4m5_noshield
C$440 \$82 topn 3.56528e-14
* device instance $441 r0 *1 358.4,87 cap_mim_2f0_m4m5_noshield
C$441 \$84 topn 3.56528e-14
* device instance $442 r0 *1 364.8,87 cap_mim_2f0_m4m5_noshield
C$442 \$82 topn 3.56528e-14
* device instance $443 r0 *1 371.2,87 cap_mim_2f0_m4m5_noshield
C$443 \$84 topn 3.56528e-14
* device instance $444 r0 *1 377.6,87 cap_mim_2f0_m4m5_noshield
C$444 \$82 topn 3.56528e-14
* device instance $445 r0 *1 384,87 cap_mim_2f0_m4m5_noshield
C$445 \$84 topn 3.56528e-14
* device instance $446 r0 *1 390.4,87 cap_mim_2f0_m4m5_noshield
C$446 \$82 topn 3.56528e-14
* device instance $447 r0 *1 396.8,87 cap_mim_2f0_m4m5_noshield
C$447 \$84 topn 3.56528e-14
* device instance $448 r0 *1 403.2,87 cap_mim_2f0_m4m5_noshield
C$448 \$82 topn 3.56528e-14
* device instance $449 r0 *1 409.6,87 cap_mim_2f0_m4m5_noshield
C$449 \$84 topn 3.56528e-14
* device instance $450 r0 *1 416,87 cap_mim_2f0_m4m5_noshield
C$450 \$82 topn 3.56528e-14
* device instance $451 r0 *1 422.4,87 cap_mim_2f0_m4m5_noshield
C$451 \$84 topn 3.56528e-14
* device instance $452 r0 *1 2.6,93.4 cap_mim_2f0_m4m5_noshield
C$452 \$12 topp 3.56528e-14
* device instance $453 r0 *1 9,93.4 cap_mim_2f0_m4m5_noshield
C$453 \$24 topp 3.56528e-14
* device instance $454 r0 *1 15.4,93.4 cap_mim_2f0_m4m5_noshield
C$454 \$12 topp 3.56528e-14
* device instance $455 r0 *1 21.8,93.4 cap_mim_2f0_m4m5_noshield
C$455 \$24 topp 3.56528e-14
* device instance $456 r0 *1 28.2,93.4 cap_mim_2f0_m4m5_noshield
C$456 \$12 topp 3.56528e-14
* device instance $457 r0 *1 34.6,93.4 cap_mim_2f0_m4m5_noshield
C$457 \$24 topp 3.56528e-14
* device instance $458 r0 *1 41,93.4 cap_mim_2f0_m4m5_noshield
C$458 \$12 topp 3.56528e-14
* device instance $459 r0 *1 47.4,93.4 cap_mim_2f0_m4m5_noshield
C$459 \$24 topp 3.56528e-14
* device instance $460 r0 *1 53.8,93.4 cap_mim_2f0_m4m5_noshield
C$460 \$12 topp 3.56528e-14
* device instance $461 r0 *1 60.2,93.4 cap_mim_2f0_m4m5_noshield
C$461 \$24 topp 3.56528e-14
* device instance $462 r0 *1 66.6,93.4 cap_mim_2f0_m4m5_noshield
C$462 \$12 topp 3.56528e-14
* device instance $463 r0 *1 73,93.4 cap_mim_2f0_m4m5_noshield
C$463 \$24 topp 3.56528e-14
* device instance $464 r0 *1 79.4,93.4 cap_mim_2f0_m4m5_noshield
C$464 \$12 topp 3.56528e-14
* device instance $465 r0 *1 85.8,93.4 cap_mim_2f0_m4m5_noshield
C$465 \$24 topp 3.56528e-14
* device instance $466 r0 *1 92.2,93.4 cap_mim_2f0_m4m5_noshield
C$466 \$12 topp 3.56528e-14
* device instance $467 r0 *1 98.6,93.4 cap_mim_2f0_m4m5_noshield
C$467 \$24 topp 3.56528e-14
* device instance $468 r0 *1 105,93.4 cap_mim_2f0_m4m5_noshield
C$468 \$12 topp 3.56528e-14
* device instance $469 r0 *1 111.4,93.4 cap_mim_2f0_m4m5_noshield
C$469 \$24 topp 3.56528e-14
* device instance $470 r0 *1 117.8,93.4 cap_mim_2f0_m4m5_noshield
C$470 \$12 topp 3.56528e-14
* device instance $471 r0 *1 124.2,93.4 cap_mim_2f0_m4m5_noshield
C$471 \$24 topp 3.56528e-14
* device instance $472 r0 *1 130.6,93.4 cap_mim_2f0_m4m5_noshield
C$472 \$12 topp 3.56528e-14
* device instance $473 r0 *1 137,93.4 cap_mim_2f0_m4m5_noshield
C$473 \$24 topp 3.56528e-14
* device instance $474 r0 *1 143.4,93.4 cap_mim_2f0_m4m5_noshield
C$474 \$12 topp 3.56528e-14
* device instance $475 r0 *1 149.8,93.4 cap_mim_2f0_m4m5_noshield
C$475 \$24 topp 3.56528e-14
* device instance $476 r0 *1 156.2,93.4 cap_mim_2f0_m4m5_noshield
C$476 \$12 topp 3.56528e-14
* device instance $477 r0 *1 162.6,93.4 cap_mim_2f0_m4m5_noshield
C$477 \$24 topp 3.56528e-14
* device instance $478 r0 *1 169,93.4 cap_mim_2f0_m4m5_noshield
C$478 \$12 topp 3.56528e-14
* device instance $479 r0 *1 175.4,93.4 cap_mim_2f0_m4m5_noshield
C$479 \$24 topp 3.56528e-14
* device instance $480 r0 *1 181.8,93.4 cap_mim_2f0_m4m5_noshield
C$480 \$12 topp 3.56528e-14
* device instance $481 r0 *1 188.2,93.4 cap_mim_2f0_m4m5_noshield
C$481 \$24 topp 3.56528e-14
* device instance $482 r0 *1 194.6,93.4 cap_mim_2f0_m4m5_noshield
C$482 \$12 topp 3.56528e-14
* device instance $483 r0 *1 201,93.4 cap_mim_2f0_m4m5_noshield
C$483 \$24 topp 3.56528e-14
* device instance $484 r0 *1 224,93.4 cap_mim_2f0_m4m5_noshield
C$484 \$82 topn 3.56528e-14
* device instance $485 r0 *1 230.4,93.4 cap_mim_2f0_m4m5_noshield
C$485 \$83 topn 3.56528e-14
* device instance $486 r0 *1 236.8,93.4 cap_mim_2f0_m4m5_noshield
C$486 \$82 topn 3.56528e-14
* device instance $487 r0 *1 243.2,93.4 cap_mim_2f0_m4m5_noshield
C$487 \$83 topn 3.56528e-14
* device instance $488 r0 *1 249.6,93.4 cap_mim_2f0_m4m5_noshield
C$488 \$82 topn 3.56528e-14
* device instance $489 r0 *1 256,93.4 cap_mim_2f0_m4m5_noshield
C$489 \$83 topn 3.56528e-14
* device instance $490 r0 *1 262.4,93.4 cap_mim_2f0_m4m5_noshield
C$490 \$82 topn 3.56528e-14
* device instance $491 r0 *1 268.8,93.4 cap_mim_2f0_m4m5_noshield
C$491 \$83 topn 3.56528e-14
* device instance $492 r0 *1 275.2,93.4 cap_mim_2f0_m4m5_noshield
C$492 \$82 topn 3.56528e-14
* device instance $493 r0 *1 281.6,93.4 cap_mim_2f0_m4m5_noshield
C$493 \$83 topn 3.56528e-14
* device instance $494 r0 *1 288,93.4 cap_mim_2f0_m4m5_noshield
C$494 \$82 topn 3.56528e-14
* device instance $495 r0 *1 294.4,93.4 cap_mim_2f0_m4m5_noshield
C$495 \$83 topn 3.56528e-14
* device instance $496 r0 *1 300.8,93.4 cap_mim_2f0_m4m5_noshield
C$496 \$82 topn 3.56528e-14
* device instance $497 r0 *1 307.2,93.4 cap_mim_2f0_m4m5_noshield
C$497 \$83 topn 3.56528e-14
* device instance $498 r0 *1 313.6,93.4 cap_mim_2f0_m4m5_noshield
C$498 \$82 topn 3.56528e-14
* device instance $499 r0 *1 320,93.4 cap_mim_2f0_m4m5_noshield
C$499 \$83 topn 3.56528e-14
* device instance $500 r0 *1 326.4,93.4 cap_mim_2f0_m4m5_noshield
C$500 \$82 topn 3.56528e-14
* device instance $501 r0 *1 332.8,93.4 cap_mim_2f0_m4m5_noshield
C$501 \$83 topn 3.56528e-14
* device instance $502 r0 *1 339.2,93.4 cap_mim_2f0_m4m5_noshield
C$502 \$82 topn 3.56528e-14
* device instance $503 r0 *1 345.6,93.4 cap_mim_2f0_m4m5_noshield
C$503 \$83 topn 3.56528e-14
* device instance $504 r0 *1 352,93.4 cap_mim_2f0_m4m5_noshield
C$504 \$82 topn 3.56528e-14
* device instance $505 r0 *1 358.4,93.4 cap_mim_2f0_m4m5_noshield
C$505 \$83 topn 3.56528e-14
* device instance $506 r0 *1 364.8,93.4 cap_mim_2f0_m4m5_noshield
C$506 \$82 topn 3.56528e-14
* device instance $507 r0 *1 371.2,93.4 cap_mim_2f0_m4m5_noshield
C$507 \$83 topn 3.56528e-14
* device instance $508 r0 *1 377.6,93.4 cap_mim_2f0_m4m5_noshield
C$508 \$82 topn 3.56528e-14
* device instance $509 r0 *1 384,93.4 cap_mim_2f0_m4m5_noshield
C$509 \$83 topn 3.56528e-14
* device instance $510 r0 *1 390.4,93.4 cap_mim_2f0_m4m5_noshield
C$510 \$82 topn 3.56528e-14
* device instance $511 r0 *1 396.8,93.4 cap_mim_2f0_m4m5_noshield
C$511 \$83 topn 3.56528e-14
* device instance $512 r0 *1 403.2,93.4 cap_mim_2f0_m4m5_noshield
C$512 \$82 topn 3.56528e-14
* device instance $513 r0 *1 409.6,93.4 cap_mim_2f0_m4m5_noshield
C$513 \$83 topn 3.56528e-14
* device instance $514 r0 *1 416,93.4 cap_mim_2f0_m4m5_noshield
C$514 \$82 topn 3.56528e-14
* device instance $515 r0 *1 422.4,93.4 cap_mim_2f0_m4m5_noshield
C$515 \$83 topn 3.56528e-14
* device instance $516 r0 *1 2.6,99.8 cap_mim_2f0_m4m5_noshield
C$516 \$12 topp 3.56528e-14
* device instance $517 r0 *1 9,99.8 cap_mim_2f0_m4m5_noshield
C$517 \$24 topp 3.56528e-14
* device instance $518 r0 *1 15.4,99.8 cap_mim_2f0_m4m5_noshield
C$518 \$12 topp 3.56528e-14
* device instance $519 r0 *1 21.8,99.8 cap_mim_2f0_m4m5_noshield
C$519 \$24 topp 3.56528e-14
* device instance $520 r0 *1 28.2,99.8 cap_mim_2f0_m4m5_noshield
C$520 \$12 topp 3.56528e-14
* device instance $521 r0 *1 34.6,99.8 cap_mim_2f0_m4m5_noshield
C$521 \$24 topp 3.56528e-14
* device instance $522 r0 *1 41,99.8 cap_mim_2f0_m4m5_noshield
C$522 \$12 topp 3.56528e-14
* device instance $523 r0 *1 47.4,99.8 cap_mim_2f0_m4m5_noshield
C$523 \$24 topp 3.56528e-14
* device instance $524 r0 *1 53.8,99.8 cap_mim_2f0_m4m5_noshield
C$524 \$12 topp 3.56528e-14
* device instance $525 r0 *1 60.2,99.8 cap_mim_2f0_m4m5_noshield
C$525 \$24 topp 3.56528e-14
* device instance $526 r0 *1 66.6,99.8 cap_mim_2f0_m4m5_noshield
C$526 \$12 topp 3.56528e-14
* device instance $527 r0 *1 73,99.8 cap_mim_2f0_m4m5_noshield
C$527 \$24 topp 3.56528e-14
* device instance $528 r0 *1 79.4,99.8 cap_mim_2f0_m4m5_noshield
C$528 \$12 topp 3.56528e-14
* device instance $529 r0 *1 85.8,99.8 cap_mim_2f0_m4m5_noshield
C$529 \$24 topp 3.56528e-14
* device instance $530 r0 *1 92.2,99.8 cap_mim_2f0_m4m5_noshield
C$530 \$12 topp 3.56528e-14
* device instance $531 r0 *1 98.6,99.8 cap_mim_2f0_m4m5_noshield
C$531 \$24 topp 3.56528e-14
* device instance $532 r0 *1 105,99.8 cap_mim_2f0_m4m5_noshield
C$532 \$12 topp 3.56528e-14
* device instance $533 r0 *1 111.4,99.8 cap_mim_2f0_m4m5_noshield
C$533 \$24 topp 3.56528e-14
* device instance $534 r0 *1 117.8,99.8 cap_mim_2f0_m4m5_noshield
C$534 \$12 topp 3.56528e-14
* device instance $535 r0 *1 124.2,99.8 cap_mim_2f0_m4m5_noshield
C$535 \$24 topp 3.56528e-14
* device instance $536 r0 *1 130.6,99.8 cap_mim_2f0_m4m5_noshield
C$536 \$12 topp 3.56528e-14
* device instance $537 r0 *1 137,99.8 cap_mim_2f0_m4m5_noshield
C$537 \$24 topp 3.56528e-14
* device instance $538 r0 *1 143.4,99.8 cap_mim_2f0_m4m5_noshield
C$538 \$12 topp 3.56528e-14
* device instance $539 r0 *1 149.8,99.8 cap_mim_2f0_m4m5_noshield
C$539 \$24 topp 3.56528e-14
* device instance $540 r0 *1 156.2,99.8 cap_mim_2f0_m4m5_noshield
C$540 \$12 topp 3.56528e-14
* device instance $541 r0 *1 162.6,99.8 cap_mim_2f0_m4m5_noshield
C$541 \$24 topp 3.56528e-14
* device instance $542 r0 *1 169,99.8 cap_mim_2f0_m4m5_noshield
C$542 \$12 topp 3.56528e-14
* device instance $543 r0 *1 175.4,99.8 cap_mim_2f0_m4m5_noshield
C$543 \$24 topp 3.56528e-14
* device instance $544 r0 *1 181.8,99.8 cap_mim_2f0_m4m5_noshield
C$544 \$12 topp 3.56528e-14
* device instance $545 r0 *1 188.2,99.8 cap_mim_2f0_m4m5_noshield
C$545 \$24 topp 3.56528e-14
* device instance $546 r0 *1 194.6,99.8 cap_mim_2f0_m4m5_noshield
C$546 \$12 topp 3.56528e-14
* device instance $547 r0 *1 201,99.8 cap_mim_2f0_m4m5_noshield
C$547 \$24 topp 3.56528e-14
* device instance $548 r0 *1 224,99.8 cap_mim_2f0_m4m5_noshield
C$548 \$82 topn 3.56528e-14
* device instance $549 r0 *1 230.4,99.8 cap_mim_2f0_m4m5_noshield
C$549 \$83 topn 3.56528e-14
* device instance $550 r0 *1 236.8,99.8 cap_mim_2f0_m4m5_noshield
C$550 \$82 topn 3.56528e-14
* device instance $551 r0 *1 243.2,99.8 cap_mim_2f0_m4m5_noshield
C$551 \$83 topn 3.56528e-14
* device instance $552 r0 *1 249.6,99.8 cap_mim_2f0_m4m5_noshield
C$552 \$82 topn 3.56528e-14
* device instance $553 r0 *1 256,99.8 cap_mim_2f0_m4m5_noshield
C$553 \$83 topn 3.56528e-14
* device instance $554 r0 *1 262.4,99.8 cap_mim_2f0_m4m5_noshield
C$554 \$82 topn 3.56528e-14
* device instance $555 r0 *1 268.8,99.8 cap_mim_2f0_m4m5_noshield
C$555 \$83 topn 3.56528e-14
* device instance $556 r0 *1 275.2,99.8 cap_mim_2f0_m4m5_noshield
C$556 \$82 topn 3.56528e-14
* device instance $557 r0 *1 281.6,99.8 cap_mim_2f0_m4m5_noshield
C$557 \$83 topn 3.56528e-14
* device instance $558 r0 *1 288,99.8 cap_mim_2f0_m4m5_noshield
C$558 \$82 topn 3.56528e-14
* device instance $559 r0 *1 294.4,99.8 cap_mim_2f0_m4m5_noshield
C$559 \$83 topn 3.56528e-14
* device instance $560 r0 *1 300.8,99.8 cap_mim_2f0_m4m5_noshield
C$560 \$82 topn 3.56528e-14
* device instance $561 r0 *1 307.2,99.8 cap_mim_2f0_m4m5_noshield
C$561 \$83 topn 3.56528e-14
* device instance $562 r0 *1 313.6,99.8 cap_mim_2f0_m4m5_noshield
C$562 \$82 topn 3.56528e-14
* device instance $563 r0 *1 320,99.8 cap_mim_2f0_m4m5_noshield
C$563 \$83 topn 3.56528e-14
* device instance $564 r0 *1 326.4,99.8 cap_mim_2f0_m4m5_noshield
C$564 \$82 topn 3.56528e-14
* device instance $565 r0 *1 332.8,99.8 cap_mim_2f0_m4m5_noshield
C$565 \$83 topn 3.56528e-14
* device instance $566 r0 *1 339.2,99.8 cap_mim_2f0_m4m5_noshield
C$566 \$82 topn 3.56528e-14
* device instance $567 r0 *1 345.6,99.8 cap_mim_2f0_m4m5_noshield
C$567 \$83 topn 3.56528e-14
* device instance $568 r0 *1 352,99.8 cap_mim_2f0_m4m5_noshield
C$568 \$82 topn 3.56528e-14
* device instance $569 r0 *1 358.4,99.8 cap_mim_2f0_m4m5_noshield
C$569 \$83 topn 3.56528e-14
* device instance $570 r0 *1 364.8,99.8 cap_mim_2f0_m4m5_noshield
C$570 \$82 topn 3.56528e-14
* device instance $571 r0 *1 371.2,99.8 cap_mim_2f0_m4m5_noshield
C$571 \$83 topn 3.56528e-14
* device instance $572 r0 *1 377.6,99.8 cap_mim_2f0_m4m5_noshield
C$572 \$82 topn 3.56528e-14
* device instance $573 r0 *1 384,99.8 cap_mim_2f0_m4m5_noshield
C$573 \$83 topn 3.56528e-14
* device instance $574 r0 *1 390.4,99.8 cap_mim_2f0_m4m5_noshield
C$574 \$82 topn 3.56528e-14
* device instance $575 r0 *1 396.8,99.8 cap_mim_2f0_m4m5_noshield
C$575 \$83 topn 3.56528e-14
* device instance $576 r0 *1 403.2,99.8 cap_mim_2f0_m4m5_noshield
C$576 \$82 topn 3.56528e-14
* device instance $577 r0 *1 409.6,99.8 cap_mim_2f0_m4m5_noshield
C$577 \$83 topn 3.56528e-14
* device instance $578 r0 *1 416,99.8 cap_mim_2f0_m4m5_noshield
C$578 \$82 topn 3.56528e-14
* device instance $579 r0 *1 422.4,99.8 cap_mim_2f0_m4m5_noshield
C$579 \$83 topn 3.56528e-14
* device instance $580 r0 *1 2.6,106.2 cap_mim_2f0_m4m5_noshield
C$580 \$24 topp 3.56528e-14
* device instance $581 r0 *1 9,106.2 cap_mim_2f0_m4m5_noshield
C$581 \$12 topp 3.56528e-14
* device instance $582 r0 *1 15.4,106.2 cap_mim_2f0_m4m5_noshield
C$582 \$24 topp 3.56528e-14
* device instance $583 r0 *1 21.8,106.2 cap_mim_2f0_m4m5_noshield
C$583 \$12 topp 3.56528e-14
* device instance $584 r0 *1 28.2,106.2 cap_mim_2f0_m4m5_noshield
C$584 \$24 topp 3.56528e-14
* device instance $585 r0 *1 34.6,106.2 cap_mim_2f0_m4m5_noshield
C$585 \$12 topp 3.56528e-14
* device instance $586 r0 *1 41,106.2 cap_mim_2f0_m4m5_noshield
C$586 \$24 topp 3.56528e-14
* device instance $587 r0 *1 47.4,106.2 cap_mim_2f0_m4m5_noshield
C$587 \$12 topp 3.56528e-14
* device instance $588 r0 *1 53.8,106.2 cap_mim_2f0_m4m5_noshield
C$588 \$24 topp 3.56528e-14
* device instance $589 r0 *1 60.2,106.2 cap_mim_2f0_m4m5_noshield
C$589 \$12 topp 3.56528e-14
* device instance $590 r0 *1 66.6,106.2 cap_mim_2f0_m4m5_noshield
C$590 \$24 topp 3.56528e-14
* device instance $591 r0 *1 73,106.2 cap_mim_2f0_m4m5_noshield
C$591 \$12 topp 3.56528e-14
* device instance $592 r0 *1 79.4,106.2 cap_mim_2f0_m4m5_noshield
C$592 \$24 topp 3.56528e-14
* device instance $593 r0 *1 85.8,106.2 cap_mim_2f0_m4m5_noshield
C$593 \$12 topp 3.56528e-14
* device instance $594 r0 *1 92.2,106.2 cap_mim_2f0_m4m5_noshield
C$594 \$24 topp 3.56528e-14
* device instance $595 r0 *1 98.6,106.2 cap_mim_2f0_m4m5_noshield
C$595 \$12 topp 3.56528e-14
* device instance $596 r0 *1 105,106.2 cap_mim_2f0_m4m5_noshield
C$596 \$24 topp 3.56528e-14
* device instance $597 r0 *1 111.4,106.2 cap_mim_2f0_m4m5_noshield
C$597 \$12 topp 3.56528e-14
* device instance $598 r0 *1 117.8,106.2 cap_mim_2f0_m4m5_noshield
C$598 \$24 topp 3.56528e-14
* device instance $599 r0 *1 124.2,106.2 cap_mim_2f0_m4m5_noshield
C$599 \$12 topp 3.56528e-14
* device instance $600 r0 *1 130.6,106.2 cap_mim_2f0_m4m5_noshield
C$600 \$24 topp 3.56528e-14
* device instance $601 r0 *1 137,106.2 cap_mim_2f0_m4m5_noshield
C$601 \$12 topp 3.56528e-14
* device instance $602 r0 *1 143.4,106.2 cap_mim_2f0_m4m5_noshield
C$602 \$24 topp 3.56528e-14
* device instance $603 r0 *1 149.8,106.2 cap_mim_2f0_m4m5_noshield
C$603 \$12 topp 3.56528e-14
* device instance $604 r0 *1 156.2,106.2 cap_mim_2f0_m4m5_noshield
C$604 \$24 topp 3.56528e-14
* device instance $605 r0 *1 162.6,106.2 cap_mim_2f0_m4m5_noshield
C$605 \$12 topp 3.56528e-14
* device instance $606 r0 *1 169,106.2 cap_mim_2f0_m4m5_noshield
C$606 \$24 topp 3.56528e-14
* device instance $607 r0 *1 175.4,106.2 cap_mim_2f0_m4m5_noshield
C$607 \$12 topp 3.56528e-14
* device instance $608 r0 *1 181.8,106.2 cap_mim_2f0_m4m5_noshield
C$608 \$24 topp 3.56528e-14
* device instance $609 r0 *1 188.2,106.2 cap_mim_2f0_m4m5_noshield
C$609 \$12 topp 3.56528e-14
* device instance $610 r0 *1 194.6,106.2 cap_mim_2f0_m4m5_noshield
C$610 \$24 topp 3.56528e-14
* device instance $611 r0 *1 201,106.2 cap_mim_2f0_m4m5_noshield
C$611 \$12 topp 3.56528e-14
* device instance $612 r0 *1 224,106.2 cap_mim_2f0_m4m5_noshield
C$612 \$83 topn 3.56528e-14
* device instance $613 r0 *1 230.4,106.2 cap_mim_2f0_m4m5_noshield
C$613 \$82 topn 3.56528e-14
* device instance $614 r0 *1 236.8,106.2 cap_mim_2f0_m4m5_noshield
C$614 \$83 topn 3.56528e-14
* device instance $615 r0 *1 243.2,106.2 cap_mim_2f0_m4m5_noshield
C$615 \$82 topn 3.56528e-14
* device instance $616 r0 *1 249.6,106.2 cap_mim_2f0_m4m5_noshield
C$616 \$83 topn 3.56528e-14
* device instance $617 r0 *1 256,106.2 cap_mim_2f0_m4m5_noshield
C$617 \$82 topn 3.56528e-14
* device instance $618 r0 *1 262.4,106.2 cap_mim_2f0_m4m5_noshield
C$618 \$83 topn 3.56528e-14
* device instance $619 r0 *1 268.8,106.2 cap_mim_2f0_m4m5_noshield
C$619 \$82 topn 3.56528e-14
* device instance $620 r0 *1 275.2,106.2 cap_mim_2f0_m4m5_noshield
C$620 \$83 topn 3.56528e-14
* device instance $621 r0 *1 281.6,106.2 cap_mim_2f0_m4m5_noshield
C$621 \$82 topn 3.56528e-14
* device instance $622 r0 *1 288,106.2 cap_mim_2f0_m4m5_noshield
C$622 \$83 topn 3.56528e-14
* device instance $623 r0 *1 294.4,106.2 cap_mim_2f0_m4m5_noshield
C$623 \$82 topn 3.56528e-14
* device instance $624 r0 *1 300.8,106.2 cap_mim_2f0_m4m5_noshield
C$624 \$83 topn 3.56528e-14
* device instance $625 r0 *1 307.2,106.2 cap_mim_2f0_m4m5_noshield
C$625 \$82 topn 3.56528e-14
* device instance $626 r0 *1 313.6,106.2 cap_mim_2f0_m4m5_noshield
C$626 \$83 topn 3.56528e-14
* device instance $627 r0 *1 320,106.2 cap_mim_2f0_m4m5_noshield
C$627 \$82 topn 3.56528e-14
* device instance $628 r0 *1 326.4,106.2 cap_mim_2f0_m4m5_noshield
C$628 \$83 topn 3.56528e-14
* device instance $629 r0 *1 332.8,106.2 cap_mim_2f0_m4m5_noshield
C$629 \$82 topn 3.56528e-14
* device instance $630 r0 *1 339.2,106.2 cap_mim_2f0_m4m5_noshield
C$630 \$83 topn 3.56528e-14
* device instance $631 r0 *1 345.6,106.2 cap_mim_2f0_m4m5_noshield
C$631 \$82 topn 3.56528e-14
* device instance $632 r0 *1 352,106.2 cap_mim_2f0_m4m5_noshield
C$632 \$83 topn 3.56528e-14
* device instance $633 r0 *1 358.4,106.2 cap_mim_2f0_m4m5_noshield
C$633 \$82 topn 3.56528e-14
* device instance $634 r0 *1 364.8,106.2 cap_mim_2f0_m4m5_noshield
C$634 \$83 topn 3.56528e-14
* device instance $635 r0 *1 371.2,106.2 cap_mim_2f0_m4m5_noshield
C$635 \$82 topn 3.56528e-14
* device instance $636 r0 *1 377.6,106.2 cap_mim_2f0_m4m5_noshield
C$636 \$83 topn 3.56528e-14
* device instance $637 r0 *1 384,106.2 cap_mim_2f0_m4m5_noshield
C$637 \$82 topn 3.56528e-14
* device instance $638 r0 *1 390.4,106.2 cap_mim_2f0_m4m5_noshield
C$638 \$83 topn 3.56528e-14
* device instance $639 r0 *1 396.8,106.2 cap_mim_2f0_m4m5_noshield
C$639 \$82 topn 3.56528e-14
* device instance $640 r0 *1 403.2,106.2 cap_mim_2f0_m4m5_noshield
C$640 \$83 topn 3.56528e-14
* device instance $641 r0 *1 409.6,106.2 cap_mim_2f0_m4m5_noshield
C$641 \$82 topn 3.56528e-14
* device instance $642 r0 *1 416,106.2 cap_mim_2f0_m4m5_noshield
C$642 \$83 topn 3.56528e-14
* device instance $643 r0 *1 422.4,106.2 cap_mim_2f0_m4m5_noshield
C$643 \$82 topn 3.56528e-14
* device instance $644 r0 *1 2.6,112.6 cap_mim_2f0_m4m5_noshield
C$644 \$24 topp 3.56528e-14
* device instance $645 r0 *1 9,112.6 cap_mim_2f0_m4m5_noshield
C$645 \$12 topp 3.56528e-14
* device instance $646 r0 *1 15.4,112.6 cap_mim_2f0_m4m5_noshield
C$646 \$24 topp 3.56528e-14
* device instance $647 r0 *1 21.8,112.6 cap_mim_2f0_m4m5_noshield
C$647 \$12 topp 3.56528e-14
* device instance $648 r0 *1 28.2,112.6 cap_mim_2f0_m4m5_noshield
C$648 \$24 topp 3.56528e-14
* device instance $649 r0 *1 34.6,112.6 cap_mim_2f0_m4m5_noshield
C$649 \$12 topp 3.56528e-14
* device instance $650 r0 *1 41,112.6 cap_mim_2f0_m4m5_noshield
C$650 \$24 topp 3.56528e-14
* device instance $651 r0 *1 47.4,112.6 cap_mim_2f0_m4m5_noshield
C$651 \$12 topp 3.56528e-14
* device instance $652 r0 *1 53.8,112.6 cap_mim_2f0_m4m5_noshield
C$652 \$24 topp 3.56528e-14
* device instance $653 r0 *1 60.2,112.6 cap_mim_2f0_m4m5_noshield
C$653 \$12 topp 3.56528e-14
* device instance $654 r0 *1 66.6,112.6 cap_mim_2f0_m4m5_noshield
C$654 \$24 topp 3.56528e-14
* device instance $655 r0 *1 73,112.6 cap_mim_2f0_m4m5_noshield
C$655 \$12 topp 3.56528e-14
* device instance $656 r0 *1 79.4,112.6 cap_mim_2f0_m4m5_noshield
C$656 \$24 topp 3.56528e-14
* device instance $657 r0 *1 85.8,112.6 cap_mim_2f0_m4m5_noshield
C$657 \$12 topp 3.56528e-14
* device instance $658 r0 *1 92.2,112.6 cap_mim_2f0_m4m5_noshield
C$658 \$24 topp 3.56528e-14
* device instance $659 r0 *1 98.6,112.6 cap_mim_2f0_m4m5_noshield
C$659 \$12 topp 3.56528e-14
* device instance $660 r0 *1 105,112.6 cap_mim_2f0_m4m5_noshield
C$660 \$24 topp 3.56528e-14
* device instance $661 r0 *1 111.4,112.6 cap_mim_2f0_m4m5_noshield
C$661 \$12 topp 3.56528e-14
* device instance $662 r0 *1 117.8,112.6 cap_mim_2f0_m4m5_noshield
C$662 \$24 topp 3.56528e-14
* device instance $663 r0 *1 124.2,112.6 cap_mim_2f0_m4m5_noshield
C$663 \$12 topp 3.56528e-14
* device instance $664 r0 *1 130.6,112.6 cap_mim_2f0_m4m5_noshield
C$664 \$24 topp 3.56528e-14
* device instance $665 r0 *1 137,112.6 cap_mim_2f0_m4m5_noshield
C$665 \$12 topp 3.56528e-14
* device instance $666 r0 *1 143.4,112.6 cap_mim_2f0_m4m5_noshield
C$666 \$24 topp 3.56528e-14
* device instance $667 r0 *1 149.8,112.6 cap_mim_2f0_m4m5_noshield
C$667 \$12 topp 3.56528e-14
* device instance $668 r0 *1 156.2,112.6 cap_mim_2f0_m4m5_noshield
C$668 \$24 topp 3.56528e-14
* device instance $669 r0 *1 162.6,112.6 cap_mim_2f0_m4m5_noshield
C$669 \$12 topp 3.56528e-14
* device instance $670 r0 *1 169,112.6 cap_mim_2f0_m4m5_noshield
C$670 \$24 topp 3.56528e-14
* device instance $671 r0 *1 175.4,112.6 cap_mim_2f0_m4m5_noshield
C$671 \$12 topp 3.56528e-14
* device instance $672 r0 *1 181.8,112.6 cap_mim_2f0_m4m5_noshield
C$672 \$24 topp 3.56528e-14
* device instance $673 r0 *1 188.2,112.6 cap_mim_2f0_m4m5_noshield
C$673 \$12 topp 3.56528e-14
* device instance $674 r0 *1 194.6,112.6 cap_mim_2f0_m4m5_noshield
C$674 \$24 topp 3.56528e-14
* device instance $675 r0 *1 201,112.6 cap_mim_2f0_m4m5_noshield
C$675 \$12 topp 3.56528e-14
* device instance $676 r0 *1 224,112.6 cap_mim_2f0_m4m5_noshield
C$676 \$83 topn 3.56528e-14
* device instance $677 r0 *1 230.4,112.6 cap_mim_2f0_m4m5_noshield
C$677 \$82 topn 3.56528e-14
* device instance $678 r0 *1 236.8,112.6 cap_mim_2f0_m4m5_noshield
C$678 \$83 topn 3.56528e-14
* device instance $679 r0 *1 243.2,112.6 cap_mim_2f0_m4m5_noshield
C$679 \$82 topn 3.56528e-14
* device instance $680 r0 *1 249.6,112.6 cap_mim_2f0_m4m5_noshield
C$680 \$83 topn 3.56528e-14
* device instance $681 r0 *1 256,112.6 cap_mim_2f0_m4m5_noshield
C$681 \$82 topn 3.56528e-14
* device instance $682 r0 *1 262.4,112.6 cap_mim_2f0_m4m5_noshield
C$682 \$83 topn 3.56528e-14
* device instance $683 r0 *1 268.8,112.6 cap_mim_2f0_m4m5_noshield
C$683 \$82 topn 3.56528e-14
* device instance $684 r0 *1 275.2,112.6 cap_mim_2f0_m4m5_noshield
C$684 \$83 topn 3.56528e-14
* device instance $685 r0 *1 281.6,112.6 cap_mim_2f0_m4m5_noshield
C$685 \$82 topn 3.56528e-14
* device instance $686 r0 *1 288,112.6 cap_mim_2f0_m4m5_noshield
C$686 \$83 topn 3.56528e-14
* device instance $687 r0 *1 294.4,112.6 cap_mim_2f0_m4m5_noshield
C$687 \$82 topn 3.56528e-14
* device instance $688 r0 *1 300.8,112.6 cap_mim_2f0_m4m5_noshield
C$688 \$83 topn 3.56528e-14
* device instance $689 r0 *1 307.2,112.6 cap_mim_2f0_m4m5_noshield
C$689 \$82 topn 3.56528e-14
* device instance $690 r0 *1 313.6,112.6 cap_mim_2f0_m4m5_noshield
C$690 \$83 topn 3.56528e-14
* device instance $691 r0 *1 320,112.6 cap_mim_2f0_m4m5_noshield
C$691 \$82 topn 3.56528e-14
* device instance $692 r0 *1 326.4,112.6 cap_mim_2f0_m4m5_noshield
C$692 \$83 topn 3.56528e-14
* device instance $693 r0 *1 332.8,112.6 cap_mim_2f0_m4m5_noshield
C$693 \$82 topn 3.56528e-14
* device instance $694 r0 *1 339.2,112.6 cap_mim_2f0_m4m5_noshield
C$694 \$83 topn 3.56528e-14
* device instance $695 r0 *1 345.6,112.6 cap_mim_2f0_m4m5_noshield
C$695 \$82 topn 3.56528e-14
* device instance $696 r0 *1 352,112.6 cap_mim_2f0_m4m5_noshield
C$696 \$83 topn 3.56528e-14
* device instance $697 r0 *1 358.4,112.6 cap_mim_2f0_m4m5_noshield
C$697 \$82 topn 3.56528e-14
* device instance $698 r0 *1 364.8,112.6 cap_mim_2f0_m4m5_noshield
C$698 \$83 topn 3.56528e-14
* device instance $699 r0 *1 371.2,112.6 cap_mim_2f0_m4m5_noshield
C$699 \$82 topn 3.56528e-14
* device instance $700 r0 *1 377.6,112.6 cap_mim_2f0_m4m5_noshield
C$700 \$83 topn 3.56528e-14
* device instance $701 r0 *1 384,112.6 cap_mim_2f0_m4m5_noshield
C$701 \$82 topn 3.56528e-14
* device instance $702 r0 *1 390.4,112.6 cap_mim_2f0_m4m5_noshield
C$702 \$83 topn 3.56528e-14
* device instance $703 r0 *1 396.8,112.6 cap_mim_2f0_m4m5_noshield
C$703 \$82 topn 3.56528e-14
* device instance $704 r0 *1 403.2,112.6 cap_mim_2f0_m4m5_noshield
C$704 \$83 topn 3.56528e-14
* device instance $705 r0 *1 409.6,112.6 cap_mim_2f0_m4m5_noshield
C$705 \$82 topn 3.56528e-14
* device instance $706 r0 *1 416,112.6 cap_mim_2f0_m4m5_noshield
C$706 \$83 topn 3.56528e-14
* device instance $707 r0 *1 422.4,112.6 cap_mim_2f0_m4m5_noshield
C$707 \$82 topn 3.56528e-14
* device instance $708 r0 *1 2.6,119 cap_mim_2f0_m4m5_noshield
C$708 \$32 topp 3.56528e-14
* device instance $709 r0 *1 9,119 cap_mim_2f0_m4m5_noshield
C$709 \$12 topp 3.56528e-14
* device instance $710 r0 *1 15.4,119 cap_mim_2f0_m4m5_noshield
C$710 \$32 topp 3.56528e-14
* device instance $711 r0 *1 21.8,119 cap_mim_2f0_m4m5_noshield
C$711 \$12 topp 3.56528e-14
* device instance $712 r0 *1 28.2,119 cap_mim_2f0_m4m5_noshield
C$712 \$32 topp 3.56528e-14
* device instance $713 r0 *1 34.6,119 cap_mim_2f0_m4m5_noshield
C$713 \$12 topp 3.56528e-14
* device instance $714 r0 *1 41,119 cap_mim_2f0_m4m5_noshield
C$714 \$32 topp 3.56528e-14
* device instance $715 r0 *1 47.4,119 cap_mim_2f0_m4m5_noshield
C$715 \$12 topp 3.56528e-14
* device instance $716 r0 *1 53.8,119 cap_mim_2f0_m4m5_noshield
C$716 \$32 topp 3.56528e-14
* device instance $717 r0 *1 60.2,119 cap_mim_2f0_m4m5_noshield
C$717 \$12 topp 3.56528e-14
* device instance $718 r0 *1 66.6,119 cap_mim_2f0_m4m5_noshield
C$718 \$32 topp 3.56528e-14
* device instance $719 r0 *1 73,119 cap_mim_2f0_m4m5_noshield
C$719 \$12 topp 3.56528e-14
* device instance $720 r0 *1 79.4,119 cap_mim_2f0_m4m5_noshield
C$720 \$32 topp 3.56528e-14
* device instance $721 r0 *1 85.8,119 cap_mim_2f0_m4m5_noshield
C$721 \$12 topp 3.56528e-14
* device instance $722 r0 *1 92.2,119 cap_mim_2f0_m4m5_noshield
C$722 \$32 topp 3.56528e-14
* device instance $723 r0 *1 98.6,119 cap_mim_2f0_m4m5_noshield
C$723 \$12 topp 3.56528e-14
* device instance $724 r0 *1 105,119 cap_mim_2f0_m4m5_noshield
C$724 \$32 topp 3.56528e-14
* device instance $725 r0 *1 111.4,119 cap_mim_2f0_m4m5_noshield
C$725 \$12 topp 3.56528e-14
* device instance $726 r0 *1 117.8,119 cap_mim_2f0_m4m5_noshield
C$726 \$32 topp 3.56528e-14
* device instance $727 r0 *1 124.2,119 cap_mim_2f0_m4m5_noshield
C$727 \$12 topp 3.56528e-14
* device instance $728 r0 *1 130.6,119 cap_mim_2f0_m4m5_noshield
C$728 \$32 topp 3.56528e-14
* device instance $729 r0 *1 137,119 cap_mim_2f0_m4m5_noshield
C$729 \$12 topp 3.56528e-14
* device instance $730 r0 *1 143.4,119 cap_mim_2f0_m4m5_noshield
C$730 \$32 topp 3.56528e-14
* device instance $731 r0 *1 149.8,119 cap_mim_2f0_m4m5_noshield
C$731 \$12 topp 3.56528e-14
* device instance $732 r0 *1 156.2,119 cap_mim_2f0_m4m5_noshield
C$732 \$32 topp 3.56528e-14
* device instance $733 r0 *1 162.6,119 cap_mim_2f0_m4m5_noshield
C$733 \$12 topp 3.56528e-14
* device instance $734 r0 *1 169,119 cap_mim_2f0_m4m5_noshield
C$734 \$32 topp 3.56528e-14
* device instance $735 r0 *1 175.4,119 cap_mim_2f0_m4m5_noshield
C$735 \$12 topp 3.56528e-14
* device instance $736 r0 *1 181.8,119 cap_mim_2f0_m4m5_noshield
C$736 \$32 topp 3.56528e-14
* device instance $737 r0 *1 188.2,119 cap_mim_2f0_m4m5_noshield
C$737 \$12 topp 3.56528e-14
* device instance $738 r0 *1 194.6,119 cap_mim_2f0_m4m5_noshield
C$738 \$32 topp 3.56528e-14
* device instance $739 r0 *1 201,119 cap_mim_2f0_m4m5_noshield
C$739 \$12 topp 3.56528e-14
* device instance $740 r0 *1 224,119 cap_mim_2f0_m4m5_noshield
C$740 \$84 topn 3.56528e-14
* device instance $741 r0 *1 230.4,119 cap_mim_2f0_m4m5_noshield
C$741 \$82 topn 3.56528e-14
* device instance $742 r0 *1 236.8,119 cap_mim_2f0_m4m5_noshield
C$742 \$84 topn 3.56528e-14
* device instance $743 r0 *1 243.2,119 cap_mim_2f0_m4m5_noshield
C$743 \$82 topn 3.56528e-14
* device instance $744 r0 *1 249.6,119 cap_mim_2f0_m4m5_noshield
C$744 \$84 topn 3.56528e-14
* device instance $745 r0 *1 256,119 cap_mim_2f0_m4m5_noshield
C$745 \$82 topn 3.56528e-14
* device instance $746 r0 *1 262.4,119 cap_mim_2f0_m4m5_noshield
C$746 \$84 topn 3.56528e-14
* device instance $747 r0 *1 268.8,119 cap_mim_2f0_m4m5_noshield
C$747 \$82 topn 3.56528e-14
* device instance $748 r0 *1 275.2,119 cap_mim_2f0_m4m5_noshield
C$748 \$84 topn 3.56528e-14
* device instance $749 r0 *1 281.6,119 cap_mim_2f0_m4m5_noshield
C$749 \$82 topn 3.56528e-14
* device instance $750 r0 *1 288,119 cap_mim_2f0_m4m5_noshield
C$750 \$84 topn 3.56528e-14
* device instance $751 r0 *1 294.4,119 cap_mim_2f0_m4m5_noshield
C$751 \$82 topn 3.56528e-14
* device instance $752 r0 *1 300.8,119 cap_mim_2f0_m4m5_noshield
C$752 \$84 topn 3.56528e-14
* device instance $753 r0 *1 307.2,119 cap_mim_2f0_m4m5_noshield
C$753 \$82 topn 3.56528e-14
* device instance $754 r0 *1 313.6,119 cap_mim_2f0_m4m5_noshield
C$754 \$84 topn 3.56528e-14
* device instance $755 r0 *1 320,119 cap_mim_2f0_m4m5_noshield
C$755 \$82 topn 3.56528e-14
* device instance $756 r0 *1 326.4,119 cap_mim_2f0_m4m5_noshield
C$756 \$84 topn 3.56528e-14
* device instance $757 r0 *1 332.8,119 cap_mim_2f0_m4m5_noshield
C$757 \$82 topn 3.56528e-14
* device instance $758 r0 *1 339.2,119 cap_mim_2f0_m4m5_noshield
C$758 \$84 topn 3.56528e-14
* device instance $759 r0 *1 345.6,119 cap_mim_2f0_m4m5_noshield
C$759 \$82 topn 3.56528e-14
* device instance $760 r0 *1 352,119 cap_mim_2f0_m4m5_noshield
C$760 \$84 topn 3.56528e-14
* device instance $761 r0 *1 358.4,119 cap_mim_2f0_m4m5_noshield
C$761 \$82 topn 3.56528e-14
* device instance $762 r0 *1 364.8,119 cap_mim_2f0_m4m5_noshield
C$762 \$84 topn 3.56528e-14
* device instance $763 r0 *1 371.2,119 cap_mim_2f0_m4m5_noshield
C$763 \$82 topn 3.56528e-14
* device instance $764 r0 *1 377.6,119 cap_mim_2f0_m4m5_noshield
C$764 \$84 topn 3.56528e-14
* device instance $765 r0 *1 384,119 cap_mim_2f0_m4m5_noshield
C$765 \$82 topn 3.56528e-14
* device instance $766 r0 *1 390.4,119 cap_mim_2f0_m4m5_noshield
C$766 \$84 topn 3.56528e-14
* device instance $767 r0 *1 396.8,119 cap_mim_2f0_m4m5_noshield
C$767 \$82 topn 3.56528e-14
* device instance $768 r0 *1 403.2,119 cap_mim_2f0_m4m5_noshield
C$768 \$84 topn 3.56528e-14
* device instance $769 r0 *1 409.6,119 cap_mim_2f0_m4m5_noshield
C$769 \$82 topn 3.56528e-14
* device instance $770 r0 *1 416,119 cap_mim_2f0_m4m5_noshield
C$770 \$84 topn 3.56528e-14
* device instance $771 r0 *1 422.4,119 cap_mim_2f0_m4m5_noshield
C$771 \$82 topn 3.56528e-14
* device instance $772 r0 *1 2.6,125.4 cap_mim_2f0_m4m5_noshield
C$772 \$40 topp 3.56528e-14
* device instance $773 r0 *1 9,125.4 cap_mim_2f0_m4m5_noshield
C$773 \$12 topp 3.56528e-14
* device instance $774 r0 *1 15.4,125.4 cap_mim_2f0_m4m5_noshield
C$774 \$40 topp 3.56528e-14
* device instance $775 r0 *1 21.8,125.4 cap_mim_2f0_m4m5_noshield
C$775 \$12 topp 3.56528e-14
* device instance $776 r0 *1 28.2,125.4 cap_mim_2f0_m4m5_noshield
C$776 \$40 topp 3.56528e-14
* device instance $777 r0 *1 34.6,125.4 cap_mim_2f0_m4m5_noshield
C$777 \$12 topp 3.56528e-14
* device instance $778 r0 *1 41,125.4 cap_mim_2f0_m4m5_noshield
C$778 \$40 topp 3.56528e-14
* device instance $779 r0 *1 47.4,125.4 cap_mim_2f0_m4m5_noshield
C$779 \$12 topp 3.56528e-14
* device instance $780 r0 *1 53.8,125.4 cap_mim_2f0_m4m5_noshield
C$780 \$40 topp 3.56528e-14
* device instance $781 r0 *1 60.2,125.4 cap_mim_2f0_m4m5_noshield
C$781 \$12 topp 3.56528e-14
* device instance $782 r0 *1 66.6,125.4 cap_mim_2f0_m4m5_noshield
C$782 \$40 topp 3.56528e-14
* device instance $783 r0 *1 73,125.4 cap_mim_2f0_m4m5_noshield
C$783 \$12 topp 3.56528e-14
* device instance $784 r0 *1 79.4,125.4 cap_mim_2f0_m4m5_noshield
C$784 \$40 topp 3.56528e-14
* device instance $785 r0 *1 85.8,125.4 cap_mim_2f0_m4m5_noshield
C$785 \$12 topp 3.56528e-14
* device instance $786 r0 *1 92.2,125.4 cap_mim_2f0_m4m5_noshield
C$786 \$40 topp 3.56528e-14
* device instance $787 r0 *1 98.6,125.4 cap_mim_2f0_m4m5_noshield
C$787 \$12 topp 3.56528e-14
* device instance $788 r0 *1 105,125.4 cap_mim_2f0_m4m5_noshield
C$788 \$48 topp 3.56528e-14
* device instance $789 r0 *1 111.4,125.4 cap_mim_2f0_m4m5_noshield
C$789 \$12 topp 3.56528e-14
* device instance $790 r0 *1 117.8,125.4 cap_mim_2f0_m4m5_noshield
C$790 \$48 topp 3.56528e-14
* device instance $791 r0 *1 124.2,125.4 cap_mim_2f0_m4m5_noshield
C$791 \$12 topp 3.56528e-14
* device instance $792 r0 *1 130.6,125.4 cap_mim_2f0_m4m5_noshield
C$792 \$48 topp 3.56528e-14
* device instance $793 r0 *1 137,125.4 cap_mim_2f0_m4m5_noshield
C$793 \$12 topp 3.56528e-14
* device instance $794 r0 *1 143.4,125.4 cap_mim_2f0_m4m5_noshield
C$794 \$48 topp 3.56528e-14
* device instance $795 r0 *1 149.8,125.4 cap_mim_2f0_m4m5_noshield
C$795 \$12 topp 3.56528e-14
* device instance $796 r0 *1 156.2,125.4 cap_mim_2f0_m4m5_noshield
C$796 \$56 topp 3.56528e-14
* device instance $797 r0 *1 162.6,125.4 cap_mim_2f0_m4m5_noshield
C$797 \$12 topp 3.56528e-14
* device instance $798 r0 *1 169,125.4 cap_mim_2f0_m4m5_noshield
C$798 \$56 topp 3.56528e-14
* device instance $799 r0 *1 175.4,125.4 cap_mim_2f0_m4m5_noshield
C$799 \$12 topp 3.56528e-14
* device instance $800 r0 *1 181.8,125.4 cap_mim_2f0_m4m5_noshield
C$800 \$64 topp 3.56528e-14
* device instance $801 r0 *1 188.2,125.4 cap_mim_2f0_m4m5_noshield
C$801 \$12 topp 3.56528e-14
* device instance $802 r0 *1 194.6,125.4 cap_mim_2f0_m4m5_noshield
C$802 \$80 topp 3.56528e-14
* device instance $803 r0 *1 201,125.4 cap_mim_2f0_m4m5_noshield
C$803 \$12 topp 3.56528e-14
* device instance $804 r0 *1 224,125.4 cap_mim_2f0_m4m5_noshield
C$804 \$85 topn 3.56528e-14
* device instance $805 r0 *1 230.4,125.4 cap_mim_2f0_m4m5_noshield
C$805 \$82 topn 3.56528e-14
* device instance $806 r0 *1 236.8,125.4 cap_mim_2f0_m4m5_noshield
C$806 \$85 topn 3.56528e-14
* device instance $807 r0 *1 243.2,125.4 cap_mim_2f0_m4m5_noshield
C$807 \$82 topn 3.56528e-14
* device instance $808 r0 *1 249.6,125.4 cap_mim_2f0_m4m5_noshield
C$808 \$85 topn 3.56528e-14
* device instance $809 r0 *1 256,125.4 cap_mim_2f0_m4m5_noshield
C$809 \$82 topn 3.56528e-14
* device instance $810 r0 *1 262.4,125.4 cap_mim_2f0_m4m5_noshield
C$810 \$85 topn 3.56528e-14
* device instance $811 r0 *1 268.8,125.4 cap_mim_2f0_m4m5_noshield
C$811 \$82 topn 3.56528e-14
* device instance $812 r0 *1 275.2,125.4 cap_mim_2f0_m4m5_noshield
C$812 \$85 topn 3.56528e-14
* device instance $813 r0 *1 281.6,125.4 cap_mim_2f0_m4m5_noshield
C$813 \$82 topn 3.56528e-14
* device instance $814 r0 *1 288,125.4 cap_mim_2f0_m4m5_noshield
C$814 \$85 topn 3.56528e-14
* device instance $815 r0 *1 294.4,125.4 cap_mim_2f0_m4m5_noshield
C$815 \$82 topn 3.56528e-14
* device instance $816 r0 *1 300.8,125.4 cap_mim_2f0_m4m5_noshield
C$816 \$85 topn 3.56528e-14
* device instance $817 r0 *1 307.2,125.4 cap_mim_2f0_m4m5_noshield
C$817 \$82 topn 3.56528e-14
* device instance $818 r0 *1 313.6,125.4 cap_mim_2f0_m4m5_noshield
C$818 \$85 topn 3.56528e-14
* device instance $819 r0 *1 320,125.4 cap_mim_2f0_m4m5_noshield
C$819 \$82 topn 3.56528e-14
* device instance $820 r0 *1 326.4,125.4 cap_mim_2f0_m4m5_noshield
C$820 \$86 topn 3.56528e-14
* device instance $821 r0 *1 332.8,125.4 cap_mim_2f0_m4m5_noshield
C$821 \$82 topn 3.56528e-14
* device instance $822 r0 *1 339.2,125.4 cap_mim_2f0_m4m5_noshield
C$822 \$86 topn 3.56528e-14
* device instance $823 r0 *1 345.6,125.4 cap_mim_2f0_m4m5_noshield
C$823 \$82 topn 3.56528e-14
* device instance $824 r0 *1 352,125.4 cap_mim_2f0_m4m5_noshield
C$824 \$86 topn 3.56528e-14
* device instance $825 r0 *1 358.4,125.4 cap_mim_2f0_m4m5_noshield
C$825 \$82 topn 3.56528e-14
* device instance $826 r0 *1 364.8,125.4 cap_mim_2f0_m4m5_noshield
C$826 \$86 topn 3.56528e-14
* device instance $827 r0 *1 371.2,125.4 cap_mim_2f0_m4m5_noshield
C$827 \$82 topn 3.56528e-14
* device instance $828 r0 *1 377.6,125.4 cap_mim_2f0_m4m5_noshield
C$828 \$87 topn 3.56528e-14
* device instance $829 r0 *1 384,125.4 cap_mim_2f0_m4m5_noshield
C$829 \$82 topn 3.56528e-14
* device instance $830 r0 *1 390.4,125.4 cap_mim_2f0_m4m5_noshield
C$830 \$87 topn 3.56528e-14
* device instance $831 r0 *1 396.8,125.4 cap_mim_2f0_m4m5_noshield
C$831 \$82 topn 3.56528e-14
* device instance $832 r0 *1 403.2,125.4 cap_mim_2f0_m4m5_noshield
C$832 \$88 topn 3.56528e-14
* device instance $833 r0 *1 409.6,125.4 cap_mim_2f0_m4m5_noshield
C$833 \$82 topn 3.56528e-14
* device instance $834 r0 *1 416,125.4 cap_mim_2f0_m4m5_noshield
C$834 \$90 topn 3.56528e-14
* device instance $835 r0 *1 422.4,125.4 cap_mim_2f0_m4m5_noshield
C$835 \$82 topn 3.56528e-14
* device instance $836 r0 *1 2.6,131.8 cap_mim_2f0_m4m5_noshield
C$836 \$12 topp 3.56528e-14
* device instance $837 r0 *1 9,131.8 cap_mim_2f0_m4m5_noshield
C$837 vcm topp 3.56528e-14
* device instance $838 r0 *1 15.4,131.8 cap_mim_2f0_m4m5_noshield
C$838 \$12 topp 3.56528e-14
* device instance $839 r0 *1 21.8,131.8 cap_mim_2f0_m4m5_noshield
C$839 \$64 topp 3.56528e-14
* device instance $840 r0 *1 28.2,131.8 cap_mim_2f0_m4m5_noshield
C$840 \$12 topp 3.56528e-14
* device instance $841 r0 *1 34.6,131.8 cap_mim_2f0_m4m5_noshield
C$841 \$56 topp 3.56528e-14
* device instance $842 r0 *1 41,131.8 cap_mim_2f0_m4m5_noshield
C$842 \$12 topp 3.56528e-14
* device instance $843 r0 *1 47.4,131.8 cap_mim_2f0_m4m5_noshield
C$843 \$56 topp 3.56528e-14
* device instance $844 r0 *1 53.8,131.8 cap_mim_2f0_m4m5_noshield
C$844 \$12 topp 3.56528e-14
* device instance $845 r0 *1 60.2,131.8 cap_mim_2f0_m4m5_noshield
C$845 \$48 topp 3.56528e-14
* device instance $846 r0 *1 66.6,131.8 cap_mim_2f0_m4m5_noshield
C$846 \$12 topp 3.56528e-14
* device instance $847 r0 *1 73,131.8 cap_mim_2f0_m4m5_noshield
C$847 \$48 topp 3.56528e-14
* device instance $848 r0 *1 79.4,131.8 cap_mim_2f0_m4m5_noshield
C$848 \$12 topp 3.56528e-14
* device instance $849 r0 *1 85.8,131.8 cap_mim_2f0_m4m5_noshield
C$849 \$48 topp 3.56528e-14
* device instance $850 r0 *1 92.2,131.8 cap_mim_2f0_m4m5_noshield
C$850 \$12 topp 3.56528e-14
* device instance $851 r0 *1 98.6,131.8 cap_mim_2f0_m4m5_noshield
C$851 \$48 topp 3.56528e-14
* device instance $852 r0 *1 105,131.8 cap_mim_2f0_m4m5_noshield
C$852 \$12 topp 3.56528e-14
* device instance $853 r0 *1 111.4,131.8 cap_mim_2f0_m4m5_noshield
C$853 \$40 topp 3.56528e-14
* device instance $854 r0 *1 117.8,131.8 cap_mim_2f0_m4m5_noshield
C$854 \$12 topp 3.56528e-14
* device instance $855 r0 *1 124.2,131.8 cap_mim_2f0_m4m5_noshield
C$855 \$40 topp 3.56528e-14
* device instance $856 r0 *1 130.6,131.8 cap_mim_2f0_m4m5_noshield
C$856 \$12 topp 3.56528e-14
* device instance $857 r0 *1 137,131.8 cap_mim_2f0_m4m5_noshield
C$857 \$40 topp 3.56528e-14
* device instance $858 r0 *1 143.4,131.8 cap_mim_2f0_m4m5_noshield
C$858 \$12 topp 3.56528e-14
* device instance $859 r0 *1 149.8,131.8 cap_mim_2f0_m4m5_noshield
C$859 \$40 topp 3.56528e-14
* device instance $860 r0 *1 156.2,131.8 cap_mim_2f0_m4m5_noshield
C$860 \$12 topp 3.56528e-14
* device instance $861 r0 *1 162.6,131.8 cap_mim_2f0_m4m5_noshield
C$861 \$40 topp 3.56528e-14
* device instance $862 r0 *1 169,131.8 cap_mim_2f0_m4m5_noshield
C$862 \$12 topp 3.56528e-14
* device instance $863 r0 *1 175.4,131.8 cap_mim_2f0_m4m5_noshield
C$863 \$40 topp 3.56528e-14
* device instance $864 r0 *1 181.8,131.8 cap_mim_2f0_m4m5_noshield
C$864 \$12 topp 3.56528e-14
* device instance $865 r0 *1 188.2,131.8 cap_mim_2f0_m4m5_noshield
C$865 \$40 topp 3.56528e-14
* device instance $866 r0 *1 194.6,131.8 cap_mim_2f0_m4m5_noshield
C$866 \$12 topp 3.56528e-14
* device instance $867 r0 *1 201,131.8 cap_mim_2f0_m4m5_noshield
C$867 \$40 topp 3.56528e-14
* device instance $868 r0 *1 224,131.8 cap_mim_2f0_m4m5_noshield
C$868 \$82 topn 3.56528e-14
* device instance $869 r0 *1 230.4,131.8 cap_mim_2f0_m4m5_noshield
C$869 vcm topn 3.56528e-14
* device instance $870 r0 *1 236.8,131.8 cap_mim_2f0_m4m5_noshield
C$870 \$82 topn 3.56528e-14
* device instance $871 r0 *1 243.2,131.8 cap_mim_2f0_m4m5_noshield
C$871 \$88 topn 3.56528e-14
* device instance $872 r0 *1 249.6,131.8 cap_mim_2f0_m4m5_noshield
C$872 \$82 topn 3.56528e-14
* device instance $873 r0 *1 256,131.8 cap_mim_2f0_m4m5_noshield
C$873 \$87 topn 3.56528e-14
* device instance $874 r0 *1 262.4,131.8 cap_mim_2f0_m4m5_noshield
C$874 \$82 topn 3.56528e-14
* device instance $875 r0 *1 268.8,131.8 cap_mim_2f0_m4m5_noshield
C$875 \$87 topn 3.56528e-14
* device instance $876 r0 *1 275.2,131.8 cap_mim_2f0_m4m5_noshield
C$876 \$82 topn 3.56528e-14
* device instance $877 r0 *1 281.6,131.8 cap_mim_2f0_m4m5_noshield
C$877 \$86 topn 3.56528e-14
* device instance $878 r0 *1 288,131.8 cap_mim_2f0_m4m5_noshield
C$878 \$82 topn 3.56528e-14
* device instance $879 r0 *1 294.4,131.8 cap_mim_2f0_m4m5_noshield
C$879 \$86 topn 3.56528e-14
* device instance $880 r0 *1 300.8,131.8 cap_mim_2f0_m4m5_noshield
C$880 \$82 topn 3.56528e-14
* device instance $881 r0 *1 307.2,131.8 cap_mim_2f0_m4m5_noshield
C$881 \$86 topn 3.56528e-14
* device instance $882 r0 *1 313.6,131.8 cap_mim_2f0_m4m5_noshield
C$882 \$82 topn 3.56528e-14
* device instance $883 r0 *1 320,131.8 cap_mim_2f0_m4m5_noshield
C$883 \$86 topn 3.56528e-14
* device instance $884 r0 *1 326.4,131.8 cap_mim_2f0_m4m5_noshield
C$884 \$82 topn 3.56528e-14
* device instance $885 r0 *1 332.8,131.8 cap_mim_2f0_m4m5_noshield
C$885 \$85 topn 3.56528e-14
* device instance $886 r0 *1 339.2,131.8 cap_mim_2f0_m4m5_noshield
C$886 \$82 topn 3.56528e-14
* device instance $887 r0 *1 345.6,131.8 cap_mim_2f0_m4m5_noshield
C$887 \$85 topn 3.56528e-14
* device instance $888 r0 *1 352,131.8 cap_mim_2f0_m4m5_noshield
C$888 \$82 topn 3.56528e-14
* device instance $889 r0 *1 358.4,131.8 cap_mim_2f0_m4m5_noshield
C$889 \$85 topn 3.56528e-14
* device instance $890 r0 *1 364.8,131.8 cap_mim_2f0_m4m5_noshield
C$890 \$82 topn 3.56528e-14
* device instance $891 r0 *1 371.2,131.8 cap_mim_2f0_m4m5_noshield
C$891 \$85 topn 3.56528e-14
* device instance $892 r0 *1 377.6,131.8 cap_mim_2f0_m4m5_noshield
C$892 \$82 topn 3.56528e-14
* device instance $893 r0 *1 384,131.8 cap_mim_2f0_m4m5_noshield
C$893 \$85 topn 3.56528e-14
* device instance $894 r0 *1 390.4,131.8 cap_mim_2f0_m4m5_noshield
C$894 \$82 topn 3.56528e-14
* device instance $895 r0 *1 396.8,131.8 cap_mim_2f0_m4m5_noshield
C$895 \$85 topn 3.56528e-14
* device instance $896 r0 *1 403.2,131.8 cap_mim_2f0_m4m5_noshield
C$896 \$82 topn 3.56528e-14
* device instance $897 r0 *1 409.6,131.8 cap_mim_2f0_m4m5_noshield
C$897 \$85 topn 3.56528e-14
* device instance $898 r0 *1 416,131.8 cap_mim_2f0_m4m5_noshield
C$898 \$82 topn 3.56528e-14
* device instance $899 r0 *1 422.4,131.8 cap_mim_2f0_m4m5_noshield
C$899 \$85 topn 3.56528e-14
* device instance $900 r0 *1 2.6,138.2 cap_mim_2f0_m4m5_noshield
C$900 \$12 topp 3.56528e-14
* device instance $901 r0 *1 9,138.2 cap_mim_2f0_m4m5_noshield
C$901 \$32 topp 3.56528e-14
* device instance $902 r0 *1 15.4,138.2 cap_mim_2f0_m4m5_noshield
C$902 \$12 topp 3.56528e-14
* device instance $903 r0 *1 21.8,138.2 cap_mim_2f0_m4m5_noshield
C$903 \$32 topp 3.56528e-14
* device instance $904 r0 *1 28.2,138.2 cap_mim_2f0_m4m5_noshield
C$904 \$12 topp 3.56528e-14
* device instance $905 r0 *1 34.6,138.2 cap_mim_2f0_m4m5_noshield
C$905 \$32 topp 3.56528e-14
* device instance $906 r0 *1 41,138.2 cap_mim_2f0_m4m5_noshield
C$906 \$12 topp 3.56528e-14
* device instance $907 r0 *1 47.4,138.2 cap_mim_2f0_m4m5_noshield
C$907 \$32 topp 3.56528e-14
* device instance $908 r0 *1 53.8,138.2 cap_mim_2f0_m4m5_noshield
C$908 \$12 topp 3.56528e-14
* device instance $909 r0 *1 60.2,138.2 cap_mim_2f0_m4m5_noshield
C$909 \$32 topp 3.56528e-14
* device instance $910 r0 *1 66.6,138.2 cap_mim_2f0_m4m5_noshield
C$910 \$12 topp 3.56528e-14
* device instance $911 r0 *1 73,138.2 cap_mim_2f0_m4m5_noshield
C$911 \$32 topp 3.56528e-14
* device instance $912 r0 *1 79.4,138.2 cap_mim_2f0_m4m5_noshield
C$912 \$12 topp 3.56528e-14
* device instance $913 r0 *1 85.8,138.2 cap_mim_2f0_m4m5_noshield
C$913 \$32 topp 3.56528e-14
* device instance $914 r0 *1 92.2,138.2 cap_mim_2f0_m4m5_noshield
C$914 \$12 topp 3.56528e-14
* device instance $915 r0 *1 98.6,138.2 cap_mim_2f0_m4m5_noshield
C$915 \$32 topp 3.56528e-14
* device instance $916 r0 *1 105,138.2 cap_mim_2f0_m4m5_noshield
C$916 \$12 topp 3.56528e-14
* device instance $917 r0 *1 111.4,138.2 cap_mim_2f0_m4m5_noshield
C$917 \$32 topp 3.56528e-14
* device instance $918 r0 *1 117.8,138.2 cap_mim_2f0_m4m5_noshield
C$918 \$12 topp 3.56528e-14
* device instance $919 r0 *1 124.2,138.2 cap_mim_2f0_m4m5_noshield
C$919 \$32 topp 3.56528e-14
* device instance $920 r0 *1 130.6,138.2 cap_mim_2f0_m4m5_noshield
C$920 \$12 topp 3.56528e-14
* device instance $921 r0 *1 137,138.2 cap_mim_2f0_m4m5_noshield
C$921 \$32 topp 3.56528e-14
* device instance $922 r0 *1 143.4,138.2 cap_mim_2f0_m4m5_noshield
C$922 \$12 topp 3.56528e-14
* device instance $923 r0 *1 149.8,138.2 cap_mim_2f0_m4m5_noshield
C$923 \$32 topp 3.56528e-14
* device instance $924 r0 *1 156.2,138.2 cap_mim_2f0_m4m5_noshield
C$924 \$12 topp 3.56528e-14
* device instance $925 r0 *1 162.6,138.2 cap_mim_2f0_m4m5_noshield
C$925 \$32 topp 3.56528e-14
* device instance $926 r0 *1 169,138.2 cap_mim_2f0_m4m5_noshield
C$926 \$12 topp 3.56528e-14
* device instance $927 r0 *1 175.4,138.2 cap_mim_2f0_m4m5_noshield
C$927 \$32 topp 3.56528e-14
* device instance $928 r0 *1 181.8,138.2 cap_mim_2f0_m4m5_noshield
C$928 \$12 topp 3.56528e-14
* device instance $929 r0 *1 188.2,138.2 cap_mim_2f0_m4m5_noshield
C$929 \$32 topp 3.56528e-14
* device instance $930 r0 *1 194.6,138.2 cap_mim_2f0_m4m5_noshield
C$930 \$12 topp 3.56528e-14
* device instance $931 r0 *1 201,138.2 cap_mim_2f0_m4m5_noshield
C$931 \$32 topp 3.56528e-14
* device instance $932 r0 *1 224,138.2 cap_mim_2f0_m4m5_noshield
C$932 \$82 topn 3.56528e-14
* device instance $933 r0 *1 230.4,138.2 cap_mim_2f0_m4m5_noshield
C$933 \$84 topn 3.56528e-14
* device instance $934 r0 *1 236.8,138.2 cap_mim_2f0_m4m5_noshield
C$934 \$82 topn 3.56528e-14
* device instance $935 r0 *1 243.2,138.2 cap_mim_2f0_m4m5_noshield
C$935 \$84 topn 3.56528e-14
* device instance $936 r0 *1 249.6,138.2 cap_mim_2f0_m4m5_noshield
C$936 \$82 topn 3.56528e-14
* device instance $937 r0 *1 256,138.2 cap_mim_2f0_m4m5_noshield
C$937 \$84 topn 3.56528e-14
* device instance $938 r0 *1 262.4,138.2 cap_mim_2f0_m4m5_noshield
C$938 \$82 topn 3.56528e-14
* device instance $939 r0 *1 268.8,138.2 cap_mim_2f0_m4m5_noshield
C$939 \$84 topn 3.56528e-14
* device instance $940 r0 *1 275.2,138.2 cap_mim_2f0_m4m5_noshield
C$940 \$82 topn 3.56528e-14
* device instance $941 r0 *1 281.6,138.2 cap_mim_2f0_m4m5_noshield
C$941 \$84 topn 3.56528e-14
* device instance $942 r0 *1 288,138.2 cap_mim_2f0_m4m5_noshield
C$942 \$82 topn 3.56528e-14
* device instance $943 r0 *1 294.4,138.2 cap_mim_2f0_m4m5_noshield
C$943 \$84 topn 3.56528e-14
* device instance $944 r0 *1 300.8,138.2 cap_mim_2f0_m4m5_noshield
C$944 \$82 topn 3.56528e-14
* device instance $945 r0 *1 307.2,138.2 cap_mim_2f0_m4m5_noshield
C$945 \$84 topn 3.56528e-14
* device instance $946 r0 *1 313.6,138.2 cap_mim_2f0_m4m5_noshield
C$946 \$82 topn 3.56528e-14
* device instance $947 r0 *1 320,138.2 cap_mim_2f0_m4m5_noshield
C$947 \$84 topn 3.56528e-14
* device instance $948 r0 *1 326.4,138.2 cap_mim_2f0_m4m5_noshield
C$948 \$82 topn 3.56528e-14
* device instance $949 r0 *1 332.8,138.2 cap_mim_2f0_m4m5_noshield
C$949 \$84 topn 3.56528e-14
* device instance $950 r0 *1 339.2,138.2 cap_mim_2f0_m4m5_noshield
C$950 \$82 topn 3.56528e-14
* device instance $951 r0 *1 345.6,138.2 cap_mim_2f0_m4m5_noshield
C$951 \$84 topn 3.56528e-14
* device instance $952 r0 *1 352,138.2 cap_mim_2f0_m4m5_noshield
C$952 \$82 topn 3.56528e-14
* device instance $953 r0 *1 358.4,138.2 cap_mim_2f0_m4m5_noshield
C$953 \$84 topn 3.56528e-14
* device instance $954 r0 *1 364.8,138.2 cap_mim_2f0_m4m5_noshield
C$954 \$82 topn 3.56528e-14
* device instance $955 r0 *1 371.2,138.2 cap_mim_2f0_m4m5_noshield
C$955 \$84 topn 3.56528e-14
* device instance $956 r0 *1 377.6,138.2 cap_mim_2f0_m4m5_noshield
C$956 \$82 topn 3.56528e-14
* device instance $957 r0 *1 384,138.2 cap_mim_2f0_m4m5_noshield
C$957 \$84 topn 3.56528e-14
* device instance $958 r0 *1 390.4,138.2 cap_mim_2f0_m4m5_noshield
C$958 \$82 topn 3.56528e-14
* device instance $959 r0 *1 396.8,138.2 cap_mim_2f0_m4m5_noshield
C$959 \$84 topn 3.56528e-14
* device instance $960 r0 *1 403.2,138.2 cap_mim_2f0_m4m5_noshield
C$960 \$82 topn 3.56528e-14
* device instance $961 r0 *1 409.6,138.2 cap_mim_2f0_m4m5_noshield
C$961 \$84 topn 3.56528e-14
* device instance $962 r0 *1 416,138.2 cap_mim_2f0_m4m5_noshield
C$962 \$82 topn 3.56528e-14
* device instance $963 r0 *1 422.4,138.2 cap_mim_2f0_m4m5_noshield
C$963 \$84 topn 3.56528e-14
* device instance $964 r0 *1 2.6,144.6 cap_mim_2f0_m4m5_noshield
C$964 \$12 topp 3.56528e-14
* device instance $965 r0 *1 9,144.6 cap_mim_2f0_m4m5_noshield
C$965 \$24 topp 3.56528e-14
* device instance $966 r0 *1 15.4,144.6 cap_mim_2f0_m4m5_noshield
C$966 \$12 topp 3.56528e-14
* device instance $967 r0 *1 21.8,144.6 cap_mim_2f0_m4m5_noshield
C$967 \$24 topp 3.56528e-14
* device instance $968 r0 *1 28.2,144.6 cap_mim_2f0_m4m5_noshield
C$968 \$12 topp 3.56528e-14
* device instance $969 r0 *1 34.6,144.6 cap_mim_2f0_m4m5_noshield
C$969 \$24 topp 3.56528e-14
* device instance $970 r0 *1 41,144.6 cap_mim_2f0_m4m5_noshield
C$970 \$12 topp 3.56528e-14
* device instance $971 r0 *1 47.4,144.6 cap_mim_2f0_m4m5_noshield
C$971 \$24 topp 3.56528e-14
* device instance $972 r0 *1 53.8,144.6 cap_mim_2f0_m4m5_noshield
C$972 \$12 topp 3.56528e-14
* device instance $973 r0 *1 60.2,144.6 cap_mim_2f0_m4m5_noshield
C$973 \$24 topp 3.56528e-14
* device instance $974 r0 *1 66.6,144.6 cap_mim_2f0_m4m5_noshield
C$974 \$12 topp 3.56528e-14
* device instance $975 r0 *1 73,144.6 cap_mim_2f0_m4m5_noshield
C$975 \$24 topp 3.56528e-14
* device instance $976 r0 *1 79.4,144.6 cap_mim_2f0_m4m5_noshield
C$976 \$12 topp 3.56528e-14
* device instance $977 r0 *1 85.8,144.6 cap_mim_2f0_m4m5_noshield
C$977 \$24 topp 3.56528e-14
* device instance $978 r0 *1 92.2,144.6 cap_mim_2f0_m4m5_noshield
C$978 \$12 topp 3.56528e-14
* device instance $979 r0 *1 98.6,144.6 cap_mim_2f0_m4m5_noshield
C$979 \$24 topp 3.56528e-14
* device instance $980 r0 *1 105,144.6 cap_mim_2f0_m4m5_noshield
C$980 \$12 topp 3.56528e-14
* device instance $981 r0 *1 111.4,144.6 cap_mim_2f0_m4m5_noshield
C$981 \$24 topp 3.56528e-14
* device instance $982 r0 *1 117.8,144.6 cap_mim_2f0_m4m5_noshield
C$982 \$12 topp 3.56528e-14
* device instance $983 r0 *1 124.2,144.6 cap_mim_2f0_m4m5_noshield
C$983 \$24 topp 3.56528e-14
* device instance $984 r0 *1 130.6,144.6 cap_mim_2f0_m4m5_noshield
C$984 \$12 topp 3.56528e-14
* device instance $985 r0 *1 137,144.6 cap_mim_2f0_m4m5_noshield
C$985 \$24 topp 3.56528e-14
* device instance $986 r0 *1 143.4,144.6 cap_mim_2f0_m4m5_noshield
C$986 \$12 topp 3.56528e-14
* device instance $987 r0 *1 149.8,144.6 cap_mim_2f0_m4m5_noshield
C$987 \$24 topp 3.56528e-14
* device instance $988 r0 *1 156.2,144.6 cap_mim_2f0_m4m5_noshield
C$988 \$12 topp 3.56528e-14
* device instance $989 r0 *1 162.6,144.6 cap_mim_2f0_m4m5_noshield
C$989 \$24 topp 3.56528e-14
* device instance $990 r0 *1 169,144.6 cap_mim_2f0_m4m5_noshield
C$990 \$12 topp 3.56528e-14
* device instance $991 r0 *1 175.4,144.6 cap_mim_2f0_m4m5_noshield
C$991 \$24 topp 3.56528e-14
* device instance $992 r0 *1 181.8,144.6 cap_mim_2f0_m4m5_noshield
C$992 \$12 topp 3.56528e-14
* device instance $993 r0 *1 188.2,144.6 cap_mim_2f0_m4m5_noshield
C$993 \$24 topp 3.56528e-14
* device instance $994 r0 *1 194.6,144.6 cap_mim_2f0_m4m5_noshield
C$994 \$12 topp 3.56528e-14
* device instance $995 r0 *1 201,144.6 cap_mim_2f0_m4m5_noshield
C$995 \$24 topp 3.56528e-14
* device instance $996 r0 *1 224,144.6 cap_mim_2f0_m4m5_noshield
C$996 \$82 topn 3.56528e-14
* device instance $997 r0 *1 230.4,144.6 cap_mim_2f0_m4m5_noshield
C$997 \$83 topn 3.56528e-14
* device instance $998 r0 *1 236.8,144.6 cap_mim_2f0_m4m5_noshield
C$998 \$82 topn 3.56528e-14
* device instance $999 r0 *1 243.2,144.6 cap_mim_2f0_m4m5_noshield
C$999 \$83 topn 3.56528e-14
* device instance $1000 r0 *1 249.6,144.6 cap_mim_2f0_m4m5_noshield
C$1000 \$82 topn 3.56528e-14
* device instance $1001 r0 *1 256,144.6 cap_mim_2f0_m4m5_noshield
C$1001 \$83 topn 3.56528e-14
* device instance $1002 r0 *1 262.4,144.6 cap_mim_2f0_m4m5_noshield
C$1002 \$82 topn 3.56528e-14
* device instance $1003 r0 *1 268.8,144.6 cap_mim_2f0_m4m5_noshield
C$1003 \$83 topn 3.56528e-14
* device instance $1004 r0 *1 275.2,144.6 cap_mim_2f0_m4m5_noshield
C$1004 \$82 topn 3.56528e-14
* device instance $1005 r0 *1 281.6,144.6 cap_mim_2f0_m4m5_noshield
C$1005 \$83 topn 3.56528e-14
* device instance $1006 r0 *1 288,144.6 cap_mim_2f0_m4m5_noshield
C$1006 \$82 topn 3.56528e-14
* device instance $1007 r0 *1 294.4,144.6 cap_mim_2f0_m4m5_noshield
C$1007 \$83 topn 3.56528e-14
* device instance $1008 r0 *1 300.8,144.6 cap_mim_2f0_m4m5_noshield
C$1008 \$82 topn 3.56528e-14
* device instance $1009 r0 *1 307.2,144.6 cap_mim_2f0_m4m5_noshield
C$1009 \$83 topn 3.56528e-14
* device instance $1010 r0 *1 313.6,144.6 cap_mim_2f0_m4m5_noshield
C$1010 \$82 topn 3.56528e-14
* device instance $1011 r0 *1 320,144.6 cap_mim_2f0_m4m5_noshield
C$1011 \$83 topn 3.56528e-14
* device instance $1012 r0 *1 326.4,144.6 cap_mim_2f0_m4m5_noshield
C$1012 \$82 topn 3.56528e-14
* device instance $1013 r0 *1 332.8,144.6 cap_mim_2f0_m4m5_noshield
C$1013 \$83 topn 3.56528e-14
* device instance $1014 r0 *1 339.2,144.6 cap_mim_2f0_m4m5_noshield
C$1014 \$82 topn 3.56528e-14
* device instance $1015 r0 *1 345.6,144.6 cap_mim_2f0_m4m5_noshield
C$1015 \$83 topn 3.56528e-14
* device instance $1016 r0 *1 352,144.6 cap_mim_2f0_m4m5_noshield
C$1016 \$82 topn 3.56528e-14
* device instance $1017 r0 *1 358.4,144.6 cap_mim_2f0_m4m5_noshield
C$1017 \$83 topn 3.56528e-14
* device instance $1018 r0 *1 364.8,144.6 cap_mim_2f0_m4m5_noshield
C$1018 \$82 topn 3.56528e-14
* device instance $1019 r0 *1 371.2,144.6 cap_mim_2f0_m4m5_noshield
C$1019 \$83 topn 3.56528e-14
* device instance $1020 r0 *1 377.6,144.6 cap_mim_2f0_m4m5_noshield
C$1020 \$82 topn 3.56528e-14
* device instance $1021 r0 *1 384,144.6 cap_mim_2f0_m4m5_noshield
C$1021 \$83 topn 3.56528e-14
* device instance $1022 r0 *1 390.4,144.6 cap_mim_2f0_m4m5_noshield
C$1022 \$82 topn 3.56528e-14
* device instance $1023 r0 *1 396.8,144.6 cap_mim_2f0_m4m5_noshield
C$1023 \$83 topn 3.56528e-14
* device instance $1024 r0 *1 403.2,144.6 cap_mim_2f0_m4m5_noshield
C$1024 \$82 topn 3.56528e-14
* device instance $1025 r0 *1 409.6,144.6 cap_mim_2f0_m4m5_noshield
C$1025 \$83 topn 3.56528e-14
* device instance $1026 r0 *1 416,144.6 cap_mim_2f0_m4m5_noshield
C$1026 \$82 topn 3.56528e-14
* device instance $1027 r0 *1 422.4,144.6 cap_mim_2f0_m4m5_noshield
C$1027 \$83 topn 3.56528e-14
* device instance $1028 r0 *1 2.6,151 cap_mim_2f0_m4m5_noshield
C$1028 \$12 topp 3.56528e-14
* device instance $1029 r0 *1 9,151 cap_mim_2f0_m4m5_noshield
C$1029 \$24 topp 3.56528e-14
* device instance $1030 r0 *1 15.4,151 cap_mim_2f0_m4m5_noshield
C$1030 \$12 topp 3.56528e-14
* device instance $1031 r0 *1 21.8,151 cap_mim_2f0_m4m5_noshield
C$1031 \$24 topp 3.56528e-14
* device instance $1032 r0 *1 28.2,151 cap_mim_2f0_m4m5_noshield
C$1032 \$12 topp 3.56528e-14
* device instance $1033 r0 *1 34.6,151 cap_mim_2f0_m4m5_noshield
C$1033 \$24 topp 3.56528e-14
* device instance $1034 r0 *1 41,151 cap_mim_2f0_m4m5_noshield
C$1034 \$12 topp 3.56528e-14
* device instance $1035 r0 *1 47.4,151 cap_mim_2f0_m4m5_noshield
C$1035 \$24 topp 3.56528e-14
* device instance $1036 r0 *1 53.8,151 cap_mim_2f0_m4m5_noshield
C$1036 \$12 topp 3.56528e-14
* device instance $1037 r0 *1 60.2,151 cap_mim_2f0_m4m5_noshield
C$1037 \$24 topp 3.56528e-14
* device instance $1038 r0 *1 66.6,151 cap_mim_2f0_m4m5_noshield
C$1038 \$12 topp 3.56528e-14
* device instance $1039 r0 *1 73,151 cap_mim_2f0_m4m5_noshield
C$1039 \$24 topp 3.56528e-14
* device instance $1040 r0 *1 79.4,151 cap_mim_2f0_m4m5_noshield
C$1040 \$12 topp 3.56528e-14
* device instance $1041 r0 *1 85.8,151 cap_mim_2f0_m4m5_noshield
C$1041 \$24 topp 3.56528e-14
* device instance $1042 r0 *1 92.2,151 cap_mim_2f0_m4m5_noshield
C$1042 \$12 topp 3.56528e-14
* device instance $1043 r0 *1 98.6,151 cap_mim_2f0_m4m5_noshield
C$1043 \$24 topp 3.56528e-14
* device instance $1044 r0 *1 105,151 cap_mim_2f0_m4m5_noshield
C$1044 \$12 topp 3.56528e-14
* device instance $1045 r0 *1 111.4,151 cap_mim_2f0_m4m5_noshield
C$1045 \$24 topp 3.56528e-14
* device instance $1046 r0 *1 117.8,151 cap_mim_2f0_m4m5_noshield
C$1046 \$12 topp 3.56528e-14
* device instance $1047 r0 *1 124.2,151 cap_mim_2f0_m4m5_noshield
C$1047 \$24 topp 3.56528e-14
* device instance $1048 r0 *1 130.6,151 cap_mim_2f0_m4m5_noshield
C$1048 \$12 topp 3.56528e-14
* device instance $1049 r0 *1 137,151 cap_mim_2f0_m4m5_noshield
C$1049 \$24 topp 3.56528e-14
* device instance $1050 r0 *1 143.4,151 cap_mim_2f0_m4m5_noshield
C$1050 \$12 topp 3.56528e-14
* device instance $1051 r0 *1 149.8,151 cap_mim_2f0_m4m5_noshield
C$1051 \$24 topp 3.56528e-14
* device instance $1052 r0 *1 156.2,151 cap_mim_2f0_m4m5_noshield
C$1052 \$12 topp 3.56528e-14
* device instance $1053 r0 *1 162.6,151 cap_mim_2f0_m4m5_noshield
C$1053 \$24 topp 3.56528e-14
* device instance $1054 r0 *1 169,151 cap_mim_2f0_m4m5_noshield
C$1054 \$12 topp 3.56528e-14
* device instance $1055 r0 *1 175.4,151 cap_mim_2f0_m4m5_noshield
C$1055 \$24 topp 3.56528e-14
* device instance $1056 r0 *1 181.8,151 cap_mim_2f0_m4m5_noshield
C$1056 \$12 topp 3.56528e-14
* device instance $1057 r0 *1 188.2,151 cap_mim_2f0_m4m5_noshield
C$1057 \$24 topp 3.56528e-14
* device instance $1058 r0 *1 194.6,151 cap_mim_2f0_m4m5_noshield
C$1058 \$12 topp 3.56528e-14
* device instance $1059 r0 *1 201,151 cap_mim_2f0_m4m5_noshield
C$1059 \$24 topp 3.56528e-14
* device instance $1060 r0 *1 224,151 cap_mim_2f0_m4m5_noshield
C$1060 \$82 topn 3.56528e-14
* device instance $1061 r0 *1 230.4,151 cap_mim_2f0_m4m5_noshield
C$1061 \$83 topn 3.56528e-14
* device instance $1062 r0 *1 236.8,151 cap_mim_2f0_m4m5_noshield
C$1062 \$82 topn 3.56528e-14
* device instance $1063 r0 *1 243.2,151 cap_mim_2f0_m4m5_noshield
C$1063 \$83 topn 3.56528e-14
* device instance $1064 r0 *1 249.6,151 cap_mim_2f0_m4m5_noshield
C$1064 \$82 topn 3.56528e-14
* device instance $1065 r0 *1 256,151 cap_mim_2f0_m4m5_noshield
C$1065 \$83 topn 3.56528e-14
* device instance $1066 r0 *1 262.4,151 cap_mim_2f0_m4m5_noshield
C$1066 \$82 topn 3.56528e-14
* device instance $1067 r0 *1 268.8,151 cap_mim_2f0_m4m5_noshield
C$1067 \$83 topn 3.56528e-14
* device instance $1068 r0 *1 275.2,151 cap_mim_2f0_m4m5_noshield
C$1068 \$82 topn 3.56528e-14
* device instance $1069 r0 *1 281.6,151 cap_mim_2f0_m4m5_noshield
C$1069 \$83 topn 3.56528e-14
* device instance $1070 r0 *1 288,151 cap_mim_2f0_m4m5_noshield
C$1070 \$82 topn 3.56528e-14
* device instance $1071 r0 *1 294.4,151 cap_mim_2f0_m4m5_noshield
C$1071 \$83 topn 3.56528e-14
* device instance $1072 r0 *1 300.8,151 cap_mim_2f0_m4m5_noshield
C$1072 \$82 topn 3.56528e-14
* device instance $1073 r0 *1 307.2,151 cap_mim_2f0_m4m5_noshield
C$1073 \$83 topn 3.56528e-14
* device instance $1074 r0 *1 313.6,151 cap_mim_2f0_m4m5_noshield
C$1074 \$82 topn 3.56528e-14
* device instance $1075 r0 *1 320,151 cap_mim_2f0_m4m5_noshield
C$1075 \$83 topn 3.56528e-14
* device instance $1076 r0 *1 326.4,151 cap_mim_2f0_m4m5_noshield
C$1076 \$82 topn 3.56528e-14
* device instance $1077 r0 *1 332.8,151 cap_mim_2f0_m4m5_noshield
C$1077 \$83 topn 3.56528e-14
* device instance $1078 r0 *1 339.2,151 cap_mim_2f0_m4m5_noshield
C$1078 \$82 topn 3.56528e-14
* device instance $1079 r0 *1 345.6,151 cap_mim_2f0_m4m5_noshield
C$1079 \$83 topn 3.56528e-14
* device instance $1080 r0 *1 352,151 cap_mim_2f0_m4m5_noshield
C$1080 \$82 topn 3.56528e-14
* device instance $1081 r0 *1 358.4,151 cap_mim_2f0_m4m5_noshield
C$1081 \$83 topn 3.56528e-14
* device instance $1082 r0 *1 364.8,151 cap_mim_2f0_m4m5_noshield
C$1082 \$82 topn 3.56528e-14
* device instance $1083 r0 *1 371.2,151 cap_mim_2f0_m4m5_noshield
C$1083 \$83 topn 3.56528e-14
* device instance $1084 r0 *1 377.6,151 cap_mim_2f0_m4m5_noshield
C$1084 \$82 topn 3.56528e-14
* device instance $1085 r0 *1 384,151 cap_mim_2f0_m4m5_noshield
C$1085 \$83 topn 3.56528e-14
* device instance $1086 r0 *1 390.4,151 cap_mim_2f0_m4m5_noshield
C$1086 \$82 topn 3.56528e-14
* device instance $1087 r0 *1 396.8,151 cap_mim_2f0_m4m5_noshield
C$1087 \$83 topn 3.56528e-14
* device instance $1088 r0 *1 403.2,151 cap_mim_2f0_m4m5_noshield
C$1088 \$82 topn 3.56528e-14
* device instance $1089 r0 *1 409.6,151 cap_mim_2f0_m4m5_noshield
C$1089 \$83 topn 3.56528e-14
* device instance $1090 r0 *1 416,151 cap_mim_2f0_m4m5_noshield
C$1090 \$82 topn 3.56528e-14
* device instance $1091 r0 *1 422.4,151 cap_mim_2f0_m4m5_noshield
C$1091 \$83 topn 3.56528e-14
* device instance $1092 r0 *1 2.6,157.4 cap_mim_2f0_m4m5_noshield
C$1092 \$24 topp 3.56528e-14
* device instance $1093 r0 *1 9,157.4 cap_mim_2f0_m4m5_noshield
C$1093 \$12 topp 3.56528e-14
* device instance $1094 r0 *1 15.4,157.4 cap_mim_2f0_m4m5_noshield
C$1094 \$24 topp 3.56528e-14
* device instance $1095 r0 *1 21.8,157.4 cap_mim_2f0_m4m5_noshield
C$1095 \$12 topp 3.56528e-14
* device instance $1096 r0 *1 28.2,157.4 cap_mim_2f0_m4m5_noshield
C$1096 \$24 topp 3.56528e-14
* device instance $1097 r0 *1 34.6,157.4 cap_mim_2f0_m4m5_noshield
C$1097 \$12 topp 3.56528e-14
* device instance $1098 r0 *1 41,157.4 cap_mim_2f0_m4m5_noshield
C$1098 \$24 topp 3.56528e-14
* device instance $1099 r0 *1 47.4,157.4 cap_mim_2f0_m4m5_noshield
C$1099 \$12 topp 3.56528e-14
* device instance $1100 r0 *1 53.8,157.4 cap_mim_2f0_m4m5_noshield
C$1100 \$24 topp 3.56528e-14
* device instance $1101 r0 *1 60.2,157.4 cap_mim_2f0_m4m5_noshield
C$1101 \$12 topp 3.56528e-14
* device instance $1102 r0 *1 66.6,157.4 cap_mim_2f0_m4m5_noshield
C$1102 \$24 topp 3.56528e-14
* device instance $1103 r0 *1 73,157.4 cap_mim_2f0_m4m5_noshield
C$1103 \$12 topp 3.56528e-14
* device instance $1104 r0 *1 79.4,157.4 cap_mim_2f0_m4m5_noshield
C$1104 \$24 topp 3.56528e-14
* device instance $1105 r0 *1 85.8,157.4 cap_mim_2f0_m4m5_noshield
C$1105 \$12 topp 3.56528e-14
* device instance $1106 r0 *1 92.2,157.4 cap_mim_2f0_m4m5_noshield
C$1106 \$24 topp 3.56528e-14
* device instance $1107 r0 *1 98.6,157.4 cap_mim_2f0_m4m5_noshield
C$1107 \$12 topp 3.56528e-14
* device instance $1108 r0 *1 105,157.4 cap_mim_2f0_m4m5_noshield
C$1108 \$24 topp 3.56528e-14
* device instance $1109 r0 *1 111.4,157.4 cap_mim_2f0_m4m5_noshield
C$1109 \$12 topp 3.56528e-14
* device instance $1110 r0 *1 117.8,157.4 cap_mim_2f0_m4m5_noshield
C$1110 \$24 topp 3.56528e-14
* device instance $1111 r0 *1 124.2,157.4 cap_mim_2f0_m4m5_noshield
C$1111 \$12 topp 3.56528e-14
* device instance $1112 r0 *1 130.6,157.4 cap_mim_2f0_m4m5_noshield
C$1112 \$24 topp 3.56528e-14
* device instance $1113 r0 *1 137,157.4 cap_mim_2f0_m4m5_noshield
C$1113 \$12 topp 3.56528e-14
* device instance $1114 r0 *1 143.4,157.4 cap_mim_2f0_m4m5_noshield
C$1114 \$24 topp 3.56528e-14
* device instance $1115 r0 *1 149.8,157.4 cap_mim_2f0_m4m5_noshield
C$1115 \$12 topp 3.56528e-14
* device instance $1116 r0 *1 156.2,157.4 cap_mim_2f0_m4m5_noshield
C$1116 \$24 topp 3.56528e-14
* device instance $1117 r0 *1 162.6,157.4 cap_mim_2f0_m4m5_noshield
C$1117 \$12 topp 3.56528e-14
* device instance $1118 r0 *1 169,157.4 cap_mim_2f0_m4m5_noshield
C$1118 \$24 topp 3.56528e-14
* device instance $1119 r0 *1 175.4,157.4 cap_mim_2f0_m4m5_noshield
C$1119 \$12 topp 3.56528e-14
* device instance $1120 r0 *1 181.8,157.4 cap_mim_2f0_m4m5_noshield
C$1120 \$24 topp 3.56528e-14
* device instance $1121 r0 *1 188.2,157.4 cap_mim_2f0_m4m5_noshield
C$1121 \$12 topp 3.56528e-14
* device instance $1122 r0 *1 194.6,157.4 cap_mim_2f0_m4m5_noshield
C$1122 \$24 topp 3.56528e-14
* device instance $1123 r0 *1 201,157.4 cap_mim_2f0_m4m5_noshield
C$1123 \$12 topp 3.56528e-14
* device instance $1124 r0 *1 224,157.4 cap_mim_2f0_m4m5_noshield
C$1124 \$83 topn 3.56528e-14
* device instance $1125 r0 *1 230.4,157.4 cap_mim_2f0_m4m5_noshield
C$1125 \$82 topn 3.56528e-14
* device instance $1126 r0 *1 236.8,157.4 cap_mim_2f0_m4m5_noshield
C$1126 \$83 topn 3.56528e-14
* device instance $1127 r0 *1 243.2,157.4 cap_mim_2f0_m4m5_noshield
C$1127 \$82 topn 3.56528e-14
* device instance $1128 r0 *1 249.6,157.4 cap_mim_2f0_m4m5_noshield
C$1128 \$83 topn 3.56528e-14
* device instance $1129 r0 *1 256,157.4 cap_mim_2f0_m4m5_noshield
C$1129 \$82 topn 3.56528e-14
* device instance $1130 r0 *1 262.4,157.4 cap_mim_2f0_m4m5_noshield
C$1130 \$83 topn 3.56528e-14
* device instance $1131 r0 *1 268.8,157.4 cap_mim_2f0_m4m5_noshield
C$1131 \$82 topn 3.56528e-14
* device instance $1132 r0 *1 275.2,157.4 cap_mim_2f0_m4m5_noshield
C$1132 \$83 topn 3.56528e-14
* device instance $1133 r0 *1 281.6,157.4 cap_mim_2f0_m4m5_noshield
C$1133 \$82 topn 3.56528e-14
* device instance $1134 r0 *1 288,157.4 cap_mim_2f0_m4m5_noshield
C$1134 \$83 topn 3.56528e-14
* device instance $1135 r0 *1 294.4,157.4 cap_mim_2f0_m4m5_noshield
C$1135 \$82 topn 3.56528e-14
* device instance $1136 r0 *1 300.8,157.4 cap_mim_2f0_m4m5_noshield
C$1136 \$83 topn 3.56528e-14
* device instance $1137 r0 *1 307.2,157.4 cap_mim_2f0_m4m5_noshield
C$1137 \$82 topn 3.56528e-14
* device instance $1138 r0 *1 313.6,157.4 cap_mim_2f0_m4m5_noshield
C$1138 \$83 topn 3.56528e-14
* device instance $1139 r0 *1 320,157.4 cap_mim_2f0_m4m5_noshield
C$1139 \$82 topn 3.56528e-14
* device instance $1140 r0 *1 326.4,157.4 cap_mim_2f0_m4m5_noshield
C$1140 \$83 topn 3.56528e-14
* device instance $1141 r0 *1 332.8,157.4 cap_mim_2f0_m4m5_noshield
C$1141 \$82 topn 3.56528e-14
* device instance $1142 r0 *1 339.2,157.4 cap_mim_2f0_m4m5_noshield
C$1142 \$83 topn 3.56528e-14
* device instance $1143 r0 *1 345.6,157.4 cap_mim_2f0_m4m5_noshield
C$1143 \$82 topn 3.56528e-14
* device instance $1144 r0 *1 352,157.4 cap_mim_2f0_m4m5_noshield
C$1144 \$83 topn 3.56528e-14
* device instance $1145 r0 *1 358.4,157.4 cap_mim_2f0_m4m5_noshield
C$1145 \$82 topn 3.56528e-14
* device instance $1146 r0 *1 364.8,157.4 cap_mim_2f0_m4m5_noshield
C$1146 \$83 topn 3.56528e-14
* device instance $1147 r0 *1 371.2,157.4 cap_mim_2f0_m4m5_noshield
C$1147 \$82 topn 3.56528e-14
* device instance $1148 r0 *1 377.6,157.4 cap_mim_2f0_m4m5_noshield
C$1148 \$83 topn 3.56528e-14
* device instance $1149 r0 *1 384,157.4 cap_mim_2f0_m4m5_noshield
C$1149 \$82 topn 3.56528e-14
* device instance $1150 r0 *1 390.4,157.4 cap_mim_2f0_m4m5_noshield
C$1150 \$83 topn 3.56528e-14
* device instance $1151 r0 *1 396.8,157.4 cap_mim_2f0_m4m5_noshield
C$1151 \$82 topn 3.56528e-14
* device instance $1152 r0 *1 403.2,157.4 cap_mim_2f0_m4m5_noshield
C$1152 \$83 topn 3.56528e-14
* device instance $1153 r0 *1 409.6,157.4 cap_mim_2f0_m4m5_noshield
C$1153 \$82 topn 3.56528e-14
* device instance $1154 r0 *1 416,157.4 cap_mim_2f0_m4m5_noshield
C$1154 \$83 topn 3.56528e-14
* device instance $1155 r0 *1 422.4,157.4 cap_mim_2f0_m4m5_noshield
C$1155 \$82 topn 3.56528e-14
* device instance $1156 r0 *1 2.6,163.8 cap_mim_2f0_m4m5_noshield
C$1156 \$24 topp 3.56528e-14
* device instance $1157 r0 *1 9,163.8 cap_mim_2f0_m4m5_noshield
C$1157 \$12 topp 3.56528e-14
* device instance $1158 r0 *1 15.4,163.8 cap_mim_2f0_m4m5_noshield
C$1158 \$24 topp 3.56528e-14
* device instance $1159 r0 *1 21.8,163.8 cap_mim_2f0_m4m5_noshield
C$1159 \$12 topp 3.56528e-14
* device instance $1160 r0 *1 28.2,163.8 cap_mim_2f0_m4m5_noshield
C$1160 \$24 topp 3.56528e-14
* device instance $1161 r0 *1 34.6,163.8 cap_mim_2f0_m4m5_noshield
C$1161 \$12 topp 3.56528e-14
* device instance $1162 r0 *1 41,163.8 cap_mim_2f0_m4m5_noshield
C$1162 \$24 topp 3.56528e-14
* device instance $1163 r0 *1 47.4,163.8 cap_mim_2f0_m4m5_noshield
C$1163 \$12 topp 3.56528e-14
* device instance $1164 r0 *1 53.8,163.8 cap_mim_2f0_m4m5_noshield
C$1164 \$24 topp 3.56528e-14
* device instance $1165 r0 *1 60.2,163.8 cap_mim_2f0_m4m5_noshield
C$1165 \$12 topp 3.56528e-14
* device instance $1166 r0 *1 66.6,163.8 cap_mim_2f0_m4m5_noshield
C$1166 \$24 topp 3.56528e-14
* device instance $1167 r0 *1 73,163.8 cap_mim_2f0_m4m5_noshield
C$1167 \$12 topp 3.56528e-14
* device instance $1168 r0 *1 79.4,163.8 cap_mim_2f0_m4m5_noshield
C$1168 \$24 topp 3.56528e-14
* device instance $1169 r0 *1 85.8,163.8 cap_mim_2f0_m4m5_noshield
C$1169 \$12 topp 3.56528e-14
* device instance $1170 r0 *1 92.2,163.8 cap_mim_2f0_m4m5_noshield
C$1170 \$24 topp 3.56528e-14
* device instance $1171 r0 *1 98.6,163.8 cap_mim_2f0_m4m5_noshield
C$1171 \$12 topp 3.56528e-14
* device instance $1172 r0 *1 105,163.8 cap_mim_2f0_m4m5_noshield
C$1172 \$24 topp 3.56528e-14
* device instance $1173 r0 *1 111.4,163.8 cap_mim_2f0_m4m5_noshield
C$1173 \$12 topp 3.56528e-14
* device instance $1174 r0 *1 117.8,163.8 cap_mim_2f0_m4m5_noshield
C$1174 \$24 topp 3.56528e-14
* device instance $1175 r0 *1 124.2,163.8 cap_mim_2f0_m4m5_noshield
C$1175 \$12 topp 3.56528e-14
* device instance $1176 r0 *1 130.6,163.8 cap_mim_2f0_m4m5_noshield
C$1176 \$24 topp 3.56528e-14
* device instance $1177 r0 *1 137,163.8 cap_mim_2f0_m4m5_noshield
C$1177 \$12 topp 3.56528e-14
* device instance $1178 r0 *1 143.4,163.8 cap_mim_2f0_m4m5_noshield
C$1178 \$24 topp 3.56528e-14
* device instance $1179 r0 *1 149.8,163.8 cap_mim_2f0_m4m5_noshield
C$1179 \$12 topp 3.56528e-14
* device instance $1180 r0 *1 156.2,163.8 cap_mim_2f0_m4m5_noshield
C$1180 \$24 topp 3.56528e-14
* device instance $1181 r0 *1 162.6,163.8 cap_mim_2f0_m4m5_noshield
C$1181 \$12 topp 3.56528e-14
* device instance $1182 r0 *1 169,163.8 cap_mim_2f0_m4m5_noshield
C$1182 \$24 topp 3.56528e-14
* device instance $1183 r0 *1 175.4,163.8 cap_mim_2f0_m4m5_noshield
C$1183 \$12 topp 3.56528e-14
* device instance $1184 r0 *1 181.8,163.8 cap_mim_2f0_m4m5_noshield
C$1184 \$24 topp 3.56528e-14
* device instance $1185 r0 *1 188.2,163.8 cap_mim_2f0_m4m5_noshield
C$1185 \$12 topp 3.56528e-14
* device instance $1186 r0 *1 194.6,163.8 cap_mim_2f0_m4m5_noshield
C$1186 \$24 topp 3.56528e-14
* device instance $1187 r0 *1 201,163.8 cap_mim_2f0_m4m5_noshield
C$1187 \$12 topp 3.56528e-14
* device instance $1188 r0 *1 224,163.8 cap_mim_2f0_m4m5_noshield
C$1188 \$83 topn 3.56528e-14
* device instance $1189 r0 *1 230.4,163.8 cap_mim_2f0_m4m5_noshield
C$1189 \$82 topn 3.56528e-14
* device instance $1190 r0 *1 236.8,163.8 cap_mim_2f0_m4m5_noshield
C$1190 \$83 topn 3.56528e-14
* device instance $1191 r0 *1 243.2,163.8 cap_mim_2f0_m4m5_noshield
C$1191 \$82 topn 3.56528e-14
* device instance $1192 r0 *1 249.6,163.8 cap_mim_2f0_m4m5_noshield
C$1192 \$83 topn 3.56528e-14
* device instance $1193 r0 *1 256,163.8 cap_mim_2f0_m4m5_noshield
C$1193 \$82 topn 3.56528e-14
* device instance $1194 r0 *1 262.4,163.8 cap_mim_2f0_m4m5_noshield
C$1194 \$83 topn 3.56528e-14
* device instance $1195 r0 *1 268.8,163.8 cap_mim_2f0_m4m5_noshield
C$1195 \$82 topn 3.56528e-14
* device instance $1196 r0 *1 275.2,163.8 cap_mim_2f0_m4m5_noshield
C$1196 \$83 topn 3.56528e-14
* device instance $1197 r0 *1 281.6,163.8 cap_mim_2f0_m4m5_noshield
C$1197 \$82 topn 3.56528e-14
* device instance $1198 r0 *1 288,163.8 cap_mim_2f0_m4m5_noshield
C$1198 \$83 topn 3.56528e-14
* device instance $1199 r0 *1 294.4,163.8 cap_mim_2f0_m4m5_noshield
C$1199 \$82 topn 3.56528e-14
* device instance $1200 r0 *1 300.8,163.8 cap_mim_2f0_m4m5_noshield
C$1200 \$83 topn 3.56528e-14
* device instance $1201 r0 *1 307.2,163.8 cap_mim_2f0_m4m5_noshield
C$1201 \$82 topn 3.56528e-14
* device instance $1202 r0 *1 313.6,163.8 cap_mim_2f0_m4m5_noshield
C$1202 \$83 topn 3.56528e-14
* device instance $1203 r0 *1 320,163.8 cap_mim_2f0_m4m5_noshield
C$1203 \$82 topn 3.56528e-14
* device instance $1204 r0 *1 326.4,163.8 cap_mim_2f0_m4m5_noshield
C$1204 \$83 topn 3.56528e-14
* device instance $1205 r0 *1 332.8,163.8 cap_mim_2f0_m4m5_noshield
C$1205 \$82 topn 3.56528e-14
* device instance $1206 r0 *1 339.2,163.8 cap_mim_2f0_m4m5_noshield
C$1206 \$83 topn 3.56528e-14
* device instance $1207 r0 *1 345.6,163.8 cap_mim_2f0_m4m5_noshield
C$1207 \$82 topn 3.56528e-14
* device instance $1208 r0 *1 352,163.8 cap_mim_2f0_m4m5_noshield
C$1208 \$83 topn 3.56528e-14
* device instance $1209 r0 *1 358.4,163.8 cap_mim_2f0_m4m5_noshield
C$1209 \$82 topn 3.56528e-14
* device instance $1210 r0 *1 364.8,163.8 cap_mim_2f0_m4m5_noshield
C$1210 \$83 topn 3.56528e-14
* device instance $1211 r0 *1 371.2,163.8 cap_mim_2f0_m4m5_noshield
C$1211 \$82 topn 3.56528e-14
* device instance $1212 r0 *1 377.6,163.8 cap_mim_2f0_m4m5_noshield
C$1212 \$83 topn 3.56528e-14
* device instance $1213 r0 *1 384,163.8 cap_mim_2f0_m4m5_noshield
C$1213 \$82 topn 3.56528e-14
* device instance $1214 r0 *1 390.4,163.8 cap_mim_2f0_m4m5_noshield
C$1214 \$83 topn 3.56528e-14
* device instance $1215 r0 *1 396.8,163.8 cap_mim_2f0_m4m5_noshield
C$1215 \$82 topn 3.56528e-14
* device instance $1216 r0 *1 403.2,163.8 cap_mim_2f0_m4m5_noshield
C$1216 \$83 topn 3.56528e-14
* device instance $1217 r0 *1 409.6,163.8 cap_mim_2f0_m4m5_noshield
C$1217 \$82 topn 3.56528e-14
* device instance $1218 r0 *1 416,163.8 cap_mim_2f0_m4m5_noshield
C$1218 \$83 topn 3.56528e-14
* device instance $1219 r0 *1 422.4,163.8 cap_mim_2f0_m4m5_noshield
C$1219 \$82 topn 3.56528e-14
* device instance $1220 r0 *1 2.6,170.2 cap_mim_2f0_m4m5_noshield
C$1220 \$32 topp 3.56528e-14
* device instance $1221 r0 *1 9,170.2 cap_mim_2f0_m4m5_noshield
C$1221 \$12 topp 3.56528e-14
* device instance $1222 r0 *1 15.4,170.2 cap_mim_2f0_m4m5_noshield
C$1222 \$32 topp 3.56528e-14
* device instance $1223 r0 *1 21.8,170.2 cap_mim_2f0_m4m5_noshield
C$1223 \$12 topp 3.56528e-14
* device instance $1224 r0 *1 28.2,170.2 cap_mim_2f0_m4m5_noshield
C$1224 \$32 topp 3.56528e-14
* device instance $1225 r0 *1 34.6,170.2 cap_mim_2f0_m4m5_noshield
C$1225 \$12 topp 3.56528e-14
* device instance $1226 r0 *1 41,170.2 cap_mim_2f0_m4m5_noshield
C$1226 \$32 topp 3.56528e-14
* device instance $1227 r0 *1 47.4,170.2 cap_mim_2f0_m4m5_noshield
C$1227 \$12 topp 3.56528e-14
* device instance $1228 r0 *1 53.8,170.2 cap_mim_2f0_m4m5_noshield
C$1228 \$32 topp 3.56528e-14
* device instance $1229 r0 *1 60.2,170.2 cap_mim_2f0_m4m5_noshield
C$1229 \$12 topp 3.56528e-14
* device instance $1230 r0 *1 66.6,170.2 cap_mim_2f0_m4m5_noshield
C$1230 \$32 topp 3.56528e-14
* device instance $1231 r0 *1 73,170.2 cap_mim_2f0_m4m5_noshield
C$1231 \$12 topp 3.56528e-14
* device instance $1232 r0 *1 79.4,170.2 cap_mim_2f0_m4m5_noshield
C$1232 \$32 topp 3.56528e-14
* device instance $1233 r0 *1 85.8,170.2 cap_mim_2f0_m4m5_noshield
C$1233 \$12 topp 3.56528e-14
* device instance $1234 r0 *1 92.2,170.2 cap_mim_2f0_m4m5_noshield
C$1234 \$32 topp 3.56528e-14
* device instance $1235 r0 *1 98.6,170.2 cap_mim_2f0_m4m5_noshield
C$1235 \$12 topp 3.56528e-14
* device instance $1236 r0 *1 105,170.2 cap_mim_2f0_m4m5_noshield
C$1236 \$32 topp 3.56528e-14
* device instance $1237 r0 *1 111.4,170.2 cap_mim_2f0_m4m5_noshield
C$1237 \$12 topp 3.56528e-14
* device instance $1238 r0 *1 117.8,170.2 cap_mim_2f0_m4m5_noshield
C$1238 \$32 topp 3.56528e-14
* device instance $1239 r0 *1 124.2,170.2 cap_mim_2f0_m4m5_noshield
C$1239 \$12 topp 3.56528e-14
* device instance $1240 r0 *1 130.6,170.2 cap_mim_2f0_m4m5_noshield
C$1240 \$32 topp 3.56528e-14
* device instance $1241 r0 *1 137,170.2 cap_mim_2f0_m4m5_noshield
C$1241 \$12 topp 3.56528e-14
* device instance $1242 r0 *1 143.4,170.2 cap_mim_2f0_m4m5_noshield
C$1242 \$32 topp 3.56528e-14
* device instance $1243 r0 *1 149.8,170.2 cap_mim_2f0_m4m5_noshield
C$1243 \$12 topp 3.56528e-14
* device instance $1244 r0 *1 156.2,170.2 cap_mim_2f0_m4m5_noshield
C$1244 \$32 topp 3.56528e-14
* device instance $1245 r0 *1 162.6,170.2 cap_mim_2f0_m4m5_noshield
C$1245 \$12 topp 3.56528e-14
* device instance $1246 r0 *1 169,170.2 cap_mim_2f0_m4m5_noshield
C$1246 \$32 topp 3.56528e-14
* device instance $1247 r0 *1 175.4,170.2 cap_mim_2f0_m4m5_noshield
C$1247 \$12 topp 3.56528e-14
* device instance $1248 r0 *1 181.8,170.2 cap_mim_2f0_m4m5_noshield
C$1248 \$32 topp 3.56528e-14
* device instance $1249 r0 *1 188.2,170.2 cap_mim_2f0_m4m5_noshield
C$1249 \$12 topp 3.56528e-14
* device instance $1250 r0 *1 194.6,170.2 cap_mim_2f0_m4m5_noshield
C$1250 \$32 topp 3.56528e-14
* device instance $1251 r0 *1 201,170.2 cap_mim_2f0_m4m5_noshield
C$1251 \$12 topp 3.56528e-14
* device instance $1252 r0 *1 224,170.2 cap_mim_2f0_m4m5_noshield
C$1252 \$84 topn 3.56528e-14
* device instance $1253 r0 *1 230.4,170.2 cap_mim_2f0_m4m5_noshield
C$1253 \$82 topn 3.56528e-14
* device instance $1254 r0 *1 236.8,170.2 cap_mim_2f0_m4m5_noshield
C$1254 \$84 topn 3.56528e-14
* device instance $1255 r0 *1 243.2,170.2 cap_mim_2f0_m4m5_noshield
C$1255 \$82 topn 3.56528e-14
* device instance $1256 r0 *1 249.6,170.2 cap_mim_2f0_m4m5_noshield
C$1256 \$84 topn 3.56528e-14
* device instance $1257 r0 *1 256,170.2 cap_mim_2f0_m4m5_noshield
C$1257 \$82 topn 3.56528e-14
* device instance $1258 r0 *1 262.4,170.2 cap_mim_2f0_m4m5_noshield
C$1258 \$84 topn 3.56528e-14
* device instance $1259 r0 *1 268.8,170.2 cap_mim_2f0_m4m5_noshield
C$1259 \$82 topn 3.56528e-14
* device instance $1260 r0 *1 275.2,170.2 cap_mim_2f0_m4m5_noshield
C$1260 \$84 topn 3.56528e-14
* device instance $1261 r0 *1 281.6,170.2 cap_mim_2f0_m4m5_noshield
C$1261 \$82 topn 3.56528e-14
* device instance $1262 r0 *1 288,170.2 cap_mim_2f0_m4m5_noshield
C$1262 \$84 topn 3.56528e-14
* device instance $1263 r0 *1 294.4,170.2 cap_mim_2f0_m4m5_noshield
C$1263 \$82 topn 3.56528e-14
* device instance $1264 r0 *1 300.8,170.2 cap_mim_2f0_m4m5_noshield
C$1264 \$84 topn 3.56528e-14
* device instance $1265 r0 *1 307.2,170.2 cap_mim_2f0_m4m5_noshield
C$1265 \$82 topn 3.56528e-14
* device instance $1266 r0 *1 313.6,170.2 cap_mim_2f0_m4m5_noshield
C$1266 \$84 topn 3.56528e-14
* device instance $1267 r0 *1 320,170.2 cap_mim_2f0_m4m5_noshield
C$1267 \$82 topn 3.56528e-14
* device instance $1268 r0 *1 326.4,170.2 cap_mim_2f0_m4m5_noshield
C$1268 \$84 topn 3.56528e-14
* device instance $1269 r0 *1 332.8,170.2 cap_mim_2f0_m4m5_noshield
C$1269 \$82 topn 3.56528e-14
* device instance $1270 r0 *1 339.2,170.2 cap_mim_2f0_m4m5_noshield
C$1270 \$84 topn 3.56528e-14
* device instance $1271 r0 *1 345.6,170.2 cap_mim_2f0_m4m5_noshield
C$1271 \$82 topn 3.56528e-14
* device instance $1272 r0 *1 352,170.2 cap_mim_2f0_m4m5_noshield
C$1272 \$84 topn 3.56528e-14
* device instance $1273 r0 *1 358.4,170.2 cap_mim_2f0_m4m5_noshield
C$1273 \$82 topn 3.56528e-14
* device instance $1274 r0 *1 364.8,170.2 cap_mim_2f0_m4m5_noshield
C$1274 \$84 topn 3.56528e-14
* device instance $1275 r0 *1 371.2,170.2 cap_mim_2f0_m4m5_noshield
C$1275 \$82 topn 3.56528e-14
* device instance $1276 r0 *1 377.6,170.2 cap_mim_2f0_m4m5_noshield
C$1276 \$84 topn 3.56528e-14
* device instance $1277 r0 *1 384,170.2 cap_mim_2f0_m4m5_noshield
C$1277 \$82 topn 3.56528e-14
* device instance $1278 r0 *1 390.4,170.2 cap_mim_2f0_m4m5_noshield
C$1278 \$84 topn 3.56528e-14
* device instance $1279 r0 *1 396.8,170.2 cap_mim_2f0_m4m5_noshield
C$1279 \$82 topn 3.56528e-14
* device instance $1280 r0 *1 403.2,170.2 cap_mim_2f0_m4m5_noshield
C$1280 \$84 topn 3.56528e-14
* device instance $1281 r0 *1 409.6,170.2 cap_mim_2f0_m4m5_noshield
C$1281 \$82 topn 3.56528e-14
* device instance $1282 r0 *1 416,170.2 cap_mim_2f0_m4m5_noshield
C$1282 \$84 topn 3.56528e-14
* device instance $1283 r0 *1 422.4,170.2 cap_mim_2f0_m4m5_noshield
C$1283 \$82 topn 3.56528e-14
* device instance $1284 r0 *1 2.6,176.6 cap_mim_2f0_m4m5_noshield
C$1284 \$40 topp 3.56528e-14
* device instance $1285 r0 *1 9,176.6 cap_mim_2f0_m4m5_noshield
C$1285 \$12 topp 3.56528e-14
* device instance $1286 r0 *1 15.4,176.6 cap_mim_2f0_m4m5_noshield
C$1286 \$40 topp 3.56528e-14
* device instance $1287 r0 *1 21.8,176.6 cap_mim_2f0_m4m5_noshield
C$1287 \$12 topp 3.56528e-14
* device instance $1288 r0 *1 28.2,176.6 cap_mim_2f0_m4m5_noshield
C$1288 \$40 topp 3.56528e-14
* device instance $1289 r0 *1 34.6,176.6 cap_mim_2f0_m4m5_noshield
C$1289 \$12 topp 3.56528e-14
* device instance $1290 r0 *1 41,176.6 cap_mim_2f0_m4m5_noshield
C$1290 \$40 topp 3.56528e-14
* device instance $1291 r0 *1 47.4,176.6 cap_mim_2f0_m4m5_noshield
C$1291 \$12 topp 3.56528e-14
* device instance $1292 r0 *1 53.8,176.6 cap_mim_2f0_m4m5_noshield
C$1292 \$40 topp 3.56528e-14
* device instance $1293 r0 *1 60.2,176.6 cap_mim_2f0_m4m5_noshield
C$1293 \$12 topp 3.56528e-14
* device instance $1294 r0 *1 66.6,176.6 cap_mim_2f0_m4m5_noshield
C$1294 \$40 topp 3.56528e-14
* device instance $1295 r0 *1 73,176.6 cap_mim_2f0_m4m5_noshield
C$1295 \$12 topp 3.56528e-14
* device instance $1296 r0 *1 79.4,176.6 cap_mim_2f0_m4m5_noshield
C$1296 \$40 topp 3.56528e-14
* device instance $1297 r0 *1 85.8,176.6 cap_mim_2f0_m4m5_noshield
C$1297 \$12 topp 3.56528e-14
* device instance $1298 r0 *1 92.2,176.6 cap_mim_2f0_m4m5_noshield
C$1298 \$40 topp 3.56528e-14
* device instance $1299 r0 *1 98.6,176.6 cap_mim_2f0_m4m5_noshield
C$1299 \$12 topp 3.56528e-14
* device instance $1300 r0 *1 105,176.6 cap_mim_2f0_m4m5_noshield
C$1300 \$48 topp 3.56528e-14
* device instance $1301 r0 *1 111.4,176.6 cap_mim_2f0_m4m5_noshield
C$1301 \$12 topp 3.56528e-14
* device instance $1302 r0 *1 117.8,176.6 cap_mim_2f0_m4m5_noshield
C$1302 \$48 topp 3.56528e-14
* device instance $1303 r0 *1 124.2,176.6 cap_mim_2f0_m4m5_noshield
C$1303 \$12 topp 3.56528e-14
* device instance $1304 r0 *1 130.6,176.6 cap_mim_2f0_m4m5_noshield
C$1304 \$48 topp 3.56528e-14
* device instance $1305 r0 *1 137,176.6 cap_mim_2f0_m4m5_noshield
C$1305 \$12 topp 3.56528e-14
* device instance $1306 r0 *1 143.4,176.6 cap_mim_2f0_m4m5_noshield
C$1306 \$48 topp 3.56528e-14
* device instance $1307 r0 *1 149.8,176.6 cap_mim_2f0_m4m5_noshield
C$1307 \$12 topp 3.56528e-14
* device instance $1308 r0 *1 156.2,176.6 cap_mim_2f0_m4m5_noshield
C$1308 \$56 topp 3.56528e-14
* device instance $1309 r0 *1 162.6,176.6 cap_mim_2f0_m4m5_noshield
C$1309 \$12 topp 3.56528e-14
* device instance $1310 r0 *1 169,176.6 cap_mim_2f0_m4m5_noshield
C$1310 \$56 topp 3.56528e-14
* device instance $1311 r0 *1 175.4,176.6 cap_mim_2f0_m4m5_noshield
C$1311 \$12 topp 3.56528e-14
* device instance $1312 r0 *1 181.8,176.6 cap_mim_2f0_m4m5_noshield
C$1312 \$64 topp 3.56528e-14
* device instance $1313 r0 *1 188.2,176.6 cap_mim_2f0_m4m5_noshield
C$1313 \$12 topp 3.56528e-14
* device instance $1314 r0 *1 194.6,176.6 cap_mim_2f0_m4m5_noshield
C$1314 \$72 topp 3.56528e-14
* device instance $1315 r0 *1 201,176.6 cap_mim_2f0_m4m5_noshield
C$1315 \$12 topp 3.56528e-14
* device instance $1316 r0 *1 224,176.6 cap_mim_2f0_m4m5_noshield
C$1316 \$85 topn 3.56528e-14
* device instance $1317 r0 *1 230.4,176.6 cap_mim_2f0_m4m5_noshield
C$1317 \$82 topn 3.56528e-14
* device instance $1318 r0 *1 236.8,176.6 cap_mim_2f0_m4m5_noshield
C$1318 \$85 topn 3.56528e-14
* device instance $1319 r0 *1 243.2,176.6 cap_mim_2f0_m4m5_noshield
C$1319 \$82 topn 3.56528e-14
* device instance $1320 r0 *1 249.6,176.6 cap_mim_2f0_m4m5_noshield
C$1320 \$85 topn 3.56528e-14
* device instance $1321 r0 *1 256,176.6 cap_mim_2f0_m4m5_noshield
C$1321 \$82 topn 3.56528e-14
* device instance $1322 r0 *1 262.4,176.6 cap_mim_2f0_m4m5_noshield
C$1322 \$85 topn 3.56528e-14
* device instance $1323 r0 *1 268.8,176.6 cap_mim_2f0_m4m5_noshield
C$1323 \$82 topn 3.56528e-14
* device instance $1324 r0 *1 275.2,176.6 cap_mim_2f0_m4m5_noshield
C$1324 \$85 topn 3.56528e-14
* device instance $1325 r0 *1 281.6,176.6 cap_mim_2f0_m4m5_noshield
C$1325 \$82 topn 3.56528e-14
* device instance $1326 r0 *1 288,176.6 cap_mim_2f0_m4m5_noshield
C$1326 \$85 topn 3.56528e-14
* device instance $1327 r0 *1 294.4,176.6 cap_mim_2f0_m4m5_noshield
C$1327 \$82 topn 3.56528e-14
* device instance $1328 r0 *1 300.8,176.6 cap_mim_2f0_m4m5_noshield
C$1328 \$85 topn 3.56528e-14
* device instance $1329 r0 *1 307.2,176.6 cap_mim_2f0_m4m5_noshield
C$1329 \$82 topn 3.56528e-14
* device instance $1330 r0 *1 313.6,176.6 cap_mim_2f0_m4m5_noshield
C$1330 \$85 topn 3.56528e-14
* device instance $1331 r0 *1 320,176.6 cap_mim_2f0_m4m5_noshield
C$1331 \$82 topn 3.56528e-14
* device instance $1332 r0 *1 326.4,176.6 cap_mim_2f0_m4m5_noshield
C$1332 \$86 topn 3.56528e-14
* device instance $1333 r0 *1 332.8,176.6 cap_mim_2f0_m4m5_noshield
C$1333 \$82 topn 3.56528e-14
* device instance $1334 r0 *1 339.2,176.6 cap_mim_2f0_m4m5_noshield
C$1334 \$86 topn 3.56528e-14
* device instance $1335 r0 *1 345.6,176.6 cap_mim_2f0_m4m5_noshield
C$1335 \$82 topn 3.56528e-14
* device instance $1336 r0 *1 352,176.6 cap_mim_2f0_m4m5_noshield
C$1336 \$86 topn 3.56528e-14
* device instance $1337 r0 *1 358.4,176.6 cap_mim_2f0_m4m5_noshield
C$1337 \$82 topn 3.56528e-14
* device instance $1338 r0 *1 364.8,176.6 cap_mim_2f0_m4m5_noshield
C$1338 \$86 topn 3.56528e-14
* device instance $1339 r0 *1 371.2,176.6 cap_mim_2f0_m4m5_noshield
C$1339 \$82 topn 3.56528e-14
* device instance $1340 r0 *1 377.6,176.6 cap_mim_2f0_m4m5_noshield
C$1340 \$87 topn 3.56528e-14
* device instance $1341 r0 *1 384,176.6 cap_mim_2f0_m4m5_noshield
C$1341 \$82 topn 3.56528e-14
* device instance $1342 r0 *1 390.4,176.6 cap_mim_2f0_m4m5_noshield
C$1342 \$87 topn 3.56528e-14
* device instance $1343 r0 *1 396.8,176.6 cap_mim_2f0_m4m5_noshield
C$1343 \$82 topn 3.56528e-14
* device instance $1344 r0 *1 403.2,176.6 cap_mim_2f0_m4m5_noshield
C$1344 \$88 topn 3.56528e-14
* device instance $1345 r0 *1 409.6,176.6 cap_mim_2f0_m4m5_noshield
C$1345 \$82 topn 3.56528e-14
* device instance $1346 r0 *1 416,176.6 cap_mim_2f0_m4m5_noshield
C$1346 \$89 topn 3.56528e-14
* device instance $1347 r0 *1 422.4,176.6 cap_mim_2f0_m4m5_noshield
C$1347 \$82 topn 3.56528e-14
* device instance $1348 r0 *1 575.65,92.885 ppolyf_u_1k
R$1348 vdd XCMP_pop vss 150000 ppolyf_u_1k L=150U W=1U
* device instance $1349 r0 *1 581.85,92.885 ppolyf_u_1k
R$1349 vdd XCMP_pon vss 150000 ppolyf_u_1k L=150U W=1U
.ENDS ADC_BLOCK
