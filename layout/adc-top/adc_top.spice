* extracted by klt extract --deck gf180mcu

* cell ADC_TOP
* pin hi_128_n
* pin hi_128_p
* pin hi_16_n
* pin hi_16_p
* pin hi_1_n
* pin hi_1_p
* pin hi_256_n
* pin hi_256_p
* pin hi_2_n
* pin hi_2_p
* pin hi_32_n
* pin hi_32_p
* pin hi_4_n
* pin hi_4_p
* pin hi_64_n
* pin hi_64_p
* pin hi_8_n
* pin hi_8_p
* pin lo_128_n
* pin lo_128_p
* pin lo_16_n
* pin lo_16_p
* pin lo_1_n
* pin lo_1_p
* pin lo_256_n
* pin lo_256_p
* pin lo_2_n
* pin lo_2_p
* pin lo_32_n
* pin lo_32_p
* pin lo_4_n
* pin lo_4_p
* pin lo_64_n
* pin lo_64_p
* pin lo_8_n
* pin lo_8_p
* pin pinn
* pin pinp
* pin rel_128_n
* pin rel_128_p
* pin rel_16_n
* pin rel_16_p
* pin rel_1_n
* pin rel_1_p
* pin rel_256_n
* pin rel_256_p
* pin rel_2_n
* pin rel_2_p
* pin rel_32_n
* pin rel_32_p
* pin rel_4_n
* pin rel_4_p
* pin rel_64_n
* pin rel_64_p
* pin rel_8_n
* pin rel_8_p
* pin sel_in
* pin topn
* pin topp
* pin tp_gn
* pin vcm
* pin vdd
* pin vref
* pin vss
.SUBCKT ADC_TOP hi_128_n hi_128_p hi_16_n hi_16_p hi_1_n hi_1_p hi_256_n
+ hi_256_p hi_2_n hi_2_p hi_32_n hi_32_p hi_4_n hi_4_p hi_64_n hi_64_p hi_8_n
+ hi_8_p lo_128_n lo_128_p lo_16_n lo_16_p lo_1_n lo_1_p lo_256_n lo_256_p
+ lo_2_n lo_2_p lo_32_n lo_32_p lo_4_n lo_4_p lo_64_n lo_64_p lo_8_n lo_8_p
+ pinn pinp rel_128_n rel_128_p rel_16_n rel_16_p rel_1_n rel_1_p rel_256_n
+ rel_256_p rel_2_n rel_2_p rel_32_n rel_32_p rel_4_n rel_4_p rel_64_n rel_64_p
+ rel_8_n rel_8_p sel_in topn topp tp_gn vcm vdd vref vss
* device instance $1 r0 *1 1.275,2 nfet
M$1 \$70 sel_in vss vss nfet L=0.35U W=4U AS=4.4P AD=4.4P PS=10.2U PD=10.2U
* device instance $2 r0 *1 4.225,2 nfet
M$2 \$34 rel_256_p vss vss nfet L=0.35U W=4U AS=4.4P AD=4.4P PS=10.2U PD=10.2U
* device instance $3 r0 *1 7.175,2 nfet
M$3 \$36 hi_256_p vss vss nfet L=0.35U W=4U AS=4.4P AD=4.4P PS=10.2U PD=10.2U
* device instance $4 r0 *1 10.125,2 nfet
M$4 \$7 lo_256_p vss vss nfet L=0.35U W=4U AS=4.4P AD=4.4P PS=10.2U PD=10.2U
* device instance $5 r0 *1 13.04,5 nfet
M$5 pinp sel_in \$8 vss nfet L=0.28U W=10U AS=11P AD=11P PS=22.2U PD=22.2U
* device instance $6 r0 *1 15.92,5 nfet
M$6 vcm rel_256_p \$8 vss nfet L=0.28U W=10U AS=11P AD=11P PS=22.2U PD=22.2U
* device instance $7 r0 *1 18.8,5 nfet
M$7 vref hi_256_p \$8 vss nfet L=0.28U W=10U AS=11P AD=11P PS=22.2U PD=22.2U
* device instance $8 r0 *1 21.68,5 nfet
M$8 vss lo_256_p \$8 vss nfet L=0.28U W=10U AS=11P AD=11P PS=22.2U PD=22.2U
* device instance $9 r0 *1 59.635,2 nfet
M$9 \$71 sel_in vss vss nfet L=0.35U W=4U AS=4.4P AD=4.4P PS=10.2U PD=10.2U
* device instance $10 r0 *1 62.585,2 nfet
M$10 \$38 rel_128_p vss vss nfet L=0.35U W=4U AS=4.4P AD=4.4P PS=10.2U PD=10.2U
* device instance $11 r0 *1 65.535,2 nfet
M$11 \$40 hi_128_p vss vss nfet L=0.35U W=4U AS=4.4P AD=4.4P PS=10.2U PD=10.2U
* device instance $12 r0 *1 68.485,2 nfet
M$12 \$10 lo_128_p vss vss nfet L=0.35U W=4U AS=4.4P AD=4.4P PS=10.2U PD=10.2U
* device instance $13 r0 *1 71.4,5 nfet
M$13 pinp sel_in \$11 vss nfet L=0.28U W=10U AS=11P AD=11P PS=22.2U PD=22.2U
* device instance $14 r0 *1 74.28,5 nfet
M$14 vcm rel_128_p \$11 vss nfet L=0.28U W=10U AS=11P AD=11P PS=22.2U PD=22.2U
* device instance $15 r0 *1 77.16,5 nfet
M$15 vref hi_128_p \$11 vss nfet L=0.28U W=10U AS=11P AD=11P PS=22.2U PD=22.2U
* device instance $16 r0 *1 80.04,5 nfet
M$16 vss lo_128_p \$11 vss nfet L=0.28U W=10U AS=11P AD=11P PS=22.2U PD=22.2U
* device instance $17 r0 *1 117.995,2 nfet
M$17 \$72 sel_in vss vss nfet L=0.35U W=4U AS=4.4P AD=4.4P PS=10.2U PD=10.2U
* device instance $18 r0 *1 120.945,2 nfet
M$18 \$42 rel_64_p vss vss nfet L=0.35U W=4U AS=4.4P AD=4.4P PS=10.2U PD=10.2U
* device instance $19 r0 *1 123.895,2 nfet
M$19 \$44 hi_64_p vss vss nfet L=0.35U W=4U AS=4.4P AD=4.4P PS=10.2U PD=10.2U
* device instance $20 r0 *1 126.845,2 nfet
M$20 \$13 lo_64_p vss vss nfet L=0.35U W=4U AS=4.4P AD=4.4P PS=10.2U PD=10.2U
* device instance $21 r0 *1 129.76,5 nfet
M$21 pinp sel_in \$14 vss nfet L=0.28U W=10U AS=11P AD=11P PS=22.2U PD=22.2U
* device instance $22 r0 *1 132.64,5 nfet
M$22 vcm rel_64_p \$14 vss nfet L=0.28U W=10U AS=11P AD=11P PS=22.2U PD=22.2U
* device instance $23 r0 *1 135.52,5 nfet
M$23 vref hi_64_p \$14 vss nfet L=0.28U W=10U AS=11P AD=11P PS=22.2U PD=22.2U
* device instance $24 r0 *1 138.4,5 nfet
M$24 vss lo_64_p \$14 vss nfet L=0.28U W=10U AS=11P AD=11P PS=22.2U PD=22.2U
* device instance $25 r0 *1 176.355,2 nfet
M$25 \$73 sel_in vss vss nfet L=0.35U W=4U AS=4.4P AD=4.4P PS=10.2U PD=10.2U
* device instance $26 r0 *1 179.305,2 nfet
M$26 \$46 rel_32_p vss vss nfet L=0.35U W=4U AS=4.4P AD=4.4P PS=10.2U PD=10.2U
* device instance $27 r0 *1 182.255,2 nfet
M$27 \$48 hi_32_p vss vss nfet L=0.35U W=4U AS=4.4P AD=4.4P PS=10.2U PD=10.2U
* device instance $28 r0 *1 185.205,2 nfet
M$28 \$16 lo_32_p vss vss nfet L=0.35U W=4U AS=4.4P AD=4.4P PS=10.2U PD=10.2U
* device instance $29 r0 *1 188.12,5 nfet
M$29 pinp sel_in \$17 vss nfet L=0.28U W=10U AS=11P AD=11P PS=22.2U PD=22.2U
* device instance $30 r0 *1 191,5 nfet
M$30 vcm rel_32_p \$17 vss nfet L=0.28U W=10U AS=11P AD=11P PS=22.2U PD=22.2U
* device instance $31 r0 *1 193.88,5 nfet
M$31 vref hi_32_p \$17 vss nfet L=0.28U W=10U AS=11P AD=11P PS=22.2U PD=22.2U
* device instance $32 r0 *1 196.76,5 nfet
M$32 vss lo_32_p \$17 vss nfet L=0.28U W=10U AS=11P AD=11P PS=22.2U PD=22.2U
* device instance $33 r0 *1 234.715,2 nfet
M$33 \$74 sel_in vss vss nfet L=0.35U W=4U AS=4.4P AD=4.4P PS=10.2U PD=10.2U
* device instance $34 r0 *1 237.665,2 nfet
M$34 \$50 rel_16_p vss vss nfet L=0.35U W=4U AS=4.4P AD=4.4P PS=10.2U PD=10.2U
* device instance $35 r0 *1 240.615,2 nfet
M$35 \$52 hi_16_p vss vss nfet L=0.35U W=4U AS=4.4P AD=4.4P PS=10.2U PD=10.2U
* device instance $36 r0 *1 243.565,2 nfet
M$36 \$19 lo_16_p vss vss nfet L=0.35U W=4U AS=4.4P AD=4.4P PS=10.2U PD=10.2U
* device instance $37 r0 *1 246.48,5 nfet
M$37 pinp sel_in \$20 vss nfet L=0.28U W=10U AS=11P AD=11P PS=22.2U PD=22.2U
* device instance $38 r0 *1 249.36,5 nfet
M$38 vcm rel_16_p \$20 vss nfet L=0.28U W=10U AS=11P AD=11P PS=22.2U PD=22.2U
* device instance $39 r0 *1 252.24,5 nfet
M$39 vref hi_16_p \$20 vss nfet L=0.28U W=10U AS=11P AD=11P PS=22.2U PD=22.2U
* device instance $40 r0 *1 255.12,5 nfet
M$40 vss lo_16_p \$20 vss nfet L=0.28U W=10U AS=11P AD=11P PS=22.2U PD=22.2U
* device instance $41 r0 *1 293.075,2 nfet
M$41 \$75 sel_in vss vss nfet L=0.35U W=4U AS=4.4P AD=4.4P PS=10.2U PD=10.2U
* device instance $42 r0 *1 296.025,2 nfet
M$42 \$54 rel_8_p vss vss nfet L=0.35U W=4U AS=4.4P AD=4.4P PS=10.2U PD=10.2U
* device instance $43 r0 *1 298.975,2 nfet
M$43 \$56 hi_8_p vss vss nfet L=0.35U W=4U AS=4.4P AD=4.4P PS=10.2U PD=10.2U
* device instance $44 r0 *1 301.925,2 nfet
M$44 \$22 lo_8_p vss vss nfet L=0.35U W=4U AS=4.4P AD=4.4P PS=10.2U PD=10.2U
* device instance $45 r0 *1 304.84,5 nfet
M$45 pinp sel_in \$23 vss nfet L=0.28U W=10U AS=11P AD=11P PS=22.2U PD=22.2U
* device instance $46 r0 *1 307.72,5 nfet
M$46 vcm rel_8_p \$23 vss nfet L=0.28U W=10U AS=11P AD=11P PS=22.2U PD=22.2U
* device instance $47 r0 *1 310.6,5 nfet
M$47 vref hi_8_p \$23 vss nfet L=0.28U W=10U AS=11P AD=11P PS=22.2U PD=22.2U
* device instance $48 r0 *1 313.48,5 nfet
M$48 vss lo_8_p \$23 vss nfet L=0.28U W=10U AS=11P AD=11P PS=22.2U PD=22.2U
* device instance $49 r0 *1 351.435,2 nfet
M$49 \$76 sel_in vss vss nfet L=0.35U W=4U AS=4.4P AD=4.4P PS=10.2U PD=10.2U
* device instance $50 r0 *1 354.385,2 nfet
M$50 \$58 rel_4_p vss vss nfet L=0.35U W=4U AS=4.4P AD=4.4P PS=10.2U PD=10.2U
* device instance $51 r0 *1 357.335,2 nfet
M$51 \$60 hi_4_p vss vss nfet L=0.35U W=4U AS=4.4P AD=4.4P PS=10.2U PD=10.2U
* device instance $52 r0 *1 360.285,2 nfet
M$52 \$25 lo_4_p vss vss nfet L=0.35U W=4U AS=4.4P AD=4.4P PS=10.2U PD=10.2U
* device instance $53 r0 *1 363.2,5 nfet
M$53 pinp sel_in \$26 vss nfet L=0.28U W=10U AS=11P AD=11P PS=22.2U PD=22.2U
* device instance $54 r0 *1 366.08,5 nfet
M$54 vcm rel_4_p \$26 vss nfet L=0.28U W=10U AS=11P AD=11P PS=22.2U PD=22.2U
* device instance $55 r0 *1 368.96,5 nfet
M$55 vref hi_4_p \$26 vss nfet L=0.28U W=10U AS=11P AD=11P PS=22.2U PD=22.2U
* device instance $56 r0 *1 371.84,5 nfet
M$56 vss lo_4_p \$26 vss nfet L=0.28U W=10U AS=11P AD=11P PS=22.2U PD=22.2U
* device instance $57 r0 *1 409.795,2 nfet
M$57 \$77 sel_in vss vss nfet L=0.35U W=4U AS=4.4P AD=4.4P PS=10.2U PD=10.2U
* device instance $58 r0 *1 412.745,2 nfet
M$58 \$62 rel_2_p vss vss nfet L=0.35U W=4U AS=4.4P AD=4.4P PS=10.2U PD=10.2U
* device instance $59 r0 *1 415.695,2 nfet
M$59 \$64 hi_2_p vss vss nfet L=0.35U W=4U AS=4.4P AD=4.4P PS=10.2U PD=10.2U
* device instance $60 r0 *1 418.645,2 nfet
M$60 \$28 lo_2_p vss vss nfet L=0.35U W=4U AS=4.4P AD=4.4P PS=10.2U PD=10.2U
* device instance $61 r0 *1 421.56,5 nfet
M$61 pinp sel_in \$29 vss nfet L=0.28U W=10U AS=11P AD=11P PS=22.2U PD=22.2U
* device instance $62 r0 *1 424.44,5 nfet
M$62 vcm rel_2_p \$29 vss nfet L=0.28U W=10U AS=11P AD=11P PS=22.2U PD=22.2U
* device instance $63 r0 *1 427.32,5 nfet
M$63 vref hi_2_p \$29 vss nfet L=0.28U W=10U AS=11P AD=11P PS=22.2U PD=22.2U
* device instance $64 r0 *1 430.2,5 nfet
M$64 vss lo_2_p \$29 vss nfet L=0.28U W=10U AS=11P AD=11P PS=22.2U PD=22.2U
* device instance $65 r0 *1 468.155,2 nfet
M$65 \$78 sel_in vss vss nfet L=0.35U W=4U AS=4.4P AD=4.4P PS=10.2U PD=10.2U
* device instance $66 r0 *1 471.105,2 nfet
M$66 \$66 rel_1_p vss vss nfet L=0.35U W=4U AS=4.4P AD=4.4P PS=10.2U PD=10.2U
* device instance $67 r0 *1 474.055,2 nfet
M$67 \$68 hi_1_p vss vss nfet L=0.35U W=4U AS=4.4P AD=4.4P PS=10.2U PD=10.2U
* device instance $68 r0 *1 477.005,2 nfet
M$68 \$31 lo_1_p vss vss nfet L=0.35U W=4U AS=4.4P AD=4.4P PS=10.2U PD=10.2U
* device instance $69 r0 *1 479.92,5 nfet
M$69 pinp sel_in \$32 vss nfet L=0.28U W=10U AS=11P AD=11P PS=22.2U PD=22.2U
* device instance $70 r0 *1 482.8,5 nfet
M$70 vcm rel_1_p \$32 vss nfet L=0.28U W=10U AS=11P AD=11P PS=22.2U PD=22.2U
* device instance $71 r0 *1 485.68,5 nfet
M$71 vref hi_1_p \$32 vss nfet L=0.28U W=10U AS=11P AD=11P PS=22.2U PD=22.2U
* device instance $72 r0 *1 488.56,5 nfet
M$72 vss lo_1_p \$32 vss nfet L=0.28U W=10U AS=11P AD=11P PS=22.2U PD=22.2U
* device instance $73 r0 *1 1.275,26.96 nfet
M$73 \$79 sel_in vss vss nfet L=0.35U W=4U AS=4.4P AD=4.4P PS=10.2U PD=10.2U
* device instance $74 r0 *1 4.225,26.96 nfet
M$74 \$81 rel_256_n vss vss nfet L=0.35U W=4U AS=4.4P AD=4.4P PS=10.2U PD=10.2U
* device instance $75 r0 *1 7.175,26.96 nfet
M$75 \$83 hi_256_n vss vss nfet L=0.35U W=4U AS=4.4P AD=4.4P PS=10.2U PD=10.2U
* device instance $76 r0 *1 10.125,26.96 nfet
M$76 \$85 lo_256_n vss vss nfet L=0.35U W=4U AS=4.4P AD=4.4P PS=10.2U PD=10.2U
* device instance $77 r0 *1 13.04,29.96 nfet
M$77 pinn sel_in \$86 vss nfet L=0.28U W=10U AS=11P AD=11P PS=22.2U PD=22.2U
* device instance $78 r0 *1 15.92,29.96 nfet
M$78 vcm rel_256_n \$86 vss nfet L=0.28U W=10U AS=11P AD=11P PS=22.2U PD=22.2U
* device instance $79 r0 *1 18.8,29.96 nfet
M$79 vref hi_256_n \$86 vss nfet L=0.28U W=10U AS=11P AD=11P PS=22.2U PD=22.2U
* device instance $80 r0 *1 21.68,29.96 nfet
M$80 vss lo_256_n \$86 vss nfet L=0.28U W=10U AS=11P AD=11P PS=22.2U PD=22.2U
* device instance $81 r0 *1 59.635,26.96 nfet
M$81 \$88 sel_in vss vss nfet L=0.35U W=4U AS=4.4P AD=4.4P PS=10.2U PD=10.2U
* device instance $82 r0 *1 62.585,26.96 nfet
M$82 \$90 rel_128_n vss vss nfet L=0.35U W=4U AS=4.4P AD=4.4P PS=10.2U PD=10.2U
* device instance $83 r0 *1 65.535,26.96 nfet
M$83 \$92 hi_128_n vss vss nfet L=0.35U W=4U AS=4.4P AD=4.4P PS=10.2U PD=10.2U
* device instance $84 r0 *1 68.485,26.96 nfet
M$84 \$94 lo_128_n vss vss nfet L=0.35U W=4U AS=4.4P AD=4.4P PS=10.2U PD=10.2U
* device instance $85 r0 *1 71.4,29.96 nfet
M$85 pinn sel_in \$95 vss nfet L=0.28U W=10U AS=11P AD=11P PS=22.2U PD=22.2U
* device instance $86 r0 *1 74.28,29.96 nfet
M$86 vcm rel_128_n \$95 vss nfet L=0.28U W=10U AS=11P AD=11P PS=22.2U PD=22.2U
* device instance $87 r0 *1 77.16,29.96 nfet
M$87 vref hi_128_n \$95 vss nfet L=0.28U W=10U AS=11P AD=11P PS=22.2U PD=22.2U
* device instance $88 r0 *1 80.04,29.96 nfet
M$88 vss lo_128_n \$95 vss nfet L=0.28U W=10U AS=11P AD=11P PS=22.2U PD=22.2U
* device instance $89 r0 *1 117.995,26.96 nfet
M$89 \$96 sel_in vss vss nfet L=0.35U W=4U AS=4.4P AD=4.4P PS=10.2U PD=10.2U
* device instance $90 r0 *1 120.945,26.96 nfet
M$90 \$98 rel_64_n vss vss nfet L=0.35U W=4U AS=4.4P AD=4.4P PS=10.2U PD=10.2U
* device instance $91 r0 *1 123.895,26.96 nfet
M$91 \$100 hi_64_n vss vss nfet L=0.35U W=4U AS=4.4P AD=4.4P PS=10.2U PD=10.2U
* device instance $92 r0 *1 126.845,26.96 nfet
M$92 \$102 lo_64_n vss vss nfet L=0.35U W=4U AS=4.4P AD=4.4P PS=10.2U PD=10.2U
* device instance $93 r0 *1 129.76,29.96 nfet
M$93 pinn sel_in \$103 vss nfet L=0.28U W=10U AS=11P AD=11P PS=22.2U PD=22.2U
* device instance $94 r0 *1 132.64,29.96 nfet
M$94 vcm rel_64_n \$103 vss nfet L=0.28U W=10U AS=11P AD=11P PS=22.2U PD=22.2U
* device instance $95 r0 *1 135.52,29.96 nfet
M$95 vref hi_64_n \$103 vss nfet L=0.28U W=10U AS=11P AD=11P PS=22.2U PD=22.2U
* device instance $96 r0 *1 138.4,29.96 nfet
M$96 vss lo_64_n \$103 vss nfet L=0.28U W=10U AS=11P AD=11P PS=22.2U PD=22.2U
* device instance $97 r0 *1 176.355,26.96 nfet
M$97 \$104 sel_in vss vss nfet L=0.35U W=4U AS=4.4P AD=4.4P PS=10.2U PD=10.2U
* device instance $98 r0 *1 179.305,26.96 nfet
M$98 \$106 rel_32_n vss vss nfet L=0.35U W=4U AS=4.4P AD=4.4P PS=10.2U PD=10.2U
* device instance $99 r0 *1 182.255,26.96 nfet
M$99 \$108 hi_32_n vss vss nfet L=0.35U W=4U AS=4.4P AD=4.4P PS=10.2U PD=10.2U
* device instance $100 r0 *1 185.205,26.96 nfet
M$100 \$110 lo_32_n vss vss nfet L=0.35U W=4U AS=4.4P AD=4.4P PS=10.2U PD=10.2U
* device instance $101 r0 *1 188.12,29.96 nfet
M$101 pinn sel_in \$111 vss nfet L=0.28U W=10U AS=11P AD=11P PS=22.2U PD=22.2U
* device instance $102 r0 *1 191,29.96 nfet
M$102 vcm rel_32_n \$111 vss nfet L=0.28U W=10U AS=11P AD=11P PS=22.2U PD=22.2U
* device instance $103 r0 *1 193.88,29.96 nfet
M$103 vref hi_32_n \$111 vss nfet L=0.28U W=10U AS=11P AD=11P PS=22.2U PD=22.2U
* device instance $104 r0 *1 196.76,29.96 nfet
M$104 vss lo_32_n \$111 vss nfet L=0.28U W=10U AS=11P AD=11P PS=22.2U PD=22.2U
* device instance $105 r0 *1 234.715,26.96 nfet
M$105 \$112 sel_in vss vss nfet L=0.35U W=4U AS=4.4P AD=4.4P PS=10.2U PD=10.2U
* device instance $106 r0 *1 237.665,26.96 nfet
M$106 \$114 rel_16_n vss vss nfet L=0.35U W=4U AS=4.4P AD=4.4P PS=10.2U PD=10.2U
* device instance $107 r0 *1 240.615,26.96 nfet
M$107 \$116 hi_16_n vss vss nfet L=0.35U W=4U AS=4.4P AD=4.4P PS=10.2U PD=10.2U
* device instance $108 r0 *1 243.565,26.96 nfet
M$108 \$118 lo_16_n vss vss nfet L=0.35U W=4U AS=4.4P AD=4.4P PS=10.2U PD=10.2U
* device instance $109 r0 *1 246.48,29.96 nfet
M$109 pinn sel_in \$119 vss nfet L=0.28U W=10U AS=11P AD=11P PS=22.2U PD=22.2U
* device instance $110 r0 *1 249.36,29.96 nfet
M$110 vcm rel_16_n \$119 vss nfet L=0.28U W=10U AS=11P AD=11P PS=22.2U PD=22.2U
* device instance $111 r0 *1 252.24,29.96 nfet
M$111 vref hi_16_n \$119 vss nfet L=0.28U W=10U AS=11P AD=11P PS=22.2U PD=22.2U
* device instance $112 r0 *1 255.12,29.96 nfet
M$112 vss lo_16_n \$119 vss nfet L=0.28U W=10U AS=11P AD=11P PS=22.2U PD=22.2U
* device instance $113 r0 *1 293.075,26.96 nfet
M$113 \$120 sel_in vss vss nfet L=0.35U W=4U AS=4.4P AD=4.4P PS=10.2U PD=10.2U
* device instance $114 r0 *1 296.025,26.96 nfet
M$114 \$122 rel_8_n vss vss nfet L=0.35U W=4U AS=4.4P AD=4.4P PS=10.2U PD=10.2U
* device instance $115 r0 *1 298.975,26.96 nfet
M$115 \$124 hi_8_n vss vss nfet L=0.35U W=4U AS=4.4P AD=4.4P PS=10.2U PD=10.2U
* device instance $116 r0 *1 301.925,26.96 nfet
M$116 \$126 lo_8_n vss vss nfet L=0.35U W=4U AS=4.4P AD=4.4P PS=10.2U PD=10.2U
* device instance $117 r0 *1 304.84,29.96 nfet
M$117 pinn sel_in \$127 vss nfet L=0.28U W=10U AS=11P AD=11P PS=22.2U PD=22.2U
* device instance $118 r0 *1 307.72,29.96 nfet
M$118 vcm rel_8_n \$127 vss nfet L=0.28U W=10U AS=11P AD=11P PS=22.2U PD=22.2U
* device instance $119 r0 *1 310.6,29.96 nfet
M$119 vref hi_8_n \$127 vss nfet L=0.28U W=10U AS=11P AD=11P PS=22.2U PD=22.2U
* device instance $120 r0 *1 313.48,29.96 nfet
M$120 vss lo_8_n \$127 vss nfet L=0.28U W=10U AS=11P AD=11P PS=22.2U PD=22.2U
* device instance $121 r0 *1 351.435,26.96 nfet
M$121 \$128 sel_in vss vss nfet L=0.35U W=4U AS=4.4P AD=4.4P PS=10.2U PD=10.2U
* device instance $122 r0 *1 354.385,26.96 nfet
M$122 \$130 rel_4_n vss vss nfet L=0.35U W=4U AS=4.4P AD=4.4P PS=10.2U PD=10.2U
* device instance $123 r0 *1 357.335,26.96 nfet
M$123 \$132 hi_4_n vss vss nfet L=0.35U W=4U AS=4.4P AD=4.4P PS=10.2U PD=10.2U
* device instance $124 r0 *1 360.285,26.96 nfet
M$124 \$134 lo_4_n vss vss nfet L=0.35U W=4U AS=4.4P AD=4.4P PS=10.2U PD=10.2U
* device instance $125 r0 *1 363.2,29.96 nfet
M$125 pinn sel_in \$135 vss nfet L=0.28U W=10U AS=11P AD=11P PS=22.2U PD=22.2U
* device instance $126 r0 *1 366.08,29.96 nfet
M$126 vcm rel_4_n \$135 vss nfet L=0.28U W=10U AS=11P AD=11P PS=22.2U PD=22.2U
* device instance $127 r0 *1 368.96,29.96 nfet
M$127 vref hi_4_n \$135 vss nfet L=0.28U W=10U AS=11P AD=11P PS=22.2U PD=22.2U
* device instance $128 r0 *1 371.84,29.96 nfet
M$128 vss lo_4_n \$135 vss nfet L=0.28U W=10U AS=11P AD=11P PS=22.2U PD=22.2U
* device instance $129 r0 *1 409.795,26.96 nfet
M$129 \$136 sel_in vss vss nfet L=0.35U W=4U AS=4.4P AD=4.4P PS=10.2U PD=10.2U
* device instance $130 r0 *1 412.745,26.96 nfet
M$130 \$138 rel_2_n vss vss nfet L=0.35U W=4U AS=4.4P AD=4.4P PS=10.2U PD=10.2U
* device instance $131 r0 *1 415.695,26.96 nfet
M$131 \$140 hi_2_n vss vss nfet L=0.35U W=4U AS=4.4P AD=4.4P PS=10.2U PD=10.2U
* device instance $132 r0 *1 418.645,26.96 nfet
M$132 \$142 lo_2_n vss vss nfet L=0.35U W=4U AS=4.4P AD=4.4P PS=10.2U PD=10.2U
* device instance $133 r0 *1 421.56,29.96 nfet
M$133 pinn sel_in \$143 vss nfet L=0.28U W=10U AS=11P AD=11P PS=22.2U PD=22.2U
* device instance $134 r0 *1 424.44,29.96 nfet
M$134 vcm rel_2_n \$143 vss nfet L=0.28U W=10U AS=11P AD=11P PS=22.2U PD=22.2U
* device instance $135 r0 *1 427.32,29.96 nfet
M$135 vref hi_2_n \$143 vss nfet L=0.28U W=10U AS=11P AD=11P PS=22.2U PD=22.2U
* device instance $136 r0 *1 430.2,29.96 nfet
M$136 vss lo_2_n \$143 vss nfet L=0.28U W=10U AS=11P AD=11P PS=22.2U PD=22.2U
* device instance $137 r0 *1 468.155,26.96 nfet
M$137 \$144 sel_in vss vss nfet L=0.35U W=4U AS=4.4P AD=4.4P PS=10.2U PD=10.2U
* device instance $138 r0 *1 471.105,26.96 nfet
M$138 \$146 rel_1_n vss vss nfet L=0.35U W=4U AS=4.4P AD=4.4P PS=10.2U PD=10.2U
* device instance $139 r0 *1 474.055,26.96 nfet
M$139 \$148 hi_1_n vss vss nfet L=0.35U W=4U AS=4.4P AD=4.4P PS=10.2U PD=10.2U
* device instance $140 r0 *1 477.005,26.96 nfet
M$140 \$150 lo_1_n vss vss nfet L=0.35U W=4U AS=4.4P AD=4.4P PS=10.2U PD=10.2U
* device instance $141 r0 *1 479.92,29.96 nfet
M$141 pinn sel_in \$151 vss nfet L=0.28U W=10U AS=11P AD=11P PS=22.2U PD=22.2U
* device instance $142 r0 *1 482.8,29.96 nfet
M$142 vcm rel_1_n \$151 vss nfet L=0.28U W=10U AS=11P AD=11P PS=22.2U PD=22.2U
* device instance $143 r0 *1 485.68,29.96 nfet
M$143 vref hi_1_n \$151 vss nfet L=0.28U W=10U AS=11P AD=11P PS=22.2U PD=22.2U
* device instance $144 r0 *1 488.56,29.96 nfet
M$144 vss lo_1_n \$151 vss nfet L=0.28U W=10U AS=11P AD=11P PS=22.2U PD=22.2U
* device instance $145 r0 *1 444.075,51.92 nfet
M$145 \$153 tp_gn vss vss nfet L=0.35U W=4U AS=4.4P AD=4.4P PS=10.2U PD=10.2U
* device instance $146 r0 *1 446.99,54.92 nfet
M$146 vcm tp_gn topp vss nfet L=0.28U W=10U AS=11P AD=11P PS=22.2U PD=22.2U
* device instance $147 r0 *1 457.535,51.92 nfet
M$147 \$154 tp_gn vss vss nfet L=0.35U W=4U AS=4.4P AD=4.4P PS=10.2U PD=10.2U
* device instance $148 r0 *1 460.45,54.92 nfet
M$148 vcm tp_gn topn vss nfet L=0.28U W=10U AS=11P AD=11P PS=22.2U PD=22.2U
* device instance $149 r0 *1 25.495,4 pfet
M$149 \$70 sel_in vdd vdd pfet L=0.35U W=8U AS=8.8P AD=8.8P PS=18.2U PD=18.2U
* device instance $150 r0 *1 28.445,4 pfet
M$150 \$34 rel_256_p vdd vdd pfet L=0.35U W=8U AS=8.8P AD=8.8P PS=18.2U PD=18.2U
* device instance $151 r0 *1 31.395,4 pfet
M$151 \$36 hi_256_p vdd vdd pfet L=0.35U W=8U AS=8.8P AD=8.8P PS=18.2U PD=18.2U
* device instance $152 r0 *1 34.345,4 pfet
M$152 \$7 lo_256_p vdd vdd pfet L=0.35U W=8U AS=8.8P AD=8.8P PS=18.2U PD=18.2U
* device instance $153 r0 *1 37.26,5 pfet
M$153 pinp \$70 \$8 vdd pfet L=0.28U W=10U AS=11P AD=11P PS=22.2U PD=12.2U
* device instance $154 r0 *1 39.74,5 pfet
M$154 \$8 \$70 pinp vdd pfet L=0.28U W=10U AS=11P AD=11P PS=12.2U PD=22.2U
* device instance $155 r0 *1 42.62,5 pfet
M$155 vcm \$34 \$8 vdd pfet L=0.28U W=10U AS=11P AD=11P PS=22.2U PD=12.2U
* device instance $156 r0 *1 45.1,5 pfet
M$156 \$8 \$34 vcm vdd pfet L=0.28U W=10U AS=11P AD=11P PS=12.2U PD=22.2U
* device instance $157 r0 *1 47.98,5 pfet
M$157 vref \$36 \$8 vdd pfet L=0.28U W=10U AS=11P AD=11P PS=22.2U PD=12.2U
* device instance $158 r0 *1 50.46,5 pfet
M$158 \$8 \$36 vref vdd pfet L=0.28U W=10U AS=11P AD=11P PS=12.2U PD=22.2U
* device instance $159 r0 *1 53.34,5 pfet
M$159 vss \$7 \$8 vdd pfet L=0.28U W=10U AS=11P AD=11P PS=22.2U PD=12.2U
* device instance $160 r0 *1 55.82,5 pfet
M$160 \$8 \$7 vss vdd pfet L=0.28U W=10U AS=11P AD=11P PS=12.2U PD=22.2U
* device instance $161 r0 *1 83.855,4 pfet
M$161 \$71 sel_in vdd vdd pfet L=0.35U W=8U AS=8.8P AD=8.8P PS=18.2U PD=18.2U
* device instance $162 r0 *1 86.805,4 pfet
M$162 \$38 rel_128_p vdd vdd pfet L=0.35U W=8U AS=8.8P AD=8.8P PS=18.2U PD=18.2U
* device instance $163 r0 *1 89.755,4 pfet
M$163 \$40 hi_128_p vdd vdd pfet L=0.35U W=8U AS=8.8P AD=8.8P PS=18.2U PD=18.2U
* device instance $164 r0 *1 92.705,4 pfet
M$164 \$10 lo_128_p vdd vdd pfet L=0.35U W=8U AS=8.8P AD=8.8P PS=18.2U PD=18.2U
* device instance $165 r0 *1 95.62,5 pfet
M$165 pinp \$71 \$11 vdd pfet L=0.28U W=10U AS=11P AD=11P PS=22.2U PD=12.2U
* device instance $166 r0 *1 98.1,5 pfet
M$166 \$11 \$71 pinp vdd pfet L=0.28U W=10U AS=11P AD=11P PS=12.2U PD=22.2U
* device instance $167 r0 *1 100.98,5 pfet
M$167 vcm \$38 \$11 vdd pfet L=0.28U W=10U AS=11P AD=11P PS=22.2U PD=12.2U
* device instance $168 r0 *1 103.46,5 pfet
M$168 \$11 \$38 vcm vdd pfet L=0.28U W=10U AS=11P AD=11P PS=12.2U PD=22.2U
* device instance $169 r0 *1 106.34,5 pfet
M$169 vref \$40 \$11 vdd pfet L=0.28U W=10U AS=11P AD=11P PS=22.2U PD=12.2U
* device instance $170 r0 *1 108.82,5 pfet
M$170 \$11 \$40 vref vdd pfet L=0.28U W=10U AS=11P AD=11P PS=12.2U PD=22.2U
* device instance $171 r0 *1 111.7,5 pfet
M$171 vss \$10 \$11 vdd pfet L=0.28U W=10U AS=11P AD=11P PS=22.2U PD=12.2U
* device instance $172 r0 *1 114.18,5 pfet
M$172 \$11 \$10 vss vdd pfet L=0.28U W=10U AS=11P AD=11P PS=12.2U PD=22.2U
* device instance $173 r0 *1 142.215,4 pfet
M$173 \$72 sel_in vdd vdd pfet L=0.35U W=8U AS=8.8P AD=8.8P PS=18.2U PD=18.2U
* device instance $174 r0 *1 145.165,4 pfet
M$174 \$42 rel_64_p vdd vdd pfet L=0.35U W=8U AS=8.8P AD=8.8P PS=18.2U PD=18.2U
* device instance $175 r0 *1 148.115,4 pfet
M$175 \$44 hi_64_p vdd vdd pfet L=0.35U W=8U AS=8.8P AD=8.8P PS=18.2U PD=18.2U
* device instance $176 r0 *1 151.065,4 pfet
M$176 \$13 lo_64_p vdd vdd pfet L=0.35U W=8U AS=8.8P AD=8.8P PS=18.2U PD=18.2U
* device instance $177 r0 *1 153.98,5 pfet
M$177 pinp \$72 \$14 vdd pfet L=0.28U W=10U AS=11P AD=11P PS=22.2U PD=12.2U
* device instance $178 r0 *1 156.46,5 pfet
M$178 \$14 \$72 pinp vdd pfet L=0.28U W=10U AS=11P AD=11P PS=12.2U PD=22.2U
* device instance $179 r0 *1 159.34,5 pfet
M$179 vcm \$42 \$14 vdd pfet L=0.28U W=10U AS=11P AD=11P PS=22.2U PD=12.2U
* device instance $180 r0 *1 161.82,5 pfet
M$180 \$14 \$42 vcm vdd pfet L=0.28U W=10U AS=11P AD=11P PS=12.2U PD=22.2U
* device instance $181 r0 *1 164.7,5 pfet
M$181 vref \$44 \$14 vdd pfet L=0.28U W=10U AS=11P AD=11P PS=22.2U PD=12.2U
* device instance $182 r0 *1 167.18,5 pfet
M$182 \$14 \$44 vref vdd pfet L=0.28U W=10U AS=11P AD=11P PS=12.2U PD=22.2U
* device instance $183 r0 *1 170.06,5 pfet
M$183 vss \$13 \$14 vdd pfet L=0.28U W=10U AS=11P AD=11P PS=22.2U PD=12.2U
* device instance $184 r0 *1 172.54,5 pfet
M$184 \$14 \$13 vss vdd pfet L=0.28U W=10U AS=11P AD=11P PS=12.2U PD=22.2U
* device instance $185 r0 *1 200.575,4 pfet
M$185 \$73 sel_in vdd vdd pfet L=0.35U W=8U AS=8.8P AD=8.8P PS=18.2U PD=18.2U
* device instance $186 r0 *1 203.525,4 pfet
M$186 \$46 rel_32_p vdd vdd pfet L=0.35U W=8U AS=8.8P AD=8.8P PS=18.2U PD=18.2U
* device instance $187 r0 *1 206.475,4 pfet
M$187 \$48 hi_32_p vdd vdd pfet L=0.35U W=8U AS=8.8P AD=8.8P PS=18.2U PD=18.2U
* device instance $188 r0 *1 209.425,4 pfet
M$188 \$16 lo_32_p vdd vdd pfet L=0.35U W=8U AS=8.8P AD=8.8P PS=18.2U PD=18.2U
* device instance $189 r0 *1 212.34,5 pfet
M$189 pinp \$73 \$17 vdd pfet L=0.28U W=10U AS=11P AD=11P PS=22.2U PD=12.2U
* device instance $190 r0 *1 214.82,5 pfet
M$190 \$17 \$73 pinp vdd pfet L=0.28U W=10U AS=11P AD=11P PS=12.2U PD=22.2U
* device instance $191 r0 *1 217.7,5 pfet
M$191 vcm \$46 \$17 vdd pfet L=0.28U W=10U AS=11P AD=11P PS=22.2U PD=12.2U
* device instance $192 r0 *1 220.18,5 pfet
M$192 \$17 \$46 vcm vdd pfet L=0.28U W=10U AS=11P AD=11P PS=12.2U PD=22.2U
* device instance $193 r0 *1 223.06,5 pfet
M$193 vref \$48 \$17 vdd pfet L=0.28U W=10U AS=11P AD=11P PS=22.2U PD=12.2U
* device instance $194 r0 *1 225.54,5 pfet
M$194 \$17 \$48 vref vdd pfet L=0.28U W=10U AS=11P AD=11P PS=12.2U PD=22.2U
* device instance $195 r0 *1 228.42,5 pfet
M$195 vss \$16 \$17 vdd pfet L=0.28U W=10U AS=11P AD=11P PS=22.2U PD=12.2U
* device instance $196 r0 *1 230.9,5 pfet
M$196 \$17 \$16 vss vdd pfet L=0.28U W=10U AS=11P AD=11P PS=12.2U PD=22.2U
* device instance $197 r0 *1 258.935,4 pfet
M$197 \$74 sel_in vdd vdd pfet L=0.35U W=8U AS=8.8P AD=8.8P PS=18.2U PD=18.2U
* device instance $198 r0 *1 261.885,4 pfet
M$198 \$50 rel_16_p vdd vdd pfet L=0.35U W=8U AS=8.8P AD=8.8P PS=18.2U PD=18.2U
* device instance $199 r0 *1 264.835,4 pfet
M$199 \$52 hi_16_p vdd vdd pfet L=0.35U W=8U AS=8.8P AD=8.8P PS=18.2U PD=18.2U
* device instance $200 r0 *1 267.785,4 pfet
M$200 \$19 lo_16_p vdd vdd pfet L=0.35U W=8U AS=8.8P AD=8.8P PS=18.2U PD=18.2U
* device instance $201 r0 *1 270.7,5 pfet
M$201 pinp \$74 \$20 vdd pfet L=0.28U W=10U AS=11P AD=11P PS=22.2U PD=12.2U
* device instance $202 r0 *1 273.18,5 pfet
M$202 \$20 \$74 pinp vdd pfet L=0.28U W=10U AS=11P AD=11P PS=12.2U PD=22.2U
* device instance $203 r0 *1 276.06,5 pfet
M$203 vcm \$50 \$20 vdd pfet L=0.28U W=10U AS=11P AD=11P PS=22.2U PD=12.2U
* device instance $204 r0 *1 278.54,5 pfet
M$204 \$20 \$50 vcm vdd pfet L=0.28U W=10U AS=11P AD=11P PS=12.2U PD=22.2U
* device instance $205 r0 *1 281.42,5 pfet
M$205 vref \$52 \$20 vdd pfet L=0.28U W=10U AS=11P AD=11P PS=22.2U PD=12.2U
* device instance $206 r0 *1 283.9,5 pfet
M$206 \$20 \$52 vref vdd pfet L=0.28U W=10U AS=11P AD=11P PS=12.2U PD=22.2U
* device instance $207 r0 *1 286.78,5 pfet
M$207 vss \$19 \$20 vdd pfet L=0.28U W=10U AS=11P AD=11P PS=22.2U PD=12.2U
* device instance $208 r0 *1 289.26,5 pfet
M$208 \$20 \$19 vss vdd pfet L=0.28U W=10U AS=11P AD=11P PS=12.2U PD=22.2U
* device instance $209 r0 *1 317.295,4 pfet
M$209 \$75 sel_in vdd vdd pfet L=0.35U W=8U AS=8.8P AD=8.8P PS=18.2U PD=18.2U
* device instance $210 r0 *1 320.245,4 pfet
M$210 \$54 rel_8_p vdd vdd pfet L=0.35U W=8U AS=8.8P AD=8.8P PS=18.2U PD=18.2U
* device instance $211 r0 *1 323.195,4 pfet
M$211 \$56 hi_8_p vdd vdd pfet L=0.35U W=8U AS=8.8P AD=8.8P PS=18.2U PD=18.2U
* device instance $212 r0 *1 326.145,4 pfet
M$212 \$22 lo_8_p vdd vdd pfet L=0.35U W=8U AS=8.8P AD=8.8P PS=18.2U PD=18.2U
* device instance $213 r0 *1 329.06,5 pfet
M$213 pinp \$75 \$23 vdd pfet L=0.28U W=10U AS=11P AD=11P PS=22.2U PD=12.2U
* device instance $214 r0 *1 331.54,5 pfet
M$214 \$23 \$75 pinp vdd pfet L=0.28U W=10U AS=11P AD=11P PS=12.2U PD=22.2U
* device instance $215 r0 *1 334.42,5 pfet
M$215 vcm \$54 \$23 vdd pfet L=0.28U W=10U AS=11P AD=11P PS=22.2U PD=12.2U
* device instance $216 r0 *1 336.9,5 pfet
M$216 \$23 \$54 vcm vdd pfet L=0.28U W=10U AS=11P AD=11P PS=12.2U PD=22.2U
* device instance $217 r0 *1 339.78,5 pfet
M$217 vref \$56 \$23 vdd pfet L=0.28U W=10U AS=11P AD=11P PS=22.2U PD=12.2U
* device instance $218 r0 *1 342.26,5 pfet
M$218 \$23 \$56 vref vdd pfet L=0.28U W=10U AS=11P AD=11P PS=12.2U PD=22.2U
* device instance $219 r0 *1 345.14,5 pfet
M$219 vss \$22 \$23 vdd pfet L=0.28U W=10U AS=11P AD=11P PS=22.2U PD=12.2U
* device instance $220 r0 *1 347.62,5 pfet
M$220 \$23 \$22 vss vdd pfet L=0.28U W=10U AS=11P AD=11P PS=12.2U PD=22.2U
* device instance $221 r0 *1 375.655,4 pfet
M$221 \$76 sel_in vdd vdd pfet L=0.35U W=8U AS=8.8P AD=8.8P PS=18.2U PD=18.2U
* device instance $222 r0 *1 378.605,4 pfet
M$222 \$58 rel_4_p vdd vdd pfet L=0.35U W=8U AS=8.8P AD=8.8P PS=18.2U PD=18.2U
* device instance $223 r0 *1 381.555,4 pfet
M$223 \$60 hi_4_p vdd vdd pfet L=0.35U W=8U AS=8.8P AD=8.8P PS=18.2U PD=18.2U
* device instance $224 r0 *1 384.505,4 pfet
M$224 \$25 lo_4_p vdd vdd pfet L=0.35U W=8U AS=8.8P AD=8.8P PS=18.2U PD=18.2U
* device instance $225 r0 *1 387.42,5 pfet
M$225 pinp \$76 \$26 vdd pfet L=0.28U W=10U AS=11P AD=11P PS=22.2U PD=12.2U
* device instance $226 r0 *1 389.9,5 pfet
M$226 \$26 \$76 pinp vdd pfet L=0.28U W=10U AS=11P AD=11P PS=12.2U PD=22.2U
* device instance $227 r0 *1 392.78,5 pfet
M$227 vcm \$58 \$26 vdd pfet L=0.28U W=10U AS=11P AD=11P PS=22.2U PD=12.2U
* device instance $228 r0 *1 395.26,5 pfet
M$228 \$26 \$58 vcm vdd pfet L=0.28U W=10U AS=11P AD=11P PS=12.2U PD=22.2U
* device instance $229 r0 *1 398.14,5 pfet
M$229 vref \$60 \$26 vdd pfet L=0.28U W=10U AS=11P AD=11P PS=22.2U PD=12.2U
* device instance $230 r0 *1 400.62,5 pfet
M$230 \$26 \$60 vref vdd pfet L=0.28U W=10U AS=11P AD=11P PS=12.2U PD=22.2U
* device instance $231 r0 *1 403.5,5 pfet
M$231 vss \$25 \$26 vdd pfet L=0.28U W=10U AS=11P AD=11P PS=22.2U PD=12.2U
* device instance $232 r0 *1 405.98,5 pfet
M$232 \$26 \$25 vss vdd pfet L=0.28U W=10U AS=11P AD=11P PS=12.2U PD=22.2U
* device instance $233 r0 *1 434.015,4 pfet
M$233 \$77 sel_in vdd vdd pfet L=0.35U W=8U AS=8.8P AD=8.8P PS=18.2U PD=18.2U
* device instance $234 r0 *1 436.965,4 pfet
M$234 \$62 rel_2_p vdd vdd pfet L=0.35U W=8U AS=8.8P AD=8.8P PS=18.2U PD=18.2U
* device instance $235 r0 *1 439.915,4 pfet
M$235 \$64 hi_2_p vdd vdd pfet L=0.35U W=8U AS=8.8P AD=8.8P PS=18.2U PD=18.2U
* device instance $236 r0 *1 442.865,4 pfet
M$236 \$28 lo_2_p vdd vdd pfet L=0.35U W=8U AS=8.8P AD=8.8P PS=18.2U PD=18.2U
* device instance $237 r0 *1 445.78,5 pfet
M$237 pinp \$77 \$29 vdd pfet L=0.28U W=10U AS=11P AD=11P PS=22.2U PD=12.2U
* device instance $238 r0 *1 448.26,5 pfet
M$238 \$29 \$77 pinp vdd pfet L=0.28U W=10U AS=11P AD=11P PS=12.2U PD=22.2U
* device instance $239 r0 *1 451.14,5 pfet
M$239 vcm \$62 \$29 vdd pfet L=0.28U W=10U AS=11P AD=11P PS=22.2U PD=12.2U
* device instance $240 r0 *1 453.62,5 pfet
M$240 \$29 \$62 vcm vdd pfet L=0.28U W=10U AS=11P AD=11P PS=12.2U PD=22.2U
* device instance $241 r0 *1 456.5,5 pfet
M$241 vref \$64 \$29 vdd pfet L=0.28U W=10U AS=11P AD=11P PS=22.2U PD=12.2U
* device instance $242 r0 *1 458.98,5 pfet
M$242 \$29 \$64 vref vdd pfet L=0.28U W=10U AS=11P AD=11P PS=12.2U PD=22.2U
* device instance $243 r0 *1 461.86,5 pfet
M$243 vss \$28 \$29 vdd pfet L=0.28U W=10U AS=11P AD=11P PS=22.2U PD=12.2U
* device instance $244 r0 *1 464.34,5 pfet
M$244 \$29 \$28 vss vdd pfet L=0.28U W=10U AS=11P AD=11P PS=12.2U PD=22.2U
* device instance $245 r0 *1 492.375,4 pfet
M$245 \$78 sel_in vdd vdd pfet L=0.35U W=8U AS=8.8P AD=8.8P PS=18.2U PD=18.2U
* device instance $246 r0 *1 495.325,4 pfet
M$246 \$66 rel_1_p vdd vdd pfet L=0.35U W=8U AS=8.8P AD=8.8P PS=18.2U PD=18.2U
* device instance $247 r0 *1 498.275,4 pfet
M$247 \$68 hi_1_p vdd vdd pfet L=0.35U W=8U AS=8.8P AD=8.8P PS=18.2U PD=18.2U
* device instance $248 r0 *1 501.225,4 pfet
M$248 \$31 lo_1_p vdd vdd pfet L=0.35U W=8U AS=8.8P AD=8.8P PS=18.2U PD=18.2U
* device instance $249 r0 *1 504.14,5 pfet
M$249 pinp \$78 \$32 vdd pfet L=0.28U W=10U AS=11P AD=11P PS=22.2U PD=12.2U
* device instance $250 r0 *1 506.62,5 pfet
M$250 \$32 \$78 pinp vdd pfet L=0.28U W=10U AS=11P AD=11P PS=12.2U PD=22.2U
* device instance $251 r0 *1 509.5,5 pfet
M$251 vcm \$66 \$32 vdd pfet L=0.28U W=10U AS=11P AD=11P PS=22.2U PD=12.2U
* device instance $252 r0 *1 511.98,5 pfet
M$252 \$32 \$66 vcm vdd pfet L=0.28U W=10U AS=11P AD=11P PS=12.2U PD=22.2U
* device instance $253 r0 *1 514.86,5 pfet
M$253 vref \$68 \$32 vdd pfet L=0.28U W=10U AS=11P AD=11P PS=22.2U PD=12.2U
* device instance $254 r0 *1 517.34,5 pfet
M$254 \$32 \$68 vref vdd pfet L=0.28U W=10U AS=11P AD=11P PS=12.2U PD=22.2U
* device instance $255 r0 *1 520.22,5 pfet
M$255 vss \$31 \$32 vdd pfet L=0.28U W=10U AS=11P AD=11P PS=22.2U PD=12.2U
* device instance $256 r0 *1 522.7,5 pfet
M$256 \$32 \$31 vss vdd pfet L=0.28U W=10U AS=11P AD=11P PS=12.2U PD=22.2U
* device instance $257 r0 *1 25.495,28.96 pfet
M$257 \$79 sel_in vdd vdd pfet L=0.35U W=8U AS=8.8P AD=8.8P PS=18.2U PD=18.2U
* device instance $258 r0 *1 28.445,28.96 pfet
M$258 \$81 rel_256_n vdd vdd pfet L=0.35U W=8U AS=8.8P AD=8.8P PS=18.2U PD=18.2U
* device instance $259 r0 *1 31.395,28.96 pfet
M$259 \$83 hi_256_n vdd vdd pfet L=0.35U W=8U AS=8.8P AD=8.8P PS=18.2U PD=18.2U
* device instance $260 r0 *1 34.345,28.96 pfet
M$260 \$85 lo_256_n vdd vdd pfet L=0.35U W=8U AS=8.8P AD=8.8P PS=18.2U PD=18.2U
* device instance $261 r0 *1 37.26,29.96 pfet
M$261 pinn \$79 \$86 vdd pfet L=0.28U W=10U AS=11P AD=11P PS=22.2U PD=12.2U
* device instance $262 r0 *1 39.74,29.96 pfet
M$262 \$86 \$79 pinn vdd pfet L=0.28U W=10U AS=11P AD=11P PS=12.2U PD=22.2U
* device instance $263 r0 *1 42.62,29.96 pfet
M$263 vcm \$81 \$86 vdd pfet L=0.28U W=10U AS=11P AD=11P PS=22.2U PD=12.2U
* device instance $264 r0 *1 45.1,29.96 pfet
M$264 \$86 \$81 vcm vdd pfet L=0.28U W=10U AS=11P AD=11P PS=12.2U PD=22.2U
* device instance $265 r0 *1 47.98,29.96 pfet
M$265 vref \$83 \$86 vdd pfet L=0.28U W=10U AS=11P AD=11P PS=22.2U PD=12.2U
* device instance $266 r0 *1 50.46,29.96 pfet
M$266 \$86 \$83 vref vdd pfet L=0.28U W=10U AS=11P AD=11P PS=12.2U PD=22.2U
* device instance $267 r0 *1 53.34,29.96 pfet
M$267 vss \$85 \$86 vdd pfet L=0.28U W=10U AS=11P AD=11P PS=22.2U PD=12.2U
* device instance $268 r0 *1 55.82,29.96 pfet
M$268 \$86 \$85 vss vdd pfet L=0.28U W=10U AS=11P AD=11P PS=12.2U PD=22.2U
* device instance $269 r0 *1 83.855,28.96 pfet
M$269 \$88 sel_in vdd vdd pfet L=0.35U W=8U AS=8.8P AD=8.8P PS=18.2U PD=18.2U
* device instance $270 r0 *1 86.805,28.96 pfet
M$270 \$90 rel_128_n vdd vdd pfet L=0.35U W=8U AS=8.8P AD=8.8P PS=18.2U PD=18.2U
* device instance $271 r0 *1 89.755,28.96 pfet
M$271 \$92 hi_128_n vdd vdd pfet L=0.35U W=8U AS=8.8P AD=8.8P PS=18.2U PD=18.2U
* device instance $272 r0 *1 92.705,28.96 pfet
M$272 \$94 lo_128_n vdd vdd pfet L=0.35U W=8U AS=8.8P AD=8.8P PS=18.2U PD=18.2U
* device instance $273 r0 *1 95.62,29.96 pfet
M$273 pinn \$88 \$95 vdd pfet L=0.28U W=10U AS=11P AD=11P PS=22.2U PD=12.2U
* device instance $274 r0 *1 98.1,29.96 pfet
M$274 \$95 \$88 pinn vdd pfet L=0.28U W=10U AS=11P AD=11P PS=12.2U PD=22.2U
* device instance $275 r0 *1 100.98,29.96 pfet
M$275 vcm \$90 \$95 vdd pfet L=0.28U W=10U AS=11P AD=11P PS=22.2U PD=12.2U
* device instance $276 r0 *1 103.46,29.96 pfet
M$276 \$95 \$90 vcm vdd pfet L=0.28U W=10U AS=11P AD=11P PS=12.2U PD=22.2U
* device instance $277 r0 *1 106.34,29.96 pfet
M$277 vref \$92 \$95 vdd pfet L=0.28U W=10U AS=11P AD=11P PS=22.2U PD=12.2U
* device instance $278 r0 *1 108.82,29.96 pfet
M$278 \$95 \$92 vref vdd pfet L=0.28U W=10U AS=11P AD=11P PS=12.2U PD=22.2U
* device instance $279 r0 *1 111.7,29.96 pfet
M$279 vss \$94 \$95 vdd pfet L=0.28U W=10U AS=11P AD=11P PS=22.2U PD=12.2U
* device instance $280 r0 *1 114.18,29.96 pfet
M$280 \$95 \$94 vss vdd pfet L=0.28U W=10U AS=11P AD=11P PS=12.2U PD=22.2U
* device instance $281 r0 *1 142.215,28.96 pfet
M$281 \$96 sel_in vdd vdd pfet L=0.35U W=8U AS=8.8P AD=8.8P PS=18.2U PD=18.2U
* device instance $282 r0 *1 145.165,28.96 pfet
M$282 \$98 rel_64_n vdd vdd pfet L=0.35U W=8U AS=8.8P AD=8.8P PS=18.2U PD=18.2U
* device instance $283 r0 *1 148.115,28.96 pfet
M$283 \$100 hi_64_n vdd vdd pfet L=0.35U W=8U AS=8.8P AD=8.8P PS=18.2U PD=18.2U
* device instance $284 r0 *1 151.065,28.96 pfet
M$284 \$102 lo_64_n vdd vdd pfet L=0.35U W=8U AS=8.8P AD=8.8P PS=18.2U PD=18.2U
* device instance $285 r0 *1 153.98,29.96 pfet
M$285 pinn \$96 \$103 vdd pfet L=0.28U W=10U AS=11P AD=11P PS=22.2U PD=12.2U
* device instance $286 r0 *1 156.46,29.96 pfet
M$286 \$103 \$96 pinn vdd pfet L=0.28U W=10U AS=11P AD=11P PS=12.2U PD=22.2U
* device instance $287 r0 *1 159.34,29.96 pfet
M$287 vcm \$98 \$103 vdd pfet L=0.28U W=10U AS=11P AD=11P PS=22.2U PD=12.2U
* device instance $288 r0 *1 161.82,29.96 pfet
M$288 \$103 \$98 vcm vdd pfet L=0.28U W=10U AS=11P AD=11P PS=12.2U PD=22.2U
* device instance $289 r0 *1 164.7,29.96 pfet
M$289 vref \$100 \$103 vdd pfet L=0.28U W=10U AS=11P AD=11P PS=22.2U PD=12.2U
* device instance $290 r0 *1 167.18,29.96 pfet
M$290 \$103 \$100 vref vdd pfet L=0.28U W=10U AS=11P AD=11P PS=12.2U PD=22.2U
* device instance $291 r0 *1 170.06,29.96 pfet
M$291 vss \$102 \$103 vdd pfet L=0.28U W=10U AS=11P AD=11P PS=22.2U PD=12.2U
* device instance $292 r0 *1 172.54,29.96 pfet
M$292 \$103 \$102 vss vdd pfet L=0.28U W=10U AS=11P AD=11P PS=12.2U PD=22.2U
* device instance $293 r0 *1 200.575,28.96 pfet
M$293 \$104 sel_in vdd vdd pfet L=0.35U W=8U AS=8.8P AD=8.8P PS=18.2U PD=18.2U
* device instance $294 r0 *1 203.525,28.96 pfet
M$294 \$106 rel_32_n vdd vdd pfet L=0.35U W=8U AS=8.8P AD=8.8P PS=18.2U PD=18.2U
* device instance $295 r0 *1 206.475,28.96 pfet
M$295 \$108 hi_32_n vdd vdd pfet L=0.35U W=8U AS=8.8P AD=8.8P PS=18.2U PD=18.2U
* device instance $296 r0 *1 209.425,28.96 pfet
M$296 \$110 lo_32_n vdd vdd pfet L=0.35U W=8U AS=8.8P AD=8.8P PS=18.2U PD=18.2U
* device instance $297 r0 *1 212.34,29.96 pfet
M$297 pinn \$104 \$111 vdd pfet L=0.28U W=10U AS=11P AD=11P PS=22.2U PD=12.2U
* device instance $298 r0 *1 214.82,29.96 pfet
M$298 \$111 \$104 pinn vdd pfet L=0.28U W=10U AS=11P AD=11P PS=12.2U PD=22.2U
* device instance $299 r0 *1 217.7,29.96 pfet
M$299 vcm \$106 \$111 vdd pfet L=0.28U W=10U AS=11P AD=11P PS=22.2U PD=12.2U
* device instance $300 r0 *1 220.18,29.96 pfet
M$300 \$111 \$106 vcm vdd pfet L=0.28U W=10U AS=11P AD=11P PS=12.2U PD=22.2U
* device instance $301 r0 *1 223.06,29.96 pfet
M$301 vref \$108 \$111 vdd pfet L=0.28U W=10U AS=11P AD=11P PS=22.2U PD=12.2U
* device instance $302 r0 *1 225.54,29.96 pfet
M$302 \$111 \$108 vref vdd pfet L=0.28U W=10U AS=11P AD=11P PS=12.2U PD=22.2U
* device instance $303 r0 *1 228.42,29.96 pfet
M$303 vss \$110 \$111 vdd pfet L=0.28U W=10U AS=11P AD=11P PS=22.2U PD=12.2U
* device instance $304 r0 *1 230.9,29.96 pfet
M$304 \$111 \$110 vss vdd pfet L=0.28U W=10U AS=11P AD=11P PS=12.2U PD=22.2U
* device instance $305 r0 *1 258.935,28.96 pfet
M$305 \$112 sel_in vdd vdd pfet L=0.35U W=8U AS=8.8P AD=8.8P PS=18.2U PD=18.2U
* device instance $306 r0 *1 261.885,28.96 pfet
M$306 \$114 rel_16_n vdd vdd pfet L=0.35U W=8U AS=8.8P AD=8.8P PS=18.2U PD=18.2U
* device instance $307 r0 *1 264.835,28.96 pfet
M$307 \$116 hi_16_n vdd vdd pfet L=0.35U W=8U AS=8.8P AD=8.8P PS=18.2U PD=18.2U
* device instance $308 r0 *1 267.785,28.96 pfet
M$308 \$118 lo_16_n vdd vdd pfet L=0.35U W=8U AS=8.8P AD=8.8P PS=18.2U PD=18.2U
* device instance $309 r0 *1 270.7,29.96 pfet
M$309 pinn \$112 \$119 vdd pfet L=0.28U W=10U AS=11P AD=11P PS=22.2U PD=12.2U
* device instance $310 r0 *1 273.18,29.96 pfet
M$310 \$119 \$112 pinn vdd pfet L=0.28U W=10U AS=11P AD=11P PS=12.2U PD=22.2U
* device instance $311 r0 *1 276.06,29.96 pfet
M$311 vcm \$114 \$119 vdd pfet L=0.28U W=10U AS=11P AD=11P PS=22.2U PD=12.2U
* device instance $312 r0 *1 278.54,29.96 pfet
M$312 \$119 \$114 vcm vdd pfet L=0.28U W=10U AS=11P AD=11P PS=12.2U PD=22.2U
* device instance $313 r0 *1 281.42,29.96 pfet
M$313 vref \$116 \$119 vdd pfet L=0.28U W=10U AS=11P AD=11P PS=22.2U PD=12.2U
* device instance $314 r0 *1 283.9,29.96 pfet
M$314 \$119 \$116 vref vdd pfet L=0.28U W=10U AS=11P AD=11P PS=12.2U PD=22.2U
* device instance $315 r0 *1 286.78,29.96 pfet
M$315 vss \$118 \$119 vdd pfet L=0.28U W=10U AS=11P AD=11P PS=22.2U PD=12.2U
* device instance $316 r0 *1 289.26,29.96 pfet
M$316 \$119 \$118 vss vdd pfet L=0.28U W=10U AS=11P AD=11P PS=12.2U PD=22.2U
* device instance $317 r0 *1 317.295,28.96 pfet
M$317 \$120 sel_in vdd vdd pfet L=0.35U W=8U AS=8.8P AD=8.8P PS=18.2U PD=18.2U
* device instance $318 r0 *1 320.245,28.96 pfet
M$318 \$122 rel_8_n vdd vdd pfet L=0.35U W=8U AS=8.8P AD=8.8P PS=18.2U PD=18.2U
* device instance $319 r0 *1 323.195,28.96 pfet
M$319 \$124 hi_8_n vdd vdd pfet L=0.35U W=8U AS=8.8P AD=8.8P PS=18.2U PD=18.2U
* device instance $320 r0 *1 326.145,28.96 pfet
M$320 \$126 lo_8_n vdd vdd pfet L=0.35U W=8U AS=8.8P AD=8.8P PS=18.2U PD=18.2U
* device instance $321 r0 *1 329.06,29.96 pfet
M$321 pinn \$120 \$127 vdd pfet L=0.28U W=10U AS=11P AD=11P PS=22.2U PD=12.2U
* device instance $322 r0 *1 331.54,29.96 pfet
M$322 \$127 \$120 pinn vdd pfet L=0.28U W=10U AS=11P AD=11P PS=12.2U PD=22.2U
* device instance $323 r0 *1 334.42,29.96 pfet
M$323 vcm \$122 \$127 vdd pfet L=0.28U W=10U AS=11P AD=11P PS=22.2U PD=12.2U
* device instance $324 r0 *1 336.9,29.96 pfet
M$324 \$127 \$122 vcm vdd pfet L=0.28U W=10U AS=11P AD=11P PS=12.2U PD=22.2U
* device instance $325 r0 *1 339.78,29.96 pfet
M$325 vref \$124 \$127 vdd pfet L=0.28U W=10U AS=11P AD=11P PS=22.2U PD=12.2U
* device instance $326 r0 *1 342.26,29.96 pfet
M$326 \$127 \$124 vref vdd pfet L=0.28U W=10U AS=11P AD=11P PS=12.2U PD=22.2U
* device instance $327 r0 *1 345.14,29.96 pfet
M$327 vss \$126 \$127 vdd pfet L=0.28U W=10U AS=11P AD=11P PS=22.2U PD=12.2U
* device instance $328 r0 *1 347.62,29.96 pfet
M$328 \$127 \$126 vss vdd pfet L=0.28U W=10U AS=11P AD=11P PS=12.2U PD=22.2U
* device instance $329 r0 *1 375.655,28.96 pfet
M$329 \$128 sel_in vdd vdd pfet L=0.35U W=8U AS=8.8P AD=8.8P PS=18.2U PD=18.2U
* device instance $330 r0 *1 378.605,28.96 pfet
M$330 \$130 rel_4_n vdd vdd pfet L=0.35U W=8U AS=8.8P AD=8.8P PS=18.2U PD=18.2U
* device instance $331 r0 *1 381.555,28.96 pfet
M$331 \$132 hi_4_n vdd vdd pfet L=0.35U W=8U AS=8.8P AD=8.8P PS=18.2U PD=18.2U
* device instance $332 r0 *1 384.505,28.96 pfet
M$332 \$134 lo_4_n vdd vdd pfet L=0.35U W=8U AS=8.8P AD=8.8P PS=18.2U PD=18.2U
* device instance $333 r0 *1 387.42,29.96 pfet
M$333 pinn \$128 \$135 vdd pfet L=0.28U W=10U AS=11P AD=11P PS=22.2U PD=12.2U
* device instance $334 r0 *1 389.9,29.96 pfet
M$334 \$135 \$128 pinn vdd pfet L=0.28U W=10U AS=11P AD=11P PS=12.2U PD=22.2U
* device instance $335 r0 *1 392.78,29.96 pfet
M$335 vcm \$130 \$135 vdd pfet L=0.28U W=10U AS=11P AD=11P PS=22.2U PD=12.2U
* device instance $336 r0 *1 395.26,29.96 pfet
M$336 \$135 \$130 vcm vdd pfet L=0.28U W=10U AS=11P AD=11P PS=12.2U PD=22.2U
* device instance $337 r0 *1 398.14,29.96 pfet
M$337 vref \$132 \$135 vdd pfet L=0.28U W=10U AS=11P AD=11P PS=22.2U PD=12.2U
* device instance $338 r0 *1 400.62,29.96 pfet
M$338 \$135 \$132 vref vdd pfet L=0.28U W=10U AS=11P AD=11P PS=12.2U PD=22.2U
* device instance $339 r0 *1 403.5,29.96 pfet
M$339 vss \$134 \$135 vdd pfet L=0.28U W=10U AS=11P AD=11P PS=22.2U PD=12.2U
* device instance $340 r0 *1 405.98,29.96 pfet
M$340 \$135 \$134 vss vdd pfet L=0.28U W=10U AS=11P AD=11P PS=12.2U PD=22.2U
* device instance $341 r0 *1 434.015,28.96 pfet
M$341 \$136 sel_in vdd vdd pfet L=0.35U W=8U AS=8.8P AD=8.8P PS=18.2U PD=18.2U
* device instance $342 r0 *1 436.965,28.96 pfet
M$342 \$138 rel_2_n vdd vdd pfet L=0.35U W=8U AS=8.8P AD=8.8P PS=18.2U PD=18.2U
* device instance $343 r0 *1 439.915,28.96 pfet
M$343 \$140 hi_2_n vdd vdd pfet L=0.35U W=8U AS=8.8P AD=8.8P PS=18.2U PD=18.2U
* device instance $344 r0 *1 442.865,28.96 pfet
M$344 \$142 lo_2_n vdd vdd pfet L=0.35U W=8U AS=8.8P AD=8.8P PS=18.2U PD=18.2U
* device instance $345 r0 *1 445.78,29.96 pfet
M$345 pinn \$136 \$143 vdd pfet L=0.28U W=10U AS=11P AD=11P PS=22.2U PD=12.2U
* device instance $346 r0 *1 448.26,29.96 pfet
M$346 \$143 \$136 pinn vdd pfet L=0.28U W=10U AS=11P AD=11P PS=12.2U PD=22.2U
* device instance $347 r0 *1 451.14,29.96 pfet
M$347 vcm \$138 \$143 vdd pfet L=0.28U W=10U AS=11P AD=11P PS=22.2U PD=12.2U
* device instance $348 r0 *1 453.62,29.96 pfet
M$348 \$143 \$138 vcm vdd pfet L=0.28U W=10U AS=11P AD=11P PS=12.2U PD=22.2U
* device instance $349 r0 *1 456.5,29.96 pfet
M$349 vref \$140 \$143 vdd pfet L=0.28U W=10U AS=11P AD=11P PS=22.2U PD=12.2U
* device instance $350 r0 *1 458.98,29.96 pfet
M$350 \$143 \$140 vref vdd pfet L=0.28U W=10U AS=11P AD=11P PS=12.2U PD=22.2U
* device instance $351 r0 *1 461.86,29.96 pfet
M$351 vss \$142 \$143 vdd pfet L=0.28U W=10U AS=11P AD=11P PS=22.2U PD=12.2U
* device instance $352 r0 *1 464.34,29.96 pfet
M$352 \$143 \$142 vss vdd pfet L=0.28U W=10U AS=11P AD=11P PS=12.2U PD=22.2U
* device instance $353 r0 *1 492.375,28.96 pfet
M$353 \$144 sel_in vdd vdd pfet L=0.35U W=8U AS=8.8P AD=8.8P PS=18.2U PD=18.2U
* device instance $354 r0 *1 495.325,28.96 pfet
M$354 \$146 rel_1_n vdd vdd pfet L=0.35U W=8U AS=8.8P AD=8.8P PS=18.2U PD=18.2U
* device instance $355 r0 *1 498.275,28.96 pfet
M$355 \$148 hi_1_n vdd vdd pfet L=0.35U W=8U AS=8.8P AD=8.8P PS=18.2U PD=18.2U
* device instance $356 r0 *1 501.225,28.96 pfet
M$356 \$150 lo_1_n vdd vdd pfet L=0.35U W=8U AS=8.8P AD=8.8P PS=18.2U PD=18.2U
* device instance $357 r0 *1 504.14,29.96 pfet
M$357 pinn \$144 \$151 vdd pfet L=0.28U W=10U AS=11P AD=11P PS=22.2U PD=12.2U
* device instance $358 r0 *1 506.62,29.96 pfet
M$358 \$151 \$144 pinn vdd pfet L=0.28U W=10U AS=11P AD=11P PS=12.2U PD=22.2U
* device instance $359 r0 *1 509.5,29.96 pfet
M$359 vcm \$146 \$151 vdd pfet L=0.28U W=10U AS=11P AD=11P PS=22.2U PD=12.2U
* device instance $360 r0 *1 511.98,29.96 pfet
M$360 \$151 \$146 vcm vdd pfet L=0.28U W=10U AS=11P AD=11P PS=12.2U PD=22.2U
* device instance $361 r0 *1 514.86,29.96 pfet
M$361 vref \$148 \$151 vdd pfet L=0.28U W=10U AS=11P AD=11P PS=22.2U PD=12.2U
* device instance $362 r0 *1 517.34,29.96 pfet
M$362 \$151 \$148 vref vdd pfet L=0.28U W=10U AS=11P AD=11P PS=12.2U PD=22.2U
* device instance $363 r0 *1 520.22,29.96 pfet
M$363 vss \$150 \$151 vdd pfet L=0.28U W=10U AS=11P AD=11P PS=22.2U PD=12.2U
* device instance $364 r0 *1 522.7,29.96 pfet
M$364 \$151 \$150 vss vdd pfet L=0.28U W=10U AS=11P AD=11P PS=12.2U PD=22.2U
* device instance $365 r0 *1 450.805,53.92 pfet
M$365 \$153 tp_gn vdd vdd pfet L=0.35U W=8U AS=8.8P AD=8.8P PS=18.2U PD=18.2U
* device instance $366 r0 *1 453.72,59.92 pfet
M$366 vcm \$153 topp vdd pfet L=0.28U W=20U AS=22P AD=22P PS=42.2U PD=42.2U
* device instance $367 r0 *1 464.265,53.92 pfet
M$367 \$154 tp_gn vdd vdd pfet L=0.35U W=8U AS=8.8P AD=8.8P PS=18.2U PD=18.2U
* device instance $368 r0 *1 467.18,59.92 pfet
M$368 vcm \$154 topn vdd pfet L=0.28U W=20U AS=22P AD=22P PS=42.2U PD=42.2U
* device instance $369 r0 *1 2.6,52.52 cap_mim_2f0_m4m5_noshield
C$369 \$8 topp 3.56528e-14
* device instance $370 r0 *1 9,52.52 cap_mim_2f0_m4m5_noshield
C$370 \$29 topp 3.56528e-14
* device instance $371 r0 *1 15.4,52.52 cap_mim_2f0_m4m5_noshield
C$371 \$8 topp 3.56528e-14
* device instance $372 r0 *1 21.8,52.52 cap_mim_2f0_m4m5_noshield
C$372 \$26 topp 3.56528e-14
* device instance $373 r0 *1 28.2,52.52 cap_mim_2f0_m4m5_noshield
C$373 \$8 topp 3.56528e-14
* device instance $374 r0 *1 34.6,52.52 cap_mim_2f0_m4m5_noshield
C$374 \$23 topp 3.56528e-14
* device instance $375 r0 *1 41,52.52 cap_mim_2f0_m4m5_noshield
C$375 \$8 topp 3.56528e-14
* device instance $376 r0 *1 47.4,52.52 cap_mim_2f0_m4m5_noshield
C$376 \$23 topp 3.56528e-14
* device instance $377 r0 *1 53.8,52.52 cap_mim_2f0_m4m5_noshield
C$377 \$8 topp 3.56528e-14
* device instance $378 r0 *1 60.2,52.52 cap_mim_2f0_m4m5_noshield
C$378 \$20 topp 3.56528e-14
* device instance $379 r0 *1 66.6,52.52 cap_mim_2f0_m4m5_noshield
C$379 \$8 topp 3.56528e-14
* device instance $380 r0 *1 73,52.52 cap_mim_2f0_m4m5_noshield
C$380 \$20 topp 3.56528e-14
* device instance $381 r0 *1 79.4,52.52 cap_mim_2f0_m4m5_noshield
C$381 \$8 topp 3.56528e-14
* device instance $382 r0 *1 85.8,52.52 cap_mim_2f0_m4m5_noshield
C$382 \$20 topp 3.56528e-14
* device instance $383 r0 *1 92.2,52.52 cap_mim_2f0_m4m5_noshield
C$383 \$8 topp 3.56528e-14
* device instance $384 r0 *1 98.6,52.52 cap_mim_2f0_m4m5_noshield
C$384 \$20 topp 3.56528e-14
* device instance $385 r0 *1 105,52.52 cap_mim_2f0_m4m5_noshield
C$385 \$8 topp 3.56528e-14
* device instance $386 r0 *1 111.4,52.52 cap_mim_2f0_m4m5_noshield
C$386 \$17 topp 3.56528e-14
* device instance $387 r0 *1 117.8,52.52 cap_mim_2f0_m4m5_noshield
C$387 \$8 topp 3.56528e-14
* device instance $388 r0 *1 124.2,52.52 cap_mim_2f0_m4m5_noshield
C$388 \$17 topp 3.56528e-14
* device instance $389 r0 *1 130.6,52.52 cap_mim_2f0_m4m5_noshield
C$389 \$8 topp 3.56528e-14
* device instance $390 r0 *1 137,52.52 cap_mim_2f0_m4m5_noshield
C$390 \$17 topp 3.56528e-14
* device instance $391 r0 *1 143.4,52.52 cap_mim_2f0_m4m5_noshield
C$391 \$8 topp 3.56528e-14
* device instance $392 r0 *1 149.8,52.52 cap_mim_2f0_m4m5_noshield
C$392 \$17 topp 3.56528e-14
* device instance $393 r0 *1 156.2,52.52 cap_mim_2f0_m4m5_noshield
C$393 \$8 topp 3.56528e-14
* device instance $394 r0 *1 162.6,52.52 cap_mim_2f0_m4m5_noshield
C$394 \$17 topp 3.56528e-14
* device instance $395 r0 *1 169,52.52 cap_mim_2f0_m4m5_noshield
C$395 \$8 topp 3.56528e-14
* device instance $396 r0 *1 175.4,52.52 cap_mim_2f0_m4m5_noshield
C$396 \$17 topp 3.56528e-14
* device instance $397 r0 *1 181.8,52.52 cap_mim_2f0_m4m5_noshield
C$397 \$8 topp 3.56528e-14
* device instance $398 r0 *1 188.2,52.52 cap_mim_2f0_m4m5_noshield
C$398 \$17 topp 3.56528e-14
* device instance $399 r0 *1 194.6,52.52 cap_mim_2f0_m4m5_noshield
C$399 \$8 topp 3.56528e-14
* device instance $400 r0 *1 201,52.52 cap_mim_2f0_m4m5_noshield
C$400 \$17 topp 3.56528e-14
* device instance $401 r0 *1 224,52.52 cap_mim_2f0_m4m5_noshield
C$401 \$86 topn 3.56528e-14
* device instance $402 r0 *1 230.4,52.52 cap_mim_2f0_m4m5_noshield
C$402 \$143 topn 3.56528e-14
* device instance $403 r0 *1 236.8,52.52 cap_mim_2f0_m4m5_noshield
C$403 \$86 topn 3.56528e-14
* device instance $404 r0 *1 243.2,52.52 cap_mim_2f0_m4m5_noshield
C$404 \$135 topn 3.56528e-14
* device instance $405 r0 *1 249.6,52.52 cap_mim_2f0_m4m5_noshield
C$405 \$86 topn 3.56528e-14
* device instance $406 r0 *1 256,52.52 cap_mim_2f0_m4m5_noshield
C$406 \$127 topn 3.56528e-14
* device instance $407 r0 *1 262.4,52.52 cap_mim_2f0_m4m5_noshield
C$407 \$86 topn 3.56528e-14
* device instance $408 r0 *1 268.8,52.52 cap_mim_2f0_m4m5_noshield
C$408 \$127 topn 3.56528e-14
* device instance $409 r0 *1 275.2,52.52 cap_mim_2f0_m4m5_noshield
C$409 \$86 topn 3.56528e-14
* device instance $410 r0 *1 281.6,52.52 cap_mim_2f0_m4m5_noshield
C$410 \$119 topn 3.56528e-14
* device instance $411 r0 *1 288,52.52 cap_mim_2f0_m4m5_noshield
C$411 \$86 topn 3.56528e-14
* device instance $412 r0 *1 294.4,52.52 cap_mim_2f0_m4m5_noshield
C$412 \$119 topn 3.56528e-14
* device instance $413 r0 *1 300.8,52.52 cap_mim_2f0_m4m5_noshield
C$413 \$86 topn 3.56528e-14
* device instance $414 r0 *1 307.2,52.52 cap_mim_2f0_m4m5_noshield
C$414 \$119 topn 3.56528e-14
* device instance $415 r0 *1 313.6,52.52 cap_mim_2f0_m4m5_noshield
C$415 \$86 topn 3.56528e-14
* device instance $416 r0 *1 320,52.52 cap_mim_2f0_m4m5_noshield
C$416 \$119 topn 3.56528e-14
* device instance $417 r0 *1 326.4,52.52 cap_mim_2f0_m4m5_noshield
C$417 \$86 topn 3.56528e-14
* device instance $418 r0 *1 332.8,52.52 cap_mim_2f0_m4m5_noshield
C$418 \$111 topn 3.56528e-14
* device instance $419 r0 *1 339.2,52.52 cap_mim_2f0_m4m5_noshield
C$419 \$86 topn 3.56528e-14
* device instance $420 r0 *1 345.6,52.52 cap_mim_2f0_m4m5_noshield
C$420 \$111 topn 3.56528e-14
* device instance $421 r0 *1 352,52.52 cap_mim_2f0_m4m5_noshield
C$421 \$86 topn 3.56528e-14
* device instance $422 r0 *1 358.4,52.52 cap_mim_2f0_m4m5_noshield
C$422 \$111 topn 3.56528e-14
* device instance $423 r0 *1 364.8,52.52 cap_mim_2f0_m4m5_noshield
C$423 \$86 topn 3.56528e-14
* device instance $424 r0 *1 371.2,52.52 cap_mim_2f0_m4m5_noshield
C$424 \$111 topn 3.56528e-14
* device instance $425 r0 *1 377.6,52.52 cap_mim_2f0_m4m5_noshield
C$425 \$86 topn 3.56528e-14
* device instance $426 r0 *1 384,52.52 cap_mim_2f0_m4m5_noshield
C$426 \$111 topn 3.56528e-14
* device instance $427 r0 *1 390.4,52.52 cap_mim_2f0_m4m5_noshield
C$427 \$86 topn 3.56528e-14
* device instance $428 r0 *1 396.8,52.52 cap_mim_2f0_m4m5_noshield
C$428 \$111 topn 3.56528e-14
* device instance $429 r0 *1 403.2,52.52 cap_mim_2f0_m4m5_noshield
C$429 \$86 topn 3.56528e-14
* device instance $430 r0 *1 409.6,52.52 cap_mim_2f0_m4m5_noshield
C$430 \$111 topn 3.56528e-14
* device instance $431 r0 *1 416,52.52 cap_mim_2f0_m4m5_noshield
C$431 \$86 topn 3.56528e-14
* device instance $432 r0 *1 422.4,52.52 cap_mim_2f0_m4m5_noshield
C$432 \$111 topn 3.56528e-14
* device instance $433 r0 *1 2.6,58.92 cap_mim_2f0_m4m5_noshield
C$433 \$8 topp 3.56528e-14
* device instance $434 r0 *1 9,58.92 cap_mim_2f0_m4m5_noshield
C$434 \$14 topp 3.56528e-14
* device instance $435 r0 *1 15.4,58.92 cap_mim_2f0_m4m5_noshield
C$435 \$8 topp 3.56528e-14
* device instance $436 r0 *1 21.8,58.92 cap_mim_2f0_m4m5_noshield
C$436 \$14 topp 3.56528e-14
* device instance $437 r0 *1 28.2,58.92 cap_mim_2f0_m4m5_noshield
C$437 \$8 topp 3.56528e-14
* device instance $438 r0 *1 34.6,58.92 cap_mim_2f0_m4m5_noshield
C$438 \$14 topp 3.56528e-14
* device instance $439 r0 *1 41,58.92 cap_mim_2f0_m4m5_noshield
C$439 \$8 topp 3.56528e-14
* device instance $440 r0 *1 47.4,58.92 cap_mim_2f0_m4m5_noshield
C$440 \$14 topp 3.56528e-14
* device instance $441 r0 *1 53.8,58.92 cap_mim_2f0_m4m5_noshield
C$441 \$8 topp 3.56528e-14
* device instance $442 r0 *1 60.2,58.92 cap_mim_2f0_m4m5_noshield
C$442 \$14 topp 3.56528e-14
* device instance $443 r0 *1 66.6,58.92 cap_mim_2f0_m4m5_noshield
C$443 \$8 topp 3.56528e-14
* device instance $444 r0 *1 73,58.92 cap_mim_2f0_m4m5_noshield
C$444 \$14 topp 3.56528e-14
* device instance $445 r0 *1 79.4,58.92 cap_mim_2f0_m4m5_noshield
C$445 \$8 topp 3.56528e-14
* device instance $446 r0 *1 85.8,58.92 cap_mim_2f0_m4m5_noshield
C$446 \$14 topp 3.56528e-14
* device instance $447 r0 *1 92.2,58.92 cap_mim_2f0_m4m5_noshield
C$447 \$8 topp 3.56528e-14
* device instance $448 r0 *1 98.6,58.92 cap_mim_2f0_m4m5_noshield
C$448 \$14 topp 3.56528e-14
* device instance $449 r0 *1 105,58.92 cap_mim_2f0_m4m5_noshield
C$449 \$8 topp 3.56528e-14
* device instance $450 r0 *1 111.4,58.92 cap_mim_2f0_m4m5_noshield
C$450 \$14 topp 3.56528e-14
* device instance $451 r0 *1 117.8,58.92 cap_mim_2f0_m4m5_noshield
C$451 \$8 topp 3.56528e-14
* device instance $452 r0 *1 124.2,58.92 cap_mim_2f0_m4m5_noshield
C$452 \$14 topp 3.56528e-14
* device instance $453 r0 *1 130.6,58.92 cap_mim_2f0_m4m5_noshield
C$453 \$8 topp 3.56528e-14
* device instance $454 r0 *1 137,58.92 cap_mim_2f0_m4m5_noshield
C$454 \$14 topp 3.56528e-14
* device instance $455 r0 *1 143.4,58.92 cap_mim_2f0_m4m5_noshield
C$455 \$8 topp 3.56528e-14
* device instance $456 r0 *1 149.8,58.92 cap_mim_2f0_m4m5_noshield
C$456 \$14 topp 3.56528e-14
* device instance $457 r0 *1 156.2,58.92 cap_mim_2f0_m4m5_noshield
C$457 \$8 topp 3.56528e-14
* device instance $458 r0 *1 162.6,58.92 cap_mim_2f0_m4m5_noshield
C$458 \$14 topp 3.56528e-14
* device instance $459 r0 *1 169,58.92 cap_mim_2f0_m4m5_noshield
C$459 \$8 topp 3.56528e-14
* device instance $460 r0 *1 175.4,58.92 cap_mim_2f0_m4m5_noshield
C$460 \$14 topp 3.56528e-14
* device instance $461 r0 *1 181.8,58.92 cap_mim_2f0_m4m5_noshield
C$461 \$8 topp 3.56528e-14
* device instance $462 r0 *1 188.2,58.92 cap_mim_2f0_m4m5_noshield
C$462 \$14 topp 3.56528e-14
* device instance $463 r0 *1 194.6,58.92 cap_mim_2f0_m4m5_noshield
C$463 \$8 topp 3.56528e-14
* device instance $464 r0 *1 201,58.92 cap_mim_2f0_m4m5_noshield
C$464 \$14 topp 3.56528e-14
* device instance $465 r0 *1 224,58.92 cap_mim_2f0_m4m5_noshield
C$465 \$86 topn 3.56528e-14
* device instance $466 r0 *1 230.4,58.92 cap_mim_2f0_m4m5_noshield
C$466 \$103 topn 3.56528e-14
* device instance $467 r0 *1 236.8,58.92 cap_mim_2f0_m4m5_noshield
C$467 \$86 topn 3.56528e-14
* device instance $468 r0 *1 243.2,58.92 cap_mim_2f0_m4m5_noshield
C$468 \$103 topn 3.56528e-14
* device instance $469 r0 *1 249.6,58.92 cap_mim_2f0_m4m5_noshield
C$469 \$86 topn 3.56528e-14
* device instance $470 r0 *1 256,58.92 cap_mim_2f0_m4m5_noshield
C$470 \$103 topn 3.56528e-14
* device instance $471 r0 *1 262.4,58.92 cap_mim_2f0_m4m5_noshield
C$471 \$86 topn 3.56528e-14
* device instance $472 r0 *1 268.8,58.92 cap_mim_2f0_m4m5_noshield
C$472 \$103 topn 3.56528e-14
* device instance $473 r0 *1 275.2,58.92 cap_mim_2f0_m4m5_noshield
C$473 \$86 topn 3.56528e-14
* device instance $474 r0 *1 281.6,58.92 cap_mim_2f0_m4m5_noshield
C$474 \$103 topn 3.56528e-14
* device instance $475 r0 *1 288,58.92 cap_mim_2f0_m4m5_noshield
C$475 \$86 topn 3.56528e-14
* device instance $476 r0 *1 294.4,58.92 cap_mim_2f0_m4m5_noshield
C$476 \$103 topn 3.56528e-14
* device instance $477 r0 *1 300.8,58.92 cap_mim_2f0_m4m5_noshield
C$477 \$86 topn 3.56528e-14
* device instance $478 r0 *1 307.2,58.92 cap_mim_2f0_m4m5_noshield
C$478 \$103 topn 3.56528e-14
* device instance $479 r0 *1 313.6,58.92 cap_mim_2f0_m4m5_noshield
C$479 \$86 topn 3.56528e-14
* device instance $480 r0 *1 320,58.92 cap_mim_2f0_m4m5_noshield
C$480 \$103 topn 3.56528e-14
* device instance $481 r0 *1 326.4,58.92 cap_mim_2f0_m4m5_noshield
C$481 \$86 topn 3.56528e-14
* device instance $482 r0 *1 332.8,58.92 cap_mim_2f0_m4m5_noshield
C$482 \$103 topn 3.56528e-14
* device instance $483 r0 *1 339.2,58.92 cap_mim_2f0_m4m5_noshield
C$483 \$86 topn 3.56528e-14
* device instance $484 r0 *1 345.6,58.92 cap_mim_2f0_m4m5_noshield
C$484 \$103 topn 3.56528e-14
* device instance $485 r0 *1 352,58.92 cap_mim_2f0_m4m5_noshield
C$485 \$86 topn 3.56528e-14
* device instance $486 r0 *1 358.4,58.92 cap_mim_2f0_m4m5_noshield
C$486 \$103 topn 3.56528e-14
* device instance $487 r0 *1 364.8,58.92 cap_mim_2f0_m4m5_noshield
C$487 \$86 topn 3.56528e-14
* device instance $488 r0 *1 371.2,58.92 cap_mim_2f0_m4m5_noshield
C$488 \$103 topn 3.56528e-14
* device instance $489 r0 *1 377.6,58.92 cap_mim_2f0_m4m5_noshield
C$489 \$86 topn 3.56528e-14
* device instance $490 r0 *1 384,58.92 cap_mim_2f0_m4m5_noshield
C$490 \$103 topn 3.56528e-14
* device instance $491 r0 *1 390.4,58.92 cap_mim_2f0_m4m5_noshield
C$491 \$86 topn 3.56528e-14
* device instance $492 r0 *1 396.8,58.92 cap_mim_2f0_m4m5_noshield
C$492 \$103 topn 3.56528e-14
* device instance $493 r0 *1 403.2,58.92 cap_mim_2f0_m4m5_noshield
C$493 \$86 topn 3.56528e-14
* device instance $494 r0 *1 409.6,58.92 cap_mim_2f0_m4m5_noshield
C$494 \$103 topn 3.56528e-14
* device instance $495 r0 *1 416,58.92 cap_mim_2f0_m4m5_noshield
C$495 \$86 topn 3.56528e-14
* device instance $496 r0 *1 422.4,58.92 cap_mim_2f0_m4m5_noshield
C$496 \$103 topn 3.56528e-14
* device instance $497 r0 *1 2.6,65.32 cap_mim_2f0_m4m5_noshield
C$497 \$8 topp 3.56528e-14
* device instance $498 r0 *1 9,65.32 cap_mim_2f0_m4m5_noshield
C$498 \$11 topp 3.56528e-14
* device instance $499 r0 *1 15.4,65.32 cap_mim_2f0_m4m5_noshield
C$499 \$8 topp 3.56528e-14
* device instance $500 r0 *1 21.8,65.32 cap_mim_2f0_m4m5_noshield
C$500 \$11 topp 3.56528e-14
* device instance $501 r0 *1 28.2,65.32 cap_mim_2f0_m4m5_noshield
C$501 \$8 topp 3.56528e-14
* device instance $502 r0 *1 34.6,65.32 cap_mim_2f0_m4m5_noshield
C$502 \$11 topp 3.56528e-14
* device instance $503 r0 *1 41,65.32 cap_mim_2f0_m4m5_noshield
C$503 \$8 topp 3.56528e-14
* device instance $504 r0 *1 47.4,65.32 cap_mim_2f0_m4m5_noshield
C$504 \$11 topp 3.56528e-14
* device instance $505 r0 *1 53.8,65.32 cap_mim_2f0_m4m5_noshield
C$505 \$8 topp 3.56528e-14
* device instance $506 r0 *1 60.2,65.32 cap_mim_2f0_m4m5_noshield
C$506 \$11 topp 3.56528e-14
* device instance $507 r0 *1 66.6,65.32 cap_mim_2f0_m4m5_noshield
C$507 \$8 topp 3.56528e-14
* device instance $508 r0 *1 73,65.32 cap_mim_2f0_m4m5_noshield
C$508 \$11 topp 3.56528e-14
* device instance $509 r0 *1 79.4,65.32 cap_mim_2f0_m4m5_noshield
C$509 \$8 topp 3.56528e-14
* device instance $510 r0 *1 85.8,65.32 cap_mim_2f0_m4m5_noshield
C$510 \$11 topp 3.56528e-14
* device instance $511 r0 *1 92.2,65.32 cap_mim_2f0_m4m5_noshield
C$511 \$8 topp 3.56528e-14
* device instance $512 r0 *1 98.6,65.32 cap_mim_2f0_m4m5_noshield
C$512 \$11 topp 3.56528e-14
* device instance $513 r0 *1 105,65.32 cap_mim_2f0_m4m5_noshield
C$513 \$8 topp 3.56528e-14
* device instance $514 r0 *1 111.4,65.32 cap_mim_2f0_m4m5_noshield
C$514 \$11 topp 3.56528e-14
* device instance $515 r0 *1 117.8,65.32 cap_mim_2f0_m4m5_noshield
C$515 \$8 topp 3.56528e-14
* device instance $516 r0 *1 124.2,65.32 cap_mim_2f0_m4m5_noshield
C$516 \$11 topp 3.56528e-14
* device instance $517 r0 *1 130.6,65.32 cap_mim_2f0_m4m5_noshield
C$517 \$8 topp 3.56528e-14
* device instance $518 r0 *1 137,65.32 cap_mim_2f0_m4m5_noshield
C$518 \$11 topp 3.56528e-14
* device instance $519 r0 *1 143.4,65.32 cap_mim_2f0_m4m5_noshield
C$519 \$8 topp 3.56528e-14
* device instance $520 r0 *1 149.8,65.32 cap_mim_2f0_m4m5_noshield
C$520 \$11 topp 3.56528e-14
* device instance $521 r0 *1 156.2,65.32 cap_mim_2f0_m4m5_noshield
C$521 \$8 topp 3.56528e-14
* device instance $522 r0 *1 162.6,65.32 cap_mim_2f0_m4m5_noshield
C$522 \$11 topp 3.56528e-14
* device instance $523 r0 *1 169,65.32 cap_mim_2f0_m4m5_noshield
C$523 \$8 topp 3.56528e-14
* device instance $524 r0 *1 175.4,65.32 cap_mim_2f0_m4m5_noshield
C$524 \$11 topp 3.56528e-14
* device instance $525 r0 *1 181.8,65.32 cap_mim_2f0_m4m5_noshield
C$525 \$8 topp 3.56528e-14
* device instance $526 r0 *1 188.2,65.32 cap_mim_2f0_m4m5_noshield
C$526 \$11 topp 3.56528e-14
* device instance $527 r0 *1 194.6,65.32 cap_mim_2f0_m4m5_noshield
C$527 \$8 topp 3.56528e-14
* device instance $528 r0 *1 201,65.32 cap_mim_2f0_m4m5_noshield
C$528 \$11 topp 3.56528e-14
* device instance $529 r0 *1 224,65.32 cap_mim_2f0_m4m5_noshield
C$529 \$86 topn 3.56528e-14
* device instance $530 r0 *1 230.4,65.32 cap_mim_2f0_m4m5_noshield
C$530 \$95 topn 3.56528e-14
* device instance $531 r0 *1 236.8,65.32 cap_mim_2f0_m4m5_noshield
C$531 \$86 topn 3.56528e-14
* device instance $532 r0 *1 243.2,65.32 cap_mim_2f0_m4m5_noshield
C$532 \$95 topn 3.56528e-14
* device instance $533 r0 *1 249.6,65.32 cap_mim_2f0_m4m5_noshield
C$533 \$86 topn 3.56528e-14
* device instance $534 r0 *1 256,65.32 cap_mim_2f0_m4m5_noshield
C$534 \$95 topn 3.56528e-14
* device instance $535 r0 *1 262.4,65.32 cap_mim_2f0_m4m5_noshield
C$535 \$86 topn 3.56528e-14
* device instance $536 r0 *1 268.8,65.32 cap_mim_2f0_m4m5_noshield
C$536 \$95 topn 3.56528e-14
* device instance $537 r0 *1 275.2,65.32 cap_mim_2f0_m4m5_noshield
C$537 \$86 topn 3.56528e-14
* device instance $538 r0 *1 281.6,65.32 cap_mim_2f0_m4m5_noshield
C$538 \$95 topn 3.56528e-14
* device instance $539 r0 *1 288,65.32 cap_mim_2f0_m4m5_noshield
C$539 \$86 topn 3.56528e-14
* device instance $540 r0 *1 294.4,65.32 cap_mim_2f0_m4m5_noshield
C$540 \$95 topn 3.56528e-14
* device instance $541 r0 *1 300.8,65.32 cap_mim_2f0_m4m5_noshield
C$541 \$86 topn 3.56528e-14
* device instance $542 r0 *1 307.2,65.32 cap_mim_2f0_m4m5_noshield
C$542 \$95 topn 3.56528e-14
* device instance $543 r0 *1 313.6,65.32 cap_mim_2f0_m4m5_noshield
C$543 \$86 topn 3.56528e-14
* device instance $544 r0 *1 320,65.32 cap_mim_2f0_m4m5_noshield
C$544 \$95 topn 3.56528e-14
* device instance $545 r0 *1 326.4,65.32 cap_mim_2f0_m4m5_noshield
C$545 \$86 topn 3.56528e-14
* device instance $546 r0 *1 332.8,65.32 cap_mim_2f0_m4m5_noshield
C$546 \$95 topn 3.56528e-14
* device instance $547 r0 *1 339.2,65.32 cap_mim_2f0_m4m5_noshield
C$547 \$86 topn 3.56528e-14
* device instance $548 r0 *1 345.6,65.32 cap_mim_2f0_m4m5_noshield
C$548 \$95 topn 3.56528e-14
* device instance $549 r0 *1 352,65.32 cap_mim_2f0_m4m5_noshield
C$549 \$86 topn 3.56528e-14
* device instance $550 r0 *1 358.4,65.32 cap_mim_2f0_m4m5_noshield
C$550 \$95 topn 3.56528e-14
* device instance $551 r0 *1 364.8,65.32 cap_mim_2f0_m4m5_noshield
C$551 \$86 topn 3.56528e-14
* device instance $552 r0 *1 371.2,65.32 cap_mim_2f0_m4m5_noshield
C$552 \$95 topn 3.56528e-14
* device instance $553 r0 *1 377.6,65.32 cap_mim_2f0_m4m5_noshield
C$553 \$86 topn 3.56528e-14
* device instance $554 r0 *1 384,65.32 cap_mim_2f0_m4m5_noshield
C$554 \$95 topn 3.56528e-14
* device instance $555 r0 *1 390.4,65.32 cap_mim_2f0_m4m5_noshield
C$555 \$86 topn 3.56528e-14
* device instance $556 r0 *1 396.8,65.32 cap_mim_2f0_m4m5_noshield
C$556 \$95 topn 3.56528e-14
* device instance $557 r0 *1 403.2,65.32 cap_mim_2f0_m4m5_noshield
C$557 \$86 topn 3.56528e-14
* device instance $558 r0 *1 409.6,65.32 cap_mim_2f0_m4m5_noshield
C$558 \$95 topn 3.56528e-14
* device instance $559 r0 *1 416,65.32 cap_mim_2f0_m4m5_noshield
C$559 \$86 topn 3.56528e-14
* device instance $560 r0 *1 422.4,65.32 cap_mim_2f0_m4m5_noshield
C$560 \$95 topn 3.56528e-14
* device instance $561 r0 *1 2.6,71.72 cap_mim_2f0_m4m5_noshield
C$561 \$8 topp 3.56528e-14
* device instance $562 r0 *1 9,71.72 cap_mim_2f0_m4m5_noshield
C$562 \$11 topp 3.56528e-14
* device instance $563 r0 *1 15.4,71.72 cap_mim_2f0_m4m5_noshield
C$563 \$8 topp 3.56528e-14
* device instance $564 r0 *1 21.8,71.72 cap_mim_2f0_m4m5_noshield
C$564 \$11 topp 3.56528e-14
* device instance $565 r0 *1 28.2,71.72 cap_mim_2f0_m4m5_noshield
C$565 \$8 topp 3.56528e-14
* device instance $566 r0 *1 34.6,71.72 cap_mim_2f0_m4m5_noshield
C$566 \$11 topp 3.56528e-14
* device instance $567 r0 *1 41,71.72 cap_mim_2f0_m4m5_noshield
C$567 \$8 topp 3.56528e-14
* device instance $568 r0 *1 47.4,71.72 cap_mim_2f0_m4m5_noshield
C$568 \$11 topp 3.56528e-14
* device instance $569 r0 *1 53.8,71.72 cap_mim_2f0_m4m5_noshield
C$569 \$8 topp 3.56528e-14
* device instance $570 r0 *1 60.2,71.72 cap_mim_2f0_m4m5_noshield
C$570 \$11 topp 3.56528e-14
* device instance $571 r0 *1 66.6,71.72 cap_mim_2f0_m4m5_noshield
C$571 \$8 topp 3.56528e-14
* device instance $572 r0 *1 73,71.72 cap_mim_2f0_m4m5_noshield
C$572 \$11 topp 3.56528e-14
* device instance $573 r0 *1 79.4,71.72 cap_mim_2f0_m4m5_noshield
C$573 \$8 topp 3.56528e-14
* device instance $574 r0 *1 85.8,71.72 cap_mim_2f0_m4m5_noshield
C$574 \$11 topp 3.56528e-14
* device instance $575 r0 *1 92.2,71.72 cap_mim_2f0_m4m5_noshield
C$575 \$8 topp 3.56528e-14
* device instance $576 r0 *1 98.6,71.72 cap_mim_2f0_m4m5_noshield
C$576 \$11 topp 3.56528e-14
* device instance $577 r0 *1 105,71.72 cap_mim_2f0_m4m5_noshield
C$577 \$8 topp 3.56528e-14
* device instance $578 r0 *1 111.4,71.72 cap_mim_2f0_m4m5_noshield
C$578 \$11 topp 3.56528e-14
* device instance $579 r0 *1 117.8,71.72 cap_mim_2f0_m4m5_noshield
C$579 \$8 topp 3.56528e-14
* device instance $580 r0 *1 124.2,71.72 cap_mim_2f0_m4m5_noshield
C$580 \$11 topp 3.56528e-14
* device instance $581 r0 *1 130.6,71.72 cap_mim_2f0_m4m5_noshield
C$581 \$8 topp 3.56528e-14
* device instance $582 r0 *1 137,71.72 cap_mim_2f0_m4m5_noshield
C$582 \$11 topp 3.56528e-14
* device instance $583 r0 *1 143.4,71.72 cap_mim_2f0_m4m5_noshield
C$583 \$8 topp 3.56528e-14
* device instance $584 r0 *1 149.8,71.72 cap_mim_2f0_m4m5_noshield
C$584 \$11 topp 3.56528e-14
* device instance $585 r0 *1 156.2,71.72 cap_mim_2f0_m4m5_noshield
C$585 \$8 topp 3.56528e-14
* device instance $586 r0 *1 162.6,71.72 cap_mim_2f0_m4m5_noshield
C$586 \$11 topp 3.56528e-14
* device instance $587 r0 *1 169,71.72 cap_mim_2f0_m4m5_noshield
C$587 \$8 topp 3.56528e-14
* device instance $588 r0 *1 175.4,71.72 cap_mim_2f0_m4m5_noshield
C$588 \$11 topp 3.56528e-14
* device instance $589 r0 *1 181.8,71.72 cap_mim_2f0_m4m5_noshield
C$589 \$8 topp 3.56528e-14
* device instance $590 r0 *1 188.2,71.72 cap_mim_2f0_m4m5_noshield
C$590 \$11 topp 3.56528e-14
* device instance $591 r0 *1 194.6,71.72 cap_mim_2f0_m4m5_noshield
C$591 \$8 topp 3.56528e-14
* device instance $592 r0 *1 201,71.72 cap_mim_2f0_m4m5_noshield
C$592 \$11 topp 3.56528e-14
* device instance $593 r0 *1 224,71.72 cap_mim_2f0_m4m5_noshield
C$593 \$86 topn 3.56528e-14
* device instance $594 r0 *1 230.4,71.72 cap_mim_2f0_m4m5_noshield
C$594 \$95 topn 3.56528e-14
* device instance $595 r0 *1 236.8,71.72 cap_mim_2f0_m4m5_noshield
C$595 \$86 topn 3.56528e-14
* device instance $596 r0 *1 243.2,71.72 cap_mim_2f0_m4m5_noshield
C$596 \$95 topn 3.56528e-14
* device instance $597 r0 *1 249.6,71.72 cap_mim_2f0_m4m5_noshield
C$597 \$86 topn 3.56528e-14
* device instance $598 r0 *1 256,71.72 cap_mim_2f0_m4m5_noshield
C$598 \$95 topn 3.56528e-14
* device instance $599 r0 *1 262.4,71.72 cap_mim_2f0_m4m5_noshield
C$599 \$86 topn 3.56528e-14
* device instance $600 r0 *1 268.8,71.72 cap_mim_2f0_m4m5_noshield
C$600 \$95 topn 3.56528e-14
* device instance $601 r0 *1 275.2,71.72 cap_mim_2f0_m4m5_noshield
C$601 \$86 topn 3.56528e-14
* device instance $602 r0 *1 281.6,71.72 cap_mim_2f0_m4m5_noshield
C$602 \$95 topn 3.56528e-14
* device instance $603 r0 *1 288,71.72 cap_mim_2f0_m4m5_noshield
C$603 \$86 topn 3.56528e-14
* device instance $604 r0 *1 294.4,71.72 cap_mim_2f0_m4m5_noshield
C$604 \$95 topn 3.56528e-14
* device instance $605 r0 *1 300.8,71.72 cap_mim_2f0_m4m5_noshield
C$605 \$86 topn 3.56528e-14
* device instance $606 r0 *1 307.2,71.72 cap_mim_2f0_m4m5_noshield
C$606 \$95 topn 3.56528e-14
* device instance $607 r0 *1 313.6,71.72 cap_mim_2f0_m4m5_noshield
C$607 \$86 topn 3.56528e-14
* device instance $608 r0 *1 320,71.72 cap_mim_2f0_m4m5_noshield
C$608 \$95 topn 3.56528e-14
* device instance $609 r0 *1 326.4,71.72 cap_mim_2f0_m4m5_noshield
C$609 \$86 topn 3.56528e-14
* device instance $610 r0 *1 332.8,71.72 cap_mim_2f0_m4m5_noshield
C$610 \$95 topn 3.56528e-14
* device instance $611 r0 *1 339.2,71.72 cap_mim_2f0_m4m5_noshield
C$611 \$86 topn 3.56528e-14
* device instance $612 r0 *1 345.6,71.72 cap_mim_2f0_m4m5_noshield
C$612 \$95 topn 3.56528e-14
* device instance $613 r0 *1 352,71.72 cap_mim_2f0_m4m5_noshield
C$613 \$86 topn 3.56528e-14
* device instance $614 r0 *1 358.4,71.72 cap_mim_2f0_m4m5_noshield
C$614 \$95 topn 3.56528e-14
* device instance $615 r0 *1 364.8,71.72 cap_mim_2f0_m4m5_noshield
C$615 \$86 topn 3.56528e-14
* device instance $616 r0 *1 371.2,71.72 cap_mim_2f0_m4m5_noshield
C$616 \$95 topn 3.56528e-14
* device instance $617 r0 *1 377.6,71.72 cap_mim_2f0_m4m5_noshield
C$617 \$86 topn 3.56528e-14
* device instance $618 r0 *1 384,71.72 cap_mim_2f0_m4m5_noshield
C$618 \$95 topn 3.56528e-14
* device instance $619 r0 *1 390.4,71.72 cap_mim_2f0_m4m5_noshield
C$619 \$86 topn 3.56528e-14
* device instance $620 r0 *1 396.8,71.72 cap_mim_2f0_m4m5_noshield
C$620 \$95 topn 3.56528e-14
* device instance $621 r0 *1 403.2,71.72 cap_mim_2f0_m4m5_noshield
C$621 \$86 topn 3.56528e-14
* device instance $622 r0 *1 409.6,71.72 cap_mim_2f0_m4m5_noshield
C$622 \$95 topn 3.56528e-14
* device instance $623 r0 *1 416,71.72 cap_mim_2f0_m4m5_noshield
C$623 \$86 topn 3.56528e-14
* device instance $624 r0 *1 422.4,71.72 cap_mim_2f0_m4m5_noshield
C$624 \$95 topn 3.56528e-14
* device instance $625 r0 *1 2.6,78.12 cap_mim_2f0_m4m5_noshield
C$625 \$11 topp 3.56528e-14
* device instance $626 r0 *1 9,78.12 cap_mim_2f0_m4m5_noshield
C$626 \$8 topp 3.56528e-14
* device instance $627 r0 *1 15.4,78.12 cap_mim_2f0_m4m5_noshield
C$627 \$11 topp 3.56528e-14
* device instance $628 r0 *1 21.8,78.12 cap_mim_2f0_m4m5_noshield
C$628 \$8 topp 3.56528e-14
* device instance $629 r0 *1 28.2,78.12 cap_mim_2f0_m4m5_noshield
C$629 \$11 topp 3.56528e-14
* device instance $630 r0 *1 34.6,78.12 cap_mim_2f0_m4m5_noshield
C$630 \$8 topp 3.56528e-14
* device instance $631 r0 *1 41,78.12 cap_mim_2f0_m4m5_noshield
C$631 \$11 topp 3.56528e-14
* device instance $632 r0 *1 47.4,78.12 cap_mim_2f0_m4m5_noshield
C$632 \$8 topp 3.56528e-14
* device instance $633 r0 *1 53.8,78.12 cap_mim_2f0_m4m5_noshield
C$633 \$11 topp 3.56528e-14
* device instance $634 r0 *1 60.2,78.12 cap_mim_2f0_m4m5_noshield
C$634 \$8 topp 3.56528e-14
* device instance $635 r0 *1 66.6,78.12 cap_mim_2f0_m4m5_noshield
C$635 \$11 topp 3.56528e-14
* device instance $636 r0 *1 73,78.12 cap_mim_2f0_m4m5_noshield
C$636 \$8 topp 3.56528e-14
* device instance $637 r0 *1 79.4,78.12 cap_mim_2f0_m4m5_noshield
C$637 \$11 topp 3.56528e-14
* device instance $638 r0 *1 85.8,78.12 cap_mim_2f0_m4m5_noshield
C$638 \$8 topp 3.56528e-14
* device instance $639 r0 *1 92.2,78.12 cap_mim_2f0_m4m5_noshield
C$639 \$11 topp 3.56528e-14
* device instance $640 r0 *1 98.6,78.12 cap_mim_2f0_m4m5_noshield
C$640 \$8 topp 3.56528e-14
* device instance $641 r0 *1 105,78.12 cap_mim_2f0_m4m5_noshield
C$641 \$11 topp 3.56528e-14
* device instance $642 r0 *1 111.4,78.12 cap_mim_2f0_m4m5_noshield
C$642 \$8 topp 3.56528e-14
* device instance $643 r0 *1 117.8,78.12 cap_mim_2f0_m4m5_noshield
C$643 \$11 topp 3.56528e-14
* device instance $644 r0 *1 124.2,78.12 cap_mim_2f0_m4m5_noshield
C$644 \$8 topp 3.56528e-14
* device instance $645 r0 *1 130.6,78.12 cap_mim_2f0_m4m5_noshield
C$645 \$11 topp 3.56528e-14
* device instance $646 r0 *1 137,78.12 cap_mim_2f0_m4m5_noshield
C$646 \$8 topp 3.56528e-14
* device instance $647 r0 *1 143.4,78.12 cap_mim_2f0_m4m5_noshield
C$647 \$11 topp 3.56528e-14
* device instance $648 r0 *1 149.8,78.12 cap_mim_2f0_m4m5_noshield
C$648 \$8 topp 3.56528e-14
* device instance $649 r0 *1 156.2,78.12 cap_mim_2f0_m4m5_noshield
C$649 \$11 topp 3.56528e-14
* device instance $650 r0 *1 162.6,78.12 cap_mim_2f0_m4m5_noshield
C$650 \$8 topp 3.56528e-14
* device instance $651 r0 *1 169,78.12 cap_mim_2f0_m4m5_noshield
C$651 \$11 topp 3.56528e-14
* device instance $652 r0 *1 175.4,78.12 cap_mim_2f0_m4m5_noshield
C$652 \$8 topp 3.56528e-14
* device instance $653 r0 *1 181.8,78.12 cap_mim_2f0_m4m5_noshield
C$653 \$11 topp 3.56528e-14
* device instance $654 r0 *1 188.2,78.12 cap_mim_2f0_m4m5_noshield
C$654 \$8 topp 3.56528e-14
* device instance $655 r0 *1 194.6,78.12 cap_mim_2f0_m4m5_noshield
C$655 \$11 topp 3.56528e-14
* device instance $656 r0 *1 201,78.12 cap_mim_2f0_m4m5_noshield
C$656 \$8 topp 3.56528e-14
* device instance $657 r0 *1 224,78.12 cap_mim_2f0_m4m5_noshield
C$657 \$95 topn 3.56528e-14
* device instance $658 r0 *1 230.4,78.12 cap_mim_2f0_m4m5_noshield
C$658 \$86 topn 3.56528e-14
* device instance $659 r0 *1 236.8,78.12 cap_mim_2f0_m4m5_noshield
C$659 \$95 topn 3.56528e-14
* device instance $660 r0 *1 243.2,78.12 cap_mim_2f0_m4m5_noshield
C$660 \$86 topn 3.56528e-14
* device instance $661 r0 *1 249.6,78.12 cap_mim_2f0_m4m5_noshield
C$661 \$95 topn 3.56528e-14
* device instance $662 r0 *1 256,78.12 cap_mim_2f0_m4m5_noshield
C$662 \$86 topn 3.56528e-14
* device instance $663 r0 *1 262.4,78.12 cap_mim_2f0_m4m5_noshield
C$663 \$95 topn 3.56528e-14
* device instance $664 r0 *1 268.8,78.12 cap_mim_2f0_m4m5_noshield
C$664 \$86 topn 3.56528e-14
* device instance $665 r0 *1 275.2,78.12 cap_mim_2f0_m4m5_noshield
C$665 \$95 topn 3.56528e-14
* device instance $666 r0 *1 281.6,78.12 cap_mim_2f0_m4m5_noshield
C$666 \$86 topn 3.56528e-14
* device instance $667 r0 *1 288,78.12 cap_mim_2f0_m4m5_noshield
C$667 \$95 topn 3.56528e-14
* device instance $668 r0 *1 294.4,78.12 cap_mim_2f0_m4m5_noshield
C$668 \$86 topn 3.56528e-14
* device instance $669 r0 *1 300.8,78.12 cap_mim_2f0_m4m5_noshield
C$669 \$95 topn 3.56528e-14
* device instance $670 r0 *1 307.2,78.12 cap_mim_2f0_m4m5_noshield
C$670 \$86 topn 3.56528e-14
* device instance $671 r0 *1 313.6,78.12 cap_mim_2f0_m4m5_noshield
C$671 \$95 topn 3.56528e-14
* device instance $672 r0 *1 320,78.12 cap_mim_2f0_m4m5_noshield
C$672 \$86 topn 3.56528e-14
* device instance $673 r0 *1 326.4,78.12 cap_mim_2f0_m4m5_noshield
C$673 \$95 topn 3.56528e-14
* device instance $674 r0 *1 332.8,78.12 cap_mim_2f0_m4m5_noshield
C$674 \$86 topn 3.56528e-14
* device instance $675 r0 *1 339.2,78.12 cap_mim_2f0_m4m5_noshield
C$675 \$95 topn 3.56528e-14
* device instance $676 r0 *1 345.6,78.12 cap_mim_2f0_m4m5_noshield
C$676 \$86 topn 3.56528e-14
* device instance $677 r0 *1 352,78.12 cap_mim_2f0_m4m5_noshield
C$677 \$95 topn 3.56528e-14
* device instance $678 r0 *1 358.4,78.12 cap_mim_2f0_m4m5_noshield
C$678 \$86 topn 3.56528e-14
* device instance $679 r0 *1 364.8,78.12 cap_mim_2f0_m4m5_noshield
C$679 \$95 topn 3.56528e-14
* device instance $680 r0 *1 371.2,78.12 cap_mim_2f0_m4m5_noshield
C$680 \$86 topn 3.56528e-14
* device instance $681 r0 *1 377.6,78.12 cap_mim_2f0_m4m5_noshield
C$681 \$95 topn 3.56528e-14
* device instance $682 r0 *1 384,78.12 cap_mim_2f0_m4m5_noshield
C$682 \$86 topn 3.56528e-14
* device instance $683 r0 *1 390.4,78.12 cap_mim_2f0_m4m5_noshield
C$683 \$95 topn 3.56528e-14
* device instance $684 r0 *1 396.8,78.12 cap_mim_2f0_m4m5_noshield
C$684 \$86 topn 3.56528e-14
* device instance $685 r0 *1 403.2,78.12 cap_mim_2f0_m4m5_noshield
C$685 \$95 topn 3.56528e-14
* device instance $686 r0 *1 409.6,78.12 cap_mim_2f0_m4m5_noshield
C$686 \$86 topn 3.56528e-14
* device instance $687 r0 *1 416,78.12 cap_mim_2f0_m4m5_noshield
C$687 \$95 topn 3.56528e-14
* device instance $688 r0 *1 422.4,78.12 cap_mim_2f0_m4m5_noshield
C$688 \$86 topn 3.56528e-14
* device instance $689 r0 *1 2.6,84.52 cap_mim_2f0_m4m5_noshield
C$689 \$11 topp 3.56528e-14
* device instance $690 r0 *1 9,84.52 cap_mim_2f0_m4m5_noshield
C$690 \$8 topp 3.56528e-14
* device instance $691 r0 *1 15.4,84.52 cap_mim_2f0_m4m5_noshield
C$691 \$11 topp 3.56528e-14
* device instance $692 r0 *1 21.8,84.52 cap_mim_2f0_m4m5_noshield
C$692 \$8 topp 3.56528e-14
* device instance $693 r0 *1 28.2,84.52 cap_mim_2f0_m4m5_noshield
C$693 \$11 topp 3.56528e-14
* device instance $694 r0 *1 34.6,84.52 cap_mim_2f0_m4m5_noshield
C$694 \$8 topp 3.56528e-14
* device instance $695 r0 *1 41,84.52 cap_mim_2f0_m4m5_noshield
C$695 \$11 topp 3.56528e-14
* device instance $696 r0 *1 47.4,84.52 cap_mim_2f0_m4m5_noshield
C$696 \$8 topp 3.56528e-14
* device instance $697 r0 *1 53.8,84.52 cap_mim_2f0_m4m5_noshield
C$697 \$11 topp 3.56528e-14
* device instance $698 r0 *1 60.2,84.52 cap_mim_2f0_m4m5_noshield
C$698 \$8 topp 3.56528e-14
* device instance $699 r0 *1 66.6,84.52 cap_mim_2f0_m4m5_noshield
C$699 \$11 topp 3.56528e-14
* device instance $700 r0 *1 73,84.52 cap_mim_2f0_m4m5_noshield
C$700 \$8 topp 3.56528e-14
* device instance $701 r0 *1 79.4,84.52 cap_mim_2f0_m4m5_noshield
C$701 \$11 topp 3.56528e-14
* device instance $702 r0 *1 85.8,84.52 cap_mim_2f0_m4m5_noshield
C$702 \$8 topp 3.56528e-14
* device instance $703 r0 *1 92.2,84.52 cap_mim_2f0_m4m5_noshield
C$703 \$11 topp 3.56528e-14
* device instance $704 r0 *1 98.6,84.52 cap_mim_2f0_m4m5_noshield
C$704 \$8 topp 3.56528e-14
* device instance $705 r0 *1 105,84.52 cap_mim_2f0_m4m5_noshield
C$705 \$11 topp 3.56528e-14
* device instance $706 r0 *1 111.4,84.52 cap_mim_2f0_m4m5_noshield
C$706 \$8 topp 3.56528e-14
* device instance $707 r0 *1 117.8,84.52 cap_mim_2f0_m4m5_noshield
C$707 \$11 topp 3.56528e-14
* device instance $708 r0 *1 124.2,84.52 cap_mim_2f0_m4m5_noshield
C$708 \$8 topp 3.56528e-14
* device instance $709 r0 *1 130.6,84.52 cap_mim_2f0_m4m5_noshield
C$709 \$11 topp 3.56528e-14
* device instance $710 r0 *1 137,84.52 cap_mim_2f0_m4m5_noshield
C$710 \$8 topp 3.56528e-14
* device instance $711 r0 *1 143.4,84.52 cap_mim_2f0_m4m5_noshield
C$711 \$11 topp 3.56528e-14
* device instance $712 r0 *1 149.8,84.52 cap_mim_2f0_m4m5_noshield
C$712 \$8 topp 3.56528e-14
* device instance $713 r0 *1 156.2,84.52 cap_mim_2f0_m4m5_noshield
C$713 \$11 topp 3.56528e-14
* device instance $714 r0 *1 162.6,84.52 cap_mim_2f0_m4m5_noshield
C$714 \$8 topp 3.56528e-14
* device instance $715 r0 *1 169,84.52 cap_mim_2f0_m4m5_noshield
C$715 \$11 topp 3.56528e-14
* device instance $716 r0 *1 175.4,84.52 cap_mim_2f0_m4m5_noshield
C$716 \$8 topp 3.56528e-14
* device instance $717 r0 *1 181.8,84.52 cap_mim_2f0_m4m5_noshield
C$717 \$11 topp 3.56528e-14
* device instance $718 r0 *1 188.2,84.52 cap_mim_2f0_m4m5_noshield
C$718 \$8 topp 3.56528e-14
* device instance $719 r0 *1 194.6,84.52 cap_mim_2f0_m4m5_noshield
C$719 \$11 topp 3.56528e-14
* device instance $720 r0 *1 201,84.52 cap_mim_2f0_m4m5_noshield
C$720 \$8 topp 3.56528e-14
* device instance $721 r0 *1 224,84.52 cap_mim_2f0_m4m5_noshield
C$721 \$95 topn 3.56528e-14
* device instance $722 r0 *1 230.4,84.52 cap_mim_2f0_m4m5_noshield
C$722 \$86 topn 3.56528e-14
* device instance $723 r0 *1 236.8,84.52 cap_mim_2f0_m4m5_noshield
C$723 \$95 topn 3.56528e-14
* device instance $724 r0 *1 243.2,84.52 cap_mim_2f0_m4m5_noshield
C$724 \$86 topn 3.56528e-14
* device instance $725 r0 *1 249.6,84.52 cap_mim_2f0_m4m5_noshield
C$725 \$95 topn 3.56528e-14
* device instance $726 r0 *1 256,84.52 cap_mim_2f0_m4m5_noshield
C$726 \$86 topn 3.56528e-14
* device instance $727 r0 *1 262.4,84.52 cap_mim_2f0_m4m5_noshield
C$727 \$95 topn 3.56528e-14
* device instance $728 r0 *1 268.8,84.52 cap_mim_2f0_m4m5_noshield
C$728 \$86 topn 3.56528e-14
* device instance $729 r0 *1 275.2,84.52 cap_mim_2f0_m4m5_noshield
C$729 \$95 topn 3.56528e-14
* device instance $730 r0 *1 281.6,84.52 cap_mim_2f0_m4m5_noshield
C$730 \$86 topn 3.56528e-14
* device instance $731 r0 *1 288,84.52 cap_mim_2f0_m4m5_noshield
C$731 \$95 topn 3.56528e-14
* device instance $732 r0 *1 294.4,84.52 cap_mim_2f0_m4m5_noshield
C$732 \$86 topn 3.56528e-14
* device instance $733 r0 *1 300.8,84.52 cap_mim_2f0_m4m5_noshield
C$733 \$95 topn 3.56528e-14
* device instance $734 r0 *1 307.2,84.52 cap_mim_2f0_m4m5_noshield
C$734 \$86 topn 3.56528e-14
* device instance $735 r0 *1 313.6,84.52 cap_mim_2f0_m4m5_noshield
C$735 \$95 topn 3.56528e-14
* device instance $736 r0 *1 320,84.52 cap_mim_2f0_m4m5_noshield
C$736 \$86 topn 3.56528e-14
* device instance $737 r0 *1 326.4,84.52 cap_mim_2f0_m4m5_noshield
C$737 \$95 topn 3.56528e-14
* device instance $738 r0 *1 332.8,84.52 cap_mim_2f0_m4m5_noshield
C$738 \$86 topn 3.56528e-14
* device instance $739 r0 *1 339.2,84.52 cap_mim_2f0_m4m5_noshield
C$739 \$95 topn 3.56528e-14
* device instance $740 r0 *1 345.6,84.52 cap_mim_2f0_m4m5_noshield
C$740 \$86 topn 3.56528e-14
* device instance $741 r0 *1 352,84.52 cap_mim_2f0_m4m5_noshield
C$741 \$95 topn 3.56528e-14
* device instance $742 r0 *1 358.4,84.52 cap_mim_2f0_m4m5_noshield
C$742 \$86 topn 3.56528e-14
* device instance $743 r0 *1 364.8,84.52 cap_mim_2f0_m4m5_noshield
C$743 \$95 topn 3.56528e-14
* device instance $744 r0 *1 371.2,84.52 cap_mim_2f0_m4m5_noshield
C$744 \$86 topn 3.56528e-14
* device instance $745 r0 *1 377.6,84.52 cap_mim_2f0_m4m5_noshield
C$745 \$95 topn 3.56528e-14
* device instance $746 r0 *1 384,84.52 cap_mim_2f0_m4m5_noshield
C$746 \$86 topn 3.56528e-14
* device instance $747 r0 *1 390.4,84.52 cap_mim_2f0_m4m5_noshield
C$747 \$95 topn 3.56528e-14
* device instance $748 r0 *1 396.8,84.52 cap_mim_2f0_m4m5_noshield
C$748 \$86 topn 3.56528e-14
* device instance $749 r0 *1 403.2,84.52 cap_mim_2f0_m4m5_noshield
C$749 \$95 topn 3.56528e-14
* device instance $750 r0 *1 409.6,84.52 cap_mim_2f0_m4m5_noshield
C$750 \$86 topn 3.56528e-14
* device instance $751 r0 *1 416,84.52 cap_mim_2f0_m4m5_noshield
C$751 \$95 topn 3.56528e-14
* device instance $752 r0 *1 422.4,84.52 cap_mim_2f0_m4m5_noshield
C$752 \$86 topn 3.56528e-14
* device instance $753 r0 *1 2.6,90.92 cap_mim_2f0_m4m5_noshield
C$753 \$14 topp 3.56528e-14
* device instance $754 r0 *1 9,90.92 cap_mim_2f0_m4m5_noshield
C$754 \$8 topp 3.56528e-14
* device instance $755 r0 *1 15.4,90.92 cap_mim_2f0_m4m5_noshield
C$755 \$14 topp 3.56528e-14
* device instance $756 r0 *1 21.8,90.92 cap_mim_2f0_m4m5_noshield
C$756 \$8 topp 3.56528e-14
* device instance $757 r0 *1 28.2,90.92 cap_mim_2f0_m4m5_noshield
C$757 \$14 topp 3.56528e-14
* device instance $758 r0 *1 34.6,90.92 cap_mim_2f0_m4m5_noshield
C$758 \$8 topp 3.56528e-14
* device instance $759 r0 *1 41,90.92 cap_mim_2f0_m4m5_noshield
C$759 \$14 topp 3.56528e-14
* device instance $760 r0 *1 47.4,90.92 cap_mim_2f0_m4m5_noshield
C$760 \$8 topp 3.56528e-14
* device instance $761 r0 *1 53.8,90.92 cap_mim_2f0_m4m5_noshield
C$761 \$14 topp 3.56528e-14
* device instance $762 r0 *1 60.2,90.92 cap_mim_2f0_m4m5_noshield
C$762 \$8 topp 3.56528e-14
* device instance $763 r0 *1 66.6,90.92 cap_mim_2f0_m4m5_noshield
C$763 \$14 topp 3.56528e-14
* device instance $764 r0 *1 73,90.92 cap_mim_2f0_m4m5_noshield
C$764 \$8 topp 3.56528e-14
* device instance $765 r0 *1 79.4,90.92 cap_mim_2f0_m4m5_noshield
C$765 \$14 topp 3.56528e-14
* device instance $766 r0 *1 85.8,90.92 cap_mim_2f0_m4m5_noshield
C$766 \$8 topp 3.56528e-14
* device instance $767 r0 *1 92.2,90.92 cap_mim_2f0_m4m5_noshield
C$767 \$14 topp 3.56528e-14
* device instance $768 r0 *1 98.6,90.92 cap_mim_2f0_m4m5_noshield
C$768 \$8 topp 3.56528e-14
* device instance $769 r0 *1 105,90.92 cap_mim_2f0_m4m5_noshield
C$769 \$14 topp 3.56528e-14
* device instance $770 r0 *1 111.4,90.92 cap_mim_2f0_m4m5_noshield
C$770 \$8 topp 3.56528e-14
* device instance $771 r0 *1 117.8,90.92 cap_mim_2f0_m4m5_noshield
C$771 \$14 topp 3.56528e-14
* device instance $772 r0 *1 124.2,90.92 cap_mim_2f0_m4m5_noshield
C$772 \$8 topp 3.56528e-14
* device instance $773 r0 *1 130.6,90.92 cap_mim_2f0_m4m5_noshield
C$773 \$14 topp 3.56528e-14
* device instance $774 r0 *1 137,90.92 cap_mim_2f0_m4m5_noshield
C$774 \$8 topp 3.56528e-14
* device instance $775 r0 *1 143.4,90.92 cap_mim_2f0_m4m5_noshield
C$775 \$14 topp 3.56528e-14
* device instance $776 r0 *1 149.8,90.92 cap_mim_2f0_m4m5_noshield
C$776 \$8 topp 3.56528e-14
* device instance $777 r0 *1 156.2,90.92 cap_mim_2f0_m4m5_noshield
C$777 \$14 topp 3.56528e-14
* device instance $778 r0 *1 162.6,90.92 cap_mim_2f0_m4m5_noshield
C$778 \$8 topp 3.56528e-14
* device instance $779 r0 *1 169,90.92 cap_mim_2f0_m4m5_noshield
C$779 \$14 topp 3.56528e-14
* device instance $780 r0 *1 175.4,90.92 cap_mim_2f0_m4m5_noshield
C$780 \$8 topp 3.56528e-14
* device instance $781 r0 *1 181.8,90.92 cap_mim_2f0_m4m5_noshield
C$781 \$14 topp 3.56528e-14
* device instance $782 r0 *1 188.2,90.92 cap_mim_2f0_m4m5_noshield
C$782 \$8 topp 3.56528e-14
* device instance $783 r0 *1 194.6,90.92 cap_mim_2f0_m4m5_noshield
C$783 \$14 topp 3.56528e-14
* device instance $784 r0 *1 201,90.92 cap_mim_2f0_m4m5_noshield
C$784 \$8 topp 3.56528e-14
* device instance $785 r0 *1 224,90.92 cap_mim_2f0_m4m5_noshield
C$785 \$103 topn 3.56528e-14
* device instance $786 r0 *1 230.4,90.92 cap_mim_2f0_m4m5_noshield
C$786 \$86 topn 3.56528e-14
* device instance $787 r0 *1 236.8,90.92 cap_mim_2f0_m4m5_noshield
C$787 \$103 topn 3.56528e-14
* device instance $788 r0 *1 243.2,90.92 cap_mim_2f0_m4m5_noshield
C$788 \$86 topn 3.56528e-14
* device instance $789 r0 *1 249.6,90.92 cap_mim_2f0_m4m5_noshield
C$789 \$103 topn 3.56528e-14
* device instance $790 r0 *1 256,90.92 cap_mim_2f0_m4m5_noshield
C$790 \$86 topn 3.56528e-14
* device instance $791 r0 *1 262.4,90.92 cap_mim_2f0_m4m5_noshield
C$791 \$103 topn 3.56528e-14
* device instance $792 r0 *1 268.8,90.92 cap_mim_2f0_m4m5_noshield
C$792 \$86 topn 3.56528e-14
* device instance $793 r0 *1 275.2,90.92 cap_mim_2f0_m4m5_noshield
C$793 \$103 topn 3.56528e-14
* device instance $794 r0 *1 281.6,90.92 cap_mim_2f0_m4m5_noshield
C$794 \$86 topn 3.56528e-14
* device instance $795 r0 *1 288,90.92 cap_mim_2f0_m4m5_noshield
C$795 \$103 topn 3.56528e-14
* device instance $796 r0 *1 294.4,90.92 cap_mim_2f0_m4m5_noshield
C$796 \$86 topn 3.56528e-14
* device instance $797 r0 *1 300.8,90.92 cap_mim_2f0_m4m5_noshield
C$797 \$103 topn 3.56528e-14
* device instance $798 r0 *1 307.2,90.92 cap_mim_2f0_m4m5_noshield
C$798 \$86 topn 3.56528e-14
* device instance $799 r0 *1 313.6,90.92 cap_mim_2f0_m4m5_noshield
C$799 \$103 topn 3.56528e-14
* device instance $800 r0 *1 320,90.92 cap_mim_2f0_m4m5_noshield
C$800 \$86 topn 3.56528e-14
* device instance $801 r0 *1 326.4,90.92 cap_mim_2f0_m4m5_noshield
C$801 \$103 topn 3.56528e-14
* device instance $802 r0 *1 332.8,90.92 cap_mim_2f0_m4m5_noshield
C$802 \$86 topn 3.56528e-14
* device instance $803 r0 *1 339.2,90.92 cap_mim_2f0_m4m5_noshield
C$803 \$103 topn 3.56528e-14
* device instance $804 r0 *1 345.6,90.92 cap_mim_2f0_m4m5_noshield
C$804 \$86 topn 3.56528e-14
* device instance $805 r0 *1 352,90.92 cap_mim_2f0_m4m5_noshield
C$805 \$103 topn 3.56528e-14
* device instance $806 r0 *1 358.4,90.92 cap_mim_2f0_m4m5_noshield
C$806 \$86 topn 3.56528e-14
* device instance $807 r0 *1 364.8,90.92 cap_mim_2f0_m4m5_noshield
C$807 \$103 topn 3.56528e-14
* device instance $808 r0 *1 371.2,90.92 cap_mim_2f0_m4m5_noshield
C$808 \$86 topn 3.56528e-14
* device instance $809 r0 *1 377.6,90.92 cap_mim_2f0_m4m5_noshield
C$809 \$103 topn 3.56528e-14
* device instance $810 r0 *1 384,90.92 cap_mim_2f0_m4m5_noshield
C$810 \$86 topn 3.56528e-14
* device instance $811 r0 *1 390.4,90.92 cap_mim_2f0_m4m5_noshield
C$811 \$103 topn 3.56528e-14
* device instance $812 r0 *1 396.8,90.92 cap_mim_2f0_m4m5_noshield
C$812 \$86 topn 3.56528e-14
* device instance $813 r0 *1 403.2,90.92 cap_mim_2f0_m4m5_noshield
C$813 \$103 topn 3.56528e-14
* device instance $814 r0 *1 409.6,90.92 cap_mim_2f0_m4m5_noshield
C$814 \$86 topn 3.56528e-14
* device instance $815 r0 *1 416,90.92 cap_mim_2f0_m4m5_noshield
C$815 \$103 topn 3.56528e-14
* device instance $816 r0 *1 422.4,90.92 cap_mim_2f0_m4m5_noshield
C$816 \$86 topn 3.56528e-14
* device instance $817 r0 *1 2.6,97.32 cap_mim_2f0_m4m5_noshield
C$817 \$17 topp 3.56528e-14
* device instance $818 r0 *1 9,97.32 cap_mim_2f0_m4m5_noshield
C$818 \$8 topp 3.56528e-14
* device instance $819 r0 *1 15.4,97.32 cap_mim_2f0_m4m5_noshield
C$819 \$17 topp 3.56528e-14
* device instance $820 r0 *1 21.8,97.32 cap_mim_2f0_m4m5_noshield
C$820 \$8 topp 3.56528e-14
* device instance $821 r0 *1 28.2,97.32 cap_mim_2f0_m4m5_noshield
C$821 \$17 topp 3.56528e-14
* device instance $822 r0 *1 34.6,97.32 cap_mim_2f0_m4m5_noshield
C$822 \$8 topp 3.56528e-14
* device instance $823 r0 *1 41,97.32 cap_mim_2f0_m4m5_noshield
C$823 \$17 topp 3.56528e-14
* device instance $824 r0 *1 47.4,97.32 cap_mim_2f0_m4m5_noshield
C$824 \$8 topp 3.56528e-14
* device instance $825 r0 *1 53.8,97.32 cap_mim_2f0_m4m5_noshield
C$825 \$17 topp 3.56528e-14
* device instance $826 r0 *1 60.2,97.32 cap_mim_2f0_m4m5_noshield
C$826 \$8 topp 3.56528e-14
* device instance $827 r0 *1 66.6,97.32 cap_mim_2f0_m4m5_noshield
C$827 \$17 topp 3.56528e-14
* device instance $828 r0 *1 73,97.32 cap_mim_2f0_m4m5_noshield
C$828 \$8 topp 3.56528e-14
* device instance $829 r0 *1 79.4,97.32 cap_mim_2f0_m4m5_noshield
C$829 \$17 topp 3.56528e-14
* device instance $830 r0 *1 85.8,97.32 cap_mim_2f0_m4m5_noshield
C$830 \$8 topp 3.56528e-14
* device instance $831 r0 *1 92.2,97.32 cap_mim_2f0_m4m5_noshield
C$831 \$17 topp 3.56528e-14
* device instance $832 r0 *1 98.6,97.32 cap_mim_2f0_m4m5_noshield
C$832 \$8 topp 3.56528e-14
* device instance $833 r0 *1 105,97.32 cap_mim_2f0_m4m5_noshield
C$833 \$20 topp 3.56528e-14
* device instance $834 r0 *1 111.4,97.32 cap_mim_2f0_m4m5_noshield
C$834 \$8 topp 3.56528e-14
* device instance $835 r0 *1 117.8,97.32 cap_mim_2f0_m4m5_noshield
C$835 \$20 topp 3.56528e-14
* device instance $836 r0 *1 124.2,97.32 cap_mim_2f0_m4m5_noshield
C$836 \$8 topp 3.56528e-14
* device instance $837 r0 *1 130.6,97.32 cap_mim_2f0_m4m5_noshield
C$837 \$20 topp 3.56528e-14
* device instance $838 r0 *1 137,97.32 cap_mim_2f0_m4m5_noshield
C$838 \$8 topp 3.56528e-14
* device instance $839 r0 *1 143.4,97.32 cap_mim_2f0_m4m5_noshield
C$839 \$20 topp 3.56528e-14
* device instance $840 r0 *1 149.8,97.32 cap_mim_2f0_m4m5_noshield
C$840 \$8 topp 3.56528e-14
* device instance $841 r0 *1 156.2,97.32 cap_mim_2f0_m4m5_noshield
C$841 \$23 topp 3.56528e-14
* device instance $842 r0 *1 162.6,97.32 cap_mim_2f0_m4m5_noshield
C$842 \$8 topp 3.56528e-14
* device instance $843 r0 *1 169,97.32 cap_mim_2f0_m4m5_noshield
C$843 \$23 topp 3.56528e-14
* device instance $844 r0 *1 175.4,97.32 cap_mim_2f0_m4m5_noshield
C$844 \$8 topp 3.56528e-14
* device instance $845 r0 *1 181.8,97.32 cap_mim_2f0_m4m5_noshield
C$845 \$26 topp 3.56528e-14
* device instance $846 r0 *1 188.2,97.32 cap_mim_2f0_m4m5_noshield
C$846 \$8 topp 3.56528e-14
* device instance $847 r0 *1 194.6,97.32 cap_mim_2f0_m4m5_noshield
C$847 \$32 topp 3.56528e-14
* device instance $848 r0 *1 201,97.32 cap_mim_2f0_m4m5_noshield
C$848 \$8 topp 3.56528e-14
* device instance $849 r0 *1 224,97.32 cap_mim_2f0_m4m5_noshield
C$849 \$111 topn 3.56528e-14
* device instance $850 r0 *1 230.4,97.32 cap_mim_2f0_m4m5_noshield
C$850 \$86 topn 3.56528e-14
* device instance $851 r0 *1 236.8,97.32 cap_mim_2f0_m4m5_noshield
C$851 \$111 topn 3.56528e-14
* device instance $852 r0 *1 243.2,97.32 cap_mim_2f0_m4m5_noshield
C$852 \$86 topn 3.56528e-14
* device instance $853 r0 *1 249.6,97.32 cap_mim_2f0_m4m5_noshield
C$853 \$111 topn 3.56528e-14
* device instance $854 r0 *1 256,97.32 cap_mim_2f0_m4m5_noshield
C$854 \$86 topn 3.56528e-14
* device instance $855 r0 *1 262.4,97.32 cap_mim_2f0_m4m5_noshield
C$855 \$111 topn 3.56528e-14
* device instance $856 r0 *1 268.8,97.32 cap_mim_2f0_m4m5_noshield
C$856 \$86 topn 3.56528e-14
* device instance $857 r0 *1 275.2,97.32 cap_mim_2f0_m4m5_noshield
C$857 \$111 topn 3.56528e-14
* device instance $858 r0 *1 281.6,97.32 cap_mim_2f0_m4m5_noshield
C$858 \$86 topn 3.56528e-14
* device instance $859 r0 *1 288,97.32 cap_mim_2f0_m4m5_noshield
C$859 \$111 topn 3.56528e-14
* device instance $860 r0 *1 294.4,97.32 cap_mim_2f0_m4m5_noshield
C$860 \$86 topn 3.56528e-14
* device instance $861 r0 *1 300.8,97.32 cap_mim_2f0_m4m5_noshield
C$861 \$111 topn 3.56528e-14
* device instance $862 r0 *1 307.2,97.32 cap_mim_2f0_m4m5_noshield
C$862 \$86 topn 3.56528e-14
* device instance $863 r0 *1 313.6,97.32 cap_mim_2f0_m4m5_noshield
C$863 \$111 topn 3.56528e-14
* device instance $864 r0 *1 320,97.32 cap_mim_2f0_m4m5_noshield
C$864 \$86 topn 3.56528e-14
* device instance $865 r0 *1 326.4,97.32 cap_mim_2f0_m4m5_noshield
C$865 \$119 topn 3.56528e-14
* device instance $866 r0 *1 332.8,97.32 cap_mim_2f0_m4m5_noshield
C$866 \$86 topn 3.56528e-14
* device instance $867 r0 *1 339.2,97.32 cap_mim_2f0_m4m5_noshield
C$867 \$119 topn 3.56528e-14
* device instance $868 r0 *1 345.6,97.32 cap_mim_2f0_m4m5_noshield
C$868 \$86 topn 3.56528e-14
* device instance $869 r0 *1 352,97.32 cap_mim_2f0_m4m5_noshield
C$869 \$119 topn 3.56528e-14
* device instance $870 r0 *1 358.4,97.32 cap_mim_2f0_m4m5_noshield
C$870 \$86 topn 3.56528e-14
* device instance $871 r0 *1 364.8,97.32 cap_mim_2f0_m4m5_noshield
C$871 \$119 topn 3.56528e-14
* device instance $872 r0 *1 371.2,97.32 cap_mim_2f0_m4m5_noshield
C$872 \$86 topn 3.56528e-14
* device instance $873 r0 *1 377.6,97.32 cap_mim_2f0_m4m5_noshield
C$873 \$127 topn 3.56528e-14
* device instance $874 r0 *1 384,97.32 cap_mim_2f0_m4m5_noshield
C$874 \$86 topn 3.56528e-14
* device instance $875 r0 *1 390.4,97.32 cap_mim_2f0_m4m5_noshield
C$875 \$127 topn 3.56528e-14
* device instance $876 r0 *1 396.8,97.32 cap_mim_2f0_m4m5_noshield
C$876 \$86 topn 3.56528e-14
* device instance $877 r0 *1 403.2,97.32 cap_mim_2f0_m4m5_noshield
C$877 \$135 topn 3.56528e-14
* device instance $878 r0 *1 409.6,97.32 cap_mim_2f0_m4m5_noshield
C$878 \$86 topn 3.56528e-14
* device instance $879 r0 *1 416,97.32 cap_mim_2f0_m4m5_noshield
C$879 \$151 topn 3.56528e-14
* device instance $880 r0 *1 422.4,97.32 cap_mim_2f0_m4m5_noshield
C$880 \$86 topn 3.56528e-14
* device instance $881 r0 *1 2.6,103.72 cap_mim_2f0_m4m5_noshield
C$881 \$8 topp 3.56528e-14
* device instance $882 r0 *1 9,103.72 cap_mim_2f0_m4m5_noshield
C$882 vcm topp 3.56528e-14
* device instance $883 r0 *1 15.4,103.72 cap_mim_2f0_m4m5_noshield
C$883 \$8 topp 3.56528e-14
* device instance $884 r0 *1 21.8,103.72 cap_mim_2f0_m4m5_noshield
C$884 \$26 topp 3.56528e-14
* device instance $885 r0 *1 28.2,103.72 cap_mim_2f0_m4m5_noshield
C$885 \$8 topp 3.56528e-14
* device instance $886 r0 *1 34.6,103.72 cap_mim_2f0_m4m5_noshield
C$886 \$23 topp 3.56528e-14
* device instance $887 r0 *1 41,103.72 cap_mim_2f0_m4m5_noshield
C$887 \$8 topp 3.56528e-14
* device instance $888 r0 *1 47.4,103.72 cap_mim_2f0_m4m5_noshield
C$888 \$23 topp 3.56528e-14
* device instance $889 r0 *1 53.8,103.72 cap_mim_2f0_m4m5_noshield
C$889 \$8 topp 3.56528e-14
* device instance $890 r0 *1 60.2,103.72 cap_mim_2f0_m4m5_noshield
C$890 \$20 topp 3.56528e-14
* device instance $891 r0 *1 66.6,103.72 cap_mim_2f0_m4m5_noshield
C$891 \$8 topp 3.56528e-14
* device instance $892 r0 *1 73,103.72 cap_mim_2f0_m4m5_noshield
C$892 \$20 topp 3.56528e-14
* device instance $893 r0 *1 79.4,103.72 cap_mim_2f0_m4m5_noshield
C$893 \$8 topp 3.56528e-14
* device instance $894 r0 *1 85.8,103.72 cap_mim_2f0_m4m5_noshield
C$894 \$20 topp 3.56528e-14
* device instance $895 r0 *1 92.2,103.72 cap_mim_2f0_m4m5_noshield
C$895 \$8 topp 3.56528e-14
* device instance $896 r0 *1 98.6,103.72 cap_mim_2f0_m4m5_noshield
C$896 \$20 topp 3.56528e-14
* device instance $897 r0 *1 105,103.72 cap_mim_2f0_m4m5_noshield
C$897 \$8 topp 3.56528e-14
* device instance $898 r0 *1 111.4,103.72 cap_mim_2f0_m4m5_noshield
C$898 \$17 topp 3.56528e-14
* device instance $899 r0 *1 117.8,103.72 cap_mim_2f0_m4m5_noshield
C$899 \$8 topp 3.56528e-14
* device instance $900 r0 *1 124.2,103.72 cap_mim_2f0_m4m5_noshield
C$900 \$17 topp 3.56528e-14
* device instance $901 r0 *1 130.6,103.72 cap_mim_2f0_m4m5_noshield
C$901 \$8 topp 3.56528e-14
* device instance $902 r0 *1 137,103.72 cap_mim_2f0_m4m5_noshield
C$902 \$17 topp 3.56528e-14
* device instance $903 r0 *1 143.4,103.72 cap_mim_2f0_m4m5_noshield
C$903 \$8 topp 3.56528e-14
* device instance $904 r0 *1 149.8,103.72 cap_mim_2f0_m4m5_noshield
C$904 \$17 topp 3.56528e-14
* device instance $905 r0 *1 156.2,103.72 cap_mim_2f0_m4m5_noshield
C$905 \$8 topp 3.56528e-14
* device instance $906 r0 *1 162.6,103.72 cap_mim_2f0_m4m5_noshield
C$906 \$17 topp 3.56528e-14
* device instance $907 r0 *1 169,103.72 cap_mim_2f0_m4m5_noshield
C$907 \$8 topp 3.56528e-14
* device instance $908 r0 *1 175.4,103.72 cap_mim_2f0_m4m5_noshield
C$908 \$17 topp 3.56528e-14
* device instance $909 r0 *1 181.8,103.72 cap_mim_2f0_m4m5_noshield
C$909 \$8 topp 3.56528e-14
* device instance $910 r0 *1 188.2,103.72 cap_mim_2f0_m4m5_noshield
C$910 \$17 topp 3.56528e-14
* device instance $911 r0 *1 194.6,103.72 cap_mim_2f0_m4m5_noshield
C$911 \$8 topp 3.56528e-14
* device instance $912 r0 *1 201,103.72 cap_mim_2f0_m4m5_noshield
C$912 \$17 topp 3.56528e-14
* device instance $913 r0 *1 224,103.72 cap_mim_2f0_m4m5_noshield
C$913 \$86 topn 3.56528e-14
* device instance $914 r0 *1 230.4,103.72 cap_mim_2f0_m4m5_noshield
C$914 vcm topn 3.56528e-14
* device instance $915 r0 *1 236.8,103.72 cap_mim_2f0_m4m5_noshield
C$915 \$86 topn 3.56528e-14
* device instance $916 r0 *1 243.2,103.72 cap_mim_2f0_m4m5_noshield
C$916 \$135 topn 3.56528e-14
* device instance $917 r0 *1 249.6,103.72 cap_mim_2f0_m4m5_noshield
C$917 \$86 topn 3.56528e-14
* device instance $918 r0 *1 256,103.72 cap_mim_2f0_m4m5_noshield
C$918 \$127 topn 3.56528e-14
* device instance $919 r0 *1 262.4,103.72 cap_mim_2f0_m4m5_noshield
C$919 \$86 topn 3.56528e-14
* device instance $920 r0 *1 268.8,103.72 cap_mim_2f0_m4m5_noshield
C$920 \$127 topn 3.56528e-14
* device instance $921 r0 *1 275.2,103.72 cap_mim_2f0_m4m5_noshield
C$921 \$86 topn 3.56528e-14
* device instance $922 r0 *1 281.6,103.72 cap_mim_2f0_m4m5_noshield
C$922 \$119 topn 3.56528e-14
* device instance $923 r0 *1 288,103.72 cap_mim_2f0_m4m5_noshield
C$923 \$86 topn 3.56528e-14
* device instance $924 r0 *1 294.4,103.72 cap_mim_2f0_m4m5_noshield
C$924 \$119 topn 3.56528e-14
* device instance $925 r0 *1 300.8,103.72 cap_mim_2f0_m4m5_noshield
C$925 \$86 topn 3.56528e-14
* device instance $926 r0 *1 307.2,103.72 cap_mim_2f0_m4m5_noshield
C$926 \$119 topn 3.56528e-14
* device instance $927 r0 *1 313.6,103.72 cap_mim_2f0_m4m5_noshield
C$927 \$86 topn 3.56528e-14
* device instance $928 r0 *1 320,103.72 cap_mim_2f0_m4m5_noshield
C$928 \$119 topn 3.56528e-14
* device instance $929 r0 *1 326.4,103.72 cap_mim_2f0_m4m5_noshield
C$929 \$86 topn 3.56528e-14
* device instance $930 r0 *1 332.8,103.72 cap_mim_2f0_m4m5_noshield
C$930 \$111 topn 3.56528e-14
* device instance $931 r0 *1 339.2,103.72 cap_mim_2f0_m4m5_noshield
C$931 \$86 topn 3.56528e-14
* device instance $932 r0 *1 345.6,103.72 cap_mim_2f0_m4m5_noshield
C$932 \$111 topn 3.56528e-14
* device instance $933 r0 *1 352,103.72 cap_mim_2f0_m4m5_noshield
C$933 \$86 topn 3.56528e-14
* device instance $934 r0 *1 358.4,103.72 cap_mim_2f0_m4m5_noshield
C$934 \$111 topn 3.56528e-14
* device instance $935 r0 *1 364.8,103.72 cap_mim_2f0_m4m5_noshield
C$935 \$86 topn 3.56528e-14
* device instance $936 r0 *1 371.2,103.72 cap_mim_2f0_m4m5_noshield
C$936 \$111 topn 3.56528e-14
* device instance $937 r0 *1 377.6,103.72 cap_mim_2f0_m4m5_noshield
C$937 \$86 topn 3.56528e-14
* device instance $938 r0 *1 384,103.72 cap_mim_2f0_m4m5_noshield
C$938 \$111 topn 3.56528e-14
* device instance $939 r0 *1 390.4,103.72 cap_mim_2f0_m4m5_noshield
C$939 \$86 topn 3.56528e-14
* device instance $940 r0 *1 396.8,103.72 cap_mim_2f0_m4m5_noshield
C$940 \$111 topn 3.56528e-14
* device instance $941 r0 *1 403.2,103.72 cap_mim_2f0_m4m5_noshield
C$941 \$86 topn 3.56528e-14
* device instance $942 r0 *1 409.6,103.72 cap_mim_2f0_m4m5_noshield
C$942 \$111 topn 3.56528e-14
* device instance $943 r0 *1 416,103.72 cap_mim_2f0_m4m5_noshield
C$943 \$86 topn 3.56528e-14
* device instance $944 r0 *1 422.4,103.72 cap_mim_2f0_m4m5_noshield
C$944 \$111 topn 3.56528e-14
* device instance $945 r0 *1 2.6,110.12 cap_mim_2f0_m4m5_noshield
C$945 \$8 topp 3.56528e-14
* device instance $946 r0 *1 9,110.12 cap_mim_2f0_m4m5_noshield
C$946 \$14 topp 3.56528e-14
* device instance $947 r0 *1 15.4,110.12 cap_mim_2f0_m4m5_noshield
C$947 \$8 topp 3.56528e-14
* device instance $948 r0 *1 21.8,110.12 cap_mim_2f0_m4m5_noshield
C$948 \$14 topp 3.56528e-14
* device instance $949 r0 *1 28.2,110.12 cap_mim_2f0_m4m5_noshield
C$949 \$8 topp 3.56528e-14
* device instance $950 r0 *1 34.6,110.12 cap_mim_2f0_m4m5_noshield
C$950 \$14 topp 3.56528e-14
* device instance $951 r0 *1 41,110.12 cap_mim_2f0_m4m5_noshield
C$951 \$8 topp 3.56528e-14
* device instance $952 r0 *1 47.4,110.12 cap_mim_2f0_m4m5_noshield
C$952 \$14 topp 3.56528e-14
* device instance $953 r0 *1 53.8,110.12 cap_mim_2f0_m4m5_noshield
C$953 \$8 topp 3.56528e-14
* device instance $954 r0 *1 60.2,110.12 cap_mim_2f0_m4m5_noshield
C$954 \$14 topp 3.56528e-14
* device instance $955 r0 *1 66.6,110.12 cap_mim_2f0_m4m5_noshield
C$955 \$8 topp 3.56528e-14
* device instance $956 r0 *1 73,110.12 cap_mim_2f0_m4m5_noshield
C$956 \$14 topp 3.56528e-14
* device instance $957 r0 *1 79.4,110.12 cap_mim_2f0_m4m5_noshield
C$957 \$8 topp 3.56528e-14
* device instance $958 r0 *1 85.8,110.12 cap_mim_2f0_m4m5_noshield
C$958 \$14 topp 3.56528e-14
* device instance $959 r0 *1 92.2,110.12 cap_mim_2f0_m4m5_noshield
C$959 \$8 topp 3.56528e-14
* device instance $960 r0 *1 98.6,110.12 cap_mim_2f0_m4m5_noshield
C$960 \$14 topp 3.56528e-14
* device instance $961 r0 *1 105,110.12 cap_mim_2f0_m4m5_noshield
C$961 \$8 topp 3.56528e-14
* device instance $962 r0 *1 111.4,110.12 cap_mim_2f0_m4m5_noshield
C$962 \$14 topp 3.56528e-14
* device instance $963 r0 *1 117.8,110.12 cap_mim_2f0_m4m5_noshield
C$963 \$8 topp 3.56528e-14
* device instance $964 r0 *1 124.2,110.12 cap_mim_2f0_m4m5_noshield
C$964 \$14 topp 3.56528e-14
* device instance $965 r0 *1 130.6,110.12 cap_mim_2f0_m4m5_noshield
C$965 \$8 topp 3.56528e-14
* device instance $966 r0 *1 137,110.12 cap_mim_2f0_m4m5_noshield
C$966 \$14 topp 3.56528e-14
* device instance $967 r0 *1 143.4,110.12 cap_mim_2f0_m4m5_noshield
C$967 \$8 topp 3.56528e-14
* device instance $968 r0 *1 149.8,110.12 cap_mim_2f0_m4m5_noshield
C$968 \$14 topp 3.56528e-14
* device instance $969 r0 *1 156.2,110.12 cap_mim_2f0_m4m5_noshield
C$969 \$8 topp 3.56528e-14
* device instance $970 r0 *1 162.6,110.12 cap_mim_2f0_m4m5_noshield
C$970 \$14 topp 3.56528e-14
* device instance $971 r0 *1 169,110.12 cap_mim_2f0_m4m5_noshield
C$971 \$8 topp 3.56528e-14
* device instance $972 r0 *1 175.4,110.12 cap_mim_2f0_m4m5_noshield
C$972 \$14 topp 3.56528e-14
* device instance $973 r0 *1 181.8,110.12 cap_mim_2f0_m4m5_noshield
C$973 \$8 topp 3.56528e-14
* device instance $974 r0 *1 188.2,110.12 cap_mim_2f0_m4m5_noshield
C$974 \$14 topp 3.56528e-14
* device instance $975 r0 *1 194.6,110.12 cap_mim_2f0_m4m5_noshield
C$975 \$8 topp 3.56528e-14
* device instance $976 r0 *1 201,110.12 cap_mim_2f0_m4m5_noshield
C$976 \$14 topp 3.56528e-14
* device instance $977 r0 *1 224,110.12 cap_mim_2f0_m4m5_noshield
C$977 \$86 topn 3.56528e-14
* device instance $978 r0 *1 230.4,110.12 cap_mim_2f0_m4m5_noshield
C$978 \$103 topn 3.56528e-14
* device instance $979 r0 *1 236.8,110.12 cap_mim_2f0_m4m5_noshield
C$979 \$86 topn 3.56528e-14
* device instance $980 r0 *1 243.2,110.12 cap_mim_2f0_m4m5_noshield
C$980 \$103 topn 3.56528e-14
* device instance $981 r0 *1 249.6,110.12 cap_mim_2f0_m4m5_noshield
C$981 \$86 topn 3.56528e-14
* device instance $982 r0 *1 256,110.12 cap_mim_2f0_m4m5_noshield
C$982 \$103 topn 3.56528e-14
* device instance $983 r0 *1 262.4,110.12 cap_mim_2f0_m4m5_noshield
C$983 \$86 topn 3.56528e-14
* device instance $984 r0 *1 268.8,110.12 cap_mim_2f0_m4m5_noshield
C$984 \$103 topn 3.56528e-14
* device instance $985 r0 *1 275.2,110.12 cap_mim_2f0_m4m5_noshield
C$985 \$86 topn 3.56528e-14
* device instance $986 r0 *1 281.6,110.12 cap_mim_2f0_m4m5_noshield
C$986 \$103 topn 3.56528e-14
* device instance $987 r0 *1 288,110.12 cap_mim_2f0_m4m5_noshield
C$987 \$86 topn 3.56528e-14
* device instance $988 r0 *1 294.4,110.12 cap_mim_2f0_m4m5_noshield
C$988 \$103 topn 3.56528e-14
* device instance $989 r0 *1 300.8,110.12 cap_mim_2f0_m4m5_noshield
C$989 \$86 topn 3.56528e-14
* device instance $990 r0 *1 307.2,110.12 cap_mim_2f0_m4m5_noshield
C$990 \$103 topn 3.56528e-14
* device instance $991 r0 *1 313.6,110.12 cap_mim_2f0_m4m5_noshield
C$991 \$86 topn 3.56528e-14
* device instance $992 r0 *1 320,110.12 cap_mim_2f0_m4m5_noshield
C$992 \$103 topn 3.56528e-14
* device instance $993 r0 *1 326.4,110.12 cap_mim_2f0_m4m5_noshield
C$993 \$86 topn 3.56528e-14
* device instance $994 r0 *1 332.8,110.12 cap_mim_2f0_m4m5_noshield
C$994 \$103 topn 3.56528e-14
* device instance $995 r0 *1 339.2,110.12 cap_mim_2f0_m4m5_noshield
C$995 \$86 topn 3.56528e-14
* device instance $996 r0 *1 345.6,110.12 cap_mim_2f0_m4m5_noshield
C$996 \$103 topn 3.56528e-14
* device instance $997 r0 *1 352,110.12 cap_mim_2f0_m4m5_noshield
C$997 \$86 topn 3.56528e-14
* device instance $998 r0 *1 358.4,110.12 cap_mim_2f0_m4m5_noshield
C$998 \$103 topn 3.56528e-14
* device instance $999 r0 *1 364.8,110.12 cap_mim_2f0_m4m5_noshield
C$999 \$86 topn 3.56528e-14
* device instance $1000 r0 *1 371.2,110.12 cap_mim_2f0_m4m5_noshield
C$1000 \$103 topn 3.56528e-14
* device instance $1001 r0 *1 377.6,110.12 cap_mim_2f0_m4m5_noshield
C$1001 \$86 topn 3.56528e-14
* device instance $1002 r0 *1 384,110.12 cap_mim_2f0_m4m5_noshield
C$1002 \$103 topn 3.56528e-14
* device instance $1003 r0 *1 390.4,110.12 cap_mim_2f0_m4m5_noshield
C$1003 \$86 topn 3.56528e-14
* device instance $1004 r0 *1 396.8,110.12 cap_mim_2f0_m4m5_noshield
C$1004 \$103 topn 3.56528e-14
* device instance $1005 r0 *1 403.2,110.12 cap_mim_2f0_m4m5_noshield
C$1005 \$86 topn 3.56528e-14
* device instance $1006 r0 *1 409.6,110.12 cap_mim_2f0_m4m5_noshield
C$1006 \$103 topn 3.56528e-14
* device instance $1007 r0 *1 416,110.12 cap_mim_2f0_m4m5_noshield
C$1007 \$86 topn 3.56528e-14
* device instance $1008 r0 *1 422.4,110.12 cap_mim_2f0_m4m5_noshield
C$1008 \$103 topn 3.56528e-14
* device instance $1009 r0 *1 2.6,116.52 cap_mim_2f0_m4m5_noshield
C$1009 \$8 topp 3.56528e-14
* device instance $1010 r0 *1 9,116.52 cap_mim_2f0_m4m5_noshield
C$1010 \$11 topp 3.56528e-14
* device instance $1011 r0 *1 15.4,116.52 cap_mim_2f0_m4m5_noshield
C$1011 \$8 topp 3.56528e-14
* device instance $1012 r0 *1 21.8,116.52 cap_mim_2f0_m4m5_noshield
C$1012 \$11 topp 3.56528e-14
* device instance $1013 r0 *1 28.2,116.52 cap_mim_2f0_m4m5_noshield
C$1013 \$8 topp 3.56528e-14
* device instance $1014 r0 *1 34.6,116.52 cap_mim_2f0_m4m5_noshield
C$1014 \$11 topp 3.56528e-14
* device instance $1015 r0 *1 41,116.52 cap_mim_2f0_m4m5_noshield
C$1015 \$8 topp 3.56528e-14
* device instance $1016 r0 *1 47.4,116.52 cap_mim_2f0_m4m5_noshield
C$1016 \$11 topp 3.56528e-14
* device instance $1017 r0 *1 53.8,116.52 cap_mim_2f0_m4m5_noshield
C$1017 \$8 topp 3.56528e-14
* device instance $1018 r0 *1 60.2,116.52 cap_mim_2f0_m4m5_noshield
C$1018 \$11 topp 3.56528e-14
* device instance $1019 r0 *1 66.6,116.52 cap_mim_2f0_m4m5_noshield
C$1019 \$8 topp 3.56528e-14
* device instance $1020 r0 *1 73,116.52 cap_mim_2f0_m4m5_noshield
C$1020 \$11 topp 3.56528e-14
* device instance $1021 r0 *1 79.4,116.52 cap_mim_2f0_m4m5_noshield
C$1021 \$8 topp 3.56528e-14
* device instance $1022 r0 *1 85.8,116.52 cap_mim_2f0_m4m5_noshield
C$1022 \$11 topp 3.56528e-14
* device instance $1023 r0 *1 92.2,116.52 cap_mim_2f0_m4m5_noshield
C$1023 \$8 topp 3.56528e-14
* device instance $1024 r0 *1 98.6,116.52 cap_mim_2f0_m4m5_noshield
C$1024 \$11 topp 3.56528e-14
* device instance $1025 r0 *1 105,116.52 cap_mim_2f0_m4m5_noshield
C$1025 \$8 topp 3.56528e-14
* device instance $1026 r0 *1 111.4,116.52 cap_mim_2f0_m4m5_noshield
C$1026 \$11 topp 3.56528e-14
* device instance $1027 r0 *1 117.8,116.52 cap_mim_2f0_m4m5_noshield
C$1027 \$8 topp 3.56528e-14
* device instance $1028 r0 *1 124.2,116.52 cap_mim_2f0_m4m5_noshield
C$1028 \$11 topp 3.56528e-14
* device instance $1029 r0 *1 130.6,116.52 cap_mim_2f0_m4m5_noshield
C$1029 \$8 topp 3.56528e-14
* device instance $1030 r0 *1 137,116.52 cap_mim_2f0_m4m5_noshield
C$1030 \$11 topp 3.56528e-14
* device instance $1031 r0 *1 143.4,116.52 cap_mim_2f0_m4m5_noshield
C$1031 \$8 topp 3.56528e-14
* device instance $1032 r0 *1 149.8,116.52 cap_mim_2f0_m4m5_noshield
C$1032 \$11 topp 3.56528e-14
* device instance $1033 r0 *1 156.2,116.52 cap_mim_2f0_m4m5_noshield
C$1033 \$8 topp 3.56528e-14
* device instance $1034 r0 *1 162.6,116.52 cap_mim_2f0_m4m5_noshield
C$1034 \$11 topp 3.56528e-14
* device instance $1035 r0 *1 169,116.52 cap_mim_2f0_m4m5_noshield
C$1035 \$8 topp 3.56528e-14
* device instance $1036 r0 *1 175.4,116.52 cap_mim_2f0_m4m5_noshield
C$1036 \$11 topp 3.56528e-14
* device instance $1037 r0 *1 181.8,116.52 cap_mim_2f0_m4m5_noshield
C$1037 \$8 topp 3.56528e-14
* device instance $1038 r0 *1 188.2,116.52 cap_mim_2f0_m4m5_noshield
C$1038 \$11 topp 3.56528e-14
* device instance $1039 r0 *1 194.6,116.52 cap_mim_2f0_m4m5_noshield
C$1039 \$8 topp 3.56528e-14
* device instance $1040 r0 *1 201,116.52 cap_mim_2f0_m4m5_noshield
C$1040 \$11 topp 3.56528e-14
* device instance $1041 r0 *1 224,116.52 cap_mim_2f0_m4m5_noshield
C$1041 \$86 topn 3.56528e-14
* device instance $1042 r0 *1 230.4,116.52 cap_mim_2f0_m4m5_noshield
C$1042 \$95 topn 3.56528e-14
* device instance $1043 r0 *1 236.8,116.52 cap_mim_2f0_m4m5_noshield
C$1043 \$86 topn 3.56528e-14
* device instance $1044 r0 *1 243.2,116.52 cap_mim_2f0_m4m5_noshield
C$1044 \$95 topn 3.56528e-14
* device instance $1045 r0 *1 249.6,116.52 cap_mim_2f0_m4m5_noshield
C$1045 \$86 topn 3.56528e-14
* device instance $1046 r0 *1 256,116.52 cap_mim_2f0_m4m5_noshield
C$1046 \$95 topn 3.56528e-14
* device instance $1047 r0 *1 262.4,116.52 cap_mim_2f0_m4m5_noshield
C$1047 \$86 topn 3.56528e-14
* device instance $1048 r0 *1 268.8,116.52 cap_mim_2f0_m4m5_noshield
C$1048 \$95 topn 3.56528e-14
* device instance $1049 r0 *1 275.2,116.52 cap_mim_2f0_m4m5_noshield
C$1049 \$86 topn 3.56528e-14
* device instance $1050 r0 *1 281.6,116.52 cap_mim_2f0_m4m5_noshield
C$1050 \$95 topn 3.56528e-14
* device instance $1051 r0 *1 288,116.52 cap_mim_2f0_m4m5_noshield
C$1051 \$86 topn 3.56528e-14
* device instance $1052 r0 *1 294.4,116.52 cap_mim_2f0_m4m5_noshield
C$1052 \$95 topn 3.56528e-14
* device instance $1053 r0 *1 300.8,116.52 cap_mim_2f0_m4m5_noshield
C$1053 \$86 topn 3.56528e-14
* device instance $1054 r0 *1 307.2,116.52 cap_mim_2f0_m4m5_noshield
C$1054 \$95 topn 3.56528e-14
* device instance $1055 r0 *1 313.6,116.52 cap_mim_2f0_m4m5_noshield
C$1055 \$86 topn 3.56528e-14
* device instance $1056 r0 *1 320,116.52 cap_mim_2f0_m4m5_noshield
C$1056 \$95 topn 3.56528e-14
* device instance $1057 r0 *1 326.4,116.52 cap_mim_2f0_m4m5_noshield
C$1057 \$86 topn 3.56528e-14
* device instance $1058 r0 *1 332.8,116.52 cap_mim_2f0_m4m5_noshield
C$1058 \$95 topn 3.56528e-14
* device instance $1059 r0 *1 339.2,116.52 cap_mim_2f0_m4m5_noshield
C$1059 \$86 topn 3.56528e-14
* device instance $1060 r0 *1 345.6,116.52 cap_mim_2f0_m4m5_noshield
C$1060 \$95 topn 3.56528e-14
* device instance $1061 r0 *1 352,116.52 cap_mim_2f0_m4m5_noshield
C$1061 \$86 topn 3.56528e-14
* device instance $1062 r0 *1 358.4,116.52 cap_mim_2f0_m4m5_noshield
C$1062 \$95 topn 3.56528e-14
* device instance $1063 r0 *1 364.8,116.52 cap_mim_2f0_m4m5_noshield
C$1063 \$86 topn 3.56528e-14
* device instance $1064 r0 *1 371.2,116.52 cap_mim_2f0_m4m5_noshield
C$1064 \$95 topn 3.56528e-14
* device instance $1065 r0 *1 377.6,116.52 cap_mim_2f0_m4m5_noshield
C$1065 \$86 topn 3.56528e-14
* device instance $1066 r0 *1 384,116.52 cap_mim_2f0_m4m5_noshield
C$1066 \$95 topn 3.56528e-14
* device instance $1067 r0 *1 390.4,116.52 cap_mim_2f0_m4m5_noshield
C$1067 \$86 topn 3.56528e-14
* device instance $1068 r0 *1 396.8,116.52 cap_mim_2f0_m4m5_noshield
C$1068 \$95 topn 3.56528e-14
* device instance $1069 r0 *1 403.2,116.52 cap_mim_2f0_m4m5_noshield
C$1069 \$86 topn 3.56528e-14
* device instance $1070 r0 *1 409.6,116.52 cap_mim_2f0_m4m5_noshield
C$1070 \$95 topn 3.56528e-14
* device instance $1071 r0 *1 416,116.52 cap_mim_2f0_m4m5_noshield
C$1071 \$86 topn 3.56528e-14
* device instance $1072 r0 *1 422.4,116.52 cap_mim_2f0_m4m5_noshield
C$1072 \$95 topn 3.56528e-14
* device instance $1073 r0 *1 2.6,122.92 cap_mim_2f0_m4m5_noshield
C$1073 \$8 topp 3.56528e-14
* device instance $1074 r0 *1 9,122.92 cap_mim_2f0_m4m5_noshield
C$1074 \$11 topp 3.56528e-14
* device instance $1075 r0 *1 15.4,122.92 cap_mim_2f0_m4m5_noshield
C$1075 \$8 topp 3.56528e-14
* device instance $1076 r0 *1 21.8,122.92 cap_mim_2f0_m4m5_noshield
C$1076 \$11 topp 3.56528e-14
* device instance $1077 r0 *1 28.2,122.92 cap_mim_2f0_m4m5_noshield
C$1077 \$8 topp 3.56528e-14
* device instance $1078 r0 *1 34.6,122.92 cap_mim_2f0_m4m5_noshield
C$1078 \$11 topp 3.56528e-14
* device instance $1079 r0 *1 41,122.92 cap_mim_2f0_m4m5_noshield
C$1079 \$8 topp 3.56528e-14
* device instance $1080 r0 *1 47.4,122.92 cap_mim_2f0_m4m5_noshield
C$1080 \$11 topp 3.56528e-14
* device instance $1081 r0 *1 53.8,122.92 cap_mim_2f0_m4m5_noshield
C$1081 \$8 topp 3.56528e-14
* device instance $1082 r0 *1 60.2,122.92 cap_mim_2f0_m4m5_noshield
C$1082 \$11 topp 3.56528e-14
* device instance $1083 r0 *1 66.6,122.92 cap_mim_2f0_m4m5_noshield
C$1083 \$8 topp 3.56528e-14
* device instance $1084 r0 *1 73,122.92 cap_mim_2f0_m4m5_noshield
C$1084 \$11 topp 3.56528e-14
* device instance $1085 r0 *1 79.4,122.92 cap_mim_2f0_m4m5_noshield
C$1085 \$8 topp 3.56528e-14
* device instance $1086 r0 *1 85.8,122.92 cap_mim_2f0_m4m5_noshield
C$1086 \$11 topp 3.56528e-14
* device instance $1087 r0 *1 92.2,122.92 cap_mim_2f0_m4m5_noshield
C$1087 \$8 topp 3.56528e-14
* device instance $1088 r0 *1 98.6,122.92 cap_mim_2f0_m4m5_noshield
C$1088 \$11 topp 3.56528e-14
* device instance $1089 r0 *1 105,122.92 cap_mim_2f0_m4m5_noshield
C$1089 \$8 topp 3.56528e-14
* device instance $1090 r0 *1 111.4,122.92 cap_mim_2f0_m4m5_noshield
C$1090 \$11 topp 3.56528e-14
* device instance $1091 r0 *1 117.8,122.92 cap_mim_2f0_m4m5_noshield
C$1091 \$8 topp 3.56528e-14
* device instance $1092 r0 *1 124.2,122.92 cap_mim_2f0_m4m5_noshield
C$1092 \$11 topp 3.56528e-14
* device instance $1093 r0 *1 130.6,122.92 cap_mim_2f0_m4m5_noshield
C$1093 \$8 topp 3.56528e-14
* device instance $1094 r0 *1 137,122.92 cap_mim_2f0_m4m5_noshield
C$1094 \$11 topp 3.56528e-14
* device instance $1095 r0 *1 143.4,122.92 cap_mim_2f0_m4m5_noshield
C$1095 \$8 topp 3.56528e-14
* device instance $1096 r0 *1 149.8,122.92 cap_mim_2f0_m4m5_noshield
C$1096 \$11 topp 3.56528e-14
* device instance $1097 r0 *1 156.2,122.92 cap_mim_2f0_m4m5_noshield
C$1097 \$8 topp 3.56528e-14
* device instance $1098 r0 *1 162.6,122.92 cap_mim_2f0_m4m5_noshield
C$1098 \$11 topp 3.56528e-14
* device instance $1099 r0 *1 169,122.92 cap_mim_2f0_m4m5_noshield
C$1099 \$8 topp 3.56528e-14
* device instance $1100 r0 *1 175.4,122.92 cap_mim_2f0_m4m5_noshield
C$1100 \$11 topp 3.56528e-14
* device instance $1101 r0 *1 181.8,122.92 cap_mim_2f0_m4m5_noshield
C$1101 \$8 topp 3.56528e-14
* device instance $1102 r0 *1 188.2,122.92 cap_mim_2f0_m4m5_noshield
C$1102 \$11 topp 3.56528e-14
* device instance $1103 r0 *1 194.6,122.92 cap_mim_2f0_m4m5_noshield
C$1103 \$8 topp 3.56528e-14
* device instance $1104 r0 *1 201,122.92 cap_mim_2f0_m4m5_noshield
C$1104 \$11 topp 3.56528e-14
* device instance $1105 r0 *1 224,122.92 cap_mim_2f0_m4m5_noshield
C$1105 \$86 topn 3.56528e-14
* device instance $1106 r0 *1 230.4,122.92 cap_mim_2f0_m4m5_noshield
C$1106 \$95 topn 3.56528e-14
* device instance $1107 r0 *1 236.8,122.92 cap_mim_2f0_m4m5_noshield
C$1107 \$86 topn 3.56528e-14
* device instance $1108 r0 *1 243.2,122.92 cap_mim_2f0_m4m5_noshield
C$1108 \$95 topn 3.56528e-14
* device instance $1109 r0 *1 249.6,122.92 cap_mim_2f0_m4m5_noshield
C$1109 \$86 topn 3.56528e-14
* device instance $1110 r0 *1 256,122.92 cap_mim_2f0_m4m5_noshield
C$1110 \$95 topn 3.56528e-14
* device instance $1111 r0 *1 262.4,122.92 cap_mim_2f0_m4m5_noshield
C$1111 \$86 topn 3.56528e-14
* device instance $1112 r0 *1 268.8,122.92 cap_mim_2f0_m4m5_noshield
C$1112 \$95 topn 3.56528e-14
* device instance $1113 r0 *1 275.2,122.92 cap_mim_2f0_m4m5_noshield
C$1113 \$86 topn 3.56528e-14
* device instance $1114 r0 *1 281.6,122.92 cap_mim_2f0_m4m5_noshield
C$1114 \$95 topn 3.56528e-14
* device instance $1115 r0 *1 288,122.92 cap_mim_2f0_m4m5_noshield
C$1115 \$86 topn 3.56528e-14
* device instance $1116 r0 *1 294.4,122.92 cap_mim_2f0_m4m5_noshield
C$1116 \$95 topn 3.56528e-14
* device instance $1117 r0 *1 300.8,122.92 cap_mim_2f0_m4m5_noshield
C$1117 \$86 topn 3.56528e-14
* device instance $1118 r0 *1 307.2,122.92 cap_mim_2f0_m4m5_noshield
C$1118 \$95 topn 3.56528e-14
* device instance $1119 r0 *1 313.6,122.92 cap_mim_2f0_m4m5_noshield
C$1119 \$86 topn 3.56528e-14
* device instance $1120 r0 *1 320,122.92 cap_mim_2f0_m4m5_noshield
C$1120 \$95 topn 3.56528e-14
* device instance $1121 r0 *1 326.4,122.92 cap_mim_2f0_m4m5_noshield
C$1121 \$86 topn 3.56528e-14
* device instance $1122 r0 *1 332.8,122.92 cap_mim_2f0_m4m5_noshield
C$1122 \$95 topn 3.56528e-14
* device instance $1123 r0 *1 339.2,122.92 cap_mim_2f0_m4m5_noshield
C$1123 \$86 topn 3.56528e-14
* device instance $1124 r0 *1 345.6,122.92 cap_mim_2f0_m4m5_noshield
C$1124 \$95 topn 3.56528e-14
* device instance $1125 r0 *1 352,122.92 cap_mim_2f0_m4m5_noshield
C$1125 \$86 topn 3.56528e-14
* device instance $1126 r0 *1 358.4,122.92 cap_mim_2f0_m4m5_noshield
C$1126 \$95 topn 3.56528e-14
* device instance $1127 r0 *1 364.8,122.92 cap_mim_2f0_m4m5_noshield
C$1127 \$86 topn 3.56528e-14
* device instance $1128 r0 *1 371.2,122.92 cap_mim_2f0_m4m5_noshield
C$1128 \$95 topn 3.56528e-14
* device instance $1129 r0 *1 377.6,122.92 cap_mim_2f0_m4m5_noshield
C$1129 \$86 topn 3.56528e-14
* device instance $1130 r0 *1 384,122.92 cap_mim_2f0_m4m5_noshield
C$1130 \$95 topn 3.56528e-14
* device instance $1131 r0 *1 390.4,122.92 cap_mim_2f0_m4m5_noshield
C$1131 \$86 topn 3.56528e-14
* device instance $1132 r0 *1 396.8,122.92 cap_mim_2f0_m4m5_noshield
C$1132 \$95 topn 3.56528e-14
* device instance $1133 r0 *1 403.2,122.92 cap_mim_2f0_m4m5_noshield
C$1133 \$86 topn 3.56528e-14
* device instance $1134 r0 *1 409.6,122.92 cap_mim_2f0_m4m5_noshield
C$1134 \$95 topn 3.56528e-14
* device instance $1135 r0 *1 416,122.92 cap_mim_2f0_m4m5_noshield
C$1135 \$86 topn 3.56528e-14
* device instance $1136 r0 *1 422.4,122.92 cap_mim_2f0_m4m5_noshield
C$1136 \$95 topn 3.56528e-14
* device instance $1137 r0 *1 2.6,129.32 cap_mim_2f0_m4m5_noshield
C$1137 \$11 topp 3.56528e-14
* device instance $1138 r0 *1 9,129.32 cap_mim_2f0_m4m5_noshield
C$1138 \$8 topp 3.56528e-14
* device instance $1139 r0 *1 15.4,129.32 cap_mim_2f0_m4m5_noshield
C$1139 \$11 topp 3.56528e-14
* device instance $1140 r0 *1 21.8,129.32 cap_mim_2f0_m4m5_noshield
C$1140 \$8 topp 3.56528e-14
* device instance $1141 r0 *1 28.2,129.32 cap_mim_2f0_m4m5_noshield
C$1141 \$11 topp 3.56528e-14
* device instance $1142 r0 *1 34.6,129.32 cap_mim_2f0_m4m5_noshield
C$1142 \$8 topp 3.56528e-14
* device instance $1143 r0 *1 41,129.32 cap_mim_2f0_m4m5_noshield
C$1143 \$11 topp 3.56528e-14
* device instance $1144 r0 *1 47.4,129.32 cap_mim_2f0_m4m5_noshield
C$1144 \$8 topp 3.56528e-14
* device instance $1145 r0 *1 53.8,129.32 cap_mim_2f0_m4m5_noshield
C$1145 \$11 topp 3.56528e-14
* device instance $1146 r0 *1 60.2,129.32 cap_mim_2f0_m4m5_noshield
C$1146 \$8 topp 3.56528e-14
* device instance $1147 r0 *1 66.6,129.32 cap_mim_2f0_m4m5_noshield
C$1147 \$11 topp 3.56528e-14
* device instance $1148 r0 *1 73,129.32 cap_mim_2f0_m4m5_noshield
C$1148 \$8 topp 3.56528e-14
* device instance $1149 r0 *1 79.4,129.32 cap_mim_2f0_m4m5_noshield
C$1149 \$11 topp 3.56528e-14
* device instance $1150 r0 *1 85.8,129.32 cap_mim_2f0_m4m5_noshield
C$1150 \$8 topp 3.56528e-14
* device instance $1151 r0 *1 92.2,129.32 cap_mim_2f0_m4m5_noshield
C$1151 \$11 topp 3.56528e-14
* device instance $1152 r0 *1 98.6,129.32 cap_mim_2f0_m4m5_noshield
C$1152 \$8 topp 3.56528e-14
* device instance $1153 r0 *1 105,129.32 cap_mim_2f0_m4m5_noshield
C$1153 \$11 topp 3.56528e-14
* device instance $1154 r0 *1 111.4,129.32 cap_mim_2f0_m4m5_noshield
C$1154 \$8 topp 3.56528e-14
* device instance $1155 r0 *1 117.8,129.32 cap_mim_2f0_m4m5_noshield
C$1155 \$11 topp 3.56528e-14
* device instance $1156 r0 *1 124.2,129.32 cap_mim_2f0_m4m5_noshield
C$1156 \$8 topp 3.56528e-14
* device instance $1157 r0 *1 130.6,129.32 cap_mim_2f0_m4m5_noshield
C$1157 \$11 topp 3.56528e-14
* device instance $1158 r0 *1 137,129.32 cap_mim_2f0_m4m5_noshield
C$1158 \$8 topp 3.56528e-14
* device instance $1159 r0 *1 143.4,129.32 cap_mim_2f0_m4m5_noshield
C$1159 \$11 topp 3.56528e-14
* device instance $1160 r0 *1 149.8,129.32 cap_mim_2f0_m4m5_noshield
C$1160 \$8 topp 3.56528e-14
* device instance $1161 r0 *1 156.2,129.32 cap_mim_2f0_m4m5_noshield
C$1161 \$11 topp 3.56528e-14
* device instance $1162 r0 *1 162.6,129.32 cap_mim_2f0_m4m5_noshield
C$1162 \$8 topp 3.56528e-14
* device instance $1163 r0 *1 169,129.32 cap_mim_2f0_m4m5_noshield
C$1163 \$11 topp 3.56528e-14
* device instance $1164 r0 *1 175.4,129.32 cap_mim_2f0_m4m5_noshield
C$1164 \$8 topp 3.56528e-14
* device instance $1165 r0 *1 181.8,129.32 cap_mim_2f0_m4m5_noshield
C$1165 \$11 topp 3.56528e-14
* device instance $1166 r0 *1 188.2,129.32 cap_mim_2f0_m4m5_noshield
C$1166 \$8 topp 3.56528e-14
* device instance $1167 r0 *1 194.6,129.32 cap_mim_2f0_m4m5_noshield
C$1167 \$11 topp 3.56528e-14
* device instance $1168 r0 *1 201,129.32 cap_mim_2f0_m4m5_noshield
C$1168 \$8 topp 3.56528e-14
* device instance $1169 r0 *1 224,129.32 cap_mim_2f0_m4m5_noshield
C$1169 \$95 topn 3.56528e-14
* device instance $1170 r0 *1 230.4,129.32 cap_mim_2f0_m4m5_noshield
C$1170 \$86 topn 3.56528e-14
* device instance $1171 r0 *1 236.8,129.32 cap_mim_2f0_m4m5_noshield
C$1171 \$95 topn 3.56528e-14
* device instance $1172 r0 *1 243.2,129.32 cap_mim_2f0_m4m5_noshield
C$1172 \$86 topn 3.56528e-14
* device instance $1173 r0 *1 249.6,129.32 cap_mim_2f0_m4m5_noshield
C$1173 \$95 topn 3.56528e-14
* device instance $1174 r0 *1 256,129.32 cap_mim_2f0_m4m5_noshield
C$1174 \$86 topn 3.56528e-14
* device instance $1175 r0 *1 262.4,129.32 cap_mim_2f0_m4m5_noshield
C$1175 \$95 topn 3.56528e-14
* device instance $1176 r0 *1 268.8,129.32 cap_mim_2f0_m4m5_noshield
C$1176 \$86 topn 3.56528e-14
* device instance $1177 r0 *1 275.2,129.32 cap_mim_2f0_m4m5_noshield
C$1177 \$95 topn 3.56528e-14
* device instance $1178 r0 *1 281.6,129.32 cap_mim_2f0_m4m5_noshield
C$1178 \$86 topn 3.56528e-14
* device instance $1179 r0 *1 288,129.32 cap_mim_2f0_m4m5_noshield
C$1179 \$95 topn 3.56528e-14
* device instance $1180 r0 *1 294.4,129.32 cap_mim_2f0_m4m5_noshield
C$1180 \$86 topn 3.56528e-14
* device instance $1181 r0 *1 300.8,129.32 cap_mim_2f0_m4m5_noshield
C$1181 \$95 topn 3.56528e-14
* device instance $1182 r0 *1 307.2,129.32 cap_mim_2f0_m4m5_noshield
C$1182 \$86 topn 3.56528e-14
* device instance $1183 r0 *1 313.6,129.32 cap_mim_2f0_m4m5_noshield
C$1183 \$95 topn 3.56528e-14
* device instance $1184 r0 *1 320,129.32 cap_mim_2f0_m4m5_noshield
C$1184 \$86 topn 3.56528e-14
* device instance $1185 r0 *1 326.4,129.32 cap_mim_2f0_m4m5_noshield
C$1185 \$95 topn 3.56528e-14
* device instance $1186 r0 *1 332.8,129.32 cap_mim_2f0_m4m5_noshield
C$1186 \$86 topn 3.56528e-14
* device instance $1187 r0 *1 339.2,129.32 cap_mim_2f0_m4m5_noshield
C$1187 \$95 topn 3.56528e-14
* device instance $1188 r0 *1 345.6,129.32 cap_mim_2f0_m4m5_noshield
C$1188 \$86 topn 3.56528e-14
* device instance $1189 r0 *1 352,129.32 cap_mim_2f0_m4m5_noshield
C$1189 \$95 topn 3.56528e-14
* device instance $1190 r0 *1 358.4,129.32 cap_mim_2f0_m4m5_noshield
C$1190 \$86 topn 3.56528e-14
* device instance $1191 r0 *1 364.8,129.32 cap_mim_2f0_m4m5_noshield
C$1191 \$95 topn 3.56528e-14
* device instance $1192 r0 *1 371.2,129.32 cap_mim_2f0_m4m5_noshield
C$1192 \$86 topn 3.56528e-14
* device instance $1193 r0 *1 377.6,129.32 cap_mim_2f0_m4m5_noshield
C$1193 \$95 topn 3.56528e-14
* device instance $1194 r0 *1 384,129.32 cap_mim_2f0_m4m5_noshield
C$1194 \$86 topn 3.56528e-14
* device instance $1195 r0 *1 390.4,129.32 cap_mim_2f0_m4m5_noshield
C$1195 \$95 topn 3.56528e-14
* device instance $1196 r0 *1 396.8,129.32 cap_mim_2f0_m4m5_noshield
C$1196 \$86 topn 3.56528e-14
* device instance $1197 r0 *1 403.2,129.32 cap_mim_2f0_m4m5_noshield
C$1197 \$95 topn 3.56528e-14
* device instance $1198 r0 *1 409.6,129.32 cap_mim_2f0_m4m5_noshield
C$1198 \$86 topn 3.56528e-14
* device instance $1199 r0 *1 416,129.32 cap_mim_2f0_m4m5_noshield
C$1199 \$95 topn 3.56528e-14
* device instance $1200 r0 *1 422.4,129.32 cap_mim_2f0_m4m5_noshield
C$1200 \$86 topn 3.56528e-14
* device instance $1201 r0 *1 2.6,135.72 cap_mim_2f0_m4m5_noshield
C$1201 \$11 topp 3.56528e-14
* device instance $1202 r0 *1 9,135.72 cap_mim_2f0_m4m5_noshield
C$1202 \$8 topp 3.56528e-14
* device instance $1203 r0 *1 15.4,135.72 cap_mim_2f0_m4m5_noshield
C$1203 \$11 topp 3.56528e-14
* device instance $1204 r0 *1 21.8,135.72 cap_mim_2f0_m4m5_noshield
C$1204 \$8 topp 3.56528e-14
* device instance $1205 r0 *1 28.2,135.72 cap_mim_2f0_m4m5_noshield
C$1205 \$11 topp 3.56528e-14
* device instance $1206 r0 *1 34.6,135.72 cap_mim_2f0_m4m5_noshield
C$1206 \$8 topp 3.56528e-14
* device instance $1207 r0 *1 41,135.72 cap_mim_2f0_m4m5_noshield
C$1207 \$11 topp 3.56528e-14
* device instance $1208 r0 *1 47.4,135.72 cap_mim_2f0_m4m5_noshield
C$1208 \$8 topp 3.56528e-14
* device instance $1209 r0 *1 53.8,135.72 cap_mim_2f0_m4m5_noshield
C$1209 \$11 topp 3.56528e-14
* device instance $1210 r0 *1 60.2,135.72 cap_mim_2f0_m4m5_noshield
C$1210 \$8 topp 3.56528e-14
* device instance $1211 r0 *1 66.6,135.72 cap_mim_2f0_m4m5_noshield
C$1211 \$11 topp 3.56528e-14
* device instance $1212 r0 *1 73,135.72 cap_mim_2f0_m4m5_noshield
C$1212 \$8 topp 3.56528e-14
* device instance $1213 r0 *1 79.4,135.72 cap_mim_2f0_m4m5_noshield
C$1213 \$11 topp 3.56528e-14
* device instance $1214 r0 *1 85.8,135.72 cap_mim_2f0_m4m5_noshield
C$1214 \$8 topp 3.56528e-14
* device instance $1215 r0 *1 92.2,135.72 cap_mim_2f0_m4m5_noshield
C$1215 \$11 topp 3.56528e-14
* device instance $1216 r0 *1 98.6,135.72 cap_mim_2f0_m4m5_noshield
C$1216 \$8 topp 3.56528e-14
* device instance $1217 r0 *1 105,135.72 cap_mim_2f0_m4m5_noshield
C$1217 \$11 topp 3.56528e-14
* device instance $1218 r0 *1 111.4,135.72 cap_mim_2f0_m4m5_noshield
C$1218 \$8 topp 3.56528e-14
* device instance $1219 r0 *1 117.8,135.72 cap_mim_2f0_m4m5_noshield
C$1219 \$11 topp 3.56528e-14
* device instance $1220 r0 *1 124.2,135.72 cap_mim_2f0_m4m5_noshield
C$1220 \$8 topp 3.56528e-14
* device instance $1221 r0 *1 130.6,135.72 cap_mim_2f0_m4m5_noshield
C$1221 \$11 topp 3.56528e-14
* device instance $1222 r0 *1 137,135.72 cap_mim_2f0_m4m5_noshield
C$1222 \$8 topp 3.56528e-14
* device instance $1223 r0 *1 143.4,135.72 cap_mim_2f0_m4m5_noshield
C$1223 \$11 topp 3.56528e-14
* device instance $1224 r0 *1 149.8,135.72 cap_mim_2f0_m4m5_noshield
C$1224 \$8 topp 3.56528e-14
* device instance $1225 r0 *1 156.2,135.72 cap_mim_2f0_m4m5_noshield
C$1225 \$11 topp 3.56528e-14
* device instance $1226 r0 *1 162.6,135.72 cap_mim_2f0_m4m5_noshield
C$1226 \$8 topp 3.56528e-14
* device instance $1227 r0 *1 169,135.72 cap_mim_2f0_m4m5_noshield
C$1227 \$11 topp 3.56528e-14
* device instance $1228 r0 *1 175.4,135.72 cap_mim_2f0_m4m5_noshield
C$1228 \$8 topp 3.56528e-14
* device instance $1229 r0 *1 181.8,135.72 cap_mim_2f0_m4m5_noshield
C$1229 \$11 topp 3.56528e-14
* device instance $1230 r0 *1 188.2,135.72 cap_mim_2f0_m4m5_noshield
C$1230 \$8 topp 3.56528e-14
* device instance $1231 r0 *1 194.6,135.72 cap_mim_2f0_m4m5_noshield
C$1231 \$11 topp 3.56528e-14
* device instance $1232 r0 *1 201,135.72 cap_mim_2f0_m4m5_noshield
C$1232 \$8 topp 3.56528e-14
* device instance $1233 r0 *1 224,135.72 cap_mim_2f0_m4m5_noshield
C$1233 \$95 topn 3.56528e-14
* device instance $1234 r0 *1 230.4,135.72 cap_mim_2f0_m4m5_noshield
C$1234 \$86 topn 3.56528e-14
* device instance $1235 r0 *1 236.8,135.72 cap_mim_2f0_m4m5_noshield
C$1235 \$95 topn 3.56528e-14
* device instance $1236 r0 *1 243.2,135.72 cap_mim_2f0_m4m5_noshield
C$1236 \$86 topn 3.56528e-14
* device instance $1237 r0 *1 249.6,135.72 cap_mim_2f0_m4m5_noshield
C$1237 \$95 topn 3.56528e-14
* device instance $1238 r0 *1 256,135.72 cap_mim_2f0_m4m5_noshield
C$1238 \$86 topn 3.56528e-14
* device instance $1239 r0 *1 262.4,135.72 cap_mim_2f0_m4m5_noshield
C$1239 \$95 topn 3.56528e-14
* device instance $1240 r0 *1 268.8,135.72 cap_mim_2f0_m4m5_noshield
C$1240 \$86 topn 3.56528e-14
* device instance $1241 r0 *1 275.2,135.72 cap_mim_2f0_m4m5_noshield
C$1241 \$95 topn 3.56528e-14
* device instance $1242 r0 *1 281.6,135.72 cap_mim_2f0_m4m5_noshield
C$1242 \$86 topn 3.56528e-14
* device instance $1243 r0 *1 288,135.72 cap_mim_2f0_m4m5_noshield
C$1243 \$95 topn 3.56528e-14
* device instance $1244 r0 *1 294.4,135.72 cap_mim_2f0_m4m5_noshield
C$1244 \$86 topn 3.56528e-14
* device instance $1245 r0 *1 300.8,135.72 cap_mim_2f0_m4m5_noshield
C$1245 \$95 topn 3.56528e-14
* device instance $1246 r0 *1 307.2,135.72 cap_mim_2f0_m4m5_noshield
C$1246 \$86 topn 3.56528e-14
* device instance $1247 r0 *1 313.6,135.72 cap_mim_2f0_m4m5_noshield
C$1247 \$95 topn 3.56528e-14
* device instance $1248 r0 *1 320,135.72 cap_mim_2f0_m4m5_noshield
C$1248 \$86 topn 3.56528e-14
* device instance $1249 r0 *1 326.4,135.72 cap_mim_2f0_m4m5_noshield
C$1249 \$95 topn 3.56528e-14
* device instance $1250 r0 *1 332.8,135.72 cap_mim_2f0_m4m5_noshield
C$1250 \$86 topn 3.56528e-14
* device instance $1251 r0 *1 339.2,135.72 cap_mim_2f0_m4m5_noshield
C$1251 \$95 topn 3.56528e-14
* device instance $1252 r0 *1 345.6,135.72 cap_mim_2f0_m4m5_noshield
C$1252 \$86 topn 3.56528e-14
* device instance $1253 r0 *1 352,135.72 cap_mim_2f0_m4m5_noshield
C$1253 \$95 topn 3.56528e-14
* device instance $1254 r0 *1 358.4,135.72 cap_mim_2f0_m4m5_noshield
C$1254 \$86 topn 3.56528e-14
* device instance $1255 r0 *1 364.8,135.72 cap_mim_2f0_m4m5_noshield
C$1255 \$95 topn 3.56528e-14
* device instance $1256 r0 *1 371.2,135.72 cap_mim_2f0_m4m5_noshield
C$1256 \$86 topn 3.56528e-14
* device instance $1257 r0 *1 377.6,135.72 cap_mim_2f0_m4m5_noshield
C$1257 \$95 topn 3.56528e-14
* device instance $1258 r0 *1 384,135.72 cap_mim_2f0_m4m5_noshield
C$1258 \$86 topn 3.56528e-14
* device instance $1259 r0 *1 390.4,135.72 cap_mim_2f0_m4m5_noshield
C$1259 \$95 topn 3.56528e-14
* device instance $1260 r0 *1 396.8,135.72 cap_mim_2f0_m4m5_noshield
C$1260 \$86 topn 3.56528e-14
* device instance $1261 r0 *1 403.2,135.72 cap_mim_2f0_m4m5_noshield
C$1261 \$95 topn 3.56528e-14
* device instance $1262 r0 *1 409.6,135.72 cap_mim_2f0_m4m5_noshield
C$1262 \$86 topn 3.56528e-14
* device instance $1263 r0 *1 416,135.72 cap_mim_2f0_m4m5_noshield
C$1263 \$95 topn 3.56528e-14
* device instance $1264 r0 *1 422.4,135.72 cap_mim_2f0_m4m5_noshield
C$1264 \$86 topn 3.56528e-14
* device instance $1265 r0 *1 2.6,142.12 cap_mim_2f0_m4m5_noshield
C$1265 \$14 topp 3.56528e-14
* device instance $1266 r0 *1 9,142.12 cap_mim_2f0_m4m5_noshield
C$1266 \$8 topp 3.56528e-14
* device instance $1267 r0 *1 15.4,142.12 cap_mim_2f0_m4m5_noshield
C$1267 \$14 topp 3.56528e-14
* device instance $1268 r0 *1 21.8,142.12 cap_mim_2f0_m4m5_noshield
C$1268 \$8 topp 3.56528e-14
* device instance $1269 r0 *1 28.2,142.12 cap_mim_2f0_m4m5_noshield
C$1269 \$14 topp 3.56528e-14
* device instance $1270 r0 *1 34.6,142.12 cap_mim_2f0_m4m5_noshield
C$1270 \$8 topp 3.56528e-14
* device instance $1271 r0 *1 41,142.12 cap_mim_2f0_m4m5_noshield
C$1271 \$14 topp 3.56528e-14
* device instance $1272 r0 *1 47.4,142.12 cap_mim_2f0_m4m5_noshield
C$1272 \$8 topp 3.56528e-14
* device instance $1273 r0 *1 53.8,142.12 cap_mim_2f0_m4m5_noshield
C$1273 \$14 topp 3.56528e-14
* device instance $1274 r0 *1 60.2,142.12 cap_mim_2f0_m4m5_noshield
C$1274 \$8 topp 3.56528e-14
* device instance $1275 r0 *1 66.6,142.12 cap_mim_2f0_m4m5_noshield
C$1275 \$14 topp 3.56528e-14
* device instance $1276 r0 *1 73,142.12 cap_mim_2f0_m4m5_noshield
C$1276 \$8 topp 3.56528e-14
* device instance $1277 r0 *1 79.4,142.12 cap_mim_2f0_m4m5_noshield
C$1277 \$14 topp 3.56528e-14
* device instance $1278 r0 *1 85.8,142.12 cap_mim_2f0_m4m5_noshield
C$1278 \$8 topp 3.56528e-14
* device instance $1279 r0 *1 92.2,142.12 cap_mim_2f0_m4m5_noshield
C$1279 \$14 topp 3.56528e-14
* device instance $1280 r0 *1 98.6,142.12 cap_mim_2f0_m4m5_noshield
C$1280 \$8 topp 3.56528e-14
* device instance $1281 r0 *1 105,142.12 cap_mim_2f0_m4m5_noshield
C$1281 \$14 topp 3.56528e-14
* device instance $1282 r0 *1 111.4,142.12 cap_mim_2f0_m4m5_noshield
C$1282 \$8 topp 3.56528e-14
* device instance $1283 r0 *1 117.8,142.12 cap_mim_2f0_m4m5_noshield
C$1283 \$14 topp 3.56528e-14
* device instance $1284 r0 *1 124.2,142.12 cap_mim_2f0_m4m5_noshield
C$1284 \$8 topp 3.56528e-14
* device instance $1285 r0 *1 130.6,142.12 cap_mim_2f0_m4m5_noshield
C$1285 \$14 topp 3.56528e-14
* device instance $1286 r0 *1 137,142.12 cap_mim_2f0_m4m5_noshield
C$1286 \$8 topp 3.56528e-14
* device instance $1287 r0 *1 143.4,142.12 cap_mim_2f0_m4m5_noshield
C$1287 \$14 topp 3.56528e-14
* device instance $1288 r0 *1 149.8,142.12 cap_mim_2f0_m4m5_noshield
C$1288 \$8 topp 3.56528e-14
* device instance $1289 r0 *1 156.2,142.12 cap_mim_2f0_m4m5_noshield
C$1289 \$14 topp 3.56528e-14
* device instance $1290 r0 *1 162.6,142.12 cap_mim_2f0_m4m5_noshield
C$1290 \$8 topp 3.56528e-14
* device instance $1291 r0 *1 169,142.12 cap_mim_2f0_m4m5_noshield
C$1291 \$14 topp 3.56528e-14
* device instance $1292 r0 *1 175.4,142.12 cap_mim_2f0_m4m5_noshield
C$1292 \$8 topp 3.56528e-14
* device instance $1293 r0 *1 181.8,142.12 cap_mim_2f0_m4m5_noshield
C$1293 \$14 topp 3.56528e-14
* device instance $1294 r0 *1 188.2,142.12 cap_mim_2f0_m4m5_noshield
C$1294 \$8 topp 3.56528e-14
* device instance $1295 r0 *1 194.6,142.12 cap_mim_2f0_m4m5_noshield
C$1295 \$14 topp 3.56528e-14
* device instance $1296 r0 *1 201,142.12 cap_mim_2f0_m4m5_noshield
C$1296 \$8 topp 3.56528e-14
* device instance $1297 r0 *1 224,142.12 cap_mim_2f0_m4m5_noshield
C$1297 \$103 topn 3.56528e-14
* device instance $1298 r0 *1 230.4,142.12 cap_mim_2f0_m4m5_noshield
C$1298 \$86 topn 3.56528e-14
* device instance $1299 r0 *1 236.8,142.12 cap_mim_2f0_m4m5_noshield
C$1299 \$103 topn 3.56528e-14
* device instance $1300 r0 *1 243.2,142.12 cap_mim_2f0_m4m5_noshield
C$1300 \$86 topn 3.56528e-14
* device instance $1301 r0 *1 249.6,142.12 cap_mim_2f0_m4m5_noshield
C$1301 \$103 topn 3.56528e-14
* device instance $1302 r0 *1 256,142.12 cap_mim_2f0_m4m5_noshield
C$1302 \$86 topn 3.56528e-14
* device instance $1303 r0 *1 262.4,142.12 cap_mim_2f0_m4m5_noshield
C$1303 \$103 topn 3.56528e-14
* device instance $1304 r0 *1 268.8,142.12 cap_mim_2f0_m4m5_noshield
C$1304 \$86 topn 3.56528e-14
* device instance $1305 r0 *1 275.2,142.12 cap_mim_2f0_m4m5_noshield
C$1305 \$103 topn 3.56528e-14
* device instance $1306 r0 *1 281.6,142.12 cap_mim_2f0_m4m5_noshield
C$1306 \$86 topn 3.56528e-14
* device instance $1307 r0 *1 288,142.12 cap_mim_2f0_m4m5_noshield
C$1307 \$103 topn 3.56528e-14
* device instance $1308 r0 *1 294.4,142.12 cap_mim_2f0_m4m5_noshield
C$1308 \$86 topn 3.56528e-14
* device instance $1309 r0 *1 300.8,142.12 cap_mim_2f0_m4m5_noshield
C$1309 \$103 topn 3.56528e-14
* device instance $1310 r0 *1 307.2,142.12 cap_mim_2f0_m4m5_noshield
C$1310 \$86 topn 3.56528e-14
* device instance $1311 r0 *1 313.6,142.12 cap_mim_2f0_m4m5_noshield
C$1311 \$103 topn 3.56528e-14
* device instance $1312 r0 *1 320,142.12 cap_mim_2f0_m4m5_noshield
C$1312 \$86 topn 3.56528e-14
* device instance $1313 r0 *1 326.4,142.12 cap_mim_2f0_m4m5_noshield
C$1313 \$103 topn 3.56528e-14
* device instance $1314 r0 *1 332.8,142.12 cap_mim_2f0_m4m5_noshield
C$1314 \$86 topn 3.56528e-14
* device instance $1315 r0 *1 339.2,142.12 cap_mim_2f0_m4m5_noshield
C$1315 \$103 topn 3.56528e-14
* device instance $1316 r0 *1 345.6,142.12 cap_mim_2f0_m4m5_noshield
C$1316 \$86 topn 3.56528e-14
* device instance $1317 r0 *1 352,142.12 cap_mim_2f0_m4m5_noshield
C$1317 \$103 topn 3.56528e-14
* device instance $1318 r0 *1 358.4,142.12 cap_mim_2f0_m4m5_noshield
C$1318 \$86 topn 3.56528e-14
* device instance $1319 r0 *1 364.8,142.12 cap_mim_2f0_m4m5_noshield
C$1319 \$103 topn 3.56528e-14
* device instance $1320 r0 *1 371.2,142.12 cap_mim_2f0_m4m5_noshield
C$1320 \$86 topn 3.56528e-14
* device instance $1321 r0 *1 377.6,142.12 cap_mim_2f0_m4m5_noshield
C$1321 \$103 topn 3.56528e-14
* device instance $1322 r0 *1 384,142.12 cap_mim_2f0_m4m5_noshield
C$1322 \$86 topn 3.56528e-14
* device instance $1323 r0 *1 390.4,142.12 cap_mim_2f0_m4m5_noshield
C$1323 \$103 topn 3.56528e-14
* device instance $1324 r0 *1 396.8,142.12 cap_mim_2f0_m4m5_noshield
C$1324 \$86 topn 3.56528e-14
* device instance $1325 r0 *1 403.2,142.12 cap_mim_2f0_m4m5_noshield
C$1325 \$103 topn 3.56528e-14
* device instance $1326 r0 *1 409.6,142.12 cap_mim_2f0_m4m5_noshield
C$1326 \$86 topn 3.56528e-14
* device instance $1327 r0 *1 416,142.12 cap_mim_2f0_m4m5_noshield
C$1327 \$103 topn 3.56528e-14
* device instance $1328 r0 *1 422.4,142.12 cap_mim_2f0_m4m5_noshield
C$1328 \$86 topn 3.56528e-14
* device instance $1329 r0 *1 2.6,148.52 cap_mim_2f0_m4m5_noshield
C$1329 \$17 topp 3.56528e-14
* device instance $1330 r0 *1 9,148.52 cap_mim_2f0_m4m5_noshield
C$1330 \$8 topp 3.56528e-14
* device instance $1331 r0 *1 15.4,148.52 cap_mim_2f0_m4m5_noshield
C$1331 \$17 topp 3.56528e-14
* device instance $1332 r0 *1 21.8,148.52 cap_mim_2f0_m4m5_noshield
C$1332 \$8 topp 3.56528e-14
* device instance $1333 r0 *1 28.2,148.52 cap_mim_2f0_m4m5_noshield
C$1333 \$17 topp 3.56528e-14
* device instance $1334 r0 *1 34.6,148.52 cap_mim_2f0_m4m5_noshield
C$1334 \$8 topp 3.56528e-14
* device instance $1335 r0 *1 41,148.52 cap_mim_2f0_m4m5_noshield
C$1335 \$17 topp 3.56528e-14
* device instance $1336 r0 *1 47.4,148.52 cap_mim_2f0_m4m5_noshield
C$1336 \$8 topp 3.56528e-14
* device instance $1337 r0 *1 53.8,148.52 cap_mim_2f0_m4m5_noshield
C$1337 \$17 topp 3.56528e-14
* device instance $1338 r0 *1 60.2,148.52 cap_mim_2f0_m4m5_noshield
C$1338 \$8 topp 3.56528e-14
* device instance $1339 r0 *1 66.6,148.52 cap_mim_2f0_m4m5_noshield
C$1339 \$17 topp 3.56528e-14
* device instance $1340 r0 *1 73,148.52 cap_mim_2f0_m4m5_noshield
C$1340 \$8 topp 3.56528e-14
* device instance $1341 r0 *1 79.4,148.52 cap_mim_2f0_m4m5_noshield
C$1341 \$17 topp 3.56528e-14
* device instance $1342 r0 *1 85.8,148.52 cap_mim_2f0_m4m5_noshield
C$1342 \$8 topp 3.56528e-14
* device instance $1343 r0 *1 92.2,148.52 cap_mim_2f0_m4m5_noshield
C$1343 \$17 topp 3.56528e-14
* device instance $1344 r0 *1 98.6,148.52 cap_mim_2f0_m4m5_noshield
C$1344 \$8 topp 3.56528e-14
* device instance $1345 r0 *1 105,148.52 cap_mim_2f0_m4m5_noshield
C$1345 \$20 topp 3.56528e-14
* device instance $1346 r0 *1 111.4,148.52 cap_mim_2f0_m4m5_noshield
C$1346 \$8 topp 3.56528e-14
* device instance $1347 r0 *1 117.8,148.52 cap_mim_2f0_m4m5_noshield
C$1347 \$20 topp 3.56528e-14
* device instance $1348 r0 *1 124.2,148.52 cap_mim_2f0_m4m5_noshield
C$1348 \$8 topp 3.56528e-14
* device instance $1349 r0 *1 130.6,148.52 cap_mim_2f0_m4m5_noshield
C$1349 \$20 topp 3.56528e-14
* device instance $1350 r0 *1 137,148.52 cap_mim_2f0_m4m5_noshield
C$1350 \$8 topp 3.56528e-14
* device instance $1351 r0 *1 143.4,148.52 cap_mim_2f0_m4m5_noshield
C$1351 \$20 topp 3.56528e-14
* device instance $1352 r0 *1 149.8,148.52 cap_mim_2f0_m4m5_noshield
C$1352 \$8 topp 3.56528e-14
* device instance $1353 r0 *1 156.2,148.52 cap_mim_2f0_m4m5_noshield
C$1353 \$23 topp 3.56528e-14
* device instance $1354 r0 *1 162.6,148.52 cap_mim_2f0_m4m5_noshield
C$1354 \$8 topp 3.56528e-14
* device instance $1355 r0 *1 169,148.52 cap_mim_2f0_m4m5_noshield
C$1355 \$23 topp 3.56528e-14
* device instance $1356 r0 *1 175.4,148.52 cap_mim_2f0_m4m5_noshield
C$1356 \$8 topp 3.56528e-14
* device instance $1357 r0 *1 181.8,148.52 cap_mim_2f0_m4m5_noshield
C$1357 \$26 topp 3.56528e-14
* device instance $1358 r0 *1 188.2,148.52 cap_mim_2f0_m4m5_noshield
C$1358 \$8 topp 3.56528e-14
* device instance $1359 r0 *1 194.6,148.52 cap_mim_2f0_m4m5_noshield
C$1359 \$29 topp 3.56528e-14
* device instance $1360 r0 *1 201,148.52 cap_mim_2f0_m4m5_noshield
C$1360 \$8 topp 3.56528e-14
* device instance $1361 r0 *1 224,148.52 cap_mim_2f0_m4m5_noshield
C$1361 \$111 topn 3.56528e-14
* device instance $1362 r0 *1 230.4,148.52 cap_mim_2f0_m4m5_noshield
C$1362 \$86 topn 3.56528e-14
* device instance $1363 r0 *1 236.8,148.52 cap_mim_2f0_m4m5_noshield
C$1363 \$111 topn 3.56528e-14
* device instance $1364 r0 *1 243.2,148.52 cap_mim_2f0_m4m5_noshield
C$1364 \$86 topn 3.56528e-14
* device instance $1365 r0 *1 249.6,148.52 cap_mim_2f0_m4m5_noshield
C$1365 \$111 topn 3.56528e-14
* device instance $1366 r0 *1 256,148.52 cap_mim_2f0_m4m5_noshield
C$1366 \$86 topn 3.56528e-14
* device instance $1367 r0 *1 262.4,148.52 cap_mim_2f0_m4m5_noshield
C$1367 \$111 topn 3.56528e-14
* device instance $1368 r0 *1 268.8,148.52 cap_mim_2f0_m4m5_noshield
C$1368 \$86 topn 3.56528e-14
* device instance $1369 r0 *1 275.2,148.52 cap_mim_2f0_m4m5_noshield
C$1369 \$111 topn 3.56528e-14
* device instance $1370 r0 *1 281.6,148.52 cap_mim_2f0_m4m5_noshield
C$1370 \$86 topn 3.56528e-14
* device instance $1371 r0 *1 288,148.52 cap_mim_2f0_m4m5_noshield
C$1371 \$111 topn 3.56528e-14
* device instance $1372 r0 *1 294.4,148.52 cap_mim_2f0_m4m5_noshield
C$1372 \$86 topn 3.56528e-14
* device instance $1373 r0 *1 300.8,148.52 cap_mim_2f0_m4m5_noshield
C$1373 \$111 topn 3.56528e-14
* device instance $1374 r0 *1 307.2,148.52 cap_mim_2f0_m4m5_noshield
C$1374 \$86 topn 3.56528e-14
* device instance $1375 r0 *1 313.6,148.52 cap_mim_2f0_m4m5_noshield
C$1375 \$111 topn 3.56528e-14
* device instance $1376 r0 *1 320,148.52 cap_mim_2f0_m4m5_noshield
C$1376 \$86 topn 3.56528e-14
* device instance $1377 r0 *1 326.4,148.52 cap_mim_2f0_m4m5_noshield
C$1377 \$119 topn 3.56528e-14
* device instance $1378 r0 *1 332.8,148.52 cap_mim_2f0_m4m5_noshield
C$1378 \$86 topn 3.56528e-14
* device instance $1379 r0 *1 339.2,148.52 cap_mim_2f0_m4m5_noshield
C$1379 \$119 topn 3.56528e-14
* device instance $1380 r0 *1 345.6,148.52 cap_mim_2f0_m4m5_noshield
C$1380 \$86 topn 3.56528e-14
* device instance $1381 r0 *1 352,148.52 cap_mim_2f0_m4m5_noshield
C$1381 \$119 topn 3.56528e-14
* device instance $1382 r0 *1 358.4,148.52 cap_mim_2f0_m4m5_noshield
C$1382 \$86 topn 3.56528e-14
* device instance $1383 r0 *1 364.8,148.52 cap_mim_2f0_m4m5_noshield
C$1383 \$119 topn 3.56528e-14
* device instance $1384 r0 *1 371.2,148.52 cap_mim_2f0_m4m5_noshield
C$1384 \$86 topn 3.56528e-14
* device instance $1385 r0 *1 377.6,148.52 cap_mim_2f0_m4m5_noshield
C$1385 \$127 topn 3.56528e-14
* device instance $1386 r0 *1 384,148.52 cap_mim_2f0_m4m5_noshield
C$1386 \$86 topn 3.56528e-14
* device instance $1387 r0 *1 390.4,148.52 cap_mim_2f0_m4m5_noshield
C$1387 \$127 topn 3.56528e-14
* device instance $1388 r0 *1 396.8,148.52 cap_mim_2f0_m4m5_noshield
C$1388 \$86 topn 3.56528e-14
* device instance $1389 r0 *1 403.2,148.52 cap_mim_2f0_m4m5_noshield
C$1389 \$135 topn 3.56528e-14
* device instance $1390 r0 *1 409.6,148.52 cap_mim_2f0_m4m5_noshield
C$1390 \$86 topn 3.56528e-14
* device instance $1391 r0 *1 416,148.52 cap_mim_2f0_m4m5_noshield
C$1391 \$143 topn 3.56528e-14
* device instance $1392 r0 *1 422.4,148.52 cap_mim_2f0_m4m5_noshield
C$1392 \$86 topn 3.56528e-14
.ENDS ADC_TOP
