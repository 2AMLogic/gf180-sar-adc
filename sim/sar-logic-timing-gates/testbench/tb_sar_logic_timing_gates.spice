* ==================================================================
* tb_sar_logic_timing -- what the synchronous choice actually buys,
* measured rather than asserted (issue #11, DR-0008).
*
* GENERATED by design/sar-logic/flow/gen_sar_ctrl_gates_tb.py -- do not edit.
*
* Four single-ended loops, identical except for a delay inserted
* between the comparator's analog decision and the controller
* sampling it. The delay stands in for everything that has to happen
* inside one 62.5 ns bit cycle before the latching edge: DAC settling,
* comparator regeneration, and logic propagation.
*   ok   0 ns    reference
*   lt  40 ns    the whole of the ~40 ns of per-cycle slack the
*                survey (Sec 4.2) claims a 62.5 ns bit cycle has,
*                spent in one place
*   xl  50 ns    80 % of the cycle consumed -- still correct
*   bad 70 ns    DELIBERATELY past the 62.5 ns cycle: the decision
*                arrives after the edge that was supposed to latch it
*
* The 50 ns point is not the survey's original guess: an earlier draft
* of this deck used 55 ns and measured a real failure (max|err| = 2
* LSB against a >= 1 LSB threshold). Bisecting against this SAME
* behavioural DAC/comparator model found the true boundary between
* 50 ns (exact) and 52 ns (max|err| = 1 LSB, already over the 0.5 LSB
* bound). 50 ns is kept as the bracket point precisely because it is
* the largest round number this model measures as exact, not because
* it was the original guess -- CLAUDE.md requires a measured number
* here, not an assumed one. DR-0010 records the gap between the
* survey's slack estimate and this measured boundary; the shortfall
* is attributed to this testbench's RC DAC-settling model (tau =
* 2.56 ns) consuming part of the delay budget the survey treated as
* separate, not to a synchronous-logic problem.
*
* `bad` is the negative control, and it is the reason the other three
* mean anything: its check asserts the conversion IS wrong. Without a
* case that must fail, an err == 0 result on the first three would not
* show that this testbench can detect a broken conversion at all.
*
* A fifth loop, `tie`, holds its input exactly on the free-MSB
* decision threshold (v_in = V_cm to the last bit) for the whole run.
* That is the near-metastable input a real comparator resolves slowly
* or wrongly. The claim under test is NOT that the code is right --
* on an exact tie either adjacent code is correct -- but that the
* conversion still COMPLETES on schedule: drdy keeps arriving exactly
* 16 clocks apart. That is the concrete form of the row
* spec/prior-art-survey.md Sec 4.3 gives synchronous logic ('a stalled
* decision corrupts one bit') against asynchronous ('a stalled
* decision stalls the whole conversion; needs a timeout/watchdog').
* ==================================================================

.param vref={vdd_val}
.param vcm={vdd_val/2}
.param vth={vdd_val/2}
.param lsbse={vdd_val/1024}
.model sarl_sw sw(vt={vdd_val/2} vh=0 ron=1 roff=1e12)

vclk clk 0 pulse(0 {vdd_val} 0 100p 100p 31.25n 62.5n)

* ---- loop ok ----
vokstart ok_start 0 pwl(0 {vdd_val} 125n {vdd_val} 125.1n 0)
vokmode ok_mode 0 dc 0
xok clk ok_start ok_mode ok_cmpo ok_samp_tp_n ok_sel_in_n ok_drdy ok_c9
+ ok_c8 ok_c7 ok_c6 ok_c5 ok_c4 ok_c3 ok_c2 ok_c1 ok_c0 ok_rel_n_256p
+ ok_sel_hi_n_256p ok_sel_lo_n_256p ok_rel_n_128p ok_sel_hi_n_128p
+ ok_sel_lo_n_128p ok_rel_n_64p ok_sel_hi_n_64p ok_sel_lo_n_64p
+ ok_rel_n_32p ok_sel_hi_n_32p ok_sel_lo_n_32p ok_rel_n_16p
+ ok_sel_hi_n_16p ok_sel_lo_n_16p ok_rel_n_8p ok_sel_hi_n_8p
+ ok_sel_lo_n_8p ok_rel_n_4p ok_sel_hi_n_4p ok_sel_lo_n_4p ok_rel_n_2p
+ ok_sel_hi_n_2p ok_sel_lo_n_2p ok_rel_n_1p ok_sel_hi_n_1p ok_sel_lo_n_1p
+ ok_rel_n_256n ok_sel_hi_n_256n ok_sel_lo_n_256n ok_rel_n_128n
+ ok_sel_hi_n_128n ok_sel_lo_n_128n ok_rel_n_64n ok_sel_hi_n_64n
+ ok_sel_lo_n_64n ok_rel_n_32n ok_sel_hi_n_32n ok_sel_lo_n_32n
+ ok_rel_n_16n ok_sel_hi_n_16n ok_sel_lo_n_16n ok_rel_n_8n ok_sel_hi_n_8n
+ ok_sel_lo_n_8n ok_rel_n_4n ok_sel_hi_n_4n ok_sel_lo_n_4n ok_rel_n_2n
+ ok_sel_hi_n_2n ok_sel_lo_n_2n ok_rel_n_1n ok_sel_hi_n_1n ok_sel_lo_n_1n
+ sar_ctrl_a
sokp ok_vinp ok_shp ok_samp_tp_n 0 sarl_sw
sokn ok_vinn ok_shn ok_samp_tp_n 0 sarl_sw
cokp ok_shp 0 1p
cokn ok_shn 0 1p
roksd ok_samp_tp_n ok_sampd 10k
coksd ok_sampd 0 1p
sokxp ok_vinp ok_shxp ok_sampd 0 sarl_sw
sokxn ok_vinn ok_shxn ok_sampd 0 sarl_sw
cokxp ok_shxp 0 1p
cokxn ok_shxn 0 1p
boktopp ok_topip 0 V = 2*vcm-v(ok_shp)+(1.0/512)*(
+ 256*((v(ok_rel_n_256p)*vcm+v(ok_sel_hi_n_256p)*vref+v(ok_sel_in_n)*v(ok_vinp))/vdd_val-vcm) + 128*((v(ok_rel_n_128p)*vcm+v(ok_sel_hi_n_128p)*vref+v(ok_sel_in_n)*v(ok_vinp))/vdd_val-vcm) + 64*((v(ok_rel_n_64p)*vcm+v(ok_sel_hi_n_64p)*vref+v(ok_sel_in_n)*v(ok_vinp))/vdd_val-vcm) + 32*((v(ok_rel_n_32p)*vcm+v(ok_sel_hi_n_32p)*vref+v(ok_sel_in_n)*v(ok_vinp))/vdd_val-vcm) + 16*((v(ok_rel_n_16p)*vcm+v(ok_sel_hi_n_16p)*vref+v(ok_sel_in_n)*v(ok_vinp))/vdd_val-vcm) + 8*((v(ok_rel_n_8p)*vcm+v(ok_sel_hi_n_8p)*vref+v(ok_sel_in_n)*v(ok_vinp))/vdd_val-vcm) + 4*((v(ok_rel_n_4p)*vcm+v(ok_sel_hi_n_4p)*vref+v(ok_sel_in_n)*v(ok_vinp))/vdd_val-vcm) + 2*((v(ok_rel_n_2p)*vcm+v(ok_sel_hi_n_2p)*vref+v(ok_sel_in_n)*v(ok_vinp))/vdd_val-vcm) + 1*((v(ok_rel_n_1p)*vcm+v(ok_sel_hi_n_1p)*vref+v(ok_sel_in_n)*v(ok_vinp))/vdd_val-vcm) )
boktopn ok_topin 0 V = 2*vcm-v(ok_shn)+(1.0/512)*(
+ 256*((v(ok_rel_n_256n)*vcm+v(ok_sel_hi_n_256n)*vref+v(ok_sel_in_n)*v(ok_vinn))/vdd_val-vcm) + 128*((v(ok_rel_n_128n)*vcm+v(ok_sel_hi_n_128n)*vref+v(ok_sel_in_n)*v(ok_vinn))/vdd_val-vcm) + 64*((v(ok_rel_n_64n)*vcm+v(ok_sel_hi_n_64n)*vref+v(ok_sel_in_n)*v(ok_vinn))/vdd_val-vcm) + 32*((v(ok_rel_n_32n)*vcm+v(ok_sel_hi_n_32n)*vref+v(ok_sel_in_n)*v(ok_vinn))/vdd_val-vcm) + 16*((v(ok_rel_n_16n)*vcm+v(ok_sel_hi_n_16n)*vref+v(ok_sel_in_n)*v(ok_vinn))/vdd_val-vcm) + 8*((v(ok_rel_n_8n)*vcm+v(ok_sel_hi_n_8n)*vref+v(ok_sel_in_n)*v(ok_vinn))/vdd_val-vcm) + 4*((v(ok_rel_n_4n)*vcm+v(ok_sel_hi_n_4n)*vref+v(ok_sel_in_n)*v(ok_vinn))/vdd_val-vcm) + 2*((v(ok_rel_n_2n)*vcm+v(ok_sel_hi_n_2n)*vref+v(ok_sel_in_n)*v(ok_vinn))/vdd_val-vcm) + 1*((v(ok_rel_n_1n)*vcm+v(ok_sel_hi_n_1n)*vref+v(ok_sel_in_n)*v(ok_vinn))/vdd_val-vcm) )
rokp ok_topip ok_topp 1k
rokn ok_topin ok_topn 1k
coktp ok_topp 0 2.56p
coktn ok_topn 0 2.56p
bokcmp ok_cmpd 0 V = v(ok_topp) > v(ok_topn) ? vdd_val : 0
rokcmps ok_cmpd ok_cmpo 1k
cokcmpl ok_cmpo 0 100f
bokcode ok_code 0 V =
+ (512)*(v(ok_c9)>vth ? 1 : 0) + (256)*(v(ok_c8)>vth ? 1 : 0) + (128)*(v(ok_c7)>vth ? 1 : 0) + (64)*(v(ok_c6)>vth ? 1 : 0) + (32)*(v(ok_c5)>vth ? 1 : 0) + (16)*(v(ok_c4)>vth ? 1 : 0) + (8)*(v(ok_c3)>vth ? 1 : 0) + (4)*(v(ok_c2)>vth ? 1 : 0) + (2)*(v(ok_c1)>vth ? 1 : 0) + (1)*(v(ok_c0)>vth ? 1 : 0)
bokdrdyb ok_drdyb 0 V = v(ok_drdy)>vth ? vdd_val : 0
rokdrdyg ok_drdyb ok_drdyg 1k
cokdrdyg ok_drdyg 0 721.348f
bokconf ok_conf 0 V = (
+ abs(v(ok_sel_in_n)+v(ok_rel_n_256p)+v(ok_sel_hi_n_256p)+v(ok_sel_lo_n_256p)-vdd_val) + abs(v(ok_sel_in_n)+v(ok_rel_n_128p)+v(ok_sel_hi_n_128p)+v(ok_sel_lo_n_128p)-vdd_val) + abs(v(ok_sel_in_n)+v(ok_rel_n_64p)+v(ok_sel_hi_n_64p)+v(ok_sel_lo_n_64p)-vdd_val) + abs(v(ok_sel_in_n)+v(ok_rel_n_32p)+v(ok_sel_hi_n_32p)+v(ok_sel_lo_n_32p)-vdd_val) + abs(v(ok_sel_in_n)+v(ok_rel_n_16p)+v(ok_sel_hi_n_16p)+v(ok_sel_lo_n_16p)-vdd_val) + abs(v(ok_sel_in_n)+v(ok_rel_n_8p)+v(ok_sel_hi_n_8p)+v(ok_sel_lo_n_8p)-vdd_val) + abs(v(ok_sel_in_n)+v(ok_rel_n_4p)+v(ok_sel_hi_n_4p)+v(ok_sel_lo_n_4p)-vdd_val) + abs(v(ok_sel_in_n)+v(ok_rel_n_2p)+v(ok_sel_hi_n_2p)+v(ok_sel_lo_n_2p)-vdd_val) + abs(v(ok_sel_in_n)+v(ok_rel_n_1p)+v(ok_sel_hi_n_1p)+v(ok_sel_lo_n_1p)-vdd_val) + abs(v(ok_sel_in_n)+v(ok_rel_n_256n)+v(ok_sel_hi_n_256n)+v(ok_sel_lo_n_256n)-vdd_val) + abs(v(ok_sel_in_n)+v(ok_rel_n_128n)+v(ok_sel_hi_n_128n)+v(ok_sel_lo_n_128n)-vdd_val) + abs(v(ok_sel_in_n)+v(ok_rel_n_64n)+v(ok_sel_hi_n_64n)+v(ok_sel_lo_n_64n)-vdd_val) + abs(v(ok_sel_in_n)+v(ok_rel_n_32n)+v(ok_sel_hi_n_32n)+v(ok_sel_lo_n_32n)-vdd_val) + abs(v(ok_sel_in_n)+v(ok_rel_n_16n)+v(ok_sel_hi_n_16n)+v(ok_sel_lo_n_16n)-vdd_val) + abs(v(ok_sel_in_n)+v(ok_rel_n_8n)+v(ok_sel_hi_n_8n)+v(ok_sel_lo_n_8n)-vdd_val) + abs(v(ok_sel_in_n)+v(ok_rel_n_4n)+v(ok_sel_hi_n_4n)+v(ok_sel_lo_n_4n)-vdd_val) + abs(v(ok_sel_in_n)+v(ok_rel_n_2n)+v(ok_sel_hi_n_2n)+v(ok_sel_lo_n_2n)-vdd_val) + abs(v(ok_sel_in_n)+v(ok_rel_n_1n)+v(ok_sel_hi_n_1n)+v(ok_sel_lo_n_1n)-vdd_val))/vdd_val
boknside ok_nside 0 V = (
+ v(ok_sel_hi_n_256n)+v(ok_sel_lo_n_256n) + v(ok_sel_hi_n_128n)+v(ok_sel_lo_n_128n) + v(ok_sel_hi_n_64n)+v(ok_sel_lo_n_64n) + v(ok_sel_hi_n_32n)+v(ok_sel_lo_n_32n) + v(ok_sel_hi_n_16n)+v(ok_sel_lo_n_16n) + v(ok_sel_hi_n_8n)+v(ok_sel_lo_n_8n) + v(ok_sel_hi_n_4n)+v(ok_sel_lo_n_4n) + v(ok_sel_hi_n_2n)+v(ok_sel_lo_n_2n) + v(ok_sel_hi_n_1n)+v(ok_sel_lo_n_1n))/vdd_val
bokacq ok_acq 0 V = v(ok_samp_tp_n)/vdd_val
bokiso ok_iso 0 V = (v(ok_sel_in_n)-v(ok_samp_tp_n))/vdd_val
* ok: input ramps one LSB per conversion THROUGH mid-scale
* (codes 507..515), so the run crosses the major carry where every
* bit changes at once -- the worst case for a late decision -- and
* exercises both branches of the free-MSB trial.
vokin ok_vinp 0 pwl(0 {vcm-4.75*lsbse} 8u {vcm+3.25*lsbse})
vokcm ok_vinn 0 dc {vcm}
bokexp ok_exp 0 V = min(max(floor(v(ok_shxp)/lsbse),0),1023)
bokerr ok_err 0 V = min(v(ok_drdy),v(ok_drdyg))>vth ? v(ok_code)-v(ok_exp) : 0
bokaerr ok_aerr 0 V = abs(v(ok_err))

* ---- loop lt ----
vltstart lt_start 0 pwl(0 {vdd_val} 125n {vdd_val} 125.1n 0)
vltmode lt_mode 0 dc 0
xlt clk lt_start lt_mode lt_cmpo lt_samp_tp_n lt_sel_in_n lt_drdy lt_c9
+ lt_c8 lt_c7 lt_c6 lt_c5 lt_c4 lt_c3 lt_c2 lt_c1 lt_c0 lt_rel_n_256p
+ lt_sel_hi_n_256p lt_sel_lo_n_256p lt_rel_n_128p lt_sel_hi_n_128p
+ lt_sel_lo_n_128p lt_rel_n_64p lt_sel_hi_n_64p lt_sel_lo_n_64p
+ lt_rel_n_32p lt_sel_hi_n_32p lt_sel_lo_n_32p lt_rel_n_16p
+ lt_sel_hi_n_16p lt_sel_lo_n_16p lt_rel_n_8p lt_sel_hi_n_8p
+ lt_sel_lo_n_8p lt_rel_n_4p lt_sel_hi_n_4p lt_sel_lo_n_4p lt_rel_n_2p
+ lt_sel_hi_n_2p lt_sel_lo_n_2p lt_rel_n_1p lt_sel_hi_n_1p lt_sel_lo_n_1p
+ lt_rel_n_256n lt_sel_hi_n_256n lt_sel_lo_n_256n lt_rel_n_128n
+ lt_sel_hi_n_128n lt_sel_lo_n_128n lt_rel_n_64n lt_sel_hi_n_64n
+ lt_sel_lo_n_64n lt_rel_n_32n lt_sel_hi_n_32n lt_sel_lo_n_32n
+ lt_rel_n_16n lt_sel_hi_n_16n lt_sel_lo_n_16n lt_rel_n_8n lt_sel_hi_n_8n
+ lt_sel_lo_n_8n lt_rel_n_4n lt_sel_hi_n_4n lt_sel_lo_n_4n lt_rel_n_2n
+ lt_sel_hi_n_2n lt_sel_lo_n_2n lt_rel_n_1n lt_sel_hi_n_1n lt_sel_lo_n_1n
+ sar_ctrl_a
sltp lt_vinp lt_shp lt_samp_tp_n 0 sarl_sw
sltn lt_vinn lt_shn lt_samp_tp_n 0 sarl_sw
cltp lt_shp 0 1p
cltn lt_shn 0 1p
rltsd lt_samp_tp_n lt_sampd 10k
cltsd lt_sampd 0 1p
sltxp lt_vinp lt_shxp lt_sampd 0 sarl_sw
sltxn lt_vinn lt_shxn lt_sampd 0 sarl_sw
cltxp lt_shxp 0 1p
cltxn lt_shxn 0 1p
blttopp lt_topip 0 V = 2*vcm-v(lt_shp)+(1.0/512)*(
+ 256*((v(lt_rel_n_256p)*vcm+v(lt_sel_hi_n_256p)*vref+v(lt_sel_in_n)*v(lt_vinp))/vdd_val-vcm) + 128*((v(lt_rel_n_128p)*vcm+v(lt_sel_hi_n_128p)*vref+v(lt_sel_in_n)*v(lt_vinp))/vdd_val-vcm) + 64*((v(lt_rel_n_64p)*vcm+v(lt_sel_hi_n_64p)*vref+v(lt_sel_in_n)*v(lt_vinp))/vdd_val-vcm) + 32*((v(lt_rel_n_32p)*vcm+v(lt_sel_hi_n_32p)*vref+v(lt_sel_in_n)*v(lt_vinp))/vdd_val-vcm) + 16*((v(lt_rel_n_16p)*vcm+v(lt_sel_hi_n_16p)*vref+v(lt_sel_in_n)*v(lt_vinp))/vdd_val-vcm) + 8*((v(lt_rel_n_8p)*vcm+v(lt_sel_hi_n_8p)*vref+v(lt_sel_in_n)*v(lt_vinp))/vdd_val-vcm) + 4*((v(lt_rel_n_4p)*vcm+v(lt_sel_hi_n_4p)*vref+v(lt_sel_in_n)*v(lt_vinp))/vdd_val-vcm) + 2*((v(lt_rel_n_2p)*vcm+v(lt_sel_hi_n_2p)*vref+v(lt_sel_in_n)*v(lt_vinp))/vdd_val-vcm) + 1*((v(lt_rel_n_1p)*vcm+v(lt_sel_hi_n_1p)*vref+v(lt_sel_in_n)*v(lt_vinp))/vdd_val-vcm) )
blttopn lt_topin 0 V = 2*vcm-v(lt_shn)+(1.0/512)*(
+ 256*((v(lt_rel_n_256n)*vcm+v(lt_sel_hi_n_256n)*vref+v(lt_sel_in_n)*v(lt_vinn))/vdd_val-vcm) + 128*((v(lt_rel_n_128n)*vcm+v(lt_sel_hi_n_128n)*vref+v(lt_sel_in_n)*v(lt_vinn))/vdd_val-vcm) + 64*((v(lt_rel_n_64n)*vcm+v(lt_sel_hi_n_64n)*vref+v(lt_sel_in_n)*v(lt_vinn))/vdd_val-vcm) + 32*((v(lt_rel_n_32n)*vcm+v(lt_sel_hi_n_32n)*vref+v(lt_sel_in_n)*v(lt_vinn))/vdd_val-vcm) + 16*((v(lt_rel_n_16n)*vcm+v(lt_sel_hi_n_16n)*vref+v(lt_sel_in_n)*v(lt_vinn))/vdd_val-vcm) + 8*((v(lt_rel_n_8n)*vcm+v(lt_sel_hi_n_8n)*vref+v(lt_sel_in_n)*v(lt_vinn))/vdd_val-vcm) + 4*((v(lt_rel_n_4n)*vcm+v(lt_sel_hi_n_4n)*vref+v(lt_sel_in_n)*v(lt_vinn))/vdd_val-vcm) + 2*((v(lt_rel_n_2n)*vcm+v(lt_sel_hi_n_2n)*vref+v(lt_sel_in_n)*v(lt_vinn))/vdd_val-vcm) + 1*((v(lt_rel_n_1n)*vcm+v(lt_sel_hi_n_1n)*vref+v(lt_sel_in_n)*v(lt_vinn))/vdd_val-vcm) )
rltp lt_topip lt_topp 1k
rltn lt_topin lt_topn 1k
clttp lt_topp 0 2.56p
clttn lt_topn 0 2.56p
bltcmp lt_cmpi 0 V = v(lt_topp) > v(lt_topn) ? vdd_val : 0
tltd lt_cmpi 0 lt_cmpo 0 z0=50 td=40n
rltterm lt_cmpo 0 50
bltcode lt_code 0 V =
+ (512)*(v(lt_c9)>vth ? 1 : 0) + (256)*(v(lt_c8)>vth ? 1 : 0) + (128)*(v(lt_c7)>vth ? 1 : 0) + (64)*(v(lt_c6)>vth ? 1 : 0) + (32)*(v(lt_c5)>vth ? 1 : 0) + (16)*(v(lt_c4)>vth ? 1 : 0) + (8)*(v(lt_c3)>vth ? 1 : 0) + (4)*(v(lt_c2)>vth ? 1 : 0) + (2)*(v(lt_c1)>vth ? 1 : 0) + (1)*(v(lt_c0)>vth ? 1 : 0)
bltdrdyb lt_drdyb 0 V = v(lt_drdy)>vth ? vdd_val : 0
rltdrdyg lt_drdyb lt_drdyg 1k
cltdrdyg lt_drdyg 0 721.348f
bltconf lt_conf 0 V = (
+ abs(v(lt_sel_in_n)+v(lt_rel_n_256p)+v(lt_sel_hi_n_256p)+v(lt_sel_lo_n_256p)-vdd_val) + abs(v(lt_sel_in_n)+v(lt_rel_n_128p)+v(lt_sel_hi_n_128p)+v(lt_sel_lo_n_128p)-vdd_val) + abs(v(lt_sel_in_n)+v(lt_rel_n_64p)+v(lt_sel_hi_n_64p)+v(lt_sel_lo_n_64p)-vdd_val) + abs(v(lt_sel_in_n)+v(lt_rel_n_32p)+v(lt_sel_hi_n_32p)+v(lt_sel_lo_n_32p)-vdd_val) + abs(v(lt_sel_in_n)+v(lt_rel_n_16p)+v(lt_sel_hi_n_16p)+v(lt_sel_lo_n_16p)-vdd_val) + abs(v(lt_sel_in_n)+v(lt_rel_n_8p)+v(lt_sel_hi_n_8p)+v(lt_sel_lo_n_8p)-vdd_val) + abs(v(lt_sel_in_n)+v(lt_rel_n_4p)+v(lt_sel_hi_n_4p)+v(lt_sel_lo_n_4p)-vdd_val) + abs(v(lt_sel_in_n)+v(lt_rel_n_2p)+v(lt_sel_hi_n_2p)+v(lt_sel_lo_n_2p)-vdd_val) + abs(v(lt_sel_in_n)+v(lt_rel_n_1p)+v(lt_sel_hi_n_1p)+v(lt_sel_lo_n_1p)-vdd_val) + abs(v(lt_sel_in_n)+v(lt_rel_n_256n)+v(lt_sel_hi_n_256n)+v(lt_sel_lo_n_256n)-vdd_val) + abs(v(lt_sel_in_n)+v(lt_rel_n_128n)+v(lt_sel_hi_n_128n)+v(lt_sel_lo_n_128n)-vdd_val) + abs(v(lt_sel_in_n)+v(lt_rel_n_64n)+v(lt_sel_hi_n_64n)+v(lt_sel_lo_n_64n)-vdd_val) + abs(v(lt_sel_in_n)+v(lt_rel_n_32n)+v(lt_sel_hi_n_32n)+v(lt_sel_lo_n_32n)-vdd_val) + abs(v(lt_sel_in_n)+v(lt_rel_n_16n)+v(lt_sel_hi_n_16n)+v(lt_sel_lo_n_16n)-vdd_val) + abs(v(lt_sel_in_n)+v(lt_rel_n_8n)+v(lt_sel_hi_n_8n)+v(lt_sel_lo_n_8n)-vdd_val) + abs(v(lt_sel_in_n)+v(lt_rel_n_4n)+v(lt_sel_hi_n_4n)+v(lt_sel_lo_n_4n)-vdd_val) + abs(v(lt_sel_in_n)+v(lt_rel_n_2n)+v(lt_sel_hi_n_2n)+v(lt_sel_lo_n_2n)-vdd_val) + abs(v(lt_sel_in_n)+v(lt_rel_n_1n)+v(lt_sel_hi_n_1n)+v(lt_sel_lo_n_1n)-vdd_val))/vdd_val
bltnside lt_nside 0 V = (
+ v(lt_sel_hi_n_256n)+v(lt_sel_lo_n_256n) + v(lt_sel_hi_n_128n)+v(lt_sel_lo_n_128n) + v(lt_sel_hi_n_64n)+v(lt_sel_lo_n_64n) + v(lt_sel_hi_n_32n)+v(lt_sel_lo_n_32n) + v(lt_sel_hi_n_16n)+v(lt_sel_lo_n_16n) + v(lt_sel_hi_n_8n)+v(lt_sel_lo_n_8n) + v(lt_sel_hi_n_4n)+v(lt_sel_lo_n_4n) + v(lt_sel_hi_n_2n)+v(lt_sel_lo_n_2n) + v(lt_sel_hi_n_1n)+v(lt_sel_lo_n_1n))/vdd_val
bltacq lt_acq 0 V = v(lt_samp_tp_n)/vdd_val
bltiso lt_iso 0 V = (v(lt_sel_in_n)-v(lt_samp_tp_n))/vdd_val
* lt: input ramps one LSB per conversion THROUGH mid-scale
* (codes 507..515), so the run crosses the major carry where every
* bit changes at once -- the worst case for a late decision -- and
* exercises both branches of the free-MSB trial.
vltin lt_vinp 0 pwl(0 {vcm-4.75*lsbse} 8u {vcm+3.25*lsbse})
vltcm lt_vinn 0 dc {vcm}
bltexp lt_exp 0 V = min(max(floor(v(lt_shxp)/lsbse),0),1023)
blterr lt_err 0 V = min(v(lt_drdy),v(lt_drdyg))>vth ? v(lt_code)-v(lt_exp) : 0
bltaerr lt_aerr 0 V = abs(v(lt_err))

* ---- loop xl ----
vxlstart xl_start 0 pwl(0 {vdd_val} 125n {vdd_val} 125.1n 0)
vxlmode xl_mode 0 dc 0
xxl clk xl_start xl_mode xl_cmpo xl_samp_tp_n xl_sel_in_n xl_drdy xl_c9
+ xl_c8 xl_c7 xl_c6 xl_c5 xl_c4 xl_c3 xl_c2 xl_c1 xl_c0 xl_rel_n_256p
+ xl_sel_hi_n_256p xl_sel_lo_n_256p xl_rel_n_128p xl_sel_hi_n_128p
+ xl_sel_lo_n_128p xl_rel_n_64p xl_sel_hi_n_64p xl_sel_lo_n_64p
+ xl_rel_n_32p xl_sel_hi_n_32p xl_sel_lo_n_32p xl_rel_n_16p
+ xl_sel_hi_n_16p xl_sel_lo_n_16p xl_rel_n_8p xl_sel_hi_n_8p
+ xl_sel_lo_n_8p xl_rel_n_4p xl_sel_hi_n_4p xl_sel_lo_n_4p xl_rel_n_2p
+ xl_sel_hi_n_2p xl_sel_lo_n_2p xl_rel_n_1p xl_sel_hi_n_1p xl_sel_lo_n_1p
+ xl_rel_n_256n xl_sel_hi_n_256n xl_sel_lo_n_256n xl_rel_n_128n
+ xl_sel_hi_n_128n xl_sel_lo_n_128n xl_rel_n_64n xl_sel_hi_n_64n
+ xl_sel_lo_n_64n xl_rel_n_32n xl_sel_hi_n_32n xl_sel_lo_n_32n
+ xl_rel_n_16n xl_sel_hi_n_16n xl_sel_lo_n_16n xl_rel_n_8n xl_sel_hi_n_8n
+ xl_sel_lo_n_8n xl_rel_n_4n xl_sel_hi_n_4n xl_sel_lo_n_4n xl_rel_n_2n
+ xl_sel_hi_n_2n xl_sel_lo_n_2n xl_rel_n_1n xl_sel_hi_n_1n xl_sel_lo_n_1n
+ sar_ctrl_a
sxlp xl_vinp xl_shp xl_samp_tp_n 0 sarl_sw
sxln xl_vinn xl_shn xl_samp_tp_n 0 sarl_sw
cxlp xl_shp 0 1p
cxln xl_shn 0 1p
rxlsd xl_samp_tp_n xl_sampd 10k
cxlsd xl_sampd 0 1p
sxlxp xl_vinp xl_shxp xl_sampd 0 sarl_sw
sxlxn xl_vinn xl_shxn xl_sampd 0 sarl_sw
cxlxp xl_shxp 0 1p
cxlxn xl_shxn 0 1p
bxltopp xl_topip 0 V = 2*vcm-v(xl_shp)+(1.0/512)*(
+ 256*((v(xl_rel_n_256p)*vcm+v(xl_sel_hi_n_256p)*vref+v(xl_sel_in_n)*v(xl_vinp))/vdd_val-vcm) + 128*((v(xl_rel_n_128p)*vcm+v(xl_sel_hi_n_128p)*vref+v(xl_sel_in_n)*v(xl_vinp))/vdd_val-vcm) + 64*((v(xl_rel_n_64p)*vcm+v(xl_sel_hi_n_64p)*vref+v(xl_sel_in_n)*v(xl_vinp))/vdd_val-vcm) + 32*((v(xl_rel_n_32p)*vcm+v(xl_sel_hi_n_32p)*vref+v(xl_sel_in_n)*v(xl_vinp))/vdd_val-vcm) + 16*((v(xl_rel_n_16p)*vcm+v(xl_sel_hi_n_16p)*vref+v(xl_sel_in_n)*v(xl_vinp))/vdd_val-vcm) + 8*((v(xl_rel_n_8p)*vcm+v(xl_sel_hi_n_8p)*vref+v(xl_sel_in_n)*v(xl_vinp))/vdd_val-vcm) + 4*((v(xl_rel_n_4p)*vcm+v(xl_sel_hi_n_4p)*vref+v(xl_sel_in_n)*v(xl_vinp))/vdd_val-vcm) + 2*((v(xl_rel_n_2p)*vcm+v(xl_sel_hi_n_2p)*vref+v(xl_sel_in_n)*v(xl_vinp))/vdd_val-vcm) + 1*((v(xl_rel_n_1p)*vcm+v(xl_sel_hi_n_1p)*vref+v(xl_sel_in_n)*v(xl_vinp))/vdd_val-vcm) )
bxltopn xl_topin 0 V = 2*vcm-v(xl_shn)+(1.0/512)*(
+ 256*((v(xl_rel_n_256n)*vcm+v(xl_sel_hi_n_256n)*vref+v(xl_sel_in_n)*v(xl_vinn))/vdd_val-vcm) + 128*((v(xl_rel_n_128n)*vcm+v(xl_sel_hi_n_128n)*vref+v(xl_sel_in_n)*v(xl_vinn))/vdd_val-vcm) + 64*((v(xl_rel_n_64n)*vcm+v(xl_sel_hi_n_64n)*vref+v(xl_sel_in_n)*v(xl_vinn))/vdd_val-vcm) + 32*((v(xl_rel_n_32n)*vcm+v(xl_sel_hi_n_32n)*vref+v(xl_sel_in_n)*v(xl_vinn))/vdd_val-vcm) + 16*((v(xl_rel_n_16n)*vcm+v(xl_sel_hi_n_16n)*vref+v(xl_sel_in_n)*v(xl_vinn))/vdd_val-vcm) + 8*((v(xl_rel_n_8n)*vcm+v(xl_sel_hi_n_8n)*vref+v(xl_sel_in_n)*v(xl_vinn))/vdd_val-vcm) + 4*((v(xl_rel_n_4n)*vcm+v(xl_sel_hi_n_4n)*vref+v(xl_sel_in_n)*v(xl_vinn))/vdd_val-vcm) + 2*((v(xl_rel_n_2n)*vcm+v(xl_sel_hi_n_2n)*vref+v(xl_sel_in_n)*v(xl_vinn))/vdd_val-vcm) + 1*((v(xl_rel_n_1n)*vcm+v(xl_sel_hi_n_1n)*vref+v(xl_sel_in_n)*v(xl_vinn))/vdd_val-vcm) )
rxlp xl_topip xl_topp 1k
rxln xl_topin xl_topn 1k
cxltp xl_topp 0 2.56p
cxltn xl_topn 0 2.56p
bxlcmp xl_cmpi 0 V = v(xl_topp) > v(xl_topn) ? vdd_val : 0
txld xl_cmpi 0 xl_cmpo 0 z0=50 td=50n
rxlterm xl_cmpo 0 50
bxlcode xl_code 0 V =
+ (512)*(v(xl_c9)>vth ? 1 : 0) + (256)*(v(xl_c8)>vth ? 1 : 0) + (128)*(v(xl_c7)>vth ? 1 : 0) + (64)*(v(xl_c6)>vth ? 1 : 0) + (32)*(v(xl_c5)>vth ? 1 : 0) + (16)*(v(xl_c4)>vth ? 1 : 0) + (8)*(v(xl_c3)>vth ? 1 : 0) + (4)*(v(xl_c2)>vth ? 1 : 0) + (2)*(v(xl_c1)>vth ? 1 : 0) + (1)*(v(xl_c0)>vth ? 1 : 0)
bxldrdyb xl_drdyb 0 V = v(xl_drdy)>vth ? vdd_val : 0
rxldrdyg xl_drdyb xl_drdyg 1k
cxldrdyg xl_drdyg 0 721.348f
bxlconf xl_conf 0 V = (
+ abs(v(xl_sel_in_n)+v(xl_rel_n_256p)+v(xl_sel_hi_n_256p)+v(xl_sel_lo_n_256p)-vdd_val) + abs(v(xl_sel_in_n)+v(xl_rel_n_128p)+v(xl_sel_hi_n_128p)+v(xl_sel_lo_n_128p)-vdd_val) + abs(v(xl_sel_in_n)+v(xl_rel_n_64p)+v(xl_sel_hi_n_64p)+v(xl_sel_lo_n_64p)-vdd_val) + abs(v(xl_sel_in_n)+v(xl_rel_n_32p)+v(xl_sel_hi_n_32p)+v(xl_sel_lo_n_32p)-vdd_val) + abs(v(xl_sel_in_n)+v(xl_rel_n_16p)+v(xl_sel_hi_n_16p)+v(xl_sel_lo_n_16p)-vdd_val) + abs(v(xl_sel_in_n)+v(xl_rel_n_8p)+v(xl_sel_hi_n_8p)+v(xl_sel_lo_n_8p)-vdd_val) + abs(v(xl_sel_in_n)+v(xl_rel_n_4p)+v(xl_sel_hi_n_4p)+v(xl_sel_lo_n_4p)-vdd_val) + abs(v(xl_sel_in_n)+v(xl_rel_n_2p)+v(xl_sel_hi_n_2p)+v(xl_sel_lo_n_2p)-vdd_val) + abs(v(xl_sel_in_n)+v(xl_rel_n_1p)+v(xl_sel_hi_n_1p)+v(xl_sel_lo_n_1p)-vdd_val) + abs(v(xl_sel_in_n)+v(xl_rel_n_256n)+v(xl_sel_hi_n_256n)+v(xl_sel_lo_n_256n)-vdd_val) + abs(v(xl_sel_in_n)+v(xl_rel_n_128n)+v(xl_sel_hi_n_128n)+v(xl_sel_lo_n_128n)-vdd_val) + abs(v(xl_sel_in_n)+v(xl_rel_n_64n)+v(xl_sel_hi_n_64n)+v(xl_sel_lo_n_64n)-vdd_val) + abs(v(xl_sel_in_n)+v(xl_rel_n_32n)+v(xl_sel_hi_n_32n)+v(xl_sel_lo_n_32n)-vdd_val) + abs(v(xl_sel_in_n)+v(xl_rel_n_16n)+v(xl_sel_hi_n_16n)+v(xl_sel_lo_n_16n)-vdd_val) + abs(v(xl_sel_in_n)+v(xl_rel_n_8n)+v(xl_sel_hi_n_8n)+v(xl_sel_lo_n_8n)-vdd_val) + abs(v(xl_sel_in_n)+v(xl_rel_n_4n)+v(xl_sel_hi_n_4n)+v(xl_sel_lo_n_4n)-vdd_val) + abs(v(xl_sel_in_n)+v(xl_rel_n_2n)+v(xl_sel_hi_n_2n)+v(xl_sel_lo_n_2n)-vdd_val) + abs(v(xl_sel_in_n)+v(xl_rel_n_1n)+v(xl_sel_hi_n_1n)+v(xl_sel_lo_n_1n)-vdd_val))/vdd_val
bxlnside xl_nside 0 V = (
+ v(xl_sel_hi_n_256n)+v(xl_sel_lo_n_256n) + v(xl_sel_hi_n_128n)+v(xl_sel_lo_n_128n) + v(xl_sel_hi_n_64n)+v(xl_sel_lo_n_64n) + v(xl_sel_hi_n_32n)+v(xl_sel_lo_n_32n) + v(xl_sel_hi_n_16n)+v(xl_sel_lo_n_16n) + v(xl_sel_hi_n_8n)+v(xl_sel_lo_n_8n) + v(xl_sel_hi_n_4n)+v(xl_sel_lo_n_4n) + v(xl_sel_hi_n_2n)+v(xl_sel_lo_n_2n) + v(xl_sel_hi_n_1n)+v(xl_sel_lo_n_1n))/vdd_val
bxlacq xl_acq 0 V = v(xl_samp_tp_n)/vdd_val
bxliso xl_iso 0 V = (v(xl_sel_in_n)-v(xl_samp_tp_n))/vdd_val
* xl: input ramps one LSB per conversion THROUGH mid-scale
* (codes 507..515), so the run crosses the major carry where every
* bit changes at once -- the worst case for a late decision -- and
* exercises both branches of the free-MSB trial.
vxlin xl_vinp 0 pwl(0 {vcm-4.75*lsbse} 8u {vcm+3.25*lsbse})
vxlcm xl_vinn 0 dc {vcm}
bxlexp xl_exp 0 V = min(max(floor(v(xl_shxp)/lsbse),0),1023)
bxlerr xl_err 0 V = min(v(xl_drdy),v(xl_drdyg))>vth ? v(xl_code)-v(xl_exp) : 0
bxlaerr xl_aerr 0 V = abs(v(xl_err))

* ---- loop bad ----
vbadstart bad_start 0 pwl(0 {vdd_val} 125n {vdd_val} 125.1n 0)
vbadmode bad_mode 0 dc 0
xbad clk bad_start bad_mode bad_cmpo bad_samp_tp_n bad_sel_in_n bad_drdy
+ bad_c9 bad_c8 bad_c7 bad_c6 bad_c5 bad_c4 bad_c3 bad_c2 bad_c1 bad_c0
+ bad_rel_n_256p bad_sel_hi_n_256p bad_sel_lo_n_256p bad_rel_n_128p
+ bad_sel_hi_n_128p bad_sel_lo_n_128p bad_rel_n_64p bad_sel_hi_n_64p
+ bad_sel_lo_n_64p bad_rel_n_32p bad_sel_hi_n_32p bad_sel_lo_n_32p
+ bad_rel_n_16p bad_sel_hi_n_16p bad_sel_lo_n_16p bad_rel_n_8p
+ bad_sel_hi_n_8p bad_sel_lo_n_8p bad_rel_n_4p bad_sel_hi_n_4p
+ bad_sel_lo_n_4p bad_rel_n_2p bad_sel_hi_n_2p bad_sel_lo_n_2p
+ bad_rel_n_1p bad_sel_hi_n_1p bad_sel_lo_n_1p bad_rel_n_256n
+ bad_sel_hi_n_256n bad_sel_lo_n_256n bad_rel_n_128n bad_sel_hi_n_128n
+ bad_sel_lo_n_128n bad_rel_n_64n bad_sel_hi_n_64n bad_sel_lo_n_64n
+ bad_rel_n_32n bad_sel_hi_n_32n bad_sel_lo_n_32n bad_rel_n_16n
+ bad_sel_hi_n_16n bad_sel_lo_n_16n bad_rel_n_8n bad_sel_hi_n_8n
+ bad_sel_lo_n_8n bad_rel_n_4n bad_sel_hi_n_4n bad_sel_lo_n_4n
+ bad_rel_n_2n bad_sel_hi_n_2n bad_sel_lo_n_2n bad_rel_n_1n
+ bad_sel_hi_n_1n bad_sel_lo_n_1n sar_ctrl_a
sbadp bad_vinp bad_shp bad_samp_tp_n 0 sarl_sw
sbadn bad_vinn bad_shn bad_samp_tp_n 0 sarl_sw
cbadp bad_shp 0 1p
cbadn bad_shn 0 1p
rbadsd bad_samp_tp_n bad_sampd 10k
cbadsd bad_sampd 0 1p
sbadxp bad_vinp bad_shxp bad_sampd 0 sarl_sw
sbadxn bad_vinn bad_shxn bad_sampd 0 sarl_sw
cbadxp bad_shxp 0 1p
cbadxn bad_shxn 0 1p
bbadtopp bad_topip 0 V = 2*vcm-v(bad_shp)+(1.0/512)*(
+ 256*((v(bad_rel_n_256p)*vcm+v(bad_sel_hi_n_256p)*vref+v(bad_sel_in_n)*v(bad_vinp))/vdd_val-vcm) + 128*((v(bad_rel_n_128p)*vcm+v(bad_sel_hi_n_128p)*vref+v(bad_sel_in_n)*v(bad_vinp))/vdd_val-vcm) + 64*((v(bad_rel_n_64p)*vcm+v(bad_sel_hi_n_64p)*vref+v(bad_sel_in_n)*v(bad_vinp))/vdd_val-vcm) + 32*((v(bad_rel_n_32p)*vcm+v(bad_sel_hi_n_32p)*vref+v(bad_sel_in_n)*v(bad_vinp))/vdd_val-vcm) + 16*((v(bad_rel_n_16p)*vcm+v(bad_sel_hi_n_16p)*vref+v(bad_sel_in_n)*v(bad_vinp))/vdd_val-vcm) + 8*((v(bad_rel_n_8p)*vcm+v(bad_sel_hi_n_8p)*vref+v(bad_sel_in_n)*v(bad_vinp))/vdd_val-vcm) + 4*((v(bad_rel_n_4p)*vcm+v(bad_sel_hi_n_4p)*vref+v(bad_sel_in_n)*v(bad_vinp))/vdd_val-vcm) + 2*((v(bad_rel_n_2p)*vcm+v(bad_sel_hi_n_2p)*vref+v(bad_sel_in_n)*v(bad_vinp))/vdd_val-vcm) + 1*((v(bad_rel_n_1p)*vcm+v(bad_sel_hi_n_1p)*vref+v(bad_sel_in_n)*v(bad_vinp))/vdd_val-vcm) )
bbadtopn bad_topin 0 V = 2*vcm-v(bad_shn)+(1.0/512)*(
+ 256*((v(bad_rel_n_256n)*vcm+v(bad_sel_hi_n_256n)*vref+v(bad_sel_in_n)*v(bad_vinn))/vdd_val-vcm) + 128*((v(bad_rel_n_128n)*vcm+v(bad_sel_hi_n_128n)*vref+v(bad_sel_in_n)*v(bad_vinn))/vdd_val-vcm) + 64*((v(bad_rel_n_64n)*vcm+v(bad_sel_hi_n_64n)*vref+v(bad_sel_in_n)*v(bad_vinn))/vdd_val-vcm) + 32*((v(bad_rel_n_32n)*vcm+v(bad_sel_hi_n_32n)*vref+v(bad_sel_in_n)*v(bad_vinn))/vdd_val-vcm) + 16*((v(bad_rel_n_16n)*vcm+v(bad_sel_hi_n_16n)*vref+v(bad_sel_in_n)*v(bad_vinn))/vdd_val-vcm) + 8*((v(bad_rel_n_8n)*vcm+v(bad_sel_hi_n_8n)*vref+v(bad_sel_in_n)*v(bad_vinn))/vdd_val-vcm) + 4*((v(bad_rel_n_4n)*vcm+v(bad_sel_hi_n_4n)*vref+v(bad_sel_in_n)*v(bad_vinn))/vdd_val-vcm) + 2*((v(bad_rel_n_2n)*vcm+v(bad_sel_hi_n_2n)*vref+v(bad_sel_in_n)*v(bad_vinn))/vdd_val-vcm) + 1*((v(bad_rel_n_1n)*vcm+v(bad_sel_hi_n_1n)*vref+v(bad_sel_in_n)*v(bad_vinn))/vdd_val-vcm) )
rbadp bad_topip bad_topp 1k
rbadn bad_topin bad_topn 1k
cbadtp bad_topp 0 2.56p
cbadtn bad_topn 0 2.56p
bbadcmp bad_cmpi 0 V = v(bad_topp) > v(bad_topn) ? vdd_val : 0
tbadd bad_cmpi 0 bad_cmpo 0 z0=50 td=70n
rbadterm bad_cmpo 0 50
bbadcode bad_code 0 V =
+ (512)*(v(bad_c9)>vth ? 1 : 0) + (256)*(v(bad_c8)>vth ? 1 : 0) + (128)*(v(bad_c7)>vth ? 1 : 0) + (64)*(v(bad_c6)>vth ? 1 : 0) + (32)*(v(bad_c5)>vth ? 1 : 0) + (16)*(v(bad_c4)>vth ? 1 : 0) + (8)*(v(bad_c3)>vth ? 1 : 0) + (4)*(v(bad_c2)>vth ? 1 : 0) + (2)*(v(bad_c1)>vth ? 1 : 0) + (1)*(v(bad_c0)>vth ? 1 : 0)
bbaddrdyb bad_drdyb 0 V = v(bad_drdy)>vth ? vdd_val : 0
rbaddrdyg bad_drdyb bad_drdyg 1k
cbaddrdyg bad_drdyg 0 721.348f
bbadconf bad_conf 0 V = (
+ abs(v(bad_sel_in_n)+v(bad_rel_n_256p)+v(bad_sel_hi_n_256p)+v(bad_sel_lo_n_256p)-vdd_val) + abs(v(bad_sel_in_n)+v(bad_rel_n_128p)+v(bad_sel_hi_n_128p)+v(bad_sel_lo_n_128p)-vdd_val) + abs(v(bad_sel_in_n)+v(bad_rel_n_64p)+v(bad_sel_hi_n_64p)+v(bad_sel_lo_n_64p)-vdd_val) + abs(v(bad_sel_in_n)+v(bad_rel_n_32p)+v(bad_sel_hi_n_32p)+v(bad_sel_lo_n_32p)-vdd_val) + abs(v(bad_sel_in_n)+v(bad_rel_n_16p)+v(bad_sel_hi_n_16p)+v(bad_sel_lo_n_16p)-vdd_val) + abs(v(bad_sel_in_n)+v(bad_rel_n_8p)+v(bad_sel_hi_n_8p)+v(bad_sel_lo_n_8p)-vdd_val) + abs(v(bad_sel_in_n)+v(bad_rel_n_4p)+v(bad_sel_hi_n_4p)+v(bad_sel_lo_n_4p)-vdd_val) + abs(v(bad_sel_in_n)+v(bad_rel_n_2p)+v(bad_sel_hi_n_2p)+v(bad_sel_lo_n_2p)-vdd_val) + abs(v(bad_sel_in_n)+v(bad_rel_n_1p)+v(bad_sel_hi_n_1p)+v(bad_sel_lo_n_1p)-vdd_val) + abs(v(bad_sel_in_n)+v(bad_rel_n_256n)+v(bad_sel_hi_n_256n)+v(bad_sel_lo_n_256n)-vdd_val) + abs(v(bad_sel_in_n)+v(bad_rel_n_128n)+v(bad_sel_hi_n_128n)+v(bad_sel_lo_n_128n)-vdd_val) + abs(v(bad_sel_in_n)+v(bad_rel_n_64n)+v(bad_sel_hi_n_64n)+v(bad_sel_lo_n_64n)-vdd_val) + abs(v(bad_sel_in_n)+v(bad_rel_n_32n)+v(bad_sel_hi_n_32n)+v(bad_sel_lo_n_32n)-vdd_val) + abs(v(bad_sel_in_n)+v(bad_rel_n_16n)+v(bad_sel_hi_n_16n)+v(bad_sel_lo_n_16n)-vdd_val) + abs(v(bad_sel_in_n)+v(bad_rel_n_8n)+v(bad_sel_hi_n_8n)+v(bad_sel_lo_n_8n)-vdd_val) + abs(v(bad_sel_in_n)+v(bad_rel_n_4n)+v(bad_sel_hi_n_4n)+v(bad_sel_lo_n_4n)-vdd_val) + abs(v(bad_sel_in_n)+v(bad_rel_n_2n)+v(bad_sel_hi_n_2n)+v(bad_sel_lo_n_2n)-vdd_val) + abs(v(bad_sel_in_n)+v(bad_rel_n_1n)+v(bad_sel_hi_n_1n)+v(bad_sel_lo_n_1n)-vdd_val))/vdd_val
bbadnside bad_nside 0 V = (
+ v(bad_sel_hi_n_256n)+v(bad_sel_lo_n_256n) + v(bad_sel_hi_n_128n)+v(bad_sel_lo_n_128n) + v(bad_sel_hi_n_64n)+v(bad_sel_lo_n_64n) + v(bad_sel_hi_n_32n)+v(bad_sel_lo_n_32n) + v(bad_sel_hi_n_16n)+v(bad_sel_lo_n_16n) + v(bad_sel_hi_n_8n)+v(bad_sel_lo_n_8n) + v(bad_sel_hi_n_4n)+v(bad_sel_lo_n_4n) + v(bad_sel_hi_n_2n)+v(bad_sel_lo_n_2n) + v(bad_sel_hi_n_1n)+v(bad_sel_lo_n_1n))/vdd_val
bbadacq bad_acq 0 V = v(bad_samp_tp_n)/vdd_val
bbadiso bad_iso 0 V = (v(bad_sel_in_n)-v(bad_samp_tp_n))/vdd_val
* bad: input ramps one LSB per conversion THROUGH mid-scale
* (codes 507..515), so the run crosses the major carry where every
* bit changes at once -- the worst case for a late decision -- and
* exercises both branches of the free-MSB trial.
vbadin bad_vinp 0 pwl(0 {vcm-4.75*lsbse} 8u {vcm+3.25*lsbse})
vbadcm bad_vinn 0 dc {vcm}
bbadexp bad_exp 0 V = min(max(floor(v(bad_shxp)/lsbse),0),1023)
bbaderr bad_err 0 V = min(v(bad_drdy),v(bad_drdyg))>vth ? v(bad_code)-v(bad_exp) : 0
bbadaerr bad_aerr 0 V = abs(v(bad_err))

* ---- loop tie ----
vtiestart tie_start 0 pwl(0 {vdd_val} 125n {vdd_val} 125.1n 0)
vtiemode tie_mode 0 dc 0
xtie clk tie_start tie_mode tie_cmpo tie_samp_tp_n tie_sel_in_n tie_drdy
+ tie_c9 tie_c8 tie_c7 tie_c6 tie_c5 tie_c4 tie_c3 tie_c2 tie_c1 tie_c0
+ tie_rel_n_256p tie_sel_hi_n_256p tie_sel_lo_n_256p tie_rel_n_128p
+ tie_sel_hi_n_128p tie_sel_lo_n_128p tie_rel_n_64p tie_sel_hi_n_64p
+ tie_sel_lo_n_64p tie_rel_n_32p tie_sel_hi_n_32p tie_sel_lo_n_32p
+ tie_rel_n_16p tie_sel_hi_n_16p tie_sel_lo_n_16p tie_rel_n_8p
+ tie_sel_hi_n_8p tie_sel_lo_n_8p tie_rel_n_4p tie_sel_hi_n_4p
+ tie_sel_lo_n_4p tie_rel_n_2p tie_sel_hi_n_2p tie_sel_lo_n_2p
+ tie_rel_n_1p tie_sel_hi_n_1p tie_sel_lo_n_1p tie_rel_n_256n
+ tie_sel_hi_n_256n tie_sel_lo_n_256n tie_rel_n_128n tie_sel_hi_n_128n
+ tie_sel_lo_n_128n tie_rel_n_64n tie_sel_hi_n_64n tie_sel_lo_n_64n
+ tie_rel_n_32n tie_sel_hi_n_32n tie_sel_lo_n_32n tie_rel_n_16n
+ tie_sel_hi_n_16n tie_sel_lo_n_16n tie_rel_n_8n tie_sel_hi_n_8n
+ tie_sel_lo_n_8n tie_rel_n_4n tie_sel_hi_n_4n tie_sel_lo_n_4n
+ tie_rel_n_2n tie_sel_hi_n_2n tie_sel_lo_n_2n tie_rel_n_1n
+ tie_sel_hi_n_1n tie_sel_lo_n_1n sar_ctrl_a
stiep tie_vinp tie_shp tie_samp_tp_n 0 sarl_sw
stien tie_vinn tie_shn tie_samp_tp_n 0 sarl_sw
ctiep tie_shp 0 1p
ctien tie_shn 0 1p
rtiesd tie_samp_tp_n tie_sampd 10k
ctiesd tie_sampd 0 1p
stiexp tie_vinp tie_shxp tie_sampd 0 sarl_sw
stiexn tie_vinn tie_shxn tie_sampd 0 sarl_sw
ctiexp tie_shxp 0 1p
ctiexn tie_shxn 0 1p
btietopp tie_topip 0 V = 2*vcm-v(tie_shp)+(1.0/512)*(
+ 256*((v(tie_rel_n_256p)*vcm+v(tie_sel_hi_n_256p)*vref+v(tie_sel_in_n)*v(tie_vinp))/vdd_val-vcm) + 128*((v(tie_rel_n_128p)*vcm+v(tie_sel_hi_n_128p)*vref+v(tie_sel_in_n)*v(tie_vinp))/vdd_val-vcm) + 64*((v(tie_rel_n_64p)*vcm+v(tie_sel_hi_n_64p)*vref+v(tie_sel_in_n)*v(tie_vinp))/vdd_val-vcm) + 32*((v(tie_rel_n_32p)*vcm+v(tie_sel_hi_n_32p)*vref+v(tie_sel_in_n)*v(tie_vinp))/vdd_val-vcm) + 16*((v(tie_rel_n_16p)*vcm+v(tie_sel_hi_n_16p)*vref+v(tie_sel_in_n)*v(tie_vinp))/vdd_val-vcm) + 8*((v(tie_rel_n_8p)*vcm+v(tie_sel_hi_n_8p)*vref+v(tie_sel_in_n)*v(tie_vinp))/vdd_val-vcm) + 4*((v(tie_rel_n_4p)*vcm+v(tie_sel_hi_n_4p)*vref+v(tie_sel_in_n)*v(tie_vinp))/vdd_val-vcm) + 2*((v(tie_rel_n_2p)*vcm+v(tie_sel_hi_n_2p)*vref+v(tie_sel_in_n)*v(tie_vinp))/vdd_val-vcm) + 1*((v(tie_rel_n_1p)*vcm+v(tie_sel_hi_n_1p)*vref+v(tie_sel_in_n)*v(tie_vinp))/vdd_val-vcm) )
btietopn tie_topin 0 V = 2*vcm-v(tie_shn)+(1.0/512)*(
+ 256*((v(tie_rel_n_256n)*vcm+v(tie_sel_hi_n_256n)*vref+v(tie_sel_in_n)*v(tie_vinn))/vdd_val-vcm) + 128*((v(tie_rel_n_128n)*vcm+v(tie_sel_hi_n_128n)*vref+v(tie_sel_in_n)*v(tie_vinn))/vdd_val-vcm) + 64*((v(tie_rel_n_64n)*vcm+v(tie_sel_hi_n_64n)*vref+v(tie_sel_in_n)*v(tie_vinn))/vdd_val-vcm) + 32*((v(tie_rel_n_32n)*vcm+v(tie_sel_hi_n_32n)*vref+v(tie_sel_in_n)*v(tie_vinn))/vdd_val-vcm) + 16*((v(tie_rel_n_16n)*vcm+v(tie_sel_hi_n_16n)*vref+v(tie_sel_in_n)*v(tie_vinn))/vdd_val-vcm) + 8*((v(tie_rel_n_8n)*vcm+v(tie_sel_hi_n_8n)*vref+v(tie_sel_in_n)*v(tie_vinn))/vdd_val-vcm) + 4*((v(tie_rel_n_4n)*vcm+v(tie_sel_hi_n_4n)*vref+v(tie_sel_in_n)*v(tie_vinn))/vdd_val-vcm) + 2*((v(tie_rel_n_2n)*vcm+v(tie_sel_hi_n_2n)*vref+v(tie_sel_in_n)*v(tie_vinn))/vdd_val-vcm) + 1*((v(tie_rel_n_1n)*vcm+v(tie_sel_hi_n_1n)*vref+v(tie_sel_in_n)*v(tie_vinn))/vdd_val-vcm) )
rtiep tie_topip tie_topp 1k
rtien tie_topin tie_topn 1k
ctietp tie_topp 0 2.56p
ctietn tie_topn 0 2.56p
btiecmp tie_cmpd 0 V = v(tie_topp) > v(tie_topn) ? vdd_val : 0
rtiecmps tie_cmpd tie_cmpo 1k
ctiecmpl tie_cmpo 0 100f
btiecode tie_code 0 V =
+ (512)*(v(tie_c9)>vth ? 1 : 0) + (256)*(v(tie_c8)>vth ? 1 : 0) + (128)*(v(tie_c7)>vth ? 1 : 0) + (64)*(v(tie_c6)>vth ? 1 : 0) + (32)*(v(tie_c5)>vth ? 1 : 0) + (16)*(v(tie_c4)>vth ? 1 : 0) + (8)*(v(tie_c3)>vth ? 1 : 0) + (4)*(v(tie_c2)>vth ? 1 : 0) + (2)*(v(tie_c1)>vth ? 1 : 0) + (1)*(v(tie_c0)>vth ? 1 : 0)
btiedrdyb tie_drdyb 0 V = v(tie_drdy)>vth ? vdd_val : 0
rtiedrdyg tie_drdyb tie_drdyg 1k
ctiedrdyg tie_drdyg 0 721.348f
btieconf tie_conf 0 V = (
+ abs(v(tie_sel_in_n)+v(tie_rel_n_256p)+v(tie_sel_hi_n_256p)+v(tie_sel_lo_n_256p)-vdd_val) + abs(v(tie_sel_in_n)+v(tie_rel_n_128p)+v(tie_sel_hi_n_128p)+v(tie_sel_lo_n_128p)-vdd_val) + abs(v(tie_sel_in_n)+v(tie_rel_n_64p)+v(tie_sel_hi_n_64p)+v(tie_sel_lo_n_64p)-vdd_val) + abs(v(tie_sel_in_n)+v(tie_rel_n_32p)+v(tie_sel_hi_n_32p)+v(tie_sel_lo_n_32p)-vdd_val) + abs(v(tie_sel_in_n)+v(tie_rel_n_16p)+v(tie_sel_hi_n_16p)+v(tie_sel_lo_n_16p)-vdd_val) + abs(v(tie_sel_in_n)+v(tie_rel_n_8p)+v(tie_sel_hi_n_8p)+v(tie_sel_lo_n_8p)-vdd_val) + abs(v(tie_sel_in_n)+v(tie_rel_n_4p)+v(tie_sel_hi_n_4p)+v(tie_sel_lo_n_4p)-vdd_val) + abs(v(tie_sel_in_n)+v(tie_rel_n_2p)+v(tie_sel_hi_n_2p)+v(tie_sel_lo_n_2p)-vdd_val) + abs(v(tie_sel_in_n)+v(tie_rel_n_1p)+v(tie_sel_hi_n_1p)+v(tie_sel_lo_n_1p)-vdd_val) + abs(v(tie_sel_in_n)+v(tie_rel_n_256n)+v(tie_sel_hi_n_256n)+v(tie_sel_lo_n_256n)-vdd_val) + abs(v(tie_sel_in_n)+v(tie_rel_n_128n)+v(tie_sel_hi_n_128n)+v(tie_sel_lo_n_128n)-vdd_val) + abs(v(tie_sel_in_n)+v(tie_rel_n_64n)+v(tie_sel_hi_n_64n)+v(tie_sel_lo_n_64n)-vdd_val) + abs(v(tie_sel_in_n)+v(tie_rel_n_32n)+v(tie_sel_hi_n_32n)+v(tie_sel_lo_n_32n)-vdd_val) + abs(v(tie_sel_in_n)+v(tie_rel_n_16n)+v(tie_sel_hi_n_16n)+v(tie_sel_lo_n_16n)-vdd_val) + abs(v(tie_sel_in_n)+v(tie_rel_n_8n)+v(tie_sel_hi_n_8n)+v(tie_sel_lo_n_8n)-vdd_val) + abs(v(tie_sel_in_n)+v(tie_rel_n_4n)+v(tie_sel_hi_n_4n)+v(tie_sel_lo_n_4n)-vdd_val) + abs(v(tie_sel_in_n)+v(tie_rel_n_2n)+v(tie_sel_hi_n_2n)+v(tie_sel_lo_n_2n)-vdd_val) + abs(v(tie_sel_in_n)+v(tie_rel_n_1n)+v(tie_sel_hi_n_1n)+v(tie_sel_lo_n_1n)-vdd_val))/vdd_val
btienside tie_nside 0 V = (
+ v(tie_sel_hi_n_256n)+v(tie_sel_lo_n_256n) + v(tie_sel_hi_n_128n)+v(tie_sel_lo_n_128n) + v(tie_sel_hi_n_64n)+v(tie_sel_lo_n_64n) + v(tie_sel_hi_n_32n)+v(tie_sel_lo_n_32n) + v(tie_sel_hi_n_16n)+v(tie_sel_lo_n_16n) + v(tie_sel_hi_n_8n)+v(tie_sel_lo_n_8n) + v(tie_sel_hi_n_4n)+v(tie_sel_lo_n_4n) + v(tie_sel_hi_n_2n)+v(tie_sel_lo_n_2n) + v(tie_sel_hi_n_1n)+v(tie_sel_lo_n_1n))/vdd_val
btieacq tie_acq 0 V = v(tie_samp_tp_n)/vdd_val
btieiso tie_iso 0 V = (v(tie_sel_in_n)-v(tie_samp_tp_n))/vdd_val
* tie: input pinned exactly on the free-MSB threshold for the whole
* run. No code check -- either adjacent code is a correct answer to
* an exact tie. The measured claim is the cadence.
vtiein tie_vinp 0 dc {vcm}
vtiecm tie_vinn 0 dc {vcm}
* Gated by the SETTLED drdy, like b<tag>err above: c9..c0 hold their
* POWER-UP value (all zero, i.e. code 0) until the first ph14 load,
* and an earlier draft of this deck measured tie_dev
* unconditionally -- which made every run report a spurious code-0
* deviation of 512 for the ~875 ns before the first conversion's
* drdy, independent of whether the design was actually correct.
*
* CORRECTED BY DR-0031 (issue #327). The earlier form of this
* comment claimed that gating on drdy alone 'restricts the
* measurement to windows where the register holds a completed
* conversion's result'. It does not, and issue #337 measured it not
* doing so: `assign drdy = ph[15]` and c9..c0 load on the SAME clock
* edge, so the raw gate opens as the data starts moving. At
* ff_27c_3.63v the deck's 512 is at conversion #1 -- the same
* pre-first-drdy code-0 artifact that sentence claimed had been
* removed, narrowed from ~875 ns to ~4 ps rather than removed. The
* settling guard is what actually makes the sentence true.
btiedev tie_dev 0 V = min(v(tie_drdy),v(tie_drdyg))>vth ? abs(v(tie_code)-512) : 0

* Externally-supplied net(s) this subckt's cells bind but nothing
* inside it drives. Without .global, SPICE scopes these LOCALLY to
* each instance -- the DUT would sit unpowered at ~0 V and every
* symptom would read as a solver/power-up problem (issue #282).
.global vdd_gate

.subckt sar_ctrl_a clk start mode cmp samp_tp_n sel_in_n drdy c9 c8 c7 c6 c5 c4 c3 c2 c1 c0 rel_n_256p sel_hi_n_256p sel_lo_n_256p rel_n_128p sel_hi_n_128p sel_lo_n_128p rel_n_64p sel_hi_n_64p sel_lo_n_64p rel_n_32p sel_hi_n_32p sel_lo_n_32p rel_n_16p sel_hi_n_16p sel_lo_n_16p rel_n_8p sel_hi_n_8p sel_lo_n_8p rel_n_4p sel_hi_n_4p sel_lo_n_4p rel_n_2p sel_hi_n_2p sel_lo_n_2p rel_n_1p sel_hi_n_1p sel_lo_n_1p rel_n_256n sel_hi_n_256n sel_lo_n_256n rel_n_128n sel_hi_n_128n sel_lo_n_128n rel_n_64n sel_hi_n_64n sel_lo_n_64n rel_n_32n sel_hi_n_32n sel_lo_n_32n rel_n_16n sel_hi_n_16n sel_lo_n_16n rel_n_8n sel_hi_n_8n sel_lo_n_8n rel_n_4n sel_hi_n_4n sel_lo_n_4n rel_n_2n sel_hi_n_2n sel_lo_n_2n rel_n_1n sel_hi_n_1n sel_lo_n_1n
X_065_ eng3 _030_ vdd_gate vdd_gate 0 0 gf180mcu_fd_sc_mcu7t5v0__clkinv_1
X_066_ mode _031_ vdd_gate vdd_gate 0 0 gf180mcu_fd_sc_mcu7t5v0__clkinv_1
X_067_ ph_2 _032_ vdd_gate vdd_gate 0 0 gf180mcu_fd_sc_mcu7t5v0__clkinv_1
X_068_ ph_0 _033_ vdd_gate vdd_gate 0 0 gf180mcu_fd_sc_mcu7t5v0__clkinv_1
X_069_ ph_1 _034_ vdd_gate vdd_gate 0 0 gf180mcu_fd_sc_mcu7t5v0__clkinv_1
X_070_ ph_3 _035_ vdd_gate vdd_gate 0 0 gf180mcu_fd_sc_mcu7t5v0__clkinv_1
X_071_ eng4 _036_ vdd_gate vdd_gate 0 0 gf180mcu_fd_sc_mcu7t5v0__clkinv_1
X_072_ eng5 _037_ vdd_gate vdd_gate 0 0 gf180mcu_fd_sc_mcu7t5v0__clkinv_1
X_073_ eng6 _038_ vdd_gate vdd_gate 0 0 gf180mcu_fd_sc_mcu7t5v0__clkinv_1
X_074_ eng7 _039_ vdd_gate vdd_gate 0 0 gf180mcu_fd_sc_mcu7t5v0__clkinv_1
X_075_ eng8 _040_ vdd_gate vdd_gate 0 0 gf180mcu_fd_sc_mcu7t5v0__clkinv_1
X_076_ eng9 _041_ vdd_gate vdd_gate 0 0 gf180mcu_fd_sc_mcu7t5v0__clkinv_1
X_077_ eng2 _042_ vdd_gate vdd_gate 0 0 gf180mcu_fd_sc_mcu7t5v0__clkinv_1
X_078_ ph_12 _043_ vdd_gate vdd_gate 0 0 gf180mcu_fd_sc_mcu7t5v0__clkinv_1
X_079_ eng1 _044_ vdd_gate vdd_gate 0 0 gf180mcu_fd_sc_mcu7t5v0__clkinv_1
X_080_ ph_13 _045_ vdd_gate vdd_gate 0 0 gf180mcu_fd_sc_mcu7t5v0__clkinv_1
X_081_ ph_11 _046_ vdd_gate vdd_gate 0 0 gf180mcu_fd_sc_mcu7t5v0__clkinv_1
X_082_ ph_10 _047_ vdd_gate vdd_gate 0 0 gf180mcu_fd_sc_mcu7t5v0__clkinv_1
X_083_ ph_9 _048_ vdd_gate vdd_gate 0 0 gf180mcu_fd_sc_mcu7t5v0__clkinv_1
X_084_ ph_8 _049_ vdd_gate vdd_gate 0 0 gf180mcu_fd_sc_mcu7t5v0__clkinv_1
X_085_ ph_7 _050_ vdd_gate vdd_gate 0 0 gf180mcu_fd_sc_mcu7t5v0__clkinv_1
X_086_ ph_6 _051_ vdd_gate vdd_gate 0 0 gf180mcu_fd_sc_mcu7t5v0__clkinv_1
X_087_ ph_5 _052_ vdd_gate vdd_gate 0 0 gf180mcu_fd_sc_mcu7t5v0__clkinv_1
X_088_ ph_4 _053_ vdd_gate vdd_gate 0 0 gf180mcu_fd_sc_mcu7t5v0__clkinv_1
X_089_ ph_14 _054_ vdd_gate vdd_gate 0 0 gf180mcu_fd_sc_mcu7t5v0__clkinv_1
X_090_ _030_ q3 sel_lo_n_4p vdd_gate vdd_gate 0 0 gf180mcu_fd_sc_mcu7t5v0__nor2_1
X_091_ _030_ _031_ q3 sel_hi_n_4n vdd_gate vdd_gate 0 0 gf180mcu_fd_sc_mcu7t5v0__nor3_1
X_092_ _032_ _033_ _034_ samp_tp_n vdd_gate vdd_gate 0 0 gf180mcu_fd_sc_mcu7t5v0__nand3_1
X_093_ ph_2 ph_0 ph_1 ph_3 sel_in_n vdd_gate vdd_gate 0 0 gf180mcu_fd_sc_mcu7t5v0__or4_1
X_094_ eng3 sel_in_n rel_n_4p vdd_gate vdd_gate 0 0 gf180mcu_fd_sc_mcu7t5v0__nor2_1
X_095_ eng3 mode sel_in_n rel_n_4n vdd_gate vdd_gate 0 0 gf180mcu_fd_sc_mcu7t5v0__aoi21_1
X_096_ eng3 q3 sel_hi_n_4p vdd_gate vdd_gate 0 0 gf180mcu_fd_sc_mcu7t5v0__and2_1
X_097_ q4 eng4 sel_hi_n_8p vdd_gate vdd_gate 0 0 gf180mcu_fd_sc_mcu7t5v0__and2_1
X_098_ mode sel_hi_n_8p sel_lo_n_8n vdd_gate vdd_gate 0 0 gf180mcu_fd_sc_mcu7t5v0__and2_1
X_099_ q4 _036_ sel_lo_n_8p vdd_gate vdd_gate 0 0 gf180mcu_fd_sc_mcu7t5v0__nor2_1
X_100_ _031_ q4 _036_ sel_hi_n_8n vdd_gate vdd_gate 0 0 gf180mcu_fd_sc_mcu7t5v0__nor3_1
X_101_ eng4 sel_in_n rel_n_8p vdd_gate vdd_gate 0 0 gf180mcu_fd_sc_mcu7t5v0__nor2_1
X_102_ mode eng4 sel_in_n rel_n_8n vdd_gate vdd_gate 0 0 gf180mcu_fd_sc_mcu7t5v0__aoi21_1
X_103_ q5 eng5 sel_hi_n_16p vdd_gate vdd_gate 0 0 gf180mcu_fd_sc_mcu7t5v0__and2_1
X_104_ mode sel_hi_n_16p sel_lo_n_16n vdd_gate vdd_gate 0 0 gf180mcu_fd_sc_mcu7t5v0__and2_1
X_105_ q5 _037_ sel_lo_n_16p vdd_gate vdd_gate 0 0 gf180mcu_fd_sc_mcu7t5v0__nor2_1
X_106_ _031_ q5 _037_ sel_hi_n_16n vdd_gate vdd_gate 0 0 gf180mcu_fd_sc_mcu7t5v0__nor3_1
X_107_ eng5 sel_in_n rel_n_16p vdd_gate vdd_gate 0 0 gf180mcu_fd_sc_mcu7t5v0__nor2_1
X_108_ mode eng5 sel_in_n rel_n_16n vdd_gate vdd_gate 0 0 gf180mcu_fd_sc_mcu7t5v0__aoi21_1
X_109_ q6 eng6 sel_hi_n_32p vdd_gate vdd_gate 0 0 gf180mcu_fd_sc_mcu7t5v0__and2_1
X_110_ mode sel_hi_n_32p sel_lo_n_32n vdd_gate vdd_gate 0 0 gf180mcu_fd_sc_mcu7t5v0__and2_1
X_111_ q6 _038_ sel_lo_n_32p vdd_gate vdd_gate 0 0 gf180mcu_fd_sc_mcu7t5v0__nor2_1
X_112_ _031_ q6 _038_ sel_hi_n_32n vdd_gate vdd_gate 0 0 gf180mcu_fd_sc_mcu7t5v0__nor3_1
X_113_ eng6 sel_in_n rel_n_32p vdd_gate vdd_gate 0 0 gf180mcu_fd_sc_mcu7t5v0__nor2_1
X_114_ mode eng6 sel_in_n rel_n_32n vdd_gate vdd_gate 0 0 gf180mcu_fd_sc_mcu7t5v0__aoi21_1
X_115_ q7 eng7 sel_hi_n_64p vdd_gate vdd_gate 0 0 gf180mcu_fd_sc_mcu7t5v0__and2_1
X_116_ mode sel_hi_n_64p sel_lo_n_64n vdd_gate vdd_gate 0 0 gf180mcu_fd_sc_mcu7t5v0__and2_1
X_117_ q7 _039_ sel_lo_n_64p vdd_gate vdd_gate 0 0 gf180mcu_fd_sc_mcu7t5v0__nor2_1
X_118_ _031_ q7 _039_ sel_hi_n_64n vdd_gate vdd_gate 0 0 gf180mcu_fd_sc_mcu7t5v0__nor3_1
X_119_ eng7 sel_in_n rel_n_64p vdd_gate vdd_gate 0 0 gf180mcu_fd_sc_mcu7t5v0__nor2_1
X_120_ mode eng7 sel_in_n rel_n_64n vdd_gate vdd_gate 0 0 gf180mcu_fd_sc_mcu7t5v0__aoi21_1
X_121_ q8 eng8 sel_hi_n_128p vdd_gate vdd_gate 0 0 gf180mcu_fd_sc_mcu7t5v0__and2_1
X_122_ mode sel_hi_n_128p sel_lo_n_128n vdd_gate vdd_gate 0 0 gf180mcu_fd_sc_mcu7t5v0__and2_1
X_123_ q8 _040_ sel_lo_n_128p vdd_gate vdd_gate 0 0 gf180mcu_fd_sc_mcu7t5v0__nor2_1
X_124_ _031_ q8 _040_ sel_hi_n_128n vdd_gate vdd_gate 0 0 gf180mcu_fd_sc_mcu7t5v0__nor3_1
X_125_ eng8 sel_in_n rel_n_128p vdd_gate vdd_gate 0 0 gf180mcu_fd_sc_mcu7t5v0__nor2_1
X_126_ mode eng8 sel_in_n rel_n_128n vdd_gate vdd_gate 0 0 gf180mcu_fd_sc_mcu7t5v0__aoi21_1
X_127_ mode sel_hi_n_4p sel_lo_n_4n vdd_gate vdd_gate 0 0 gf180mcu_fd_sc_mcu7t5v0__and2_1
X_128_ q9 eng9 sel_hi_n_256p vdd_gate vdd_gate 0 0 gf180mcu_fd_sc_mcu7t5v0__and2_1
X_129_ mode sel_hi_n_256p sel_lo_n_256n vdd_gate vdd_gate 0 0 gf180mcu_fd_sc_mcu7t5v0__and2_1
X_130_ q9 _041_ sel_lo_n_256p vdd_gate vdd_gate 0 0 gf180mcu_fd_sc_mcu7t5v0__nor2_1
X_131_ _031_ q9 _041_ sel_hi_n_256n vdd_gate vdd_gate 0 0 gf180mcu_fd_sc_mcu7t5v0__nor3_1
X_132_ eng9 sel_in_n rel_n_256p vdd_gate vdd_gate 0 0 gf180mcu_fd_sc_mcu7t5v0__nor2_1
X_133_ mode eng9 sel_in_n rel_n_256n vdd_gate vdd_gate 0 0 gf180mcu_fd_sc_mcu7t5v0__aoi21_1
X_134_ eng2 sel_in_n rel_n_2p vdd_gate vdd_gate 0 0 gf180mcu_fd_sc_mcu7t5v0__nor2_1
X_135_ eng2 q2 sel_hi_n_2p vdd_gate vdd_gate 0 0 gf180mcu_fd_sc_mcu7t5v0__and2_1
X_136_ _043_ _044_ ph_13 _000_ vdd_gate vdd_gate 0 0 gf180mcu_fd_sc_mcu7t5v0__aoi21_1
X_137_ _042_ _046_ ph_13 _001_ vdd_gate vdd_gate 0 0 gf180mcu_fd_sc_mcu7t5v0__aoi21_1
X_138_ _042_ q2 sel_lo_n_2p vdd_gate vdd_gate 0 0 gf180mcu_fd_sc_mcu7t5v0__nor2_1
X_139_ _030_ _047_ ph_13 _002_ vdd_gate vdd_gate 0 0 gf180mcu_fd_sc_mcu7t5v0__aoi21_1
X_140_ _036_ _048_ ph_13 _003_ vdd_gate vdd_gate 0 0 gf180mcu_fd_sc_mcu7t5v0__aoi21_1
X_141_ _037_ _049_ ph_13 _004_ vdd_gate vdd_gate 0 0 gf180mcu_fd_sc_mcu7t5v0__aoi21_1
X_142_ _038_ _050_ ph_13 _005_ vdd_gate vdd_gate 0 0 gf180mcu_fd_sc_mcu7t5v0__aoi21_1
X_143_ mode eng2 sel_in_n rel_n_2n vdd_gate vdd_gate 0 0 gf180mcu_fd_sc_mcu7t5v0__aoi21_1
X_144_ _039_ _051_ ph_13 _006_ vdd_gate vdd_gate 0 0 gf180mcu_fd_sc_mcu7t5v0__aoi21_1
X_145_ _040_ _052_ ph_13 _007_ vdd_gate vdd_gate 0 0 gf180mcu_fd_sc_mcu7t5v0__aoi21_1
X_146_ _041_ _053_ ph_13 _008_ vdd_gate vdd_gate 0 0 gf180mcu_fd_sc_mcu7t5v0__aoi21_1
X_147_ _031_ _042_ q2 sel_hi_n_2n vdd_gate vdd_gate 0 0 gf180mcu_fd_sc_mcu7t5v0__nor3_1
X_148_ _054_ start _009__15 vdd_gate vdd_gate 0 0 gf180mcu_fd_sc_mcu7t5v0__nor2_1
X_149_ _045_ start _009__14 vdd_gate vdd_gate 0 0 gf180mcu_fd_sc_mcu7t5v0__nor2_1
X_150_ mode sel_hi_n_2p sel_lo_n_2n vdd_gate vdd_gate 0 0 gf180mcu_fd_sc_mcu7t5v0__and2_1
X_151_ _043_ start _009__13 vdd_gate vdd_gate 0 0 gf180mcu_fd_sc_mcu7t5v0__nor2_1
X_152_ _046_ start _009__12 vdd_gate vdd_gate 0 0 gf180mcu_fd_sc_mcu7t5v0__nor2_1
X_153_ eng1 sel_in_n rel_n_1p vdd_gate vdd_gate 0 0 gf180mcu_fd_sc_mcu7t5v0__nor2_1
X_154_ _047_ start _009__11 vdd_gate vdd_gate 0 0 gf180mcu_fd_sc_mcu7t5v0__nor2_1
X_155_ eng1 q1 sel_hi_n_1p vdd_gate vdd_gate 0 0 gf180mcu_fd_sc_mcu7t5v0__and2_1
X_156_ _048_ start _009__10 vdd_gate vdd_gate 0 0 gf180mcu_fd_sc_mcu7t5v0__nor2_1
X_157_ _049_ start _009__9 vdd_gate vdd_gate 0 0 gf180mcu_fd_sc_mcu7t5v0__nor2_1
X_158_ _044_ q1 sel_lo_n_1p vdd_gate vdd_gate 0 0 gf180mcu_fd_sc_mcu7t5v0__nor2_1
X_159_ _050_ start _009__8 vdd_gate vdd_gate 0 0 gf180mcu_fd_sc_mcu7t5v0__nor2_1
X_160_ mode sel_hi_n_1p sel_lo_n_1n vdd_gate vdd_gate 0 0 gf180mcu_fd_sc_mcu7t5v0__and2_1
X_161_ _051_ start _009__7 vdd_gate vdd_gate 0 0 gf180mcu_fd_sc_mcu7t5v0__nor2_1
X_162_ _052_ start _009__6 vdd_gate vdd_gate 0 0 gf180mcu_fd_sc_mcu7t5v0__nor2_1
X_163_ _031_ _044_ q1 sel_hi_n_1n vdd_gate vdd_gate 0 0 gf180mcu_fd_sc_mcu7t5v0__nor3_1
X_164_ _053_ start _009__5 vdd_gate vdd_gate 0 0 gf180mcu_fd_sc_mcu7t5v0__nor2_1
X_165_ _035_ start _009__4 vdd_gate vdd_gate 0 0 gf180mcu_fd_sc_mcu7t5v0__nor2_1
X_166_ _032_ start _009__3 vdd_gate vdd_gate 0 0 gf180mcu_fd_sc_mcu7t5v0__nor2_1
X_167_ mode eng1 sel_in_n rel_n_1n vdd_gate vdd_gate 0 0 gf180mcu_fd_sc_mcu7t5v0__aoi21_1
X_168_ _034_ start _009__2 vdd_gate vdd_gate 0 0 gf180mcu_fd_sc_mcu7t5v0__nor2_1
X_169_ _033_ start _009__1 vdd_gate vdd_gate 0 0 gf180mcu_fd_sc_mcu7t5v0__nor2_1
X_170_ start drdy _009__0 vdd_gate vdd_gate 0 0 gf180mcu_fd_sc_mcu7t5v0__or2_1
X_171_ c8 q8 ph_14 _010_ vdd_gate vdd_gate 0 0 gf180mcu_fd_sc_mcu7t5v0__mux2_1
X_172_ c9 q9 ph_14 _011_ vdd_gate vdd_gate 0 0 gf180mcu_fd_sc_mcu7t5v0__mux2_1
X_173_ ph_13 q0 _055_ vdd_gate vdd_gate 0 0 gf180mcu_fd_sc_mcu7t5v0__nor2_1
X_174_ ph_13 cmp _055_ _012_ vdd_gate vdd_gate 0 0 gf180mcu_fd_sc_mcu7t5v0__aoi21_1
X_175_ c0 q0 ph_14 _013_ vdd_gate vdd_gate 0 0 gf180mcu_fd_sc_mcu7t5v0__mux2_1
X_176_ q6 ph_7 _056_ vdd_gate vdd_gate 0 0 gf180mcu_fd_sc_mcu7t5v0__nor2_1
X_177_ ph_7 cmp _056_ _014_ vdd_gate vdd_gate 0 0 gf180mcu_fd_sc_mcu7t5v0__aoi21_1
X_178_ c1 q1 ph_14 _015_ vdd_gate vdd_gate 0 0 gf180mcu_fd_sc_mcu7t5v0__mux2_1
X_179_ c2 q2 ph_14 _016_ vdd_gate vdd_gate 0 0 gf180mcu_fd_sc_mcu7t5v0__mux2_1
X_180_ q2 ph_11 _057_ vdd_gate vdd_gate 0 0 gf180mcu_fd_sc_mcu7t5v0__nor2_1
X_181_ ph_11 cmp _057_ _017_ vdd_gate vdd_gate 0 0 gf180mcu_fd_sc_mcu7t5v0__aoi21_1
X_182_ q7 ph_6 _058_ vdd_gate vdd_gate 0 0 gf180mcu_fd_sc_mcu7t5v0__nor2_1
X_183_ ph_6 cmp _058_ _018_ vdd_gate vdd_gate 0 0 gf180mcu_fd_sc_mcu7t5v0__aoi21_1
X_184_ q5 ph_8 _059_ vdd_gate vdd_gate 0 0 gf180mcu_fd_sc_mcu7t5v0__nor2_1
X_185_ ph_8 cmp _059_ _019_ vdd_gate vdd_gate 0 0 gf180mcu_fd_sc_mcu7t5v0__aoi21_1
X_186_ ph_12 q1 _060_ vdd_gate vdd_gate 0 0 gf180mcu_fd_sc_mcu7t5v0__nor2_1
X_187_ ph_12 cmp _060_ _020_ vdd_gate vdd_gate 0 0 gf180mcu_fd_sc_mcu7t5v0__aoi21_1
X_188_ c3 q3 ph_14 _021_ vdd_gate vdd_gate 0 0 gf180mcu_fd_sc_mcu7t5v0__mux2_1
X_189_ q8 ph_5 _061_ vdd_gate vdd_gate 0 0 gf180mcu_fd_sc_mcu7t5v0__nor2_1
X_190_ ph_5 cmp _061_ _022_ vdd_gate vdd_gate 0 0 gf180mcu_fd_sc_mcu7t5v0__aoi21_1
X_191_ c4 q4 ph_14 _023_ vdd_gate vdd_gate 0 0 gf180mcu_fd_sc_mcu7t5v0__mux2_1
X_192_ c5 q5 ph_14 _024_ vdd_gate vdd_gate 0 0 gf180mcu_fd_sc_mcu7t5v0__mux2_1
X_193_ q4 ph_9 _062_ vdd_gate vdd_gate 0 0 gf180mcu_fd_sc_mcu7t5v0__nor2_1
X_194_ ph_9 cmp _062_ _025_ vdd_gate vdd_gate 0 0 gf180mcu_fd_sc_mcu7t5v0__aoi21_1
X_195_ q9 ph_4 _063_ vdd_gate vdd_gate 0 0 gf180mcu_fd_sc_mcu7t5v0__nor2_1
X_196_ ph_4 cmp _063_ _026_ vdd_gate vdd_gate 0 0 gf180mcu_fd_sc_mcu7t5v0__aoi21_1
X_197_ c6 q6 ph_14 _027_ vdd_gate vdd_gate 0 0 gf180mcu_fd_sc_mcu7t5v0__mux2_1
X_198_ c7 q7 ph_14 _028_ vdd_gate vdd_gate 0 0 gf180mcu_fd_sc_mcu7t5v0__mux2_1
X_199_ q3 ph_10 _064_ vdd_gate vdd_gate 0 0 gf180mcu_fd_sc_mcu7t5v0__nor2_1
X_200_ ph_10 cmp _064_ _029_ vdd_gate vdd_gate 0 0 gf180mcu_fd_sc_mcu7t5v0__aoi21_1
X_201_ _020_ clk q1 vdd_gate vdd_gate 0 0 gf180mcu_fd_sc_mcu7t5v0__dffq_1
X_202_ _017_ clk q2 vdd_gate vdd_gate 0 0 gf180mcu_fd_sc_mcu7t5v0__dffq_1
X_203_ _029_ clk q3 vdd_gate vdd_gate 0 0 gf180mcu_fd_sc_mcu7t5v0__dffq_1
X_204_ _025_ clk q4 vdd_gate vdd_gate 0 0 gf180mcu_fd_sc_mcu7t5v0__dffq_1
X_205_ _019_ clk q5 vdd_gate vdd_gate 0 0 gf180mcu_fd_sc_mcu7t5v0__dffq_1
X_206_ _014_ clk q6 vdd_gate vdd_gate 0 0 gf180mcu_fd_sc_mcu7t5v0__dffq_1
X_207_ _018_ clk q7 vdd_gate vdd_gate 0 0 gf180mcu_fd_sc_mcu7t5v0__dffq_1
X_208_ _022_ clk q8 vdd_gate vdd_gate 0 0 gf180mcu_fd_sc_mcu7t5v0__dffq_1
X_209_ _026_ clk q9 vdd_gate vdd_gate 0 0 gf180mcu_fd_sc_mcu7t5v0__dffq_1
X_210_ _012_ clk q0 vdd_gate vdd_gate 0 0 gf180mcu_fd_sc_mcu7t5v0__dffq_1
X_211_ _013_ clk c0 vdd_gate vdd_gate 0 0 gf180mcu_fd_sc_mcu7t5v0__dffq_1
X_212_ _015_ clk c1 vdd_gate vdd_gate 0 0 gf180mcu_fd_sc_mcu7t5v0__dffq_1
X_213_ _016_ clk c2 vdd_gate vdd_gate 0 0 gf180mcu_fd_sc_mcu7t5v0__dffq_1
X_214_ _021_ clk c3 vdd_gate vdd_gate 0 0 gf180mcu_fd_sc_mcu7t5v0__dffq_1
X_215_ _023_ clk c4 vdd_gate vdd_gate 0 0 gf180mcu_fd_sc_mcu7t5v0__dffq_1
X_216_ _024_ clk c5 vdd_gate vdd_gate 0 0 gf180mcu_fd_sc_mcu7t5v0__dffq_1
X_217_ _027_ clk c6 vdd_gate vdd_gate 0 0 gf180mcu_fd_sc_mcu7t5v0__dffq_1
X_218_ _028_ clk c7 vdd_gate vdd_gate 0 0 gf180mcu_fd_sc_mcu7t5v0__dffq_1
X_219_ _010_ clk c8 vdd_gate vdd_gate 0 0 gf180mcu_fd_sc_mcu7t5v0__dffq_1
X_220_ _011_ clk c9 vdd_gate vdd_gate 0 0 gf180mcu_fd_sc_mcu7t5v0__dffq_1
X_221_ _008_ clk eng9 vdd_gate vdd_gate 0 0 gf180mcu_fd_sc_mcu7t5v0__dffq_1
X_222_ _007_ clk eng8 vdd_gate vdd_gate 0 0 gf180mcu_fd_sc_mcu7t5v0__dffq_1
X_223_ _006_ clk eng7 vdd_gate vdd_gate 0 0 gf180mcu_fd_sc_mcu7t5v0__dffq_1
X_224_ _005_ clk eng6 vdd_gate vdd_gate 0 0 gf180mcu_fd_sc_mcu7t5v0__dffq_1
X_225_ _004_ clk eng5 vdd_gate vdd_gate 0 0 gf180mcu_fd_sc_mcu7t5v0__dffq_1
X_226_ _003_ clk eng4 vdd_gate vdd_gate 0 0 gf180mcu_fd_sc_mcu7t5v0__dffq_1
X_227_ _002_ clk eng3 vdd_gate vdd_gate 0 0 gf180mcu_fd_sc_mcu7t5v0__dffq_1
X_228_ _001_ clk eng2 vdd_gate vdd_gate 0 0 gf180mcu_fd_sc_mcu7t5v0__dffq_1
X_229_ _000_ clk eng1 vdd_gate vdd_gate 0 0 gf180mcu_fd_sc_mcu7t5v0__dffq_1
X_230_ _009__0 clk ph_0 vdd_gate vdd_gate 0 0 gf180mcu_fd_sc_mcu7t5v0__dffq_1
X_231_ _009__1 clk ph_1 vdd_gate vdd_gate 0 0 gf180mcu_fd_sc_mcu7t5v0__dffq_1
X_232_ _009__2 clk ph_2 vdd_gate vdd_gate 0 0 gf180mcu_fd_sc_mcu7t5v0__dffq_1
X_233_ _009__3 clk ph_3 vdd_gate vdd_gate 0 0 gf180mcu_fd_sc_mcu7t5v0__dffq_1
X_234_ _009__4 clk ph_4 vdd_gate vdd_gate 0 0 gf180mcu_fd_sc_mcu7t5v0__dffq_1
X_235_ _009__5 clk ph_5 vdd_gate vdd_gate 0 0 gf180mcu_fd_sc_mcu7t5v0__dffq_1
X_236_ _009__6 clk ph_6 vdd_gate vdd_gate 0 0 gf180mcu_fd_sc_mcu7t5v0__dffq_1
X_237_ _009__7 clk ph_7 vdd_gate vdd_gate 0 0 gf180mcu_fd_sc_mcu7t5v0__dffq_1
X_238_ _009__8 clk ph_8 vdd_gate vdd_gate 0 0 gf180mcu_fd_sc_mcu7t5v0__dffq_1
X_239_ _009__9 clk ph_9 vdd_gate vdd_gate 0 0 gf180mcu_fd_sc_mcu7t5v0__dffq_1
X_240_ _009__10 clk ph_10 vdd_gate vdd_gate 0 0 gf180mcu_fd_sc_mcu7t5v0__dffq_1
X_241_ _009__11 clk ph_11 vdd_gate vdd_gate 0 0 gf180mcu_fd_sc_mcu7t5v0__dffq_1
X_242_ _009__12 clk ph_12 vdd_gate vdd_gate 0 0 gf180mcu_fd_sc_mcu7t5v0__dffq_1
X_243_ _009__13 clk ph_13 vdd_gate vdd_gate 0 0 gf180mcu_fd_sc_mcu7t5v0__dffq_1
X_244_ _009__14 clk ph_14 vdd_gate vdd_gate 0 0 gf180mcu_fd_sc_mcu7t5v0__dffq_1
X_245_ _009__15 clk drdy vdd_gate vdd_gate 0 0 gf180mcu_fd_sc_mcu7t5v0__dffq_1
.ends

.SUBCKT gf180mcu_fd_sc_mcu7t5v0__and2_1 A1 A2 Z VDD VNW VPW VSS
X_i_2 net_0 A1 Z_neg VPW nfet_06v0 W=3.65e-07 L=6e-07
X_i_3 VSS A2 net_0 VPW nfet_06v0 W=3.65e-07 L=6e-07
X_i_0 Z Z_neg VSS VPW nfet_06v0 W=8.15e-07 L=6e-07
X_i_4 Z_neg A1 VDD VNW pfet_06v0 W=6e-07 L=5e-07
X_i_5 VDD A2 Z_neg VNW pfet_06v0 W=6e-07 L=5e-07
X_i_1 Z Z_neg VDD VNW pfet_06v0 W=1.215e-06 L=5e-07
.ENDS

.SUBCKT gf180mcu_fd_sc_mcu7t5v0__aoi21_1 A1 A2 B ZN VDD VNW VPW VSS
X_i_1 net_0 A2 VSS VPW nfet_06v0 W=8.2e-07 L=6e-07
X_i_0 ZN A1 net_0 VPW nfet_06v0 W=8.2e-07 L=6e-07
X_i_2 VSS B ZN VPW nfet_06v0 W=5.1e-07 L=6e-07
X_i_4 ZN A2 net_1 VNW pfet_06v0 W=1.215e-06 L=5e-07
X_i_3 net_1 A1 ZN VNW pfet_06v0 W=1.215e-06 L=5e-07
X_i_5 VDD B net_1 VNW pfet_06v0 W=1.215e-06 L=5e-07
.ENDS

.SUBCKT gf180mcu_fd_sc_mcu7t5v0__clkinv_1 I ZN VDD VNW VPW VSS
X_i_0 ZN I VSS VPW nfet_06v0 W=4.8e-07 L=6e-07
X_i_1 ZN I VDD VNW pfet_06v0 W=1.22e-06 L=5e-07
.ENDS

.SUBCKT gf180mcu_fd_sc_mcu7t5v0__dffq_1 D CLK Q VDD VNW VPW VSS
X_tn3 VSS CLK ncki VPW nfet_06v0 W=4.05e-07 L=6e-07
X_tn4 cki ncki VSS VPW nfet_06v0 W=4.05e-07 L=6e-07
X_tn5 net5 ncki VSS VPW nfet_06v0 W=3.6e-07 L=6e-07
X_tn8 net4 D net5 VPW nfet_06v0 W=3.6e-07 L=6e-07
X_tn6 net6 cki net4 VPW nfet_06v0 W=3.6e-07 L=6e-07
X_tn7 VSS net0 net6 VPW nfet_06v0 W=3.6e-07 L=6e-07
X_tn0 net0 net4 VSS VPW nfet_06v0 W=3.6e-07 L=6e-07
X_tn9 net2 cki net0 VPW nfet_06v0 W=3.6e-07 L=6e-07
X_tn11 net1 ncki net2 VPW nfet_06v0 W=3.6e-07 L=6e-07
X_tn12 VSS net3 net1 VPW nfet_06v0 W=3.6e-07 L=6e-07
X_tn10 net3 net2 VSS VPW nfet_06v0 W=4e-07 L=6e-07
X_tn1 Q net3 VSS VPW nfet_06v0 W=8.2e-07 L=6e-07
X_tp3 VDD CLK ncki VNW pfet_06v0 W=8.65e-07 L=5e-07
X_tp4 cki ncki VDD VNW pfet_06v0 W=8.65e-07 L=5e-07
X_tp12 net7 cki VDD VNW pfet_06v0 W=3.6e-07 L=5e-07
X_tp11 net4 D net7 VNW pfet_06v0 W=3.6e-07 L=5e-07
X_tp6 net8 ncki net4 VNW pfet_06v0 W=3.6e-07 L=5e-07
X_tp5 VDD net0 net8 VNW pfet_06v0 W=3.6e-07 L=5e-07
X_tp0 net0 net4 VDD VNW pfet_06v0 W=3.6e-07 L=5e-07
X_tp7 net2 ncki net0 VNW pfet_06v0 W=3.6e-07 L=5e-07
X_tp9 net1x cki net2 VNW pfet_06v0 W=3.6e-07 L=5e-07
X_tp10 VDD net3 net1x VNW pfet_06v0 W=3.6e-07 L=5e-07
X_tp8 net3 net2 VDD VNW pfet_06v0 W=8e-07 L=5e-07
X_tp1 Q net3 VDD VNW pfet_06v0 W=1.22e-06 L=5e-07
.ENDS

.SUBCKT gf180mcu_fd_sc_mcu7t5v0__mux2_1 I0 I1 S Z VDD VNW VPW VSS
X_MN2 VSS int04 Z VPW nfet_06v0 W=8.2e-07 L=6e-07
X_MN4 net_1 I1 VSS VPW nfet_06v0 W=3.6e-07 L=6e-07
X_MN8 int04 S net_1 VPW nfet_06v0 W=3.6e-07 L=6e-07
X_MN7 net_3 sel1_n int04 VPW nfet_06v0 W=3.6e-07 L=6e-07
X_MN3 VSS I0 net_3 VPW nfet_06v0 W=3.6e-07 L=6e-07
X_MN1 sel1_n S VSS VPW nfet_06v0 W=3.6e-07 L=6e-07
X_MP5 VDD int04 Z VNW pfet_06v0 W=1.22e-06 L=5e-07
X_MP4 net_0 I1 VDD VNW pfet_06v0 W=6.15e-07 L=5e-07
X_MP8 int04 sel1_n net_0 VNW pfet_06v0 W=6.15e-07 L=5e-07
X_MP7 net_2 S int04 VNW pfet_06v0 W=6.15e-07 L=5e-07
X_MP3 VDD I0 net_2 VNW pfet_06v0 W=6.15e-07 L=5e-07
X_MP1 sel1_n S VDD VNW pfet_06v0 W=6.15e-07 L=5e-07
.ENDS

.SUBCKT gf180mcu_fd_sc_mcu7t5v0__nand3_1 A1 A2 A3 ZN VDD VNW VPW VSS
X_i_2 net_1 A3 VSS VPW nfet_06v0 W=8.2e-07 L=6e-07
X_i_1 net_0 A2 net_1 VPW nfet_06v0 W=8.2e-07 L=6e-07
X_i_0 ZN A1 net_0 VPW nfet_06v0 W=8.2e-07 L=6e-07
X_i_5 ZN A3 VDD VNW pfet_06v0 W=9.85e-07 L=5e-07
X_i_4 VDD A2 ZN VNW pfet_06v0 W=9.85e-07 L=5e-07
X_i_3 ZN A1 VDD VNW pfet_06v0 W=9.85e-07 L=5e-07
.ENDS

.SUBCKT gf180mcu_fd_sc_mcu7t5v0__nor2_1 A1 A2 ZN VDD VNW VPW VSS
X_i_1 ZN A2 VSS VPW nfet_06v0 W=5.65e-07 L=6e-07
X_i_0 VSS A1 ZN VPW nfet_06v0 W=5.65e-07 L=6e-07
X_i_3 net_0 A2 VDD VNW pfet_06v0 W=1.22e-06 L=5e-07
X_i_2 ZN A1 net_0 VNW pfet_06v0 W=1.22e-06 L=5e-07
.ENDS

.SUBCKT gf180mcu_fd_sc_mcu7t5v0__nor3_1 A1 A2 A3 ZN VDD VNW VPW VSS
X_i_2 ZN A3 VSS VPW nfet_06v0 W=4.65e-07 L=6e-07
X_i_1 VSS A2 ZN VPW nfet_06v0 W=4.65e-07 L=6e-07
X_i_0 ZN A1 VSS VPW nfet_06v0 W=4.65e-07 L=6e-07
X_i_5 net_1 A3 VDD VNW pfet_06v0 W=1.22e-06 L=5e-07
X_i_4 net_0 A2 net_1 VNW pfet_06v0 W=1.22e-06 L=5e-07
X_i_3 ZN A1 net_0 VNW pfet_06v0 W=1.22e-06 L=5e-07
.ENDS

.SUBCKT gf180mcu_fd_sc_mcu7t5v0__or2_1 A1 A2 Z VDD VNW VPW VSS
X_i_2 Z_neg A1 VSS VPW nfet_06v0 W=3.6e-07 L=6e-07
X_i_3 VSS A2 Z_neg VPW nfet_06v0 W=3.6e-07 L=6e-07
X_i_0 Z Z_neg VSS VPW nfet_06v0 W=8.2e-07 L=6e-07
X_i_4 net_0 A1 Z_neg VNW pfet_06v0 W=5.65e-07 L=5e-07
X_i_5 VDD A2 net_0 VNW pfet_06v0 W=5.65e-07 L=5e-07
X_i_1 Z Z_neg VDD VNW pfet_06v0 W=1.22e-06 L=5e-07
.ENDS

.SUBCKT gf180mcu_fd_sc_mcu7t5v0__or4_1 A1 A2 A3 A4 Z VDD VNW VPW VSS
X_i_2 Z_neg A1 VSS VPW nfet_06v0 W=3.6e-07 L=6e-07
X_i_3 VSS A2 Z_neg VPW nfet_06v0 W=3.6e-07 L=6e-07
X_i_4 Z_neg A3 VSS VPW nfet_06v0 W=3.6e-07 L=6e-07
X_i_5 VSS A4 Z_neg VPW nfet_06v0 W=3.6e-07 L=6e-07
X_i_0 Z Z_neg VSS VPW nfet_06v0 W=8.2e-07 L=6e-07
X_i_6 net_0 A1 Z_neg VNW pfet_06v0 W=5.6e-07 L=5e-07
X_i_7 net_1 A2 net_0 VNW pfet_06v0 W=5.6e-07 L=5e-07
X_i_8 net_2 A3 net_1 VNW pfet_06v0 W=5.6e-07 L=5e-07
X_i_9 VDD A4 net_2 VNW pfet_06v0 W=5.6e-07 L=5e-07
X_i_1 Z Z_neg VDD VNW pfet_06v0 W=1.22e-06 L=5e-07
.ENDS

vvdd_gate vdd_gate 0 dc {vdd_val}
