* extracted by klt extract --deck gf180mcu

* cell ADC_BLOCK
* pin XCMP_pon
* pin XCMP_pop
* pin cmpclk
* pin dout
* pin doutb
* pin hi_128_n
* pin hi_128_p
* pin hi_16_n
* pin hi_16_p
* pin hi_1_n
* pin hi_1_p
* pin hi_256_n
* pin hi_256_p
* pin hi_2_n
* pin hi_2_p
* pin hi_32_n
* pin hi_32_p
* pin hi_4_n
* pin hi_4_p
* pin hi_64_n
* pin hi_64_p
* pin hi_8_n
* pin hi_8_p
* pin ibias
* pin lo_128_n
* pin lo_128_p
* pin lo_16_n
* pin lo_16_p
* pin lo_1_n
* pin lo_1_p
* pin lo_256_n
* pin lo_256_p
* pin lo_2_n
* pin lo_2_p
* pin lo_32_n
* pin lo_32_p
* pin lo_4_n
* pin lo_4_p
* pin lo_64_n
* pin lo_64_p
* pin lo_8_n
* pin lo_8_p
* pin pinn
* pin pinp
* pin rel_128_n
* pin rel_128_p
* pin rel_16_n
* pin rel_16_p
* pin rel_1_n
* pin rel_1_p
* pin rel_256_n
* pin rel_256_p
* pin rel_2_n
* pin rel_2_p
* pin rel_32_n
* pin rel_32_p
* pin rel_4_n
* pin rel_4_p
* pin rel_64_n
* pin rel_64_p
* pin rel_8_n
* pin rel_8_p
* pin sel_in
* pin topn
* pin topp
* pin tp_gn
* pin vcm
* pin vdd
* pin vref
* pin vss
.SUBCKT ADC_BLOCK XCMP_pon XCMP_pop cmpclk dout doutb hi_128_n hi_128_p hi_16_n
+ hi_16_p hi_1_n hi_1_p hi_256_n hi_256_p hi_2_n hi_2_p hi_32_n hi_32_p hi_4_n
+ hi_4_p hi_64_n hi_64_p hi_8_n hi_8_p ibias lo_128_n lo_128_p lo_16_n lo_16_p
+ lo_1_n lo_1_p lo_256_n lo_256_p lo_2_n lo_2_p lo_32_n lo_32_p lo_4_n lo_4_p
+ lo_64_n lo_64_p lo_8_n lo_8_p pinn pinp rel_128_n rel_128_p rel_16_n rel_16_p
+ rel_1_n rel_1_p rel_256_n rel_256_p rel_2_n rel_2_p rel_32_n rel_32_p rel_4_n
+ rel_4_p rel_64_n rel_64_p rel_8_n rel_8_p sel_in topn topp tp_gn vcm vdd vref
+ vss
* device instance $1 r0 *1 1.275,2 nfet
M$1 \$61 sel_in vss vss nfet L=0.35U W=4U AS=4.4P AD=4.4P PS=10.2U PD=10.2U
* device instance $2 r0 *1 4.225,2 nfet
M$2 \$15 rel_256_p vss vss nfet L=0.35U W=4U AS=4.4P AD=4.4P PS=10.2U PD=10.2U
* device instance $3 r0 *1 7.175,2 nfet
M$3 \$17 hi_256_p vss vss nfet L=0.35U W=4U AS=4.4P AD=4.4P PS=10.2U PD=10.2U
* device instance $4 r0 *1 10.125,2 nfet
M$4 \$19 lo_256_p vss vss nfet L=0.35U W=4U AS=4.4P AD=4.4P PS=10.2U PD=10.2U
* device instance $5 r0 *1 13.04,5 nfet
M$5 pinp sel_in \$6 vss nfet L=0.28U W=10U AS=11P AD=11P PS=22.2U PD=22.2U
* device instance $6 r0 *1 15.92,5 nfet
M$6 vcm rel_256_p \$6 vss nfet L=0.28U W=10U AS=11P AD=11P PS=22.2U PD=22.2U
* device instance $7 r0 *1 18.8,5 nfet
M$7 vref hi_256_p \$6 vss nfet L=0.28U W=10U AS=11P AD=11P PS=22.2U PD=22.2U
* device instance $8 r0 *1 21.68,5 nfet
M$8 vss lo_256_p \$6 vss nfet L=0.28U W=10U AS=11P AD=11P PS=22.2U PD=22.2U
* device instance $9 r0 *1 59.635,2 nfet
M$9 \$63 sel_in vss vss nfet L=0.35U W=4U AS=4.4P AD=4.4P PS=10.2U PD=10.2U
* device instance $10 r0 *1 62.585,2 nfet
M$10 \$20 rel_128_p vss vss nfet L=0.35U W=4U AS=4.4P AD=4.4P PS=10.2U PD=10.2U
* device instance $11 r0 *1 65.535,2 nfet
M$11 \$22 hi_128_p vss vss nfet L=0.35U W=4U AS=4.4P AD=4.4P PS=10.2U PD=10.2U
* device instance $12 r0 *1 68.485,2 nfet
M$12 \$24 lo_128_p vss vss nfet L=0.35U W=4U AS=4.4P AD=4.4P PS=10.2U PD=10.2U
* device instance $13 r0 *1 71.4,5 nfet
M$13 pinp sel_in \$7 vss nfet L=0.28U W=10U AS=11P AD=11P PS=22.2U PD=22.2U
* device instance $14 r0 *1 74.28,5 nfet
M$14 vcm rel_128_p \$7 vss nfet L=0.28U W=10U AS=11P AD=11P PS=22.2U PD=22.2U
* device instance $15 r0 *1 77.16,5 nfet
M$15 vref hi_128_p \$7 vss nfet L=0.28U W=10U AS=11P AD=11P PS=22.2U PD=22.2U
* device instance $16 r0 *1 80.04,5 nfet
M$16 vss lo_128_p \$7 vss nfet L=0.28U W=10U AS=11P AD=11P PS=22.2U PD=22.2U
* device instance $17 r0 *1 117.995,2 nfet
M$17 \$65 sel_in vss vss nfet L=0.35U W=4U AS=4.4P AD=4.4P PS=10.2U PD=10.2U
* device instance $18 r0 *1 120.945,2 nfet
M$18 \$25 rel_64_p vss vss nfet L=0.35U W=4U AS=4.4P AD=4.4P PS=10.2U PD=10.2U
* device instance $19 r0 *1 123.895,2 nfet
M$19 \$27 hi_64_p vss vss nfet L=0.35U W=4U AS=4.4P AD=4.4P PS=10.2U PD=10.2U
* device instance $20 r0 *1 126.845,2 nfet
M$20 \$29 lo_64_p vss vss nfet L=0.35U W=4U AS=4.4P AD=4.4P PS=10.2U PD=10.2U
* device instance $21 r0 *1 129.76,5 nfet
M$21 pinp sel_in \$8 vss nfet L=0.28U W=10U AS=11P AD=11P PS=22.2U PD=22.2U
* device instance $22 r0 *1 132.64,5 nfet
M$22 vcm rel_64_p \$8 vss nfet L=0.28U W=10U AS=11P AD=11P PS=22.2U PD=22.2U
* device instance $23 r0 *1 135.52,5 nfet
M$23 vref hi_64_p \$8 vss nfet L=0.28U W=10U AS=11P AD=11P PS=22.2U PD=22.2U
* device instance $24 r0 *1 138.4,5 nfet
M$24 vss lo_64_p \$8 vss nfet L=0.28U W=10U AS=11P AD=11P PS=22.2U PD=22.2U
* device instance $25 r0 *1 176.355,2 nfet
M$25 \$67 sel_in vss vss nfet L=0.35U W=4U AS=4.4P AD=4.4P PS=10.2U PD=10.2U
* device instance $26 r0 *1 179.305,2 nfet
M$26 \$30 rel_32_p vss vss nfet L=0.35U W=4U AS=4.4P AD=4.4P PS=10.2U PD=10.2U
* device instance $27 r0 *1 182.255,2 nfet
M$27 \$32 hi_32_p vss vss nfet L=0.35U W=4U AS=4.4P AD=4.4P PS=10.2U PD=10.2U
* device instance $28 r0 *1 185.205,2 nfet
M$28 \$34 lo_32_p vss vss nfet L=0.35U W=4U AS=4.4P AD=4.4P PS=10.2U PD=10.2U
* device instance $29 r0 *1 188.12,5 nfet
M$29 pinp sel_in \$9 vss nfet L=0.28U W=10U AS=11P AD=11P PS=22.2U PD=22.2U
* device instance $30 r0 *1 191,5 nfet
M$30 vcm rel_32_p \$9 vss nfet L=0.28U W=10U AS=11P AD=11P PS=22.2U PD=22.2U
* device instance $31 r0 *1 193.88,5 nfet
M$31 vref hi_32_p \$9 vss nfet L=0.28U W=10U AS=11P AD=11P PS=22.2U PD=22.2U
* device instance $32 r0 *1 196.76,5 nfet
M$32 vss lo_32_p \$9 vss nfet L=0.28U W=10U AS=11P AD=11P PS=22.2U PD=22.2U
* device instance $33 r0 *1 234.715,2 nfet
M$33 \$69 sel_in vss vss nfet L=0.35U W=4U AS=4.4P AD=4.4P PS=10.2U PD=10.2U
* device instance $34 r0 *1 237.665,2 nfet
M$34 \$35 rel_16_p vss vss nfet L=0.35U W=4U AS=4.4P AD=4.4P PS=10.2U PD=10.2U
* device instance $35 r0 *1 240.615,2 nfet
M$35 \$37 hi_16_p vss vss nfet L=0.35U W=4U AS=4.4P AD=4.4P PS=10.2U PD=10.2U
* device instance $36 r0 *1 243.565,2 nfet
M$36 \$39 lo_16_p vss vss nfet L=0.35U W=4U AS=4.4P AD=4.4P PS=10.2U PD=10.2U
* device instance $37 r0 *1 246.48,5 nfet
M$37 pinp sel_in \$10 vss nfet L=0.28U W=10U AS=11P AD=11P PS=22.2U PD=22.2U
* device instance $38 r0 *1 249.36,5 nfet
M$38 vcm rel_16_p \$10 vss nfet L=0.28U W=10U AS=11P AD=11P PS=22.2U PD=22.2U
* device instance $39 r0 *1 252.24,5 nfet
M$39 vref hi_16_p \$10 vss nfet L=0.28U W=10U AS=11P AD=11P PS=22.2U PD=22.2U
* device instance $40 r0 *1 255.12,5 nfet
M$40 vss lo_16_p \$10 vss nfet L=0.28U W=10U AS=11P AD=11P PS=22.2U PD=22.2U
* device instance $41 r0 *1 293.075,2 nfet
M$41 \$71 sel_in vss vss nfet L=0.35U W=4U AS=4.4P AD=4.4P PS=10.2U PD=10.2U
* device instance $42 r0 *1 296.025,2 nfet
M$42 \$40 rel_8_p vss vss nfet L=0.35U W=4U AS=4.4P AD=4.4P PS=10.2U PD=10.2U
* device instance $43 r0 *1 298.975,2 nfet
M$43 \$42 hi_8_p vss vss nfet L=0.35U W=4U AS=4.4P AD=4.4P PS=10.2U PD=10.2U
* device instance $44 r0 *1 301.925,2 nfet
M$44 \$44 lo_8_p vss vss nfet L=0.35U W=4U AS=4.4P AD=4.4P PS=10.2U PD=10.2U
* device instance $45 r0 *1 304.84,5 nfet
M$45 pinp sel_in \$11 vss nfet L=0.28U W=10U AS=11P AD=11P PS=22.2U PD=22.2U
* device instance $46 r0 *1 307.72,5 nfet
M$46 vcm rel_8_p \$11 vss nfet L=0.28U W=10U AS=11P AD=11P PS=22.2U PD=22.2U
* device instance $47 r0 *1 310.6,5 nfet
M$47 vref hi_8_p \$11 vss nfet L=0.28U W=10U AS=11P AD=11P PS=22.2U PD=22.2U
* device instance $48 r0 *1 313.48,5 nfet
M$48 vss lo_8_p \$11 vss nfet L=0.28U W=10U AS=11P AD=11P PS=22.2U PD=22.2U
* device instance $49 r0 *1 351.435,2 nfet
M$49 \$73 sel_in vss vss nfet L=0.35U W=4U AS=4.4P AD=4.4P PS=10.2U PD=10.2U
* device instance $50 r0 *1 354.385,2 nfet
M$50 \$45 rel_4_p vss vss nfet L=0.35U W=4U AS=4.4P AD=4.4P PS=10.2U PD=10.2U
* device instance $51 r0 *1 357.335,2 nfet
M$51 \$47 hi_4_p vss vss nfet L=0.35U W=4U AS=4.4P AD=4.4P PS=10.2U PD=10.2U
* device instance $52 r0 *1 360.285,2 nfet
M$52 \$49 lo_4_p vss vss nfet L=0.35U W=4U AS=4.4P AD=4.4P PS=10.2U PD=10.2U
* device instance $53 r0 *1 363.2,5 nfet
M$53 pinp sel_in \$12 vss nfet L=0.28U W=10U AS=11P AD=11P PS=22.2U PD=22.2U
* device instance $54 r0 *1 366.08,5 nfet
M$54 vcm rel_4_p \$12 vss nfet L=0.28U W=10U AS=11P AD=11P PS=22.2U PD=22.2U
* device instance $55 r0 *1 368.96,5 nfet
M$55 vref hi_4_p \$12 vss nfet L=0.28U W=10U AS=11P AD=11P PS=22.2U PD=22.2U
* device instance $56 r0 *1 371.84,5 nfet
M$56 vss lo_4_p \$12 vss nfet L=0.28U W=10U AS=11P AD=11P PS=22.2U PD=22.2U
* device instance $57 r0 *1 409.795,2 nfet
M$57 \$75 sel_in vss vss nfet L=0.35U W=4U AS=4.4P AD=4.4P PS=10.2U PD=10.2U
* device instance $58 r0 *1 412.745,2 nfet
M$58 \$50 rel_2_p vss vss nfet L=0.35U W=4U AS=4.4P AD=4.4P PS=10.2U PD=10.2U
* device instance $59 r0 *1 415.695,2 nfet
M$59 \$52 hi_2_p vss vss nfet L=0.35U W=4U AS=4.4P AD=4.4P PS=10.2U PD=10.2U
* device instance $60 r0 *1 418.645,2 nfet
M$60 \$54 lo_2_p vss vss nfet L=0.35U W=4U AS=4.4P AD=4.4P PS=10.2U PD=10.2U
* device instance $61 r0 *1 421.56,5 nfet
M$61 pinp sel_in \$13 vss nfet L=0.28U W=10U AS=11P AD=11P PS=22.2U PD=22.2U
* device instance $62 r0 *1 424.44,5 nfet
M$62 vcm rel_2_p \$13 vss nfet L=0.28U W=10U AS=11P AD=11P PS=22.2U PD=22.2U
* device instance $63 r0 *1 427.32,5 nfet
M$63 vref hi_2_p \$13 vss nfet L=0.28U W=10U AS=11P AD=11P PS=22.2U PD=22.2U
* device instance $64 r0 *1 430.2,5 nfet
M$64 vss lo_2_p \$13 vss nfet L=0.28U W=10U AS=11P AD=11P PS=22.2U PD=22.2U
* device instance $65 r0 *1 468.155,2 nfet
M$65 \$77 sel_in vss vss nfet L=0.35U W=4U AS=4.4P AD=4.4P PS=10.2U PD=10.2U
* device instance $66 r0 *1 471.105,2 nfet
M$66 \$55 rel_1_p vss vss nfet L=0.35U W=4U AS=4.4P AD=4.4P PS=10.2U PD=10.2U
* device instance $67 r0 *1 474.055,2 nfet
M$67 \$57 hi_1_p vss vss nfet L=0.35U W=4U AS=4.4P AD=4.4P PS=10.2U PD=10.2U
* device instance $68 r0 *1 477.005,2 nfet
M$68 \$59 lo_1_p vss vss nfet L=0.35U W=4U AS=4.4P AD=4.4P PS=10.2U PD=10.2U
* device instance $69 r0 *1 479.92,5 nfet
M$69 pinp sel_in \$14 vss nfet L=0.28U W=10U AS=11P AD=11P PS=22.2U PD=22.2U
* device instance $70 r0 *1 482.8,5 nfet
M$70 vcm rel_1_p \$14 vss nfet L=0.28U W=10U AS=11P AD=11P PS=22.2U PD=22.2U
* device instance $71 r0 *1 485.68,5 nfet
M$71 vref hi_1_p \$14 vss nfet L=0.28U W=10U AS=11P AD=11P PS=22.2U PD=22.2U
* device instance $72 r0 *1 488.56,5 nfet
M$72 vss lo_1_p \$14 vss nfet L=0.28U W=10U AS=11P AD=11P PS=22.2U PD=22.2U
* device instance $73 r0 *1 1.275,26.96 nfet
M$73 \$79 sel_in vss vss nfet L=0.35U W=4U AS=4.4P AD=4.4P PS=10.2U PD=10.2U
* device instance $74 r0 *1 4.225,26.96 nfet
M$74 \$81 rel_256_n vss vss nfet L=0.35U W=4U AS=4.4P AD=4.4P PS=10.2U PD=10.2U
* device instance $75 r0 *1 7.175,26.96 nfet
M$75 \$83 hi_256_n vss vss nfet L=0.35U W=4U AS=4.4P AD=4.4P PS=10.2U PD=10.2U
* device instance $76 r0 *1 10.125,26.96 nfet
M$76 \$85 lo_256_n vss vss nfet L=0.35U W=4U AS=4.4P AD=4.4P PS=10.2U PD=10.2U
* device instance $77 r0 *1 13.04,29.96 nfet
M$77 pinn sel_in \$86 vss nfet L=0.28U W=10U AS=11P AD=11P PS=22.2U PD=22.2U
* device instance $78 r0 *1 15.92,29.96 nfet
M$78 vcm rel_256_n \$86 vss nfet L=0.28U W=10U AS=11P AD=11P PS=22.2U PD=22.2U
* device instance $79 r0 *1 18.8,29.96 nfet
M$79 vref hi_256_n \$86 vss nfet L=0.28U W=10U AS=11P AD=11P PS=22.2U PD=22.2U
* device instance $80 r0 *1 21.68,29.96 nfet
M$80 vss lo_256_n \$86 vss nfet L=0.28U W=10U AS=11P AD=11P PS=22.2U PD=22.2U
* device instance $81 r0 *1 59.635,26.96 nfet
M$81 \$88 sel_in vss vss nfet L=0.35U W=4U AS=4.4P AD=4.4P PS=10.2U PD=10.2U
* device instance $82 r0 *1 62.585,26.96 nfet
M$82 \$90 rel_128_n vss vss nfet L=0.35U W=4U AS=4.4P AD=4.4P PS=10.2U PD=10.2U
* device instance $83 r0 *1 65.535,26.96 nfet
M$83 \$92 hi_128_n vss vss nfet L=0.35U W=4U AS=4.4P AD=4.4P PS=10.2U PD=10.2U
* device instance $84 r0 *1 68.485,26.96 nfet
M$84 \$94 lo_128_n vss vss nfet L=0.35U W=4U AS=4.4P AD=4.4P PS=10.2U PD=10.2U
* device instance $85 r0 *1 71.4,29.96 nfet
M$85 pinn sel_in \$95 vss nfet L=0.28U W=10U AS=11P AD=11P PS=22.2U PD=22.2U
* device instance $86 r0 *1 74.28,29.96 nfet
M$86 vcm rel_128_n \$95 vss nfet L=0.28U W=10U AS=11P AD=11P PS=22.2U PD=22.2U
* device instance $87 r0 *1 77.16,29.96 nfet
M$87 vref hi_128_n \$95 vss nfet L=0.28U W=10U AS=11P AD=11P PS=22.2U PD=22.2U
* device instance $88 r0 *1 80.04,29.96 nfet
M$88 vss lo_128_n \$95 vss nfet L=0.28U W=10U AS=11P AD=11P PS=22.2U PD=22.2U
* device instance $89 r0 *1 117.995,26.96 nfet
M$89 \$96 sel_in vss vss nfet L=0.35U W=4U AS=4.4P AD=4.4P PS=10.2U PD=10.2U
* device instance $90 r0 *1 120.945,26.96 nfet
M$90 \$98 rel_64_n vss vss nfet L=0.35U W=4U AS=4.4P AD=4.4P PS=10.2U PD=10.2U
* device instance $91 r0 *1 123.895,26.96 nfet
M$91 \$100 hi_64_n vss vss nfet L=0.35U W=4U AS=4.4P AD=4.4P PS=10.2U PD=10.2U
* device instance $92 r0 *1 126.845,26.96 nfet
M$92 \$102 lo_64_n vss vss nfet L=0.35U W=4U AS=4.4P AD=4.4P PS=10.2U PD=10.2U
* device instance $93 r0 *1 129.76,29.96 nfet
M$93 pinn sel_in \$103 vss nfet L=0.28U W=10U AS=11P AD=11P PS=22.2U PD=22.2U
* device instance $94 r0 *1 132.64,29.96 nfet
M$94 vcm rel_64_n \$103 vss nfet L=0.28U W=10U AS=11P AD=11P PS=22.2U PD=22.2U
* device instance $95 r0 *1 135.52,29.96 nfet
M$95 vref hi_64_n \$103 vss nfet L=0.28U W=10U AS=11P AD=11P PS=22.2U PD=22.2U
* device instance $96 r0 *1 138.4,29.96 nfet
M$96 vss lo_64_n \$103 vss nfet L=0.28U W=10U AS=11P AD=11P PS=22.2U PD=22.2U
* device instance $97 r0 *1 176.355,26.96 nfet
M$97 \$104 sel_in vss vss nfet L=0.35U W=4U AS=4.4P AD=4.4P PS=10.2U PD=10.2U
* device instance $98 r0 *1 179.305,26.96 nfet
M$98 \$106 rel_32_n vss vss nfet L=0.35U W=4U AS=4.4P AD=4.4P PS=10.2U PD=10.2U
* device instance $99 r0 *1 182.255,26.96 nfet
M$99 \$108 hi_32_n vss vss nfet L=0.35U W=4U AS=4.4P AD=4.4P PS=10.2U PD=10.2U
* device instance $100 r0 *1 185.205,26.96 nfet
M$100 \$110 lo_32_n vss vss nfet L=0.35U W=4U AS=4.4P AD=4.4P PS=10.2U PD=10.2U
* device instance $101 r0 *1 188.12,29.96 nfet
M$101 pinn sel_in \$111 vss nfet L=0.28U W=10U AS=11P AD=11P PS=22.2U PD=22.2U
* device instance $102 r0 *1 191,29.96 nfet
M$102 vcm rel_32_n \$111 vss nfet L=0.28U W=10U AS=11P AD=11P PS=22.2U PD=22.2U
* device instance $103 r0 *1 193.88,29.96 nfet
M$103 vref hi_32_n \$111 vss nfet L=0.28U W=10U AS=11P AD=11P PS=22.2U PD=22.2U
* device instance $104 r0 *1 196.76,29.96 nfet
M$104 vss lo_32_n \$111 vss nfet L=0.28U W=10U AS=11P AD=11P PS=22.2U PD=22.2U
* device instance $105 r0 *1 234.715,26.96 nfet
M$105 \$112 sel_in vss vss nfet L=0.35U W=4U AS=4.4P AD=4.4P PS=10.2U PD=10.2U
* device instance $106 r0 *1 237.665,26.96 nfet
M$106 \$114 rel_16_n vss vss nfet L=0.35U W=4U AS=4.4P AD=4.4P PS=10.2U PD=10.2U
* device instance $107 r0 *1 240.615,26.96 nfet
M$107 \$116 hi_16_n vss vss nfet L=0.35U W=4U AS=4.4P AD=4.4P PS=10.2U PD=10.2U
* device instance $108 r0 *1 243.565,26.96 nfet
M$108 \$118 lo_16_n vss vss nfet L=0.35U W=4U AS=4.4P AD=4.4P PS=10.2U PD=10.2U
* device instance $109 r0 *1 246.48,29.96 nfet
M$109 pinn sel_in \$119 vss nfet L=0.28U W=10U AS=11P AD=11P PS=22.2U PD=22.2U
* device instance $110 r0 *1 249.36,29.96 nfet
M$110 vcm rel_16_n \$119 vss nfet L=0.28U W=10U AS=11P AD=11P PS=22.2U PD=22.2U
* device instance $111 r0 *1 252.24,29.96 nfet
M$111 vref hi_16_n \$119 vss nfet L=0.28U W=10U AS=11P AD=11P PS=22.2U PD=22.2U
* device instance $112 r0 *1 255.12,29.96 nfet
M$112 vss lo_16_n \$119 vss nfet L=0.28U W=10U AS=11P AD=11P PS=22.2U PD=22.2U
* device instance $113 r0 *1 293.075,26.96 nfet
M$113 \$120 sel_in vss vss nfet L=0.35U W=4U AS=4.4P AD=4.4P PS=10.2U PD=10.2U
* device instance $114 r0 *1 296.025,26.96 nfet
M$114 \$122 rel_8_n vss vss nfet L=0.35U W=4U AS=4.4P AD=4.4P PS=10.2U PD=10.2U
* device instance $115 r0 *1 298.975,26.96 nfet
M$115 \$124 hi_8_n vss vss nfet L=0.35U W=4U AS=4.4P AD=4.4P PS=10.2U PD=10.2U
* device instance $116 r0 *1 301.925,26.96 nfet
M$116 \$126 lo_8_n vss vss nfet L=0.35U W=4U AS=4.4P AD=4.4P PS=10.2U PD=10.2U
* device instance $117 r0 *1 304.84,29.96 nfet
M$117 pinn sel_in \$127 vss nfet L=0.28U W=10U AS=11P AD=11P PS=22.2U PD=22.2U
* device instance $118 r0 *1 307.72,29.96 nfet
M$118 vcm rel_8_n \$127 vss nfet L=0.28U W=10U AS=11P AD=11P PS=22.2U PD=22.2U
* device instance $119 r0 *1 310.6,29.96 nfet
M$119 vref hi_8_n \$127 vss nfet L=0.28U W=10U AS=11P AD=11P PS=22.2U PD=22.2U
* device instance $120 r0 *1 313.48,29.96 nfet
M$120 vss lo_8_n \$127 vss nfet L=0.28U W=10U AS=11P AD=11P PS=22.2U PD=22.2U
* device instance $121 r0 *1 351.435,26.96 nfet
M$121 \$128 sel_in vss vss nfet L=0.35U W=4U AS=4.4P AD=4.4P PS=10.2U PD=10.2U
* device instance $122 r0 *1 354.385,26.96 nfet
M$122 \$130 rel_4_n vss vss nfet L=0.35U W=4U AS=4.4P AD=4.4P PS=10.2U PD=10.2U
* device instance $123 r0 *1 357.335,26.96 nfet
M$123 \$132 hi_4_n vss vss nfet L=0.35U W=4U AS=4.4P AD=4.4P PS=10.2U PD=10.2U
* device instance $124 r0 *1 360.285,26.96 nfet
M$124 \$134 lo_4_n vss vss nfet L=0.35U W=4U AS=4.4P AD=4.4P PS=10.2U PD=10.2U
* device instance $125 r0 *1 363.2,29.96 nfet
M$125 pinn sel_in \$135 vss nfet L=0.28U W=10U AS=11P AD=11P PS=22.2U PD=22.2U
* device instance $126 r0 *1 366.08,29.96 nfet
M$126 vcm rel_4_n \$135 vss nfet L=0.28U W=10U AS=11P AD=11P PS=22.2U PD=22.2U
* device instance $127 r0 *1 368.96,29.96 nfet
M$127 vref hi_4_n \$135 vss nfet L=0.28U W=10U AS=11P AD=11P PS=22.2U PD=22.2U
* device instance $128 r0 *1 371.84,29.96 nfet
M$128 vss lo_4_n \$135 vss nfet L=0.28U W=10U AS=11P AD=11P PS=22.2U PD=22.2U
* device instance $129 r0 *1 409.795,26.96 nfet
M$129 \$136 sel_in vss vss nfet L=0.35U W=4U AS=4.4P AD=4.4P PS=10.2U PD=10.2U
* device instance $130 r0 *1 412.745,26.96 nfet
M$130 \$138 rel_2_n vss vss nfet L=0.35U W=4U AS=4.4P AD=4.4P PS=10.2U PD=10.2U
* device instance $131 r0 *1 415.695,26.96 nfet
M$131 \$140 hi_2_n vss vss nfet L=0.35U W=4U AS=4.4P AD=4.4P PS=10.2U PD=10.2U
* device instance $132 r0 *1 418.645,26.96 nfet
M$132 \$142 lo_2_n vss vss nfet L=0.35U W=4U AS=4.4P AD=4.4P PS=10.2U PD=10.2U
* device instance $133 r0 *1 421.56,29.96 nfet
M$133 pinn sel_in \$143 vss nfet L=0.28U W=10U AS=11P AD=11P PS=22.2U PD=22.2U
* device instance $134 r0 *1 424.44,29.96 nfet
M$134 vcm rel_2_n \$143 vss nfet L=0.28U W=10U AS=11P AD=11P PS=22.2U PD=22.2U
* device instance $135 r0 *1 427.32,29.96 nfet
M$135 vref hi_2_n \$143 vss nfet L=0.28U W=10U AS=11P AD=11P PS=22.2U PD=22.2U
* device instance $136 r0 *1 430.2,29.96 nfet
M$136 vss lo_2_n \$143 vss nfet L=0.28U W=10U AS=11P AD=11P PS=22.2U PD=22.2U
* device instance $137 r0 *1 468.155,26.96 nfet
M$137 \$144 sel_in vss vss nfet L=0.35U W=4U AS=4.4P AD=4.4P PS=10.2U PD=10.2U
* device instance $138 r0 *1 471.105,26.96 nfet
M$138 \$146 rel_1_n vss vss nfet L=0.35U W=4U AS=4.4P AD=4.4P PS=10.2U PD=10.2U
* device instance $139 r0 *1 474.055,26.96 nfet
M$139 \$148 hi_1_n vss vss nfet L=0.35U W=4U AS=4.4P AD=4.4P PS=10.2U PD=10.2U
* device instance $140 r0 *1 477.005,26.96 nfet
M$140 \$150 lo_1_n vss vss nfet L=0.35U W=4U AS=4.4P AD=4.4P PS=10.2U PD=10.2U
* device instance $141 r0 *1 479.92,29.96 nfet
M$141 pinn sel_in \$151 vss nfet L=0.28U W=10U AS=11P AD=11P PS=22.2U PD=22.2U
* device instance $142 r0 *1 482.8,29.96 nfet
M$142 vcm rel_1_n \$151 vss nfet L=0.28U W=10U AS=11P AD=11P PS=22.2U PD=22.2U
* device instance $143 r0 *1 485.68,29.96 nfet
M$143 vref hi_1_n \$151 vss nfet L=0.28U W=10U AS=11P AD=11P PS=22.2U PD=22.2U
* device instance $144 r0 *1 488.56,29.96 nfet
M$144 vss lo_1_n \$151 vss nfet L=0.28U W=10U AS=11P AD=11P PS=22.2U PD=22.2U
* device instance $145 r0 *1 444.075,51.92 nfet
M$145 \$168 tp_gn vss vss nfet L=0.35U W=4U AS=4.4P AD=4.4P PS=10.2U PD=10.2U
* device instance $146 r0 *1 446.99,54.92 nfet
M$146 vcm tp_gn topp vss nfet L=0.28U W=10U AS=11P AD=11P PS=22.2U PD=22.2U
* device instance $147 r0 *1 457.535,51.92 nfet
M$147 \$169 tp_gn vss vss nfet L=0.35U W=4U AS=4.4P AD=4.4P PS=10.2U PD=10.2U
* device instance $148 r0 *1 460.45,54.92 nfet
M$148 vcm tp_gn topn vss nfet L=0.28U W=10U AS=11P AD=11P PS=22.2U PD=22.2U
* device instance $149 r0 *1 482.83,55.58 nfet
M$149 ibias ibias vss vss nfet L=2U W=20U AS=22P AD=22P PS=42.2U PD=42.2U
* device instance $150 r0 *1 486.93,65.58 nfet
M$150 XCMP_pon topp \$153 vss nfet L=1U W=40U AS=44P AD=44P PS=82.2U PD=82.2U
* device instance $151 r0 *1 490.53,65.58 nfet
M$151 XCMP_pop topn \$153 vss nfet L=1U W=40U AS=44P AD=44P PS=82.2U PD=82.2U
* device instance $152 r0 *1 494.63,55.58 nfet
M$152 \$153 ibias vss vss nfet L=2U W=20U AS=22P AD=22P PS=42.2U PD=42.2U
* device instance $153 r0 *1 499.305,53.58 nfet
M$153 \$157 cmpclk vss vss nfet L=0.35U W=16U AS=17.6P AD=17.6P PS=34.2U
+ PD=34.2U
* device instance $154 r0 *1 502.33,49.58 nfet
M$154 \$158 XCMP_pop \$157 vss nfet L=0.5U W=8U AS=8.8P AD=8.8P PS=18.2U
+ PD=18.2U
* device instance $155 r0 *1 505.43,49.58 nfet
M$155 \$159 XCMP_pon \$157 vss nfet L=0.5U W=8U AS=8.8P AD=8.8P PS=18.2U
+ PD=18.2U
* device instance $156 r0 *1 508.455,48.58 nfet
M$156 \$161 \$160 \$158 vss nfet L=0.35U W=6U AS=6.6P AD=6.6P PS=14.2U PD=14.2U
* device instance $157 r0 *1 511.405,48.58 nfet
M$157 \$160 \$161 \$159 vss nfet L=0.35U W=6U AS=6.6P AD=6.6P PS=14.2U PD=14.2U
* device instance $158 r0 *1 533.855,46.08 nfet
M$158 \$162 \$161 vss vss nfet L=0.35U W=1U AS=1.1P AD=1.1P PS=4.2U PD=4.2U
* device instance $159 r0 *1 541.555,46.08 nfet
M$159 \$163 \$160 vss vss nfet L=0.35U W=1U AS=1.1P AD=1.1P PS=4.2U PD=4.2U
* device instance $160 r0 *1 549.255,47.58 nfet
M$160 dout \$163 vss vss nfet L=0.35U W=4U AS=4.4P AD=4.4P PS=10.2U PD=10.2U
* device instance $161 r0 *1 552.205,47.58 nfet
M$161 dout doutb vss vss nfet L=0.35U W=4U AS=4.4P AD=4.4P PS=10.2U PD=10.2U
* device instance $162 r0 *1 562.855,47.58 nfet
M$162 doutb \$162 vss vss nfet L=0.35U W=4U AS=4.4P AD=4.4P PS=10.2U PD=10.2U
* device instance $163 r0 *1 565.805,47.58 nfet
M$163 doutb dout vss vss nfet L=0.35U W=4U AS=4.4P AD=4.4P PS=10.2U PD=10.2U
* device instance $164 r0 *1 25.495,4 pfet
M$164 \$61 sel_in vdd vdd pfet L=0.35U W=8U AS=8.8P AD=8.8P PS=18.2U PD=18.2U
* device instance $165 r0 *1 28.445,4 pfet
M$165 \$15 rel_256_p vdd vdd pfet L=0.35U W=8U AS=8.8P AD=8.8P PS=18.2U PD=18.2U
* device instance $166 r0 *1 31.395,4 pfet
M$166 \$17 hi_256_p vdd vdd pfet L=0.35U W=8U AS=8.8P AD=8.8P PS=18.2U PD=18.2U
* device instance $167 r0 *1 34.345,4 pfet
M$167 \$19 lo_256_p vdd vdd pfet L=0.35U W=8U AS=8.8P AD=8.8P PS=18.2U PD=18.2U
* device instance $168 r0 *1 37.26,5 pfet
M$168 pinp \$61 \$6 vdd pfet L=0.28U W=10U AS=11P AD=11P PS=22.2U PD=12.2U
* device instance $169 r0 *1 39.74,5 pfet
M$169 \$6 \$61 pinp vdd pfet L=0.28U W=10U AS=11P AD=11P PS=12.2U PD=22.2U
* device instance $170 r0 *1 42.62,5 pfet
M$170 vcm \$15 \$6 vdd pfet L=0.28U W=10U AS=11P AD=11P PS=22.2U PD=12.2U
* device instance $171 r0 *1 45.1,5 pfet
M$171 \$6 \$15 vcm vdd pfet L=0.28U W=10U AS=11P AD=11P PS=12.2U PD=22.2U
* device instance $172 r0 *1 47.98,5 pfet
M$172 vref \$17 \$6 vdd pfet L=0.28U W=10U AS=11P AD=11P PS=22.2U PD=12.2U
* device instance $173 r0 *1 50.46,5 pfet
M$173 \$6 \$17 vref vdd pfet L=0.28U W=10U AS=11P AD=11P PS=12.2U PD=22.2U
* device instance $174 r0 *1 53.34,5 pfet
M$174 vss \$19 \$6 vdd pfet L=0.28U W=10U AS=11P AD=11P PS=22.2U PD=12.2U
* device instance $175 r0 *1 55.82,5 pfet
M$175 \$6 \$19 vss vdd pfet L=0.28U W=10U AS=11P AD=11P PS=12.2U PD=22.2U
* device instance $176 r0 *1 83.855,4 pfet
M$176 \$63 sel_in vdd vdd pfet L=0.35U W=8U AS=8.8P AD=8.8P PS=18.2U PD=18.2U
* device instance $177 r0 *1 86.805,4 pfet
M$177 \$20 rel_128_p vdd vdd pfet L=0.35U W=8U AS=8.8P AD=8.8P PS=18.2U PD=18.2U
* device instance $178 r0 *1 89.755,4 pfet
M$178 \$22 hi_128_p vdd vdd pfet L=0.35U W=8U AS=8.8P AD=8.8P PS=18.2U PD=18.2U
* device instance $179 r0 *1 92.705,4 pfet
M$179 \$24 lo_128_p vdd vdd pfet L=0.35U W=8U AS=8.8P AD=8.8P PS=18.2U PD=18.2U
* device instance $180 r0 *1 95.62,5 pfet
M$180 pinp \$63 \$7 vdd pfet L=0.28U W=10U AS=11P AD=11P PS=22.2U PD=12.2U
* device instance $181 r0 *1 98.1,5 pfet
M$181 \$7 \$63 pinp vdd pfet L=0.28U W=10U AS=11P AD=11P PS=12.2U PD=22.2U
* device instance $182 r0 *1 100.98,5 pfet
M$182 vcm \$20 \$7 vdd pfet L=0.28U W=10U AS=11P AD=11P PS=22.2U PD=12.2U
* device instance $183 r0 *1 103.46,5 pfet
M$183 \$7 \$20 vcm vdd pfet L=0.28U W=10U AS=11P AD=11P PS=12.2U PD=22.2U
* device instance $184 r0 *1 106.34,5 pfet
M$184 vref \$22 \$7 vdd pfet L=0.28U W=10U AS=11P AD=11P PS=22.2U PD=12.2U
* device instance $185 r0 *1 108.82,5 pfet
M$185 \$7 \$22 vref vdd pfet L=0.28U W=10U AS=11P AD=11P PS=12.2U PD=22.2U
* device instance $186 r0 *1 111.7,5 pfet
M$186 vss \$24 \$7 vdd pfet L=0.28U W=10U AS=11P AD=11P PS=22.2U PD=12.2U
* device instance $187 r0 *1 114.18,5 pfet
M$187 \$7 \$24 vss vdd pfet L=0.28U W=10U AS=11P AD=11P PS=12.2U PD=22.2U
* device instance $188 r0 *1 142.215,4 pfet
M$188 \$65 sel_in vdd vdd pfet L=0.35U W=8U AS=8.8P AD=8.8P PS=18.2U PD=18.2U
* device instance $189 r0 *1 145.165,4 pfet
M$189 \$25 rel_64_p vdd vdd pfet L=0.35U W=8U AS=8.8P AD=8.8P PS=18.2U PD=18.2U
* device instance $190 r0 *1 148.115,4 pfet
M$190 \$27 hi_64_p vdd vdd pfet L=0.35U W=8U AS=8.8P AD=8.8P PS=18.2U PD=18.2U
* device instance $191 r0 *1 151.065,4 pfet
M$191 \$29 lo_64_p vdd vdd pfet L=0.35U W=8U AS=8.8P AD=8.8P PS=18.2U PD=18.2U
* device instance $192 r0 *1 153.98,5 pfet
M$192 pinp \$65 \$8 vdd pfet L=0.28U W=10U AS=11P AD=11P PS=22.2U PD=12.2U
* device instance $193 r0 *1 156.46,5 pfet
M$193 \$8 \$65 pinp vdd pfet L=0.28U W=10U AS=11P AD=11P PS=12.2U PD=22.2U
* device instance $194 r0 *1 159.34,5 pfet
M$194 vcm \$25 \$8 vdd pfet L=0.28U W=10U AS=11P AD=11P PS=22.2U PD=12.2U
* device instance $195 r0 *1 161.82,5 pfet
M$195 \$8 \$25 vcm vdd pfet L=0.28U W=10U AS=11P AD=11P PS=12.2U PD=22.2U
* device instance $196 r0 *1 164.7,5 pfet
M$196 vref \$27 \$8 vdd pfet L=0.28U W=10U AS=11P AD=11P PS=22.2U PD=12.2U
* device instance $197 r0 *1 167.18,5 pfet
M$197 \$8 \$27 vref vdd pfet L=0.28U W=10U AS=11P AD=11P PS=12.2U PD=22.2U
* device instance $198 r0 *1 170.06,5 pfet
M$198 vss \$29 \$8 vdd pfet L=0.28U W=10U AS=11P AD=11P PS=22.2U PD=12.2U
* device instance $199 r0 *1 172.54,5 pfet
M$199 \$8 \$29 vss vdd pfet L=0.28U W=10U AS=11P AD=11P PS=12.2U PD=22.2U
* device instance $200 r0 *1 200.575,4 pfet
M$200 \$67 sel_in vdd vdd pfet L=0.35U W=8U AS=8.8P AD=8.8P PS=18.2U PD=18.2U
* device instance $201 r0 *1 203.525,4 pfet
M$201 \$30 rel_32_p vdd vdd pfet L=0.35U W=8U AS=8.8P AD=8.8P PS=18.2U PD=18.2U
* device instance $202 r0 *1 206.475,4 pfet
M$202 \$32 hi_32_p vdd vdd pfet L=0.35U W=8U AS=8.8P AD=8.8P PS=18.2U PD=18.2U
* device instance $203 r0 *1 209.425,4 pfet
M$203 \$34 lo_32_p vdd vdd pfet L=0.35U W=8U AS=8.8P AD=8.8P PS=18.2U PD=18.2U
* device instance $204 r0 *1 212.34,5 pfet
M$204 pinp \$67 \$9 vdd pfet L=0.28U W=10U AS=11P AD=11P PS=22.2U PD=12.2U
* device instance $205 r0 *1 214.82,5 pfet
M$205 \$9 \$67 pinp vdd pfet L=0.28U W=10U AS=11P AD=11P PS=12.2U PD=22.2U
* device instance $206 r0 *1 217.7,5 pfet
M$206 vcm \$30 \$9 vdd pfet L=0.28U W=10U AS=11P AD=11P PS=22.2U PD=12.2U
* device instance $207 r0 *1 220.18,5 pfet
M$207 \$9 \$30 vcm vdd pfet L=0.28U W=10U AS=11P AD=11P PS=12.2U PD=22.2U
* device instance $208 r0 *1 223.06,5 pfet
M$208 vref \$32 \$9 vdd pfet L=0.28U W=10U AS=11P AD=11P PS=22.2U PD=12.2U
* device instance $209 r0 *1 225.54,5 pfet
M$209 \$9 \$32 vref vdd pfet L=0.28U W=10U AS=11P AD=11P PS=12.2U PD=22.2U
* device instance $210 r0 *1 228.42,5 pfet
M$210 vss \$34 \$9 vdd pfet L=0.28U W=10U AS=11P AD=11P PS=22.2U PD=12.2U
* device instance $211 r0 *1 230.9,5 pfet
M$211 \$9 \$34 vss vdd pfet L=0.28U W=10U AS=11P AD=11P PS=12.2U PD=22.2U
* device instance $212 r0 *1 258.935,4 pfet
M$212 \$69 sel_in vdd vdd pfet L=0.35U W=8U AS=8.8P AD=8.8P PS=18.2U PD=18.2U
* device instance $213 r0 *1 261.885,4 pfet
M$213 \$35 rel_16_p vdd vdd pfet L=0.35U W=8U AS=8.8P AD=8.8P PS=18.2U PD=18.2U
* device instance $214 r0 *1 264.835,4 pfet
M$214 \$37 hi_16_p vdd vdd pfet L=0.35U W=8U AS=8.8P AD=8.8P PS=18.2U PD=18.2U
* device instance $215 r0 *1 267.785,4 pfet
M$215 \$39 lo_16_p vdd vdd pfet L=0.35U W=8U AS=8.8P AD=8.8P PS=18.2U PD=18.2U
* device instance $216 r0 *1 270.7,5 pfet
M$216 pinp \$69 \$10 vdd pfet L=0.28U W=10U AS=11P AD=11P PS=22.2U PD=12.2U
* device instance $217 r0 *1 273.18,5 pfet
M$217 \$10 \$69 pinp vdd pfet L=0.28U W=10U AS=11P AD=11P PS=12.2U PD=22.2U
* device instance $218 r0 *1 276.06,5 pfet
M$218 vcm \$35 \$10 vdd pfet L=0.28U W=10U AS=11P AD=11P PS=22.2U PD=12.2U
* device instance $219 r0 *1 278.54,5 pfet
M$219 \$10 \$35 vcm vdd pfet L=0.28U W=10U AS=11P AD=11P PS=12.2U PD=22.2U
* device instance $220 r0 *1 281.42,5 pfet
M$220 vref \$37 \$10 vdd pfet L=0.28U W=10U AS=11P AD=11P PS=22.2U PD=12.2U
* device instance $221 r0 *1 283.9,5 pfet
M$221 \$10 \$37 vref vdd pfet L=0.28U W=10U AS=11P AD=11P PS=12.2U PD=22.2U
* device instance $222 r0 *1 286.78,5 pfet
M$222 vss \$39 \$10 vdd pfet L=0.28U W=10U AS=11P AD=11P PS=22.2U PD=12.2U
* device instance $223 r0 *1 289.26,5 pfet
M$223 \$10 \$39 vss vdd pfet L=0.28U W=10U AS=11P AD=11P PS=12.2U PD=22.2U
* device instance $224 r0 *1 317.295,4 pfet
M$224 \$71 sel_in vdd vdd pfet L=0.35U W=8U AS=8.8P AD=8.8P PS=18.2U PD=18.2U
* device instance $225 r0 *1 320.245,4 pfet
M$225 \$40 rel_8_p vdd vdd pfet L=0.35U W=8U AS=8.8P AD=8.8P PS=18.2U PD=18.2U
* device instance $226 r0 *1 323.195,4 pfet
M$226 \$42 hi_8_p vdd vdd pfet L=0.35U W=8U AS=8.8P AD=8.8P PS=18.2U PD=18.2U
* device instance $227 r0 *1 326.145,4 pfet
M$227 \$44 lo_8_p vdd vdd pfet L=0.35U W=8U AS=8.8P AD=8.8P PS=18.2U PD=18.2U
* device instance $228 r0 *1 329.06,5 pfet
M$228 pinp \$71 \$11 vdd pfet L=0.28U W=10U AS=11P AD=11P PS=22.2U PD=12.2U
* device instance $229 r0 *1 331.54,5 pfet
M$229 \$11 \$71 pinp vdd pfet L=0.28U W=10U AS=11P AD=11P PS=12.2U PD=22.2U
* device instance $230 r0 *1 334.42,5 pfet
M$230 vcm \$40 \$11 vdd pfet L=0.28U W=10U AS=11P AD=11P PS=22.2U PD=12.2U
* device instance $231 r0 *1 336.9,5 pfet
M$231 \$11 \$40 vcm vdd pfet L=0.28U W=10U AS=11P AD=11P PS=12.2U PD=22.2U
* device instance $232 r0 *1 339.78,5 pfet
M$232 vref \$42 \$11 vdd pfet L=0.28U W=10U AS=11P AD=11P PS=22.2U PD=12.2U
* device instance $233 r0 *1 342.26,5 pfet
M$233 \$11 \$42 vref vdd pfet L=0.28U W=10U AS=11P AD=11P PS=12.2U PD=22.2U
* device instance $234 r0 *1 345.14,5 pfet
M$234 vss \$44 \$11 vdd pfet L=0.28U W=10U AS=11P AD=11P PS=22.2U PD=12.2U
* device instance $235 r0 *1 347.62,5 pfet
M$235 \$11 \$44 vss vdd pfet L=0.28U W=10U AS=11P AD=11P PS=12.2U PD=22.2U
* device instance $236 r0 *1 375.655,4 pfet
M$236 \$73 sel_in vdd vdd pfet L=0.35U W=8U AS=8.8P AD=8.8P PS=18.2U PD=18.2U
* device instance $237 r0 *1 378.605,4 pfet
M$237 \$45 rel_4_p vdd vdd pfet L=0.35U W=8U AS=8.8P AD=8.8P PS=18.2U PD=18.2U
* device instance $238 r0 *1 381.555,4 pfet
M$238 \$47 hi_4_p vdd vdd pfet L=0.35U W=8U AS=8.8P AD=8.8P PS=18.2U PD=18.2U
* device instance $239 r0 *1 384.505,4 pfet
M$239 \$49 lo_4_p vdd vdd pfet L=0.35U W=8U AS=8.8P AD=8.8P PS=18.2U PD=18.2U
* device instance $240 r0 *1 387.42,5 pfet
M$240 pinp \$73 \$12 vdd pfet L=0.28U W=10U AS=11P AD=11P PS=22.2U PD=12.2U
* device instance $241 r0 *1 389.9,5 pfet
M$241 \$12 \$73 pinp vdd pfet L=0.28U W=10U AS=11P AD=11P PS=12.2U PD=22.2U
* device instance $242 r0 *1 392.78,5 pfet
M$242 vcm \$45 \$12 vdd pfet L=0.28U W=10U AS=11P AD=11P PS=22.2U PD=12.2U
* device instance $243 r0 *1 395.26,5 pfet
M$243 \$12 \$45 vcm vdd pfet L=0.28U W=10U AS=11P AD=11P PS=12.2U PD=22.2U
* device instance $244 r0 *1 398.14,5 pfet
M$244 vref \$47 \$12 vdd pfet L=0.28U W=10U AS=11P AD=11P PS=22.2U PD=12.2U
* device instance $245 r0 *1 400.62,5 pfet
M$245 \$12 \$47 vref vdd pfet L=0.28U W=10U AS=11P AD=11P PS=12.2U PD=22.2U
* device instance $246 r0 *1 403.5,5 pfet
M$246 vss \$49 \$12 vdd pfet L=0.28U W=10U AS=11P AD=11P PS=22.2U PD=12.2U
* device instance $247 r0 *1 405.98,5 pfet
M$247 \$12 \$49 vss vdd pfet L=0.28U W=10U AS=11P AD=11P PS=12.2U PD=22.2U
* device instance $248 r0 *1 434.015,4 pfet
M$248 \$75 sel_in vdd vdd pfet L=0.35U W=8U AS=8.8P AD=8.8P PS=18.2U PD=18.2U
* device instance $249 r0 *1 436.965,4 pfet
M$249 \$50 rel_2_p vdd vdd pfet L=0.35U W=8U AS=8.8P AD=8.8P PS=18.2U PD=18.2U
* device instance $250 r0 *1 439.915,4 pfet
M$250 \$52 hi_2_p vdd vdd pfet L=0.35U W=8U AS=8.8P AD=8.8P PS=18.2U PD=18.2U
* device instance $251 r0 *1 442.865,4 pfet
M$251 \$54 lo_2_p vdd vdd pfet L=0.35U W=8U AS=8.8P AD=8.8P PS=18.2U PD=18.2U
* device instance $252 r0 *1 445.78,5 pfet
M$252 pinp \$75 \$13 vdd pfet L=0.28U W=10U AS=11P AD=11P PS=22.2U PD=12.2U
* device instance $253 r0 *1 448.26,5 pfet
M$253 \$13 \$75 pinp vdd pfet L=0.28U W=10U AS=11P AD=11P PS=12.2U PD=22.2U
* device instance $254 r0 *1 451.14,5 pfet
M$254 vcm \$50 \$13 vdd pfet L=0.28U W=10U AS=11P AD=11P PS=22.2U PD=12.2U
* device instance $255 r0 *1 453.62,5 pfet
M$255 \$13 \$50 vcm vdd pfet L=0.28U W=10U AS=11P AD=11P PS=12.2U PD=22.2U
* device instance $256 r0 *1 456.5,5 pfet
M$256 vref \$52 \$13 vdd pfet L=0.28U W=10U AS=11P AD=11P PS=22.2U PD=12.2U
* device instance $257 r0 *1 458.98,5 pfet
M$257 \$13 \$52 vref vdd pfet L=0.28U W=10U AS=11P AD=11P PS=12.2U PD=22.2U
* device instance $258 r0 *1 461.86,5 pfet
M$258 vss \$54 \$13 vdd pfet L=0.28U W=10U AS=11P AD=11P PS=22.2U PD=12.2U
* device instance $259 r0 *1 464.34,5 pfet
M$259 \$13 \$54 vss vdd pfet L=0.28U W=10U AS=11P AD=11P PS=12.2U PD=22.2U
* device instance $260 r0 *1 492.375,4 pfet
M$260 \$77 sel_in vdd vdd pfet L=0.35U W=8U AS=8.8P AD=8.8P PS=18.2U PD=18.2U
* device instance $261 r0 *1 495.325,4 pfet
M$261 \$55 rel_1_p vdd vdd pfet L=0.35U W=8U AS=8.8P AD=8.8P PS=18.2U PD=18.2U
* device instance $262 r0 *1 498.275,4 pfet
M$262 \$57 hi_1_p vdd vdd pfet L=0.35U W=8U AS=8.8P AD=8.8P PS=18.2U PD=18.2U
* device instance $263 r0 *1 501.225,4 pfet
M$263 \$59 lo_1_p vdd vdd pfet L=0.35U W=8U AS=8.8P AD=8.8P PS=18.2U PD=18.2U
* device instance $264 r0 *1 504.14,5 pfet
M$264 pinp \$77 \$14 vdd pfet L=0.28U W=10U AS=11P AD=11P PS=22.2U PD=12.2U
* device instance $265 r0 *1 506.62,5 pfet
M$265 \$14 \$77 pinp vdd pfet L=0.28U W=10U AS=11P AD=11P PS=12.2U PD=22.2U
* device instance $266 r0 *1 509.5,5 pfet
M$266 vcm \$55 \$14 vdd pfet L=0.28U W=10U AS=11P AD=11P PS=22.2U PD=12.2U
* device instance $267 r0 *1 511.98,5 pfet
M$267 \$14 \$55 vcm vdd pfet L=0.28U W=10U AS=11P AD=11P PS=12.2U PD=22.2U
* device instance $268 r0 *1 514.86,5 pfet
M$268 vref \$57 \$14 vdd pfet L=0.28U W=10U AS=11P AD=11P PS=22.2U PD=12.2U
* device instance $269 r0 *1 517.34,5 pfet
M$269 \$14 \$57 vref vdd pfet L=0.28U W=10U AS=11P AD=11P PS=12.2U PD=22.2U
* device instance $270 r0 *1 520.22,5 pfet
M$270 vss \$59 \$14 vdd pfet L=0.28U W=10U AS=11P AD=11P PS=22.2U PD=12.2U
* device instance $271 r0 *1 522.7,5 pfet
M$271 \$14 \$59 vss vdd pfet L=0.28U W=10U AS=11P AD=11P PS=12.2U PD=22.2U
* device instance $272 r0 *1 25.495,28.96 pfet
M$272 \$79 sel_in vdd vdd pfet L=0.35U W=8U AS=8.8P AD=8.8P PS=18.2U PD=18.2U
* device instance $273 r0 *1 28.445,28.96 pfet
M$273 \$81 rel_256_n vdd vdd pfet L=0.35U W=8U AS=8.8P AD=8.8P PS=18.2U PD=18.2U
* device instance $274 r0 *1 31.395,28.96 pfet
M$274 \$83 hi_256_n vdd vdd pfet L=0.35U W=8U AS=8.8P AD=8.8P PS=18.2U PD=18.2U
* device instance $275 r0 *1 34.345,28.96 pfet
M$275 \$85 lo_256_n vdd vdd pfet L=0.35U W=8U AS=8.8P AD=8.8P PS=18.2U PD=18.2U
* device instance $276 r0 *1 37.26,29.96 pfet
M$276 pinn \$79 \$86 vdd pfet L=0.28U W=10U AS=11P AD=11P PS=22.2U PD=12.2U
* device instance $277 r0 *1 39.74,29.96 pfet
M$277 \$86 \$79 pinn vdd pfet L=0.28U W=10U AS=11P AD=11P PS=12.2U PD=22.2U
* device instance $278 r0 *1 42.62,29.96 pfet
M$278 vcm \$81 \$86 vdd pfet L=0.28U W=10U AS=11P AD=11P PS=22.2U PD=12.2U
* device instance $279 r0 *1 45.1,29.96 pfet
M$279 \$86 \$81 vcm vdd pfet L=0.28U W=10U AS=11P AD=11P PS=12.2U PD=22.2U
* device instance $280 r0 *1 47.98,29.96 pfet
M$280 vref \$83 \$86 vdd pfet L=0.28U W=10U AS=11P AD=11P PS=22.2U PD=12.2U
* device instance $281 r0 *1 50.46,29.96 pfet
M$281 \$86 \$83 vref vdd pfet L=0.28U W=10U AS=11P AD=11P PS=12.2U PD=22.2U
* device instance $282 r0 *1 53.34,29.96 pfet
M$282 vss \$85 \$86 vdd pfet L=0.28U W=10U AS=11P AD=11P PS=22.2U PD=12.2U
* device instance $283 r0 *1 55.82,29.96 pfet
M$283 \$86 \$85 vss vdd pfet L=0.28U W=10U AS=11P AD=11P PS=12.2U PD=22.2U
* device instance $284 r0 *1 83.855,28.96 pfet
M$284 \$88 sel_in vdd vdd pfet L=0.35U W=8U AS=8.8P AD=8.8P PS=18.2U PD=18.2U
* device instance $285 r0 *1 86.805,28.96 pfet
M$285 \$90 rel_128_n vdd vdd pfet L=0.35U W=8U AS=8.8P AD=8.8P PS=18.2U PD=18.2U
* device instance $286 r0 *1 89.755,28.96 pfet
M$286 \$92 hi_128_n vdd vdd pfet L=0.35U W=8U AS=8.8P AD=8.8P PS=18.2U PD=18.2U
* device instance $287 r0 *1 92.705,28.96 pfet
M$287 \$94 lo_128_n vdd vdd pfet L=0.35U W=8U AS=8.8P AD=8.8P PS=18.2U PD=18.2U
* device instance $288 r0 *1 95.62,29.96 pfet
M$288 pinn \$88 \$95 vdd pfet L=0.28U W=10U AS=11P AD=11P PS=22.2U PD=12.2U
* device instance $289 r0 *1 98.1,29.96 pfet
M$289 \$95 \$88 pinn vdd pfet L=0.28U W=10U AS=11P AD=11P PS=12.2U PD=22.2U
* device instance $290 r0 *1 100.98,29.96 pfet
M$290 vcm \$90 \$95 vdd pfet L=0.28U W=10U AS=11P AD=11P PS=22.2U PD=12.2U
* device instance $291 r0 *1 103.46,29.96 pfet
M$291 \$95 \$90 vcm vdd pfet L=0.28U W=10U AS=11P AD=11P PS=12.2U PD=22.2U
* device instance $292 r0 *1 106.34,29.96 pfet
M$292 vref \$92 \$95 vdd pfet L=0.28U W=10U AS=11P AD=11P PS=22.2U PD=12.2U
* device instance $293 r0 *1 108.82,29.96 pfet
M$293 \$95 \$92 vref vdd pfet L=0.28U W=10U AS=11P AD=11P PS=12.2U PD=22.2U
* device instance $294 r0 *1 111.7,29.96 pfet
M$294 vss \$94 \$95 vdd pfet L=0.28U W=10U AS=11P AD=11P PS=22.2U PD=12.2U
* device instance $295 r0 *1 114.18,29.96 pfet
M$295 \$95 \$94 vss vdd pfet L=0.28U W=10U AS=11P AD=11P PS=12.2U PD=22.2U
* device instance $296 r0 *1 142.215,28.96 pfet
M$296 \$96 sel_in vdd vdd pfet L=0.35U W=8U AS=8.8P AD=8.8P PS=18.2U PD=18.2U
* device instance $297 r0 *1 145.165,28.96 pfet
M$297 \$98 rel_64_n vdd vdd pfet L=0.35U W=8U AS=8.8P AD=8.8P PS=18.2U PD=18.2U
* device instance $298 r0 *1 148.115,28.96 pfet
M$298 \$100 hi_64_n vdd vdd pfet L=0.35U W=8U AS=8.8P AD=8.8P PS=18.2U PD=18.2U
* device instance $299 r0 *1 151.065,28.96 pfet
M$299 \$102 lo_64_n vdd vdd pfet L=0.35U W=8U AS=8.8P AD=8.8P PS=18.2U PD=18.2U
* device instance $300 r0 *1 153.98,29.96 pfet
M$300 pinn \$96 \$103 vdd pfet L=0.28U W=10U AS=11P AD=11P PS=22.2U PD=12.2U
* device instance $301 r0 *1 156.46,29.96 pfet
M$301 \$103 \$96 pinn vdd pfet L=0.28U W=10U AS=11P AD=11P PS=12.2U PD=22.2U
* device instance $302 r0 *1 159.34,29.96 pfet
M$302 vcm \$98 \$103 vdd pfet L=0.28U W=10U AS=11P AD=11P PS=22.2U PD=12.2U
* device instance $303 r0 *1 161.82,29.96 pfet
M$303 \$103 \$98 vcm vdd pfet L=0.28U W=10U AS=11P AD=11P PS=12.2U PD=22.2U
* device instance $304 r0 *1 164.7,29.96 pfet
M$304 vref \$100 \$103 vdd pfet L=0.28U W=10U AS=11P AD=11P PS=22.2U PD=12.2U
* device instance $305 r0 *1 167.18,29.96 pfet
M$305 \$103 \$100 vref vdd pfet L=0.28U W=10U AS=11P AD=11P PS=12.2U PD=22.2U
* device instance $306 r0 *1 170.06,29.96 pfet
M$306 vss \$102 \$103 vdd pfet L=0.28U W=10U AS=11P AD=11P PS=22.2U PD=12.2U
* device instance $307 r0 *1 172.54,29.96 pfet
M$307 \$103 \$102 vss vdd pfet L=0.28U W=10U AS=11P AD=11P PS=12.2U PD=22.2U
* device instance $308 r0 *1 200.575,28.96 pfet
M$308 \$104 sel_in vdd vdd pfet L=0.35U W=8U AS=8.8P AD=8.8P PS=18.2U PD=18.2U
* device instance $309 r0 *1 203.525,28.96 pfet
M$309 \$106 rel_32_n vdd vdd pfet L=0.35U W=8U AS=8.8P AD=8.8P PS=18.2U PD=18.2U
* device instance $310 r0 *1 206.475,28.96 pfet
M$310 \$108 hi_32_n vdd vdd pfet L=0.35U W=8U AS=8.8P AD=8.8P PS=18.2U PD=18.2U
* device instance $311 r0 *1 209.425,28.96 pfet
M$311 \$110 lo_32_n vdd vdd pfet L=0.35U W=8U AS=8.8P AD=8.8P PS=18.2U PD=18.2U
* device instance $312 r0 *1 212.34,29.96 pfet
M$312 pinn \$104 \$111 vdd pfet L=0.28U W=10U AS=11P AD=11P PS=22.2U PD=12.2U
* device instance $313 r0 *1 214.82,29.96 pfet
M$313 \$111 \$104 pinn vdd pfet L=0.28U W=10U AS=11P AD=11P PS=12.2U PD=22.2U
* device instance $314 r0 *1 217.7,29.96 pfet
M$314 vcm \$106 \$111 vdd pfet L=0.28U W=10U AS=11P AD=11P PS=22.2U PD=12.2U
* device instance $315 r0 *1 220.18,29.96 pfet
M$315 \$111 \$106 vcm vdd pfet L=0.28U W=10U AS=11P AD=11P PS=12.2U PD=22.2U
* device instance $316 r0 *1 223.06,29.96 pfet
M$316 vref \$108 \$111 vdd pfet L=0.28U W=10U AS=11P AD=11P PS=22.2U PD=12.2U
* device instance $317 r0 *1 225.54,29.96 pfet
M$317 \$111 \$108 vref vdd pfet L=0.28U W=10U AS=11P AD=11P PS=12.2U PD=22.2U
* device instance $318 r0 *1 228.42,29.96 pfet
M$318 vss \$110 \$111 vdd pfet L=0.28U W=10U AS=11P AD=11P PS=22.2U PD=12.2U
* device instance $319 r0 *1 230.9,29.96 pfet
M$319 \$111 \$110 vss vdd pfet L=0.28U W=10U AS=11P AD=11P PS=12.2U PD=22.2U
* device instance $320 r0 *1 258.935,28.96 pfet
M$320 \$112 sel_in vdd vdd pfet L=0.35U W=8U AS=8.8P AD=8.8P PS=18.2U PD=18.2U
* device instance $321 r0 *1 261.885,28.96 pfet
M$321 \$114 rel_16_n vdd vdd pfet L=0.35U W=8U AS=8.8P AD=8.8P PS=18.2U PD=18.2U
* device instance $322 r0 *1 264.835,28.96 pfet
M$322 \$116 hi_16_n vdd vdd pfet L=0.35U W=8U AS=8.8P AD=8.8P PS=18.2U PD=18.2U
* device instance $323 r0 *1 267.785,28.96 pfet
M$323 \$118 lo_16_n vdd vdd pfet L=0.35U W=8U AS=8.8P AD=8.8P PS=18.2U PD=18.2U
* device instance $324 r0 *1 270.7,29.96 pfet
M$324 pinn \$112 \$119 vdd pfet L=0.28U W=10U AS=11P AD=11P PS=22.2U PD=12.2U
* device instance $325 r0 *1 273.18,29.96 pfet
M$325 \$119 \$112 pinn vdd pfet L=0.28U W=10U AS=11P AD=11P PS=12.2U PD=22.2U
* device instance $326 r0 *1 276.06,29.96 pfet
M$326 vcm \$114 \$119 vdd pfet L=0.28U W=10U AS=11P AD=11P PS=22.2U PD=12.2U
* device instance $327 r0 *1 278.54,29.96 pfet
M$327 \$119 \$114 vcm vdd pfet L=0.28U W=10U AS=11P AD=11P PS=12.2U PD=22.2U
* device instance $328 r0 *1 281.42,29.96 pfet
M$328 vref \$116 \$119 vdd pfet L=0.28U W=10U AS=11P AD=11P PS=22.2U PD=12.2U
* device instance $329 r0 *1 283.9,29.96 pfet
M$329 \$119 \$116 vref vdd pfet L=0.28U W=10U AS=11P AD=11P PS=12.2U PD=22.2U
* device instance $330 r0 *1 286.78,29.96 pfet
M$330 vss \$118 \$119 vdd pfet L=0.28U W=10U AS=11P AD=11P PS=22.2U PD=12.2U
* device instance $331 r0 *1 289.26,29.96 pfet
M$331 \$119 \$118 vss vdd pfet L=0.28U W=10U AS=11P AD=11P PS=12.2U PD=22.2U
* device instance $332 r0 *1 317.295,28.96 pfet
M$332 \$120 sel_in vdd vdd pfet L=0.35U W=8U AS=8.8P AD=8.8P PS=18.2U PD=18.2U
* device instance $333 r0 *1 320.245,28.96 pfet
M$333 \$122 rel_8_n vdd vdd pfet L=0.35U W=8U AS=8.8P AD=8.8P PS=18.2U PD=18.2U
* device instance $334 r0 *1 323.195,28.96 pfet
M$334 \$124 hi_8_n vdd vdd pfet L=0.35U W=8U AS=8.8P AD=8.8P PS=18.2U PD=18.2U
* device instance $335 r0 *1 326.145,28.96 pfet
M$335 \$126 lo_8_n vdd vdd pfet L=0.35U W=8U AS=8.8P AD=8.8P PS=18.2U PD=18.2U
* device instance $336 r0 *1 329.06,29.96 pfet
M$336 pinn \$120 \$127 vdd pfet L=0.28U W=10U AS=11P AD=11P PS=22.2U PD=12.2U
* device instance $337 r0 *1 331.54,29.96 pfet
M$337 \$127 \$120 pinn vdd pfet L=0.28U W=10U AS=11P AD=11P PS=12.2U PD=22.2U
* device instance $338 r0 *1 334.42,29.96 pfet
M$338 vcm \$122 \$127 vdd pfet L=0.28U W=10U AS=11P AD=11P PS=22.2U PD=12.2U
* device instance $339 r0 *1 336.9,29.96 pfet
M$339 \$127 \$122 vcm vdd pfet L=0.28U W=10U AS=11P AD=11P PS=12.2U PD=22.2U
* device instance $340 r0 *1 339.78,29.96 pfet
M$340 vref \$124 \$127 vdd pfet L=0.28U W=10U AS=11P AD=11P PS=22.2U PD=12.2U
* device instance $341 r0 *1 342.26,29.96 pfet
M$341 \$127 \$124 vref vdd pfet L=0.28U W=10U AS=11P AD=11P PS=12.2U PD=22.2U
* device instance $342 r0 *1 345.14,29.96 pfet
M$342 vss \$126 \$127 vdd pfet L=0.28U W=10U AS=11P AD=11P PS=22.2U PD=12.2U
* device instance $343 r0 *1 347.62,29.96 pfet
M$343 \$127 \$126 vss vdd pfet L=0.28U W=10U AS=11P AD=11P PS=12.2U PD=22.2U
* device instance $344 r0 *1 375.655,28.96 pfet
M$344 \$128 sel_in vdd vdd pfet L=0.35U W=8U AS=8.8P AD=8.8P PS=18.2U PD=18.2U
* device instance $345 r0 *1 378.605,28.96 pfet
M$345 \$130 rel_4_n vdd vdd pfet L=0.35U W=8U AS=8.8P AD=8.8P PS=18.2U PD=18.2U
* device instance $346 r0 *1 381.555,28.96 pfet
M$346 \$132 hi_4_n vdd vdd pfet L=0.35U W=8U AS=8.8P AD=8.8P PS=18.2U PD=18.2U
* device instance $347 r0 *1 384.505,28.96 pfet
M$347 \$134 lo_4_n vdd vdd pfet L=0.35U W=8U AS=8.8P AD=8.8P PS=18.2U PD=18.2U
* device instance $348 r0 *1 387.42,29.96 pfet
M$348 pinn \$128 \$135 vdd pfet L=0.28U W=10U AS=11P AD=11P PS=22.2U PD=12.2U
* device instance $349 r0 *1 389.9,29.96 pfet
M$349 \$135 \$128 pinn vdd pfet L=0.28U W=10U AS=11P AD=11P PS=12.2U PD=22.2U
* device instance $350 r0 *1 392.78,29.96 pfet
M$350 vcm \$130 \$135 vdd pfet L=0.28U W=10U AS=11P AD=11P PS=22.2U PD=12.2U
* device instance $351 r0 *1 395.26,29.96 pfet
M$351 \$135 \$130 vcm vdd pfet L=0.28U W=10U AS=11P AD=11P PS=12.2U PD=22.2U
* device instance $352 r0 *1 398.14,29.96 pfet
M$352 vref \$132 \$135 vdd pfet L=0.28U W=10U AS=11P AD=11P PS=22.2U PD=12.2U
* device instance $353 r0 *1 400.62,29.96 pfet
M$353 \$135 \$132 vref vdd pfet L=0.28U W=10U AS=11P AD=11P PS=12.2U PD=22.2U
* device instance $354 r0 *1 403.5,29.96 pfet
M$354 vss \$134 \$135 vdd pfet L=0.28U W=10U AS=11P AD=11P PS=22.2U PD=12.2U
* device instance $355 r0 *1 405.98,29.96 pfet
M$355 \$135 \$134 vss vdd pfet L=0.28U W=10U AS=11P AD=11P PS=12.2U PD=22.2U
* device instance $356 r0 *1 434.015,28.96 pfet
M$356 \$136 sel_in vdd vdd pfet L=0.35U W=8U AS=8.8P AD=8.8P PS=18.2U PD=18.2U
* device instance $357 r0 *1 436.965,28.96 pfet
M$357 \$138 rel_2_n vdd vdd pfet L=0.35U W=8U AS=8.8P AD=8.8P PS=18.2U PD=18.2U
* device instance $358 r0 *1 439.915,28.96 pfet
M$358 \$140 hi_2_n vdd vdd pfet L=0.35U W=8U AS=8.8P AD=8.8P PS=18.2U PD=18.2U
* device instance $359 r0 *1 442.865,28.96 pfet
M$359 \$142 lo_2_n vdd vdd pfet L=0.35U W=8U AS=8.8P AD=8.8P PS=18.2U PD=18.2U
* device instance $360 r0 *1 445.78,29.96 pfet
M$360 pinn \$136 \$143 vdd pfet L=0.28U W=10U AS=11P AD=11P PS=22.2U PD=12.2U
* device instance $361 r0 *1 448.26,29.96 pfet
M$361 \$143 \$136 pinn vdd pfet L=0.28U W=10U AS=11P AD=11P PS=12.2U PD=22.2U
* device instance $362 r0 *1 451.14,29.96 pfet
M$362 vcm \$138 \$143 vdd pfet L=0.28U W=10U AS=11P AD=11P PS=22.2U PD=12.2U
* device instance $363 r0 *1 453.62,29.96 pfet
M$363 \$143 \$138 vcm vdd pfet L=0.28U W=10U AS=11P AD=11P PS=12.2U PD=22.2U
* device instance $364 r0 *1 456.5,29.96 pfet
M$364 vref \$140 \$143 vdd pfet L=0.28U W=10U AS=11P AD=11P PS=22.2U PD=12.2U
* device instance $365 r0 *1 458.98,29.96 pfet
M$365 \$143 \$140 vref vdd pfet L=0.28U W=10U AS=11P AD=11P PS=12.2U PD=22.2U
* device instance $366 r0 *1 461.86,29.96 pfet
M$366 vss \$142 \$143 vdd pfet L=0.28U W=10U AS=11P AD=11P PS=22.2U PD=12.2U
* device instance $367 r0 *1 464.34,29.96 pfet
M$367 \$143 \$142 vss vdd pfet L=0.28U W=10U AS=11P AD=11P PS=12.2U PD=22.2U
* device instance $368 r0 *1 492.375,28.96 pfet
M$368 \$144 sel_in vdd vdd pfet L=0.35U W=8U AS=8.8P AD=8.8P PS=18.2U PD=18.2U
* device instance $369 r0 *1 495.325,28.96 pfet
M$369 \$146 rel_1_n vdd vdd pfet L=0.35U W=8U AS=8.8P AD=8.8P PS=18.2U PD=18.2U
* device instance $370 r0 *1 498.275,28.96 pfet
M$370 \$148 hi_1_n vdd vdd pfet L=0.35U W=8U AS=8.8P AD=8.8P PS=18.2U PD=18.2U
* device instance $371 r0 *1 501.225,28.96 pfet
M$371 \$150 lo_1_n vdd vdd pfet L=0.35U W=8U AS=8.8P AD=8.8P PS=18.2U PD=18.2U
* device instance $372 r0 *1 504.14,29.96 pfet
M$372 pinn \$144 \$151 vdd pfet L=0.28U W=10U AS=11P AD=11P PS=22.2U PD=12.2U
* device instance $373 r0 *1 506.62,29.96 pfet
M$373 \$151 \$144 pinn vdd pfet L=0.28U W=10U AS=11P AD=11P PS=12.2U PD=22.2U
* device instance $374 r0 *1 509.5,29.96 pfet
M$374 vcm \$146 \$151 vdd pfet L=0.28U W=10U AS=11P AD=11P PS=22.2U PD=12.2U
* device instance $375 r0 *1 511.98,29.96 pfet
M$375 \$151 \$146 vcm vdd pfet L=0.28U W=10U AS=11P AD=11P PS=12.2U PD=22.2U
* device instance $376 r0 *1 514.86,29.96 pfet
M$376 vref \$148 \$151 vdd pfet L=0.28U W=10U AS=11P AD=11P PS=22.2U PD=12.2U
* device instance $377 r0 *1 517.34,29.96 pfet
M$377 \$151 \$148 vref vdd pfet L=0.28U W=10U AS=11P AD=11P PS=12.2U PD=22.2U
* device instance $378 r0 *1 520.22,29.96 pfet
M$378 vss \$150 \$151 vdd pfet L=0.28U W=10U AS=11P AD=11P PS=22.2U PD=12.2U
* device instance $379 r0 *1 522.7,29.96 pfet
M$379 \$151 \$150 vss vdd pfet L=0.28U W=10U AS=11P AD=11P PS=12.2U PD=22.2U
* device instance $380 r0 *1 450.805,53.92 pfet
M$380 \$168 tp_gn vdd vdd pfet L=0.35U W=8U AS=8.8P AD=8.8P PS=18.2U PD=18.2U
* device instance $381 r0 *1 453.72,59.92 pfet
M$381 vcm \$168 topp vdd pfet L=0.28U W=20U AS=22P AD=22P PS=42.2U PD=42.2U
* device instance $382 r0 *1 464.265,53.92 pfet
M$382 \$169 tp_gn vdd vdd pfet L=0.35U W=8U AS=8.8P AD=8.8P PS=18.2U PD=18.2U
* device instance $383 r0 *1 467.18,59.92 pfet
M$383 vcm \$169 topn vdd pfet L=0.28U W=20U AS=22P AD=22P PS=42.2U PD=42.2U
* device instance $384 r0 *1 515.255,49.58 pfet
M$384 \$161 \$160 vdd vdd pfet L=0.35U W=8U AS=8.8P AD=8.8P PS=18.2U PD=18.2U
* device instance $385 r0 *1 518.205,49.58 pfet
M$385 \$160 \$161 vdd vdd pfet L=0.35U W=8U AS=8.8P AD=8.8P PS=18.2U PD=18.2U
* device instance $386 r0 *1 521.155,47.58 pfet
M$386 \$161 cmpclk vdd vdd pfet L=0.35U W=4U AS=4.4P AD=4.4P PS=10.2U PD=10.2U
* device instance $387 r0 *1 524.105,47.58 pfet
M$387 \$160 cmpclk vdd vdd pfet L=0.35U W=4U AS=4.4P AD=4.4P PS=10.2U PD=10.2U
* device instance $388 r0 *1 527.055,46.58 pfet
M$388 \$158 cmpclk vdd vdd pfet L=0.35U W=2U AS=2.2P AD=2.2P PS=6.2U PD=6.2U
* device instance $389 r0 *1 530.005,46.58 pfet
M$389 \$159 cmpclk vdd vdd pfet L=0.35U W=2U AS=2.2P AD=2.2P PS=6.2U PD=6.2U
* device instance $390 r0 *1 537.705,46.58 pfet
M$390 \$162 \$161 vdd vdd pfet L=0.35U W=2U AS=2.2P AD=2.2P PS=6.2U PD=6.2U
* device instance $391 r0 *1 545.405,46.58 pfet
M$391 \$163 \$160 vdd vdd pfet L=0.35U W=2U AS=2.2P AD=2.2P PS=6.2U PD=6.2U
* device instance $392 r0 *1 556.055,49.58 pfet
M$392 \$166 \$163 vdd vdd pfet L=0.35U W=8U AS=8.8P AD=8.8P PS=18.2U PD=18.2U
* device instance $393 r0 *1 559.005,49.58 pfet
M$393 dout doutb \$166 vdd pfet L=0.35U W=8U AS=8.8P AD=8.8P PS=18.2U PD=18.2U
* device instance $394 r0 *1 569.655,49.58 pfet
M$394 \$167 \$162 vdd vdd pfet L=0.35U W=8U AS=8.8P AD=8.8P PS=18.2U PD=18.2U
* device instance $395 r0 *1 572.605,49.58 pfet
M$395 doutb dout \$167 vdd pfet L=0.35U W=8U AS=8.8P AD=8.8P PS=18.2U PD=18.2U
* device instance $396 r0 *1 2.6,52.52 cap_mim_2f0_m4m5_noshield
C$396 \$6 topp 3.56528e-14
* device instance $397 r0 *1 9,52.52 cap_mim_2f0_m4m5_noshield
C$397 \$13 topp 3.56528e-14
* device instance $398 r0 *1 15.4,52.52 cap_mim_2f0_m4m5_noshield
C$398 \$6 topp 3.56528e-14
* device instance $399 r0 *1 21.8,52.52 cap_mim_2f0_m4m5_noshield
C$399 \$12 topp 3.56528e-14
* device instance $400 r0 *1 28.2,52.52 cap_mim_2f0_m4m5_noshield
C$400 \$6 topp 3.56528e-14
* device instance $401 r0 *1 34.6,52.52 cap_mim_2f0_m4m5_noshield
C$401 \$11 topp 3.56528e-14
* device instance $402 r0 *1 41,52.52 cap_mim_2f0_m4m5_noshield
C$402 \$6 topp 3.56528e-14
* device instance $403 r0 *1 47.4,52.52 cap_mim_2f0_m4m5_noshield
C$403 \$11 topp 3.56528e-14
* device instance $404 r0 *1 53.8,52.52 cap_mim_2f0_m4m5_noshield
C$404 \$6 topp 3.56528e-14
* device instance $405 r0 *1 60.2,52.52 cap_mim_2f0_m4m5_noshield
C$405 \$10 topp 3.56528e-14
* device instance $406 r0 *1 66.6,52.52 cap_mim_2f0_m4m5_noshield
C$406 \$6 topp 3.56528e-14
* device instance $407 r0 *1 73,52.52 cap_mim_2f0_m4m5_noshield
C$407 \$10 topp 3.56528e-14
* device instance $408 r0 *1 79.4,52.52 cap_mim_2f0_m4m5_noshield
C$408 \$6 topp 3.56528e-14
* device instance $409 r0 *1 85.8,52.52 cap_mim_2f0_m4m5_noshield
C$409 \$10 topp 3.56528e-14
* device instance $410 r0 *1 92.2,52.52 cap_mim_2f0_m4m5_noshield
C$410 \$6 topp 3.56528e-14
* device instance $411 r0 *1 98.6,52.52 cap_mim_2f0_m4m5_noshield
C$411 \$10 topp 3.56528e-14
* device instance $412 r0 *1 105,52.52 cap_mim_2f0_m4m5_noshield
C$412 \$6 topp 3.56528e-14
* device instance $413 r0 *1 111.4,52.52 cap_mim_2f0_m4m5_noshield
C$413 \$9 topp 3.56528e-14
* device instance $414 r0 *1 117.8,52.52 cap_mim_2f0_m4m5_noshield
C$414 \$6 topp 3.56528e-14
* device instance $415 r0 *1 124.2,52.52 cap_mim_2f0_m4m5_noshield
C$415 \$9 topp 3.56528e-14
* device instance $416 r0 *1 130.6,52.52 cap_mim_2f0_m4m5_noshield
C$416 \$6 topp 3.56528e-14
* device instance $417 r0 *1 137,52.52 cap_mim_2f0_m4m5_noshield
C$417 \$9 topp 3.56528e-14
* device instance $418 r0 *1 143.4,52.52 cap_mim_2f0_m4m5_noshield
C$418 \$6 topp 3.56528e-14
* device instance $419 r0 *1 149.8,52.52 cap_mim_2f0_m4m5_noshield
C$419 \$9 topp 3.56528e-14
* device instance $420 r0 *1 156.2,52.52 cap_mim_2f0_m4m5_noshield
C$420 \$6 topp 3.56528e-14
* device instance $421 r0 *1 162.6,52.52 cap_mim_2f0_m4m5_noshield
C$421 \$9 topp 3.56528e-14
* device instance $422 r0 *1 169,52.52 cap_mim_2f0_m4m5_noshield
C$422 \$6 topp 3.56528e-14
* device instance $423 r0 *1 175.4,52.52 cap_mim_2f0_m4m5_noshield
C$423 \$9 topp 3.56528e-14
* device instance $424 r0 *1 181.8,52.52 cap_mim_2f0_m4m5_noshield
C$424 \$6 topp 3.56528e-14
* device instance $425 r0 *1 188.2,52.52 cap_mim_2f0_m4m5_noshield
C$425 \$9 topp 3.56528e-14
* device instance $426 r0 *1 194.6,52.52 cap_mim_2f0_m4m5_noshield
C$426 \$6 topp 3.56528e-14
* device instance $427 r0 *1 201,52.52 cap_mim_2f0_m4m5_noshield
C$427 \$9 topp 3.56528e-14
* device instance $428 r0 *1 224,52.52 cap_mim_2f0_m4m5_noshield
C$428 \$86 topn 3.56528e-14
* device instance $429 r0 *1 230.4,52.52 cap_mim_2f0_m4m5_noshield
C$429 \$143 topn 3.56528e-14
* device instance $430 r0 *1 236.8,52.52 cap_mim_2f0_m4m5_noshield
C$430 \$86 topn 3.56528e-14
* device instance $431 r0 *1 243.2,52.52 cap_mim_2f0_m4m5_noshield
C$431 \$135 topn 3.56528e-14
* device instance $432 r0 *1 249.6,52.52 cap_mim_2f0_m4m5_noshield
C$432 \$86 topn 3.56528e-14
* device instance $433 r0 *1 256,52.52 cap_mim_2f0_m4m5_noshield
C$433 \$127 topn 3.56528e-14
* device instance $434 r0 *1 262.4,52.52 cap_mim_2f0_m4m5_noshield
C$434 \$86 topn 3.56528e-14
* device instance $435 r0 *1 268.8,52.52 cap_mim_2f0_m4m5_noshield
C$435 \$127 topn 3.56528e-14
* device instance $436 r0 *1 275.2,52.52 cap_mim_2f0_m4m5_noshield
C$436 \$86 topn 3.56528e-14
* device instance $437 r0 *1 281.6,52.52 cap_mim_2f0_m4m5_noshield
C$437 \$119 topn 3.56528e-14
* device instance $438 r0 *1 288,52.52 cap_mim_2f0_m4m5_noshield
C$438 \$86 topn 3.56528e-14
* device instance $439 r0 *1 294.4,52.52 cap_mim_2f0_m4m5_noshield
C$439 \$119 topn 3.56528e-14
* device instance $440 r0 *1 300.8,52.52 cap_mim_2f0_m4m5_noshield
C$440 \$86 topn 3.56528e-14
* device instance $441 r0 *1 307.2,52.52 cap_mim_2f0_m4m5_noshield
C$441 \$119 topn 3.56528e-14
* device instance $442 r0 *1 313.6,52.52 cap_mim_2f0_m4m5_noshield
C$442 \$86 topn 3.56528e-14
* device instance $443 r0 *1 320,52.52 cap_mim_2f0_m4m5_noshield
C$443 \$119 topn 3.56528e-14
* device instance $444 r0 *1 326.4,52.52 cap_mim_2f0_m4m5_noshield
C$444 \$86 topn 3.56528e-14
* device instance $445 r0 *1 332.8,52.52 cap_mim_2f0_m4m5_noshield
C$445 \$111 topn 3.56528e-14
* device instance $446 r0 *1 339.2,52.52 cap_mim_2f0_m4m5_noshield
C$446 \$86 topn 3.56528e-14
* device instance $447 r0 *1 345.6,52.52 cap_mim_2f0_m4m5_noshield
C$447 \$111 topn 3.56528e-14
* device instance $448 r0 *1 352,52.52 cap_mim_2f0_m4m5_noshield
C$448 \$86 topn 3.56528e-14
* device instance $449 r0 *1 358.4,52.52 cap_mim_2f0_m4m5_noshield
C$449 \$111 topn 3.56528e-14
* device instance $450 r0 *1 364.8,52.52 cap_mim_2f0_m4m5_noshield
C$450 \$86 topn 3.56528e-14
* device instance $451 r0 *1 371.2,52.52 cap_mim_2f0_m4m5_noshield
C$451 \$111 topn 3.56528e-14
* device instance $452 r0 *1 377.6,52.52 cap_mim_2f0_m4m5_noshield
C$452 \$86 topn 3.56528e-14
* device instance $453 r0 *1 384,52.52 cap_mim_2f0_m4m5_noshield
C$453 \$111 topn 3.56528e-14
* device instance $454 r0 *1 390.4,52.52 cap_mim_2f0_m4m5_noshield
C$454 \$86 topn 3.56528e-14
* device instance $455 r0 *1 396.8,52.52 cap_mim_2f0_m4m5_noshield
C$455 \$111 topn 3.56528e-14
* device instance $456 r0 *1 403.2,52.52 cap_mim_2f0_m4m5_noshield
C$456 \$86 topn 3.56528e-14
* device instance $457 r0 *1 409.6,52.52 cap_mim_2f0_m4m5_noshield
C$457 \$111 topn 3.56528e-14
* device instance $458 r0 *1 416,52.52 cap_mim_2f0_m4m5_noshield
C$458 \$86 topn 3.56528e-14
* device instance $459 r0 *1 422.4,52.52 cap_mim_2f0_m4m5_noshield
C$459 \$111 topn 3.56528e-14
* device instance $460 r0 *1 2.6,58.92 cap_mim_2f0_m4m5_noshield
C$460 \$6 topp 3.56528e-14
* device instance $461 r0 *1 9,58.92 cap_mim_2f0_m4m5_noshield
C$461 \$8 topp 3.56528e-14
* device instance $462 r0 *1 15.4,58.92 cap_mim_2f0_m4m5_noshield
C$462 \$6 topp 3.56528e-14
* device instance $463 r0 *1 21.8,58.92 cap_mim_2f0_m4m5_noshield
C$463 \$8 topp 3.56528e-14
* device instance $464 r0 *1 28.2,58.92 cap_mim_2f0_m4m5_noshield
C$464 \$6 topp 3.56528e-14
* device instance $465 r0 *1 34.6,58.92 cap_mim_2f0_m4m5_noshield
C$465 \$8 topp 3.56528e-14
* device instance $466 r0 *1 41,58.92 cap_mim_2f0_m4m5_noshield
C$466 \$6 topp 3.56528e-14
* device instance $467 r0 *1 47.4,58.92 cap_mim_2f0_m4m5_noshield
C$467 \$8 topp 3.56528e-14
* device instance $468 r0 *1 53.8,58.92 cap_mim_2f0_m4m5_noshield
C$468 \$6 topp 3.56528e-14
* device instance $469 r0 *1 60.2,58.92 cap_mim_2f0_m4m5_noshield
C$469 \$8 topp 3.56528e-14
* device instance $470 r0 *1 66.6,58.92 cap_mim_2f0_m4m5_noshield
C$470 \$6 topp 3.56528e-14
* device instance $471 r0 *1 73,58.92 cap_mim_2f0_m4m5_noshield
C$471 \$8 topp 3.56528e-14
* device instance $472 r0 *1 79.4,58.92 cap_mim_2f0_m4m5_noshield
C$472 \$6 topp 3.56528e-14
* device instance $473 r0 *1 85.8,58.92 cap_mim_2f0_m4m5_noshield
C$473 \$8 topp 3.56528e-14
* device instance $474 r0 *1 92.2,58.92 cap_mim_2f0_m4m5_noshield
C$474 \$6 topp 3.56528e-14
* device instance $475 r0 *1 98.6,58.92 cap_mim_2f0_m4m5_noshield
C$475 \$8 topp 3.56528e-14
* device instance $476 r0 *1 105,58.92 cap_mim_2f0_m4m5_noshield
C$476 \$6 topp 3.56528e-14
* device instance $477 r0 *1 111.4,58.92 cap_mim_2f0_m4m5_noshield
C$477 \$8 topp 3.56528e-14
* device instance $478 r0 *1 117.8,58.92 cap_mim_2f0_m4m5_noshield
C$478 \$6 topp 3.56528e-14
* device instance $479 r0 *1 124.2,58.92 cap_mim_2f0_m4m5_noshield
C$479 \$8 topp 3.56528e-14
* device instance $480 r0 *1 130.6,58.92 cap_mim_2f0_m4m5_noshield
C$480 \$6 topp 3.56528e-14
* device instance $481 r0 *1 137,58.92 cap_mim_2f0_m4m5_noshield
C$481 \$8 topp 3.56528e-14
* device instance $482 r0 *1 143.4,58.92 cap_mim_2f0_m4m5_noshield
C$482 \$6 topp 3.56528e-14
* device instance $483 r0 *1 149.8,58.92 cap_mim_2f0_m4m5_noshield
C$483 \$8 topp 3.56528e-14
* device instance $484 r0 *1 156.2,58.92 cap_mim_2f0_m4m5_noshield
C$484 \$6 topp 3.56528e-14
* device instance $485 r0 *1 162.6,58.92 cap_mim_2f0_m4m5_noshield
C$485 \$8 topp 3.56528e-14
* device instance $486 r0 *1 169,58.92 cap_mim_2f0_m4m5_noshield
C$486 \$6 topp 3.56528e-14
* device instance $487 r0 *1 175.4,58.92 cap_mim_2f0_m4m5_noshield
C$487 \$8 topp 3.56528e-14
* device instance $488 r0 *1 181.8,58.92 cap_mim_2f0_m4m5_noshield
C$488 \$6 topp 3.56528e-14
* device instance $489 r0 *1 188.2,58.92 cap_mim_2f0_m4m5_noshield
C$489 \$8 topp 3.56528e-14
* device instance $490 r0 *1 194.6,58.92 cap_mim_2f0_m4m5_noshield
C$490 \$6 topp 3.56528e-14
* device instance $491 r0 *1 201,58.92 cap_mim_2f0_m4m5_noshield
C$491 \$8 topp 3.56528e-14
* device instance $492 r0 *1 224,58.92 cap_mim_2f0_m4m5_noshield
C$492 \$86 topn 3.56528e-14
* device instance $493 r0 *1 230.4,58.92 cap_mim_2f0_m4m5_noshield
C$493 \$103 topn 3.56528e-14
* device instance $494 r0 *1 236.8,58.92 cap_mim_2f0_m4m5_noshield
C$494 \$86 topn 3.56528e-14
* device instance $495 r0 *1 243.2,58.92 cap_mim_2f0_m4m5_noshield
C$495 \$103 topn 3.56528e-14
* device instance $496 r0 *1 249.6,58.92 cap_mim_2f0_m4m5_noshield
C$496 \$86 topn 3.56528e-14
* device instance $497 r0 *1 256,58.92 cap_mim_2f0_m4m5_noshield
C$497 \$103 topn 3.56528e-14
* device instance $498 r0 *1 262.4,58.92 cap_mim_2f0_m4m5_noshield
C$498 \$86 topn 3.56528e-14
* device instance $499 r0 *1 268.8,58.92 cap_mim_2f0_m4m5_noshield
C$499 \$103 topn 3.56528e-14
* device instance $500 r0 *1 275.2,58.92 cap_mim_2f0_m4m5_noshield
C$500 \$86 topn 3.56528e-14
* device instance $501 r0 *1 281.6,58.92 cap_mim_2f0_m4m5_noshield
C$501 \$103 topn 3.56528e-14
* device instance $502 r0 *1 288,58.92 cap_mim_2f0_m4m5_noshield
C$502 \$86 topn 3.56528e-14
* device instance $503 r0 *1 294.4,58.92 cap_mim_2f0_m4m5_noshield
C$503 \$103 topn 3.56528e-14
* device instance $504 r0 *1 300.8,58.92 cap_mim_2f0_m4m5_noshield
C$504 \$86 topn 3.56528e-14
* device instance $505 r0 *1 307.2,58.92 cap_mim_2f0_m4m5_noshield
C$505 \$103 topn 3.56528e-14
* device instance $506 r0 *1 313.6,58.92 cap_mim_2f0_m4m5_noshield
C$506 \$86 topn 3.56528e-14
* device instance $507 r0 *1 320,58.92 cap_mim_2f0_m4m5_noshield
C$507 \$103 topn 3.56528e-14
* device instance $508 r0 *1 326.4,58.92 cap_mim_2f0_m4m5_noshield
C$508 \$86 topn 3.56528e-14
* device instance $509 r0 *1 332.8,58.92 cap_mim_2f0_m4m5_noshield
C$509 \$103 topn 3.56528e-14
* device instance $510 r0 *1 339.2,58.92 cap_mim_2f0_m4m5_noshield
C$510 \$86 topn 3.56528e-14
* device instance $511 r0 *1 345.6,58.92 cap_mim_2f0_m4m5_noshield
C$511 \$103 topn 3.56528e-14
* device instance $512 r0 *1 352,58.92 cap_mim_2f0_m4m5_noshield
C$512 \$86 topn 3.56528e-14
* device instance $513 r0 *1 358.4,58.92 cap_mim_2f0_m4m5_noshield
C$513 \$103 topn 3.56528e-14
* device instance $514 r0 *1 364.8,58.92 cap_mim_2f0_m4m5_noshield
C$514 \$86 topn 3.56528e-14
* device instance $515 r0 *1 371.2,58.92 cap_mim_2f0_m4m5_noshield
C$515 \$103 topn 3.56528e-14
* device instance $516 r0 *1 377.6,58.92 cap_mim_2f0_m4m5_noshield
C$516 \$86 topn 3.56528e-14
* device instance $517 r0 *1 384,58.92 cap_mim_2f0_m4m5_noshield
C$517 \$103 topn 3.56528e-14
* device instance $518 r0 *1 390.4,58.92 cap_mim_2f0_m4m5_noshield
C$518 \$86 topn 3.56528e-14
* device instance $519 r0 *1 396.8,58.92 cap_mim_2f0_m4m5_noshield
C$519 \$103 topn 3.56528e-14
* device instance $520 r0 *1 403.2,58.92 cap_mim_2f0_m4m5_noshield
C$520 \$86 topn 3.56528e-14
* device instance $521 r0 *1 409.6,58.92 cap_mim_2f0_m4m5_noshield
C$521 \$103 topn 3.56528e-14
* device instance $522 r0 *1 416,58.92 cap_mim_2f0_m4m5_noshield
C$522 \$86 topn 3.56528e-14
* device instance $523 r0 *1 422.4,58.92 cap_mim_2f0_m4m5_noshield
C$523 \$103 topn 3.56528e-14
* device instance $524 r0 *1 2.6,65.32 cap_mim_2f0_m4m5_noshield
C$524 \$6 topp 3.56528e-14
* device instance $525 r0 *1 9,65.32 cap_mim_2f0_m4m5_noshield
C$525 \$7 topp 3.56528e-14
* device instance $526 r0 *1 15.4,65.32 cap_mim_2f0_m4m5_noshield
C$526 \$6 topp 3.56528e-14
* device instance $527 r0 *1 21.8,65.32 cap_mim_2f0_m4m5_noshield
C$527 \$7 topp 3.56528e-14
* device instance $528 r0 *1 28.2,65.32 cap_mim_2f0_m4m5_noshield
C$528 \$6 topp 3.56528e-14
* device instance $529 r0 *1 34.6,65.32 cap_mim_2f0_m4m5_noshield
C$529 \$7 topp 3.56528e-14
* device instance $530 r0 *1 41,65.32 cap_mim_2f0_m4m5_noshield
C$530 \$6 topp 3.56528e-14
* device instance $531 r0 *1 47.4,65.32 cap_mim_2f0_m4m5_noshield
C$531 \$7 topp 3.56528e-14
* device instance $532 r0 *1 53.8,65.32 cap_mim_2f0_m4m5_noshield
C$532 \$6 topp 3.56528e-14
* device instance $533 r0 *1 60.2,65.32 cap_mim_2f0_m4m5_noshield
C$533 \$7 topp 3.56528e-14
* device instance $534 r0 *1 66.6,65.32 cap_mim_2f0_m4m5_noshield
C$534 \$6 topp 3.56528e-14
* device instance $535 r0 *1 73,65.32 cap_mim_2f0_m4m5_noshield
C$535 \$7 topp 3.56528e-14
* device instance $536 r0 *1 79.4,65.32 cap_mim_2f0_m4m5_noshield
C$536 \$6 topp 3.56528e-14
* device instance $537 r0 *1 85.8,65.32 cap_mim_2f0_m4m5_noshield
C$537 \$7 topp 3.56528e-14
* device instance $538 r0 *1 92.2,65.32 cap_mim_2f0_m4m5_noshield
C$538 \$6 topp 3.56528e-14
* device instance $539 r0 *1 98.6,65.32 cap_mim_2f0_m4m5_noshield
C$539 \$7 topp 3.56528e-14
* device instance $540 r0 *1 105,65.32 cap_mim_2f0_m4m5_noshield
C$540 \$6 topp 3.56528e-14
* device instance $541 r0 *1 111.4,65.32 cap_mim_2f0_m4m5_noshield
C$541 \$7 topp 3.56528e-14
* device instance $542 r0 *1 117.8,65.32 cap_mim_2f0_m4m5_noshield
C$542 \$6 topp 3.56528e-14
* device instance $543 r0 *1 124.2,65.32 cap_mim_2f0_m4m5_noshield
C$543 \$7 topp 3.56528e-14
* device instance $544 r0 *1 130.6,65.32 cap_mim_2f0_m4m5_noshield
C$544 \$6 topp 3.56528e-14
* device instance $545 r0 *1 137,65.32 cap_mim_2f0_m4m5_noshield
C$545 \$7 topp 3.56528e-14
* device instance $546 r0 *1 143.4,65.32 cap_mim_2f0_m4m5_noshield
C$546 \$6 topp 3.56528e-14
* device instance $547 r0 *1 149.8,65.32 cap_mim_2f0_m4m5_noshield
C$547 \$7 topp 3.56528e-14
* device instance $548 r0 *1 156.2,65.32 cap_mim_2f0_m4m5_noshield
C$548 \$6 topp 3.56528e-14
* device instance $549 r0 *1 162.6,65.32 cap_mim_2f0_m4m5_noshield
C$549 \$7 topp 3.56528e-14
* device instance $550 r0 *1 169,65.32 cap_mim_2f0_m4m5_noshield
C$550 \$6 topp 3.56528e-14
* device instance $551 r0 *1 175.4,65.32 cap_mim_2f0_m4m5_noshield
C$551 \$7 topp 3.56528e-14
* device instance $552 r0 *1 181.8,65.32 cap_mim_2f0_m4m5_noshield
C$552 \$6 topp 3.56528e-14
* device instance $553 r0 *1 188.2,65.32 cap_mim_2f0_m4m5_noshield
C$553 \$7 topp 3.56528e-14
* device instance $554 r0 *1 194.6,65.32 cap_mim_2f0_m4m5_noshield
C$554 \$6 topp 3.56528e-14
* device instance $555 r0 *1 201,65.32 cap_mim_2f0_m4m5_noshield
C$555 \$7 topp 3.56528e-14
* device instance $556 r0 *1 224,65.32 cap_mim_2f0_m4m5_noshield
C$556 \$86 topn 3.56528e-14
* device instance $557 r0 *1 230.4,65.32 cap_mim_2f0_m4m5_noshield
C$557 \$95 topn 3.56528e-14
* device instance $558 r0 *1 236.8,65.32 cap_mim_2f0_m4m5_noshield
C$558 \$86 topn 3.56528e-14
* device instance $559 r0 *1 243.2,65.32 cap_mim_2f0_m4m5_noshield
C$559 \$95 topn 3.56528e-14
* device instance $560 r0 *1 249.6,65.32 cap_mim_2f0_m4m5_noshield
C$560 \$86 topn 3.56528e-14
* device instance $561 r0 *1 256,65.32 cap_mim_2f0_m4m5_noshield
C$561 \$95 topn 3.56528e-14
* device instance $562 r0 *1 262.4,65.32 cap_mim_2f0_m4m5_noshield
C$562 \$86 topn 3.56528e-14
* device instance $563 r0 *1 268.8,65.32 cap_mim_2f0_m4m5_noshield
C$563 \$95 topn 3.56528e-14
* device instance $564 r0 *1 275.2,65.32 cap_mim_2f0_m4m5_noshield
C$564 \$86 topn 3.56528e-14
* device instance $565 r0 *1 281.6,65.32 cap_mim_2f0_m4m5_noshield
C$565 \$95 topn 3.56528e-14
* device instance $566 r0 *1 288,65.32 cap_mim_2f0_m4m5_noshield
C$566 \$86 topn 3.56528e-14
* device instance $567 r0 *1 294.4,65.32 cap_mim_2f0_m4m5_noshield
C$567 \$95 topn 3.56528e-14
* device instance $568 r0 *1 300.8,65.32 cap_mim_2f0_m4m5_noshield
C$568 \$86 topn 3.56528e-14
* device instance $569 r0 *1 307.2,65.32 cap_mim_2f0_m4m5_noshield
C$569 \$95 topn 3.56528e-14
* device instance $570 r0 *1 313.6,65.32 cap_mim_2f0_m4m5_noshield
C$570 \$86 topn 3.56528e-14
* device instance $571 r0 *1 320,65.32 cap_mim_2f0_m4m5_noshield
C$571 \$95 topn 3.56528e-14
* device instance $572 r0 *1 326.4,65.32 cap_mim_2f0_m4m5_noshield
C$572 \$86 topn 3.56528e-14
* device instance $573 r0 *1 332.8,65.32 cap_mim_2f0_m4m5_noshield
C$573 \$95 topn 3.56528e-14
* device instance $574 r0 *1 339.2,65.32 cap_mim_2f0_m4m5_noshield
C$574 \$86 topn 3.56528e-14
* device instance $575 r0 *1 345.6,65.32 cap_mim_2f0_m4m5_noshield
C$575 \$95 topn 3.56528e-14
* device instance $576 r0 *1 352,65.32 cap_mim_2f0_m4m5_noshield
C$576 \$86 topn 3.56528e-14
* device instance $577 r0 *1 358.4,65.32 cap_mim_2f0_m4m5_noshield
C$577 \$95 topn 3.56528e-14
* device instance $578 r0 *1 364.8,65.32 cap_mim_2f0_m4m5_noshield
C$578 \$86 topn 3.56528e-14
* device instance $579 r0 *1 371.2,65.32 cap_mim_2f0_m4m5_noshield
C$579 \$95 topn 3.56528e-14
* device instance $580 r0 *1 377.6,65.32 cap_mim_2f0_m4m5_noshield
C$580 \$86 topn 3.56528e-14
* device instance $581 r0 *1 384,65.32 cap_mim_2f0_m4m5_noshield
C$581 \$95 topn 3.56528e-14
* device instance $582 r0 *1 390.4,65.32 cap_mim_2f0_m4m5_noshield
C$582 \$86 topn 3.56528e-14
* device instance $583 r0 *1 396.8,65.32 cap_mim_2f0_m4m5_noshield
C$583 \$95 topn 3.56528e-14
* device instance $584 r0 *1 403.2,65.32 cap_mim_2f0_m4m5_noshield
C$584 \$86 topn 3.56528e-14
* device instance $585 r0 *1 409.6,65.32 cap_mim_2f0_m4m5_noshield
C$585 \$95 topn 3.56528e-14
* device instance $586 r0 *1 416,65.32 cap_mim_2f0_m4m5_noshield
C$586 \$86 topn 3.56528e-14
* device instance $587 r0 *1 422.4,65.32 cap_mim_2f0_m4m5_noshield
C$587 \$95 topn 3.56528e-14
* device instance $588 r0 *1 2.6,71.72 cap_mim_2f0_m4m5_noshield
C$588 \$6 topp 3.56528e-14
* device instance $589 r0 *1 9,71.72 cap_mim_2f0_m4m5_noshield
C$589 \$7 topp 3.56528e-14
* device instance $590 r0 *1 15.4,71.72 cap_mim_2f0_m4m5_noshield
C$590 \$6 topp 3.56528e-14
* device instance $591 r0 *1 21.8,71.72 cap_mim_2f0_m4m5_noshield
C$591 \$7 topp 3.56528e-14
* device instance $592 r0 *1 28.2,71.72 cap_mim_2f0_m4m5_noshield
C$592 \$6 topp 3.56528e-14
* device instance $593 r0 *1 34.6,71.72 cap_mim_2f0_m4m5_noshield
C$593 \$7 topp 3.56528e-14
* device instance $594 r0 *1 41,71.72 cap_mim_2f0_m4m5_noshield
C$594 \$6 topp 3.56528e-14
* device instance $595 r0 *1 47.4,71.72 cap_mim_2f0_m4m5_noshield
C$595 \$7 topp 3.56528e-14
* device instance $596 r0 *1 53.8,71.72 cap_mim_2f0_m4m5_noshield
C$596 \$6 topp 3.56528e-14
* device instance $597 r0 *1 60.2,71.72 cap_mim_2f0_m4m5_noshield
C$597 \$7 topp 3.56528e-14
* device instance $598 r0 *1 66.6,71.72 cap_mim_2f0_m4m5_noshield
C$598 \$6 topp 3.56528e-14
* device instance $599 r0 *1 73,71.72 cap_mim_2f0_m4m5_noshield
C$599 \$7 topp 3.56528e-14
* device instance $600 r0 *1 79.4,71.72 cap_mim_2f0_m4m5_noshield
C$600 \$6 topp 3.56528e-14
* device instance $601 r0 *1 85.8,71.72 cap_mim_2f0_m4m5_noshield
C$601 \$7 topp 3.56528e-14
* device instance $602 r0 *1 92.2,71.72 cap_mim_2f0_m4m5_noshield
C$602 \$6 topp 3.56528e-14
* device instance $603 r0 *1 98.6,71.72 cap_mim_2f0_m4m5_noshield
C$603 \$7 topp 3.56528e-14
* device instance $604 r0 *1 105,71.72 cap_mim_2f0_m4m5_noshield
C$604 \$6 topp 3.56528e-14
* device instance $605 r0 *1 111.4,71.72 cap_mim_2f0_m4m5_noshield
C$605 \$7 topp 3.56528e-14
* device instance $606 r0 *1 117.8,71.72 cap_mim_2f0_m4m5_noshield
C$606 \$6 topp 3.56528e-14
* device instance $607 r0 *1 124.2,71.72 cap_mim_2f0_m4m5_noshield
C$607 \$7 topp 3.56528e-14
* device instance $608 r0 *1 130.6,71.72 cap_mim_2f0_m4m5_noshield
C$608 \$6 topp 3.56528e-14
* device instance $609 r0 *1 137,71.72 cap_mim_2f0_m4m5_noshield
C$609 \$7 topp 3.56528e-14
* device instance $610 r0 *1 143.4,71.72 cap_mim_2f0_m4m5_noshield
C$610 \$6 topp 3.56528e-14
* device instance $611 r0 *1 149.8,71.72 cap_mim_2f0_m4m5_noshield
C$611 \$7 topp 3.56528e-14
* device instance $612 r0 *1 156.2,71.72 cap_mim_2f0_m4m5_noshield
C$612 \$6 topp 3.56528e-14
* device instance $613 r0 *1 162.6,71.72 cap_mim_2f0_m4m5_noshield
C$613 \$7 topp 3.56528e-14
* device instance $614 r0 *1 169,71.72 cap_mim_2f0_m4m5_noshield
C$614 \$6 topp 3.56528e-14
* device instance $615 r0 *1 175.4,71.72 cap_mim_2f0_m4m5_noshield
C$615 \$7 topp 3.56528e-14
* device instance $616 r0 *1 181.8,71.72 cap_mim_2f0_m4m5_noshield
C$616 \$6 topp 3.56528e-14
* device instance $617 r0 *1 188.2,71.72 cap_mim_2f0_m4m5_noshield
C$617 \$7 topp 3.56528e-14
* device instance $618 r0 *1 194.6,71.72 cap_mim_2f0_m4m5_noshield
C$618 \$6 topp 3.56528e-14
* device instance $619 r0 *1 201,71.72 cap_mim_2f0_m4m5_noshield
C$619 \$7 topp 3.56528e-14
* device instance $620 r0 *1 224,71.72 cap_mim_2f0_m4m5_noshield
C$620 \$86 topn 3.56528e-14
* device instance $621 r0 *1 230.4,71.72 cap_mim_2f0_m4m5_noshield
C$621 \$95 topn 3.56528e-14
* device instance $622 r0 *1 236.8,71.72 cap_mim_2f0_m4m5_noshield
C$622 \$86 topn 3.56528e-14
* device instance $623 r0 *1 243.2,71.72 cap_mim_2f0_m4m5_noshield
C$623 \$95 topn 3.56528e-14
* device instance $624 r0 *1 249.6,71.72 cap_mim_2f0_m4m5_noshield
C$624 \$86 topn 3.56528e-14
* device instance $625 r0 *1 256,71.72 cap_mim_2f0_m4m5_noshield
C$625 \$95 topn 3.56528e-14
* device instance $626 r0 *1 262.4,71.72 cap_mim_2f0_m4m5_noshield
C$626 \$86 topn 3.56528e-14
* device instance $627 r0 *1 268.8,71.72 cap_mim_2f0_m4m5_noshield
C$627 \$95 topn 3.56528e-14
* device instance $628 r0 *1 275.2,71.72 cap_mim_2f0_m4m5_noshield
C$628 \$86 topn 3.56528e-14
* device instance $629 r0 *1 281.6,71.72 cap_mim_2f0_m4m5_noshield
C$629 \$95 topn 3.56528e-14
* device instance $630 r0 *1 288,71.72 cap_mim_2f0_m4m5_noshield
C$630 \$86 topn 3.56528e-14
* device instance $631 r0 *1 294.4,71.72 cap_mim_2f0_m4m5_noshield
C$631 \$95 topn 3.56528e-14
* device instance $632 r0 *1 300.8,71.72 cap_mim_2f0_m4m5_noshield
C$632 \$86 topn 3.56528e-14
* device instance $633 r0 *1 307.2,71.72 cap_mim_2f0_m4m5_noshield
C$633 \$95 topn 3.56528e-14
* device instance $634 r0 *1 313.6,71.72 cap_mim_2f0_m4m5_noshield
C$634 \$86 topn 3.56528e-14
* device instance $635 r0 *1 320,71.72 cap_mim_2f0_m4m5_noshield
C$635 \$95 topn 3.56528e-14
* device instance $636 r0 *1 326.4,71.72 cap_mim_2f0_m4m5_noshield
C$636 \$86 topn 3.56528e-14
* device instance $637 r0 *1 332.8,71.72 cap_mim_2f0_m4m5_noshield
C$637 \$95 topn 3.56528e-14
* device instance $638 r0 *1 339.2,71.72 cap_mim_2f0_m4m5_noshield
C$638 \$86 topn 3.56528e-14
* device instance $639 r0 *1 345.6,71.72 cap_mim_2f0_m4m5_noshield
C$639 \$95 topn 3.56528e-14
* device instance $640 r0 *1 352,71.72 cap_mim_2f0_m4m5_noshield
C$640 \$86 topn 3.56528e-14
* device instance $641 r0 *1 358.4,71.72 cap_mim_2f0_m4m5_noshield
C$641 \$95 topn 3.56528e-14
* device instance $642 r0 *1 364.8,71.72 cap_mim_2f0_m4m5_noshield
C$642 \$86 topn 3.56528e-14
* device instance $643 r0 *1 371.2,71.72 cap_mim_2f0_m4m5_noshield
C$643 \$95 topn 3.56528e-14
* device instance $644 r0 *1 377.6,71.72 cap_mim_2f0_m4m5_noshield
C$644 \$86 topn 3.56528e-14
* device instance $645 r0 *1 384,71.72 cap_mim_2f0_m4m5_noshield
C$645 \$95 topn 3.56528e-14
* device instance $646 r0 *1 390.4,71.72 cap_mim_2f0_m4m5_noshield
C$646 \$86 topn 3.56528e-14
* device instance $647 r0 *1 396.8,71.72 cap_mim_2f0_m4m5_noshield
C$647 \$95 topn 3.56528e-14
* device instance $648 r0 *1 403.2,71.72 cap_mim_2f0_m4m5_noshield
C$648 \$86 topn 3.56528e-14
* device instance $649 r0 *1 409.6,71.72 cap_mim_2f0_m4m5_noshield
C$649 \$95 topn 3.56528e-14
* device instance $650 r0 *1 416,71.72 cap_mim_2f0_m4m5_noshield
C$650 \$86 topn 3.56528e-14
* device instance $651 r0 *1 422.4,71.72 cap_mim_2f0_m4m5_noshield
C$651 \$95 topn 3.56528e-14
* device instance $652 r0 *1 2.6,78.12 cap_mim_2f0_m4m5_noshield
C$652 \$7 topp 3.56528e-14
* device instance $653 r0 *1 9,78.12 cap_mim_2f0_m4m5_noshield
C$653 \$6 topp 3.56528e-14
* device instance $654 r0 *1 15.4,78.12 cap_mim_2f0_m4m5_noshield
C$654 \$7 topp 3.56528e-14
* device instance $655 r0 *1 21.8,78.12 cap_mim_2f0_m4m5_noshield
C$655 \$6 topp 3.56528e-14
* device instance $656 r0 *1 28.2,78.12 cap_mim_2f0_m4m5_noshield
C$656 \$7 topp 3.56528e-14
* device instance $657 r0 *1 34.6,78.12 cap_mim_2f0_m4m5_noshield
C$657 \$6 topp 3.56528e-14
* device instance $658 r0 *1 41,78.12 cap_mim_2f0_m4m5_noshield
C$658 \$7 topp 3.56528e-14
* device instance $659 r0 *1 47.4,78.12 cap_mim_2f0_m4m5_noshield
C$659 \$6 topp 3.56528e-14
* device instance $660 r0 *1 53.8,78.12 cap_mim_2f0_m4m5_noshield
C$660 \$7 topp 3.56528e-14
* device instance $661 r0 *1 60.2,78.12 cap_mim_2f0_m4m5_noshield
C$661 \$6 topp 3.56528e-14
* device instance $662 r0 *1 66.6,78.12 cap_mim_2f0_m4m5_noshield
C$662 \$7 topp 3.56528e-14
* device instance $663 r0 *1 73,78.12 cap_mim_2f0_m4m5_noshield
C$663 \$6 topp 3.56528e-14
* device instance $664 r0 *1 79.4,78.12 cap_mim_2f0_m4m5_noshield
C$664 \$7 topp 3.56528e-14
* device instance $665 r0 *1 85.8,78.12 cap_mim_2f0_m4m5_noshield
C$665 \$6 topp 3.56528e-14
* device instance $666 r0 *1 92.2,78.12 cap_mim_2f0_m4m5_noshield
C$666 \$7 topp 3.56528e-14
* device instance $667 r0 *1 98.6,78.12 cap_mim_2f0_m4m5_noshield
C$667 \$6 topp 3.56528e-14
* device instance $668 r0 *1 105,78.12 cap_mim_2f0_m4m5_noshield
C$668 \$7 topp 3.56528e-14
* device instance $669 r0 *1 111.4,78.12 cap_mim_2f0_m4m5_noshield
C$669 \$6 topp 3.56528e-14
* device instance $670 r0 *1 117.8,78.12 cap_mim_2f0_m4m5_noshield
C$670 \$7 topp 3.56528e-14
* device instance $671 r0 *1 124.2,78.12 cap_mim_2f0_m4m5_noshield
C$671 \$6 topp 3.56528e-14
* device instance $672 r0 *1 130.6,78.12 cap_mim_2f0_m4m5_noshield
C$672 \$7 topp 3.56528e-14
* device instance $673 r0 *1 137,78.12 cap_mim_2f0_m4m5_noshield
C$673 \$6 topp 3.56528e-14
* device instance $674 r0 *1 143.4,78.12 cap_mim_2f0_m4m5_noshield
C$674 \$7 topp 3.56528e-14
* device instance $675 r0 *1 149.8,78.12 cap_mim_2f0_m4m5_noshield
C$675 \$6 topp 3.56528e-14
* device instance $676 r0 *1 156.2,78.12 cap_mim_2f0_m4m5_noshield
C$676 \$7 topp 3.56528e-14
* device instance $677 r0 *1 162.6,78.12 cap_mim_2f0_m4m5_noshield
C$677 \$6 topp 3.56528e-14
* device instance $678 r0 *1 169,78.12 cap_mim_2f0_m4m5_noshield
C$678 \$7 topp 3.56528e-14
* device instance $679 r0 *1 175.4,78.12 cap_mim_2f0_m4m5_noshield
C$679 \$6 topp 3.56528e-14
* device instance $680 r0 *1 181.8,78.12 cap_mim_2f0_m4m5_noshield
C$680 \$7 topp 3.56528e-14
* device instance $681 r0 *1 188.2,78.12 cap_mim_2f0_m4m5_noshield
C$681 \$6 topp 3.56528e-14
* device instance $682 r0 *1 194.6,78.12 cap_mim_2f0_m4m5_noshield
C$682 \$7 topp 3.56528e-14
* device instance $683 r0 *1 201,78.12 cap_mim_2f0_m4m5_noshield
C$683 \$6 topp 3.56528e-14
* device instance $684 r0 *1 224,78.12 cap_mim_2f0_m4m5_noshield
C$684 \$95 topn 3.56528e-14
* device instance $685 r0 *1 230.4,78.12 cap_mim_2f0_m4m5_noshield
C$685 \$86 topn 3.56528e-14
* device instance $686 r0 *1 236.8,78.12 cap_mim_2f0_m4m5_noshield
C$686 \$95 topn 3.56528e-14
* device instance $687 r0 *1 243.2,78.12 cap_mim_2f0_m4m5_noshield
C$687 \$86 topn 3.56528e-14
* device instance $688 r0 *1 249.6,78.12 cap_mim_2f0_m4m5_noshield
C$688 \$95 topn 3.56528e-14
* device instance $689 r0 *1 256,78.12 cap_mim_2f0_m4m5_noshield
C$689 \$86 topn 3.56528e-14
* device instance $690 r0 *1 262.4,78.12 cap_mim_2f0_m4m5_noshield
C$690 \$95 topn 3.56528e-14
* device instance $691 r0 *1 268.8,78.12 cap_mim_2f0_m4m5_noshield
C$691 \$86 topn 3.56528e-14
* device instance $692 r0 *1 275.2,78.12 cap_mim_2f0_m4m5_noshield
C$692 \$95 topn 3.56528e-14
* device instance $693 r0 *1 281.6,78.12 cap_mim_2f0_m4m5_noshield
C$693 \$86 topn 3.56528e-14
* device instance $694 r0 *1 288,78.12 cap_mim_2f0_m4m5_noshield
C$694 \$95 topn 3.56528e-14
* device instance $695 r0 *1 294.4,78.12 cap_mim_2f0_m4m5_noshield
C$695 \$86 topn 3.56528e-14
* device instance $696 r0 *1 300.8,78.12 cap_mim_2f0_m4m5_noshield
C$696 \$95 topn 3.56528e-14
* device instance $697 r0 *1 307.2,78.12 cap_mim_2f0_m4m5_noshield
C$697 \$86 topn 3.56528e-14
* device instance $698 r0 *1 313.6,78.12 cap_mim_2f0_m4m5_noshield
C$698 \$95 topn 3.56528e-14
* device instance $699 r0 *1 320,78.12 cap_mim_2f0_m4m5_noshield
C$699 \$86 topn 3.56528e-14
* device instance $700 r0 *1 326.4,78.12 cap_mim_2f0_m4m5_noshield
C$700 \$95 topn 3.56528e-14
* device instance $701 r0 *1 332.8,78.12 cap_mim_2f0_m4m5_noshield
C$701 \$86 topn 3.56528e-14
* device instance $702 r0 *1 339.2,78.12 cap_mim_2f0_m4m5_noshield
C$702 \$95 topn 3.56528e-14
* device instance $703 r0 *1 345.6,78.12 cap_mim_2f0_m4m5_noshield
C$703 \$86 topn 3.56528e-14
* device instance $704 r0 *1 352,78.12 cap_mim_2f0_m4m5_noshield
C$704 \$95 topn 3.56528e-14
* device instance $705 r0 *1 358.4,78.12 cap_mim_2f0_m4m5_noshield
C$705 \$86 topn 3.56528e-14
* device instance $706 r0 *1 364.8,78.12 cap_mim_2f0_m4m5_noshield
C$706 \$95 topn 3.56528e-14
* device instance $707 r0 *1 371.2,78.12 cap_mim_2f0_m4m5_noshield
C$707 \$86 topn 3.56528e-14
* device instance $708 r0 *1 377.6,78.12 cap_mim_2f0_m4m5_noshield
C$708 \$95 topn 3.56528e-14
* device instance $709 r0 *1 384,78.12 cap_mim_2f0_m4m5_noshield
C$709 \$86 topn 3.56528e-14
* device instance $710 r0 *1 390.4,78.12 cap_mim_2f0_m4m5_noshield
C$710 \$95 topn 3.56528e-14
* device instance $711 r0 *1 396.8,78.12 cap_mim_2f0_m4m5_noshield
C$711 \$86 topn 3.56528e-14
* device instance $712 r0 *1 403.2,78.12 cap_mim_2f0_m4m5_noshield
C$712 \$95 topn 3.56528e-14
* device instance $713 r0 *1 409.6,78.12 cap_mim_2f0_m4m5_noshield
C$713 \$86 topn 3.56528e-14
* device instance $714 r0 *1 416,78.12 cap_mim_2f0_m4m5_noshield
C$714 \$95 topn 3.56528e-14
* device instance $715 r0 *1 422.4,78.12 cap_mim_2f0_m4m5_noshield
C$715 \$86 topn 3.56528e-14
* device instance $716 r0 *1 2.6,84.52 cap_mim_2f0_m4m5_noshield
C$716 \$7 topp 3.56528e-14
* device instance $717 r0 *1 9,84.52 cap_mim_2f0_m4m5_noshield
C$717 \$6 topp 3.56528e-14
* device instance $718 r0 *1 15.4,84.52 cap_mim_2f0_m4m5_noshield
C$718 \$7 topp 3.56528e-14
* device instance $719 r0 *1 21.8,84.52 cap_mim_2f0_m4m5_noshield
C$719 \$6 topp 3.56528e-14
* device instance $720 r0 *1 28.2,84.52 cap_mim_2f0_m4m5_noshield
C$720 \$7 topp 3.56528e-14
* device instance $721 r0 *1 34.6,84.52 cap_mim_2f0_m4m5_noshield
C$721 \$6 topp 3.56528e-14
* device instance $722 r0 *1 41,84.52 cap_mim_2f0_m4m5_noshield
C$722 \$7 topp 3.56528e-14
* device instance $723 r0 *1 47.4,84.52 cap_mim_2f0_m4m5_noshield
C$723 \$6 topp 3.56528e-14
* device instance $724 r0 *1 53.8,84.52 cap_mim_2f0_m4m5_noshield
C$724 \$7 topp 3.56528e-14
* device instance $725 r0 *1 60.2,84.52 cap_mim_2f0_m4m5_noshield
C$725 \$6 topp 3.56528e-14
* device instance $726 r0 *1 66.6,84.52 cap_mim_2f0_m4m5_noshield
C$726 \$7 topp 3.56528e-14
* device instance $727 r0 *1 73,84.52 cap_mim_2f0_m4m5_noshield
C$727 \$6 topp 3.56528e-14
* device instance $728 r0 *1 79.4,84.52 cap_mim_2f0_m4m5_noshield
C$728 \$7 topp 3.56528e-14
* device instance $729 r0 *1 85.8,84.52 cap_mim_2f0_m4m5_noshield
C$729 \$6 topp 3.56528e-14
* device instance $730 r0 *1 92.2,84.52 cap_mim_2f0_m4m5_noshield
C$730 \$7 topp 3.56528e-14
* device instance $731 r0 *1 98.6,84.52 cap_mim_2f0_m4m5_noshield
C$731 \$6 topp 3.56528e-14
* device instance $732 r0 *1 105,84.52 cap_mim_2f0_m4m5_noshield
C$732 \$7 topp 3.56528e-14
* device instance $733 r0 *1 111.4,84.52 cap_mim_2f0_m4m5_noshield
C$733 \$6 topp 3.56528e-14
* device instance $734 r0 *1 117.8,84.52 cap_mim_2f0_m4m5_noshield
C$734 \$7 topp 3.56528e-14
* device instance $735 r0 *1 124.2,84.52 cap_mim_2f0_m4m5_noshield
C$735 \$6 topp 3.56528e-14
* device instance $736 r0 *1 130.6,84.52 cap_mim_2f0_m4m5_noshield
C$736 \$7 topp 3.56528e-14
* device instance $737 r0 *1 137,84.52 cap_mim_2f0_m4m5_noshield
C$737 \$6 topp 3.56528e-14
* device instance $738 r0 *1 143.4,84.52 cap_mim_2f0_m4m5_noshield
C$738 \$7 topp 3.56528e-14
* device instance $739 r0 *1 149.8,84.52 cap_mim_2f0_m4m5_noshield
C$739 \$6 topp 3.56528e-14
* device instance $740 r0 *1 156.2,84.52 cap_mim_2f0_m4m5_noshield
C$740 \$7 topp 3.56528e-14
* device instance $741 r0 *1 162.6,84.52 cap_mim_2f0_m4m5_noshield
C$741 \$6 topp 3.56528e-14
* device instance $742 r0 *1 169,84.52 cap_mim_2f0_m4m5_noshield
C$742 \$7 topp 3.56528e-14
* device instance $743 r0 *1 175.4,84.52 cap_mim_2f0_m4m5_noshield
C$743 \$6 topp 3.56528e-14
* device instance $744 r0 *1 181.8,84.52 cap_mim_2f0_m4m5_noshield
C$744 \$7 topp 3.56528e-14
* device instance $745 r0 *1 188.2,84.52 cap_mim_2f0_m4m5_noshield
C$745 \$6 topp 3.56528e-14
* device instance $746 r0 *1 194.6,84.52 cap_mim_2f0_m4m5_noshield
C$746 \$7 topp 3.56528e-14
* device instance $747 r0 *1 201,84.52 cap_mim_2f0_m4m5_noshield
C$747 \$6 topp 3.56528e-14
* device instance $748 r0 *1 224,84.52 cap_mim_2f0_m4m5_noshield
C$748 \$95 topn 3.56528e-14
* device instance $749 r0 *1 230.4,84.52 cap_mim_2f0_m4m5_noshield
C$749 \$86 topn 3.56528e-14
* device instance $750 r0 *1 236.8,84.52 cap_mim_2f0_m4m5_noshield
C$750 \$95 topn 3.56528e-14
* device instance $751 r0 *1 243.2,84.52 cap_mim_2f0_m4m5_noshield
C$751 \$86 topn 3.56528e-14
* device instance $752 r0 *1 249.6,84.52 cap_mim_2f0_m4m5_noshield
C$752 \$95 topn 3.56528e-14
* device instance $753 r0 *1 256,84.52 cap_mim_2f0_m4m5_noshield
C$753 \$86 topn 3.56528e-14
* device instance $754 r0 *1 262.4,84.52 cap_mim_2f0_m4m5_noshield
C$754 \$95 topn 3.56528e-14
* device instance $755 r0 *1 268.8,84.52 cap_mim_2f0_m4m5_noshield
C$755 \$86 topn 3.56528e-14
* device instance $756 r0 *1 275.2,84.52 cap_mim_2f0_m4m5_noshield
C$756 \$95 topn 3.56528e-14
* device instance $757 r0 *1 281.6,84.52 cap_mim_2f0_m4m5_noshield
C$757 \$86 topn 3.56528e-14
* device instance $758 r0 *1 288,84.52 cap_mim_2f0_m4m5_noshield
C$758 \$95 topn 3.56528e-14
* device instance $759 r0 *1 294.4,84.52 cap_mim_2f0_m4m5_noshield
C$759 \$86 topn 3.56528e-14
* device instance $760 r0 *1 300.8,84.52 cap_mim_2f0_m4m5_noshield
C$760 \$95 topn 3.56528e-14
* device instance $761 r0 *1 307.2,84.52 cap_mim_2f0_m4m5_noshield
C$761 \$86 topn 3.56528e-14
* device instance $762 r0 *1 313.6,84.52 cap_mim_2f0_m4m5_noshield
C$762 \$95 topn 3.56528e-14
* device instance $763 r0 *1 320,84.52 cap_mim_2f0_m4m5_noshield
C$763 \$86 topn 3.56528e-14
* device instance $764 r0 *1 326.4,84.52 cap_mim_2f0_m4m5_noshield
C$764 \$95 topn 3.56528e-14
* device instance $765 r0 *1 332.8,84.52 cap_mim_2f0_m4m5_noshield
C$765 \$86 topn 3.56528e-14
* device instance $766 r0 *1 339.2,84.52 cap_mim_2f0_m4m5_noshield
C$766 \$95 topn 3.56528e-14
* device instance $767 r0 *1 345.6,84.52 cap_mim_2f0_m4m5_noshield
C$767 \$86 topn 3.56528e-14
* device instance $768 r0 *1 352,84.52 cap_mim_2f0_m4m5_noshield
C$768 \$95 topn 3.56528e-14
* device instance $769 r0 *1 358.4,84.52 cap_mim_2f0_m4m5_noshield
C$769 \$86 topn 3.56528e-14
* device instance $770 r0 *1 364.8,84.52 cap_mim_2f0_m4m5_noshield
C$770 \$95 topn 3.56528e-14
* device instance $771 r0 *1 371.2,84.52 cap_mim_2f0_m4m5_noshield
C$771 \$86 topn 3.56528e-14
* device instance $772 r0 *1 377.6,84.52 cap_mim_2f0_m4m5_noshield
C$772 \$95 topn 3.56528e-14
* device instance $773 r0 *1 384,84.52 cap_mim_2f0_m4m5_noshield
C$773 \$86 topn 3.56528e-14
* device instance $774 r0 *1 390.4,84.52 cap_mim_2f0_m4m5_noshield
C$774 \$95 topn 3.56528e-14
* device instance $775 r0 *1 396.8,84.52 cap_mim_2f0_m4m5_noshield
C$775 \$86 topn 3.56528e-14
* device instance $776 r0 *1 403.2,84.52 cap_mim_2f0_m4m5_noshield
C$776 \$95 topn 3.56528e-14
* device instance $777 r0 *1 409.6,84.52 cap_mim_2f0_m4m5_noshield
C$777 \$86 topn 3.56528e-14
* device instance $778 r0 *1 416,84.52 cap_mim_2f0_m4m5_noshield
C$778 \$95 topn 3.56528e-14
* device instance $779 r0 *1 422.4,84.52 cap_mim_2f0_m4m5_noshield
C$779 \$86 topn 3.56528e-14
* device instance $780 r0 *1 2.6,90.92 cap_mim_2f0_m4m5_noshield
C$780 \$8 topp 3.56528e-14
* device instance $781 r0 *1 9,90.92 cap_mim_2f0_m4m5_noshield
C$781 \$6 topp 3.56528e-14
* device instance $782 r0 *1 15.4,90.92 cap_mim_2f0_m4m5_noshield
C$782 \$8 topp 3.56528e-14
* device instance $783 r0 *1 21.8,90.92 cap_mim_2f0_m4m5_noshield
C$783 \$6 topp 3.56528e-14
* device instance $784 r0 *1 28.2,90.92 cap_mim_2f0_m4m5_noshield
C$784 \$8 topp 3.56528e-14
* device instance $785 r0 *1 34.6,90.92 cap_mim_2f0_m4m5_noshield
C$785 \$6 topp 3.56528e-14
* device instance $786 r0 *1 41,90.92 cap_mim_2f0_m4m5_noshield
C$786 \$8 topp 3.56528e-14
* device instance $787 r0 *1 47.4,90.92 cap_mim_2f0_m4m5_noshield
C$787 \$6 topp 3.56528e-14
* device instance $788 r0 *1 53.8,90.92 cap_mim_2f0_m4m5_noshield
C$788 \$8 topp 3.56528e-14
* device instance $789 r0 *1 60.2,90.92 cap_mim_2f0_m4m5_noshield
C$789 \$6 topp 3.56528e-14
* device instance $790 r0 *1 66.6,90.92 cap_mim_2f0_m4m5_noshield
C$790 \$8 topp 3.56528e-14
* device instance $791 r0 *1 73,90.92 cap_mim_2f0_m4m5_noshield
C$791 \$6 topp 3.56528e-14
* device instance $792 r0 *1 79.4,90.92 cap_mim_2f0_m4m5_noshield
C$792 \$8 topp 3.56528e-14
* device instance $793 r0 *1 85.8,90.92 cap_mim_2f0_m4m5_noshield
C$793 \$6 topp 3.56528e-14
* device instance $794 r0 *1 92.2,90.92 cap_mim_2f0_m4m5_noshield
C$794 \$8 topp 3.56528e-14
* device instance $795 r0 *1 98.6,90.92 cap_mim_2f0_m4m5_noshield
C$795 \$6 topp 3.56528e-14
* device instance $796 r0 *1 105,90.92 cap_mim_2f0_m4m5_noshield
C$796 \$8 topp 3.56528e-14
* device instance $797 r0 *1 111.4,90.92 cap_mim_2f0_m4m5_noshield
C$797 \$6 topp 3.56528e-14
* device instance $798 r0 *1 117.8,90.92 cap_mim_2f0_m4m5_noshield
C$798 \$8 topp 3.56528e-14
* device instance $799 r0 *1 124.2,90.92 cap_mim_2f0_m4m5_noshield
C$799 \$6 topp 3.56528e-14
* device instance $800 r0 *1 130.6,90.92 cap_mim_2f0_m4m5_noshield
C$800 \$8 topp 3.56528e-14
* device instance $801 r0 *1 137,90.92 cap_mim_2f0_m4m5_noshield
C$801 \$6 topp 3.56528e-14
* device instance $802 r0 *1 143.4,90.92 cap_mim_2f0_m4m5_noshield
C$802 \$8 topp 3.56528e-14
* device instance $803 r0 *1 149.8,90.92 cap_mim_2f0_m4m5_noshield
C$803 \$6 topp 3.56528e-14
* device instance $804 r0 *1 156.2,90.92 cap_mim_2f0_m4m5_noshield
C$804 \$8 topp 3.56528e-14
* device instance $805 r0 *1 162.6,90.92 cap_mim_2f0_m4m5_noshield
C$805 \$6 topp 3.56528e-14
* device instance $806 r0 *1 169,90.92 cap_mim_2f0_m4m5_noshield
C$806 \$8 topp 3.56528e-14
* device instance $807 r0 *1 175.4,90.92 cap_mim_2f0_m4m5_noshield
C$807 \$6 topp 3.56528e-14
* device instance $808 r0 *1 181.8,90.92 cap_mim_2f0_m4m5_noshield
C$808 \$8 topp 3.56528e-14
* device instance $809 r0 *1 188.2,90.92 cap_mim_2f0_m4m5_noshield
C$809 \$6 topp 3.56528e-14
* device instance $810 r0 *1 194.6,90.92 cap_mim_2f0_m4m5_noshield
C$810 \$8 topp 3.56528e-14
* device instance $811 r0 *1 201,90.92 cap_mim_2f0_m4m5_noshield
C$811 \$6 topp 3.56528e-14
* device instance $812 r0 *1 224,90.92 cap_mim_2f0_m4m5_noshield
C$812 \$103 topn 3.56528e-14
* device instance $813 r0 *1 230.4,90.92 cap_mim_2f0_m4m5_noshield
C$813 \$86 topn 3.56528e-14
* device instance $814 r0 *1 236.8,90.92 cap_mim_2f0_m4m5_noshield
C$814 \$103 topn 3.56528e-14
* device instance $815 r0 *1 243.2,90.92 cap_mim_2f0_m4m5_noshield
C$815 \$86 topn 3.56528e-14
* device instance $816 r0 *1 249.6,90.92 cap_mim_2f0_m4m5_noshield
C$816 \$103 topn 3.56528e-14
* device instance $817 r0 *1 256,90.92 cap_mim_2f0_m4m5_noshield
C$817 \$86 topn 3.56528e-14
* device instance $818 r0 *1 262.4,90.92 cap_mim_2f0_m4m5_noshield
C$818 \$103 topn 3.56528e-14
* device instance $819 r0 *1 268.8,90.92 cap_mim_2f0_m4m5_noshield
C$819 \$86 topn 3.56528e-14
* device instance $820 r0 *1 275.2,90.92 cap_mim_2f0_m4m5_noshield
C$820 \$103 topn 3.56528e-14
* device instance $821 r0 *1 281.6,90.92 cap_mim_2f0_m4m5_noshield
C$821 \$86 topn 3.56528e-14
* device instance $822 r0 *1 288,90.92 cap_mim_2f0_m4m5_noshield
C$822 \$103 topn 3.56528e-14
* device instance $823 r0 *1 294.4,90.92 cap_mim_2f0_m4m5_noshield
C$823 \$86 topn 3.56528e-14
* device instance $824 r0 *1 300.8,90.92 cap_mim_2f0_m4m5_noshield
C$824 \$103 topn 3.56528e-14
* device instance $825 r0 *1 307.2,90.92 cap_mim_2f0_m4m5_noshield
C$825 \$86 topn 3.56528e-14
* device instance $826 r0 *1 313.6,90.92 cap_mim_2f0_m4m5_noshield
C$826 \$103 topn 3.56528e-14
* device instance $827 r0 *1 320,90.92 cap_mim_2f0_m4m5_noshield
C$827 \$86 topn 3.56528e-14
* device instance $828 r0 *1 326.4,90.92 cap_mim_2f0_m4m5_noshield
C$828 \$103 topn 3.56528e-14
* device instance $829 r0 *1 332.8,90.92 cap_mim_2f0_m4m5_noshield
C$829 \$86 topn 3.56528e-14
* device instance $830 r0 *1 339.2,90.92 cap_mim_2f0_m4m5_noshield
C$830 \$103 topn 3.56528e-14
* device instance $831 r0 *1 345.6,90.92 cap_mim_2f0_m4m5_noshield
C$831 \$86 topn 3.56528e-14
* device instance $832 r0 *1 352,90.92 cap_mim_2f0_m4m5_noshield
C$832 \$103 topn 3.56528e-14
* device instance $833 r0 *1 358.4,90.92 cap_mim_2f0_m4m5_noshield
C$833 \$86 topn 3.56528e-14
* device instance $834 r0 *1 364.8,90.92 cap_mim_2f0_m4m5_noshield
C$834 \$103 topn 3.56528e-14
* device instance $835 r0 *1 371.2,90.92 cap_mim_2f0_m4m5_noshield
C$835 \$86 topn 3.56528e-14
* device instance $836 r0 *1 377.6,90.92 cap_mim_2f0_m4m5_noshield
C$836 \$103 topn 3.56528e-14
* device instance $837 r0 *1 384,90.92 cap_mim_2f0_m4m5_noshield
C$837 \$86 topn 3.56528e-14
* device instance $838 r0 *1 390.4,90.92 cap_mim_2f0_m4m5_noshield
C$838 \$103 topn 3.56528e-14
* device instance $839 r0 *1 396.8,90.92 cap_mim_2f0_m4m5_noshield
C$839 \$86 topn 3.56528e-14
* device instance $840 r0 *1 403.2,90.92 cap_mim_2f0_m4m5_noshield
C$840 \$103 topn 3.56528e-14
* device instance $841 r0 *1 409.6,90.92 cap_mim_2f0_m4m5_noshield
C$841 \$86 topn 3.56528e-14
* device instance $842 r0 *1 416,90.92 cap_mim_2f0_m4m5_noshield
C$842 \$103 topn 3.56528e-14
* device instance $843 r0 *1 422.4,90.92 cap_mim_2f0_m4m5_noshield
C$843 \$86 topn 3.56528e-14
* device instance $844 r0 *1 2.6,97.32 cap_mim_2f0_m4m5_noshield
C$844 \$9 topp 3.56528e-14
* device instance $845 r0 *1 9,97.32 cap_mim_2f0_m4m5_noshield
C$845 \$6 topp 3.56528e-14
* device instance $846 r0 *1 15.4,97.32 cap_mim_2f0_m4m5_noshield
C$846 \$9 topp 3.56528e-14
* device instance $847 r0 *1 21.8,97.32 cap_mim_2f0_m4m5_noshield
C$847 \$6 topp 3.56528e-14
* device instance $848 r0 *1 28.2,97.32 cap_mim_2f0_m4m5_noshield
C$848 \$9 topp 3.56528e-14
* device instance $849 r0 *1 34.6,97.32 cap_mim_2f0_m4m5_noshield
C$849 \$6 topp 3.56528e-14
* device instance $850 r0 *1 41,97.32 cap_mim_2f0_m4m5_noshield
C$850 \$9 topp 3.56528e-14
* device instance $851 r0 *1 47.4,97.32 cap_mim_2f0_m4m5_noshield
C$851 \$6 topp 3.56528e-14
* device instance $852 r0 *1 53.8,97.32 cap_mim_2f0_m4m5_noshield
C$852 \$9 topp 3.56528e-14
* device instance $853 r0 *1 60.2,97.32 cap_mim_2f0_m4m5_noshield
C$853 \$6 topp 3.56528e-14
* device instance $854 r0 *1 66.6,97.32 cap_mim_2f0_m4m5_noshield
C$854 \$9 topp 3.56528e-14
* device instance $855 r0 *1 73,97.32 cap_mim_2f0_m4m5_noshield
C$855 \$6 topp 3.56528e-14
* device instance $856 r0 *1 79.4,97.32 cap_mim_2f0_m4m5_noshield
C$856 \$9 topp 3.56528e-14
* device instance $857 r0 *1 85.8,97.32 cap_mim_2f0_m4m5_noshield
C$857 \$6 topp 3.56528e-14
* device instance $858 r0 *1 92.2,97.32 cap_mim_2f0_m4m5_noshield
C$858 \$9 topp 3.56528e-14
* device instance $859 r0 *1 98.6,97.32 cap_mim_2f0_m4m5_noshield
C$859 \$6 topp 3.56528e-14
* device instance $860 r0 *1 105,97.32 cap_mim_2f0_m4m5_noshield
C$860 \$10 topp 3.56528e-14
* device instance $861 r0 *1 111.4,97.32 cap_mim_2f0_m4m5_noshield
C$861 \$6 topp 3.56528e-14
* device instance $862 r0 *1 117.8,97.32 cap_mim_2f0_m4m5_noshield
C$862 \$10 topp 3.56528e-14
* device instance $863 r0 *1 124.2,97.32 cap_mim_2f0_m4m5_noshield
C$863 \$6 topp 3.56528e-14
* device instance $864 r0 *1 130.6,97.32 cap_mim_2f0_m4m5_noshield
C$864 \$10 topp 3.56528e-14
* device instance $865 r0 *1 137,97.32 cap_mim_2f0_m4m5_noshield
C$865 \$6 topp 3.56528e-14
* device instance $866 r0 *1 143.4,97.32 cap_mim_2f0_m4m5_noshield
C$866 \$10 topp 3.56528e-14
* device instance $867 r0 *1 149.8,97.32 cap_mim_2f0_m4m5_noshield
C$867 \$6 topp 3.56528e-14
* device instance $868 r0 *1 156.2,97.32 cap_mim_2f0_m4m5_noshield
C$868 \$11 topp 3.56528e-14
* device instance $869 r0 *1 162.6,97.32 cap_mim_2f0_m4m5_noshield
C$869 \$6 topp 3.56528e-14
* device instance $870 r0 *1 169,97.32 cap_mim_2f0_m4m5_noshield
C$870 \$11 topp 3.56528e-14
* device instance $871 r0 *1 175.4,97.32 cap_mim_2f0_m4m5_noshield
C$871 \$6 topp 3.56528e-14
* device instance $872 r0 *1 181.8,97.32 cap_mim_2f0_m4m5_noshield
C$872 \$12 topp 3.56528e-14
* device instance $873 r0 *1 188.2,97.32 cap_mim_2f0_m4m5_noshield
C$873 \$6 topp 3.56528e-14
* device instance $874 r0 *1 194.6,97.32 cap_mim_2f0_m4m5_noshield
C$874 \$14 topp 3.56528e-14
* device instance $875 r0 *1 201,97.32 cap_mim_2f0_m4m5_noshield
C$875 \$6 topp 3.56528e-14
* device instance $876 r0 *1 224,97.32 cap_mim_2f0_m4m5_noshield
C$876 \$111 topn 3.56528e-14
* device instance $877 r0 *1 230.4,97.32 cap_mim_2f0_m4m5_noshield
C$877 \$86 topn 3.56528e-14
* device instance $878 r0 *1 236.8,97.32 cap_mim_2f0_m4m5_noshield
C$878 \$111 topn 3.56528e-14
* device instance $879 r0 *1 243.2,97.32 cap_mim_2f0_m4m5_noshield
C$879 \$86 topn 3.56528e-14
* device instance $880 r0 *1 249.6,97.32 cap_mim_2f0_m4m5_noshield
C$880 \$111 topn 3.56528e-14
* device instance $881 r0 *1 256,97.32 cap_mim_2f0_m4m5_noshield
C$881 \$86 topn 3.56528e-14
* device instance $882 r0 *1 262.4,97.32 cap_mim_2f0_m4m5_noshield
C$882 \$111 topn 3.56528e-14
* device instance $883 r0 *1 268.8,97.32 cap_mim_2f0_m4m5_noshield
C$883 \$86 topn 3.56528e-14
* device instance $884 r0 *1 275.2,97.32 cap_mim_2f0_m4m5_noshield
C$884 \$111 topn 3.56528e-14
* device instance $885 r0 *1 281.6,97.32 cap_mim_2f0_m4m5_noshield
C$885 \$86 topn 3.56528e-14
* device instance $886 r0 *1 288,97.32 cap_mim_2f0_m4m5_noshield
C$886 \$111 topn 3.56528e-14
* device instance $887 r0 *1 294.4,97.32 cap_mim_2f0_m4m5_noshield
C$887 \$86 topn 3.56528e-14
* device instance $888 r0 *1 300.8,97.32 cap_mim_2f0_m4m5_noshield
C$888 \$111 topn 3.56528e-14
* device instance $889 r0 *1 307.2,97.32 cap_mim_2f0_m4m5_noshield
C$889 \$86 topn 3.56528e-14
* device instance $890 r0 *1 313.6,97.32 cap_mim_2f0_m4m5_noshield
C$890 \$111 topn 3.56528e-14
* device instance $891 r0 *1 320,97.32 cap_mim_2f0_m4m5_noshield
C$891 \$86 topn 3.56528e-14
* device instance $892 r0 *1 326.4,97.32 cap_mim_2f0_m4m5_noshield
C$892 \$119 topn 3.56528e-14
* device instance $893 r0 *1 332.8,97.32 cap_mim_2f0_m4m5_noshield
C$893 \$86 topn 3.56528e-14
* device instance $894 r0 *1 339.2,97.32 cap_mim_2f0_m4m5_noshield
C$894 \$119 topn 3.56528e-14
* device instance $895 r0 *1 345.6,97.32 cap_mim_2f0_m4m5_noshield
C$895 \$86 topn 3.56528e-14
* device instance $896 r0 *1 352,97.32 cap_mim_2f0_m4m5_noshield
C$896 \$119 topn 3.56528e-14
* device instance $897 r0 *1 358.4,97.32 cap_mim_2f0_m4m5_noshield
C$897 \$86 topn 3.56528e-14
* device instance $898 r0 *1 364.8,97.32 cap_mim_2f0_m4m5_noshield
C$898 \$119 topn 3.56528e-14
* device instance $899 r0 *1 371.2,97.32 cap_mim_2f0_m4m5_noshield
C$899 \$86 topn 3.56528e-14
* device instance $900 r0 *1 377.6,97.32 cap_mim_2f0_m4m5_noshield
C$900 \$127 topn 3.56528e-14
* device instance $901 r0 *1 384,97.32 cap_mim_2f0_m4m5_noshield
C$901 \$86 topn 3.56528e-14
* device instance $902 r0 *1 390.4,97.32 cap_mim_2f0_m4m5_noshield
C$902 \$127 topn 3.56528e-14
* device instance $903 r0 *1 396.8,97.32 cap_mim_2f0_m4m5_noshield
C$903 \$86 topn 3.56528e-14
* device instance $904 r0 *1 403.2,97.32 cap_mim_2f0_m4m5_noshield
C$904 \$135 topn 3.56528e-14
* device instance $905 r0 *1 409.6,97.32 cap_mim_2f0_m4m5_noshield
C$905 \$86 topn 3.56528e-14
* device instance $906 r0 *1 416,97.32 cap_mim_2f0_m4m5_noshield
C$906 \$151 topn 3.56528e-14
* device instance $907 r0 *1 422.4,97.32 cap_mim_2f0_m4m5_noshield
C$907 \$86 topn 3.56528e-14
* device instance $908 r0 *1 2.6,103.72 cap_mim_2f0_m4m5_noshield
C$908 \$6 topp 3.56528e-14
* device instance $909 r0 *1 9,103.72 cap_mim_2f0_m4m5_noshield
C$909 vcm topp 3.56528e-14
* device instance $910 r0 *1 15.4,103.72 cap_mim_2f0_m4m5_noshield
C$910 \$6 topp 3.56528e-14
* device instance $911 r0 *1 21.8,103.72 cap_mim_2f0_m4m5_noshield
C$911 \$12 topp 3.56528e-14
* device instance $912 r0 *1 28.2,103.72 cap_mim_2f0_m4m5_noshield
C$912 \$6 topp 3.56528e-14
* device instance $913 r0 *1 34.6,103.72 cap_mim_2f0_m4m5_noshield
C$913 \$11 topp 3.56528e-14
* device instance $914 r0 *1 41,103.72 cap_mim_2f0_m4m5_noshield
C$914 \$6 topp 3.56528e-14
* device instance $915 r0 *1 47.4,103.72 cap_mim_2f0_m4m5_noshield
C$915 \$11 topp 3.56528e-14
* device instance $916 r0 *1 53.8,103.72 cap_mim_2f0_m4m5_noshield
C$916 \$6 topp 3.56528e-14
* device instance $917 r0 *1 60.2,103.72 cap_mim_2f0_m4m5_noshield
C$917 \$10 topp 3.56528e-14
* device instance $918 r0 *1 66.6,103.72 cap_mim_2f0_m4m5_noshield
C$918 \$6 topp 3.56528e-14
* device instance $919 r0 *1 73,103.72 cap_mim_2f0_m4m5_noshield
C$919 \$10 topp 3.56528e-14
* device instance $920 r0 *1 79.4,103.72 cap_mim_2f0_m4m5_noshield
C$920 \$6 topp 3.56528e-14
* device instance $921 r0 *1 85.8,103.72 cap_mim_2f0_m4m5_noshield
C$921 \$10 topp 3.56528e-14
* device instance $922 r0 *1 92.2,103.72 cap_mim_2f0_m4m5_noshield
C$922 \$6 topp 3.56528e-14
* device instance $923 r0 *1 98.6,103.72 cap_mim_2f0_m4m5_noshield
C$923 \$10 topp 3.56528e-14
* device instance $924 r0 *1 105,103.72 cap_mim_2f0_m4m5_noshield
C$924 \$6 topp 3.56528e-14
* device instance $925 r0 *1 111.4,103.72 cap_mim_2f0_m4m5_noshield
C$925 \$9 topp 3.56528e-14
* device instance $926 r0 *1 117.8,103.72 cap_mim_2f0_m4m5_noshield
C$926 \$6 topp 3.56528e-14
* device instance $927 r0 *1 124.2,103.72 cap_mim_2f0_m4m5_noshield
C$927 \$9 topp 3.56528e-14
* device instance $928 r0 *1 130.6,103.72 cap_mim_2f0_m4m5_noshield
C$928 \$6 topp 3.56528e-14
* device instance $929 r0 *1 137,103.72 cap_mim_2f0_m4m5_noshield
C$929 \$9 topp 3.56528e-14
* device instance $930 r0 *1 143.4,103.72 cap_mim_2f0_m4m5_noshield
C$930 \$6 topp 3.56528e-14
* device instance $931 r0 *1 149.8,103.72 cap_mim_2f0_m4m5_noshield
C$931 \$9 topp 3.56528e-14
* device instance $932 r0 *1 156.2,103.72 cap_mim_2f0_m4m5_noshield
C$932 \$6 topp 3.56528e-14
* device instance $933 r0 *1 162.6,103.72 cap_mim_2f0_m4m5_noshield
C$933 \$9 topp 3.56528e-14
* device instance $934 r0 *1 169,103.72 cap_mim_2f0_m4m5_noshield
C$934 \$6 topp 3.56528e-14
* device instance $935 r0 *1 175.4,103.72 cap_mim_2f0_m4m5_noshield
C$935 \$9 topp 3.56528e-14
* device instance $936 r0 *1 181.8,103.72 cap_mim_2f0_m4m5_noshield
C$936 \$6 topp 3.56528e-14
* device instance $937 r0 *1 188.2,103.72 cap_mim_2f0_m4m5_noshield
C$937 \$9 topp 3.56528e-14
* device instance $938 r0 *1 194.6,103.72 cap_mim_2f0_m4m5_noshield
C$938 \$6 topp 3.56528e-14
* device instance $939 r0 *1 201,103.72 cap_mim_2f0_m4m5_noshield
C$939 \$9 topp 3.56528e-14
* device instance $940 r0 *1 224,103.72 cap_mim_2f0_m4m5_noshield
C$940 \$86 topn 3.56528e-14
* device instance $941 r0 *1 230.4,103.72 cap_mim_2f0_m4m5_noshield
C$941 vcm topn 3.56528e-14
* device instance $942 r0 *1 236.8,103.72 cap_mim_2f0_m4m5_noshield
C$942 \$86 topn 3.56528e-14
* device instance $943 r0 *1 243.2,103.72 cap_mim_2f0_m4m5_noshield
C$943 \$135 topn 3.56528e-14
* device instance $944 r0 *1 249.6,103.72 cap_mim_2f0_m4m5_noshield
C$944 \$86 topn 3.56528e-14
* device instance $945 r0 *1 256,103.72 cap_mim_2f0_m4m5_noshield
C$945 \$127 topn 3.56528e-14
* device instance $946 r0 *1 262.4,103.72 cap_mim_2f0_m4m5_noshield
C$946 \$86 topn 3.56528e-14
* device instance $947 r0 *1 268.8,103.72 cap_mim_2f0_m4m5_noshield
C$947 \$127 topn 3.56528e-14
* device instance $948 r0 *1 275.2,103.72 cap_mim_2f0_m4m5_noshield
C$948 \$86 topn 3.56528e-14
* device instance $949 r0 *1 281.6,103.72 cap_mim_2f0_m4m5_noshield
C$949 \$119 topn 3.56528e-14
* device instance $950 r0 *1 288,103.72 cap_mim_2f0_m4m5_noshield
C$950 \$86 topn 3.56528e-14
* device instance $951 r0 *1 294.4,103.72 cap_mim_2f0_m4m5_noshield
C$951 \$119 topn 3.56528e-14
* device instance $952 r0 *1 300.8,103.72 cap_mim_2f0_m4m5_noshield
C$952 \$86 topn 3.56528e-14
* device instance $953 r0 *1 307.2,103.72 cap_mim_2f0_m4m5_noshield
C$953 \$119 topn 3.56528e-14
* device instance $954 r0 *1 313.6,103.72 cap_mim_2f0_m4m5_noshield
C$954 \$86 topn 3.56528e-14
* device instance $955 r0 *1 320,103.72 cap_mim_2f0_m4m5_noshield
C$955 \$119 topn 3.56528e-14
* device instance $956 r0 *1 326.4,103.72 cap_mim_2f0_m4m5_noshield
C$956 \$86 topn 3.56528e-14
* device instance $957 r0 *1 332.8,103.72 cap_mim_2f0_m4m5_noshield
C$957 \$111 topn 3.56528e-14
* device instance $958 r0 *1 339.2,103.72 cap_mim_2f0_m4m5_noshield
C$958 \$86 topn 3.56528e-14
* device instance $959 r0 *1 345.6,103.72 cap_mim_2f0_m4m5_noshield
C$959 \$111 topn 3.56528e-14
* device instance $960 r0 *1 352,103.72 cap_mim_2f0_m4m5_noshield
C$960 \$86 topn 3.56528e-14
* device instance $961 r0 *1 358.4,103.72 cap_mim_2f0_m4m5_noshield
C$961 \$111 topn 3.56528e-14
* device instance $962 r0 *1 364.8,103.72 cap_mim_2f0_m4m5_noshield
C$962 \$86 topn 3.56528e-14
* device instance $963 r0 *1 371.2,103.72 cap_mim_2f0_m4m5_noshield
C$963 \$111 topn 3.56528e-14
* device instance $964 r0 *1 377.6,103.72 cap_mim_2f0_m4m5_noshield
C$964 \$86 topn 3.56528e-14
* device instance $965 r0 *1 384,103.72 cap_mim_2f0_m4m5_noshield
C$965 \$111 topn 3.56528e-14
* device instance $966 r0 *1 390.4,103.72 cap_mim_2f0_m4m5_noshield
C$966 \$86 topn 3.56528e-14
* device instance $967 r0 *1 396.8,103.72 cap_mim_2f0_m4m5_noshield
C$967 \$111 topn 3.56528e-14
* device instance $968 r0 *1 403.2,103.72 cap_mim_2f0_m4m5_noshield
C$968 \$86 topn 3.56528e-14
* device instance $969 r0 *1 409.6,103.72 cap_mim_2f0_m4m5_noshield
C$969 \$111 topn 3.56528e-14
* device instance $970 r0 *1 416,103.72 cap_mim_2f0_m4m5_noshield
C$970 \$86 topn 3.56528e-14
* device instance $971 r0 *1 422.4,103.72 cap_mim_2f0_m4m5_noshield
C$971 \$111 topn 3.56528e-14
* device instance $972 r0 *1 2.6,110.12 cap_mim_2f0_m4m5_noshield
C$972 \$6 topp 3.56528e-14
* device instance $973 r0 *1 9,110.12 cap_mim_2f0_m4m5_noshield
C$973 \$8 topp 3.56528e-14
* device instance $974 r0 *1 15.4,110.12 cap_mim_2f0_m4m5_noshield
C$974 \$6 topp 3.56528e-14
* device instance $975 r0 *1 21.8,110.12 cap_mim_2f0_m4m5_noshield
C$975 \$8 topp 3.56528e-14
* device instance $976 r0 *1 28.2,110.12 cap_mim_2f0_m4m5_noshield
C$976 \$6 topp 3.56528e-14
* device instance $977 r0 *1 34.6,110.12 cap_mim_2f0_m4m5_noshield
C$977 \$8 topp 3.56528e-14
* device instance $978 r0 *1 41,110.12 cap_mim_2f0_m4m5_noshield
C$978 \$6 topp 3.56528e-14
* device instance $979 r0 *1 47.4,110.12 cap_mim_2f0_m4m5_noshield
C$979 \$8 topp 3.56528e-14
* device instance $980 r0 *1 53.8,110.12 cap_mim_2f0_m4m5_noshield
C$980 \$6 topp 3.56528e-14
* device instance $981 r0 *1 60.2,110.12 cap_mim_2f0_m4m5_noshield
C$981 \$8 topp 3.56528e-14
* device instance $982 r0 *1 66.6,110.12 cap_mim_2f0_m4m5_noshield
C$982 \$6 topp 3.56528e-14
* device instance $983 r0 *1 73,110.12 cap_mim_2f0_m4m5_noshield
C$983 \$8 topp 3.56528e-14
* device instance $984 r0 *1 79.4,110.12 cap_mim_2f0_m4m5_noshield
C$984 \$6 topp 3.56528e-14
* device instance $985 r0 *1 85.8,110.12 cap_mim_2f0_m4m5_noshield
C$985 \$8 topp 3.56528e-14
* device instance $986 r0 *1 92.2,110.12 cap_mim_2f0_m4m5_noshield
C$986 \$6 topp 3.56528e-14
* device instance $987 r0 *1 98.6,110.12 cap_mim_2f0_m4m5_noshield
C$987 \$8 topp 3.56528e-14
* device instance $988 r0 *1 105,110.12 cap_mim_2f0_m4m5_noshield
C$988 \$6 topp 3.56528e-14
* device instance $989 r0 *1 111.4,110.12 cap_mim_2f0_m4m5_noshield
C$989 \$8 topp 3.56528e-14
* device instance $990 r0 *1 117.8,110.12 cap_mim_2f0_m4m5_noshield
C$990 \$6 topp 3.56528e-14
* device instance $991 r0 *1 124.2,110.12 cap_mim_2f0_m4m5_noshield
C$991 \$8 topp 3.56528e-14
* device instance $992 r0 *1 130.6,110.12 cap_mim_2f0_m4m5_noshield
C$992 \$6 topp 3.56528e-14
* device instance $993 r0 *1 137,110.12 cap_mim_2f0_m4m5_noshield
C$993 \$8 topp 3.56528e-14
* device instance $994 r0 *1 143.4,110.12 cap_mim_2f0_m4m5_noshield
C$994 \$6 topp 3.56528e-14
* device instance $995 r0 *1 149.8,110.12 cap_mim_2f0_m4m5_noshield
C$995 \$8 topp 3.56528e-14
* device instance $996 r0 *1 156.2,110.12 cap_mim_2f0_m4m5_noshield
C$996 \$6 topp 3.56528e-14
* device instance $997 r0 *1 162.6,110.12 cap_mim_2f0_m4m5_noshield
C$997 \$8 topp 3.56528e-14
* device instance $998 r0 *1 169,110.12 cap_mim_2f0_m4m5_noshield
C$998 \$6 topp 3.56528e-14
* device instance $999 r0 *1 175.4,110.12 cap_mim_2f0_m4m5_noshield
C$999 \$8 topp 3.56528e-14
* device instance $1000 r0 *1 181.8,110.12 cap_mim_2f0_m4m5_noshield
C$1000 \$6 topp 3.56528e-14
* device instance $1001 r0 *1 188.2,110.12 cap_mim_2f0_m4m5_noshield
C$1001 \$8 topp 3.56528e-14
* device instance $1002 r0 *1 194.6,110.12 cap_mim_2f0_m4m5_noshield
C$1002 \$6 topp 3.56528e-14
* device instance $1003 r0 *1 201,110.12 cap_mim_2f0_m4m5_noshield
C$1003 \$8 topp 3.56528e-14
* device instance $1004 r0 *1 224,110.12 cap_mim_2f0_m4m5_noshield
C$1004 \$86 topn 3.56528e-14
* device instance $1005 r0 *1 230.4,110.12 cap_mim_2f0_m4m5_noshield
C$1005 \$103 topn 3.56528e-14
* device instance $1006 r0 *1 236.8,110.12 cap_mim_2f0_m4m5_noshield
C$1006 \$86 topn 3.56528e-14
* device instance $1007 r0 *1 243.2,110.12 cap_mim_2f0_m4m5_noshield
C$1007 \$103 topn 3.56528e-14
* device instance $1008 r0 *1 249.6,110.12 cap_mim_2f0_m4m5_noshield
C$1008 \$86 topn 3.56528e-14
* device instance $1009 r0 *1 256,110.12 cap_mim_2f0_m4m5_noshield
C$1009 \$103 topn 3.56528e-14
* device instance $1010 r0 *1 262.4,110.12 cap_mim_2f0_m4m5_noshield
C$1010 \$86 topn 3.56528e-14
* device instance $1011 r0 *1 268.8,110.12 cap_mim_2f0_m4m5_noshield
C$1011 \$103 topn 3.56528e-14
* device instance $1012 r0 *1 275.2,110.12 cap_mim_2f0_m4m5_noshield
C$1012 \$86 topn 3.56528e-14
* device instance $1013 r0 *1 281.6,110.12 cap_mim_2f0_m4m5_noshield
C$1013 \$103 topn 3.56528e-14
* device instance $1014 r0 *1 288,110.12 cap_mim_2f0_m4m5_noshield
C$1014 \$86 topn 3.56528e-14
* device instance $1015 r0 *1 294.4,110.12 cap_mim_2f0_m4m5_noshield
C$1015 \$103 topn 3.56528e-14
* device instance $1016 r0 *1 300.8,110.12 cap_mim_2f0_m4m5_noshield
C$1016 \$86 topn 3.56528e-14
* device instance $1017 r0 *1 307.2,110.12 cap_mim_2f0_m4m5_noshield
C$1017 \$103 topn 3.56528e-14
* device instance $1018 r0 *1 313.6,110.12 cap_mim_2f0_m4m5_noshield
C$1018 \$86 topn 3.56528e-14
* device instance $1019 r0 *1 320,110.12 cap_mim_2f0_m4m5_noshield
C$1019 \$103 topn 3.56528e-14
* device instance $1020 r0 *1 326.4,110.12 cap_mim_2f0_m4m5_noshield
C$1020 \$86 topn 3.56528e-14
* device instance $1021 r0 *1 332.8,110.12 cap_mim_2f0_m4m5_noshield
C$1021 \$103 topn 3.56528e-14
* device instance $1022 r0 *1 339.2,110.12 cap_mim_2f0_m4m5_noshield
C$1022 \$86 topn 3.56528e-14
* device instance $1023 r0 *1 345.6,110.12 cap_mim_2f0_m4m5_noshield
C$1023 \$103 topn 3.56528e-14
* device instance $1024 r0 *1 352,110.12 cap_mim_2f0_m4m5_noshield
C$1024 \$86 topn 3.56528e-14
* device instance $1025 r0 *1 358.4,110.12 cap_mim_2f0_m4m5_noshield
C$1025 \$103 topn 3.56528e-14
* device instance $1026 r0 *1 364.8,110.12 cap_mim_2f0_m4m5_noshield
C$1026 \$86 topn 3.56528e-14
* device instance $1027 r0 *1 371.2,110.12 cap_mim_2f0_m4m5_noshield
C$1027 \$103 topn 3.56528e-14
* device instance $1028 r0 *1 377.6,110.12 cap_mim_2f0_m4m5_noshield
C$1028 \$86 topn 3.56528e-14
* device instance $1029 r0 *1 384,110.12 cap_mim_2f0_m4m5_noshield
C$1029 \$103 topn 3.56528e-14
* device instance $1030 r0 *1 390.4,110.12 cap_mim_2f0_m4m5_noshield
C$1030 \$86 topn 3.56528e-14
* device instance $1031 r0 *1 396.8,110.12 cap_mim_2f0_m4m5_noshield
C$1031 \$103 topn 3.56528e-14
* device instance $1032 r0 *1 403.2,110.12 cap_mim_2f0_m4m5_noshield
C$1032 \$86 topn 3.56528e-14
* device instance $1033 r0 *1 409.6,110.12 cap_mim_2f0_m4m5_noshield
C$1033 \$103 topn 3.56528e-14
* device instance $1034 r0 *1 416,110.12 cap_mim_2f0_m4m5_noshield
C$1034 \$86 topn 3.56528e-14
* device instance $1035 r0 *1 422.4,110.12 cap_mim_2f0_m4m5_noshield
C$1035 \$103 topn 3.56528e-14
* device instance $1036 r0 *1 2.6,116.52 cap_mim_2f0_m4m5_noshield
C$1036 \$6 topp 3.56528e-14
* device instance $1037 r0 *1 9,116.52 cap_mim_2f0_m4m5_noshield
C$1037 \$7 topp 3.56528e-14
* device instance $1038 r0 *1 15.4,116.52 cap_mim_2f0_m4m5_noshield
C$1038 \$6 topp 3.56528e-14
* device instance $1039 r0 *1 21.8,116.52 cap_mim_2f0_m4m5_noshield
C$1039 \$7 topp 3.56528e-14
* device instance $1040 r0 *1 28.2,116.52 cap_mim_2f0_m4m5_noshield
C$1040 \$6 topp 3.56528e-14
* device instance $1041 r0 *1 34.6,116.52 cap_mim_2f0_m4m5_noshield
C$1041 \$7 topp 3.56528e-14
* device instance $1042 r0 *1 41,116.52 cap_mim_2f0_m4m5_noshield
C$1042 \$6 topp 3.56528e-14
* device instance $1043 r0 *1 47.4,116.52 cap_mim_2f0_m4m5_noshield
C$1043 \$7 topp 3.56528e-14
* device instance $1044 r0 *1 53.8,116.52 cap_mim_2f0_m4m5_noshield
C$1044 \$6 topp 3.56528e-14
* device instance $1045 r0 *1 60.2,116.52 cap_mim_2f0_m4m5_noshield
C$1045 \$7 topp 3.56528e-14
* device instance $1046 r0 *1 66.6,116.52 cap_mim_2f0_m4m5_noshield
C$1046 \$6 topp 3.56528e-14
* device instance $1047 r0 *1 73,116.52 cap_mim_2f0_m4m5_noshield
C$1047 \$7 topp 3.56528e-14
* device instance $1048 r0 *1 79.4,116.52 cap_mim_2f0_m4m5_noshield
C$1048 \$6 topp 3.56528e-14
* device instance $1049 r0 *1 85.8,116.52 cap_mim_2f0_m4m5_noshield
C$1049 \$7 topp 3.56528e-14
* device instance $1050 r0 *1 92.2,116.52 cap_mim_2f0_m4m5_noshield
C$1050 \$6 topp 3.56528e-14
* device instance $1051 r0 *1 98.6,116.52 cap_mim_2f0_m4m5_noshield
C$1051 \$7 topp 3.56528e-14
* device instance $1052 r0 *1 105,116.52 cap_mim_2f0_m4m5_noshield
C$1052 \$6 topp 3.56528e-14
* device instance $1053 r0 *1 111.4,116.52 cap_mim_2f0_m4m5_noshield
C$1053 \$7 topp 3.56528e-14
* device instance $1054 r0 *1 117.8,116.52 cap_mim_2f0_m4m5_noshield
C$1054 \$6 topp 3.56528e-14
* device instance $1055 r0 *1 124.2,116.52 cap_mim_2f0_m4m5_noshield
C$1055 \$7 topp 3.56528e-14
* device instance $1056 r0 *1 130.6,116.52 cap_mim_2f0_m4m5_noshield
C$1056 \$6 topp 3.56528e-14
* device instance $1057 r0 *1 137,116.52 cap_mim_2f0_m4m5_noshield
C$1057 \$7 topp 3.56528e-14
* device instance $1058 r0 *1 143.4,116.52 cap_mim_2f0_m4m5_noshield
C$1058 \$6 topp 3.56528e-14
* device instance $1059 r0 *1 149.8,116.52 cap_mim_2f0_m4m5_noshield
C$1059 \$7 topp 3.56528e-14
* device instance $1060 r0 *1 156.2,116.52 cap_mim_2f0_m4m5_noshield
C$1060 \$6 topp 3.56528e-14
* device instance $1061 r0 *1 162.6,116.52 cap_mim_2f0_m4m5_noshield
C$1061 \$7 topp 3.56528e-14
* device instance $1062 r0 *1 169,116.52 cap_mim_2f0_m4m5_noshield
C$1062 \$6 topp 3.56528e-14
* device instance $1063 r0 *1 175.4,116.52 cap_mim_2f0_m4m5_noshield
C$1063 \$7 topp 3.56528e-14
* device instance $1064 r0 *1 181.8,116.52 cap_mim_2f0_m4m5_noshield
C$1064 \$6 topp 3.56528e-14
* device instance $1065 r0 *1 188.2,116.52 cap_mim_2f0_m4m5_noshield
C$1065 \$7 topp 3.56528e-14
* device instance $1066 r0 *1 194.6,116.52 cap_mim_2f0_m4m5_noshield
C$1066 \$6 topp 3.56528e-14
* device instance $1067 r0 *1 201,116.52 cap_mim_2f0_m4m5_noshield
C$1067 \$7 topp 3.56528e-14
* device instance $1068 r0 *1 224,116.52 cap_mim_2f0_m4m5_noshield
C$1068 \$86 topn 3.56528e-14
* device instance $1069 r0 *1 230.4,116.52 cap_mim_2f0_m4m5_noshield
C$1069 \$95 topn 3.56528e-14
* device instance $1070 r0 *1 236.8,116.52 cap_mim_2f0_m4m5_noshield
C$1070 \$86 topn 3.56528e-14
* device instance $1071 r0 *1 243.2,116.52 cap_mim_2f0_m4m5_noshield
C$1071 \$95 topn 3.56528e-14
* device instance $1072 r0 *1 249.6,116.52 cap_mim_2f0_m4m5_noshield
C$1072 \$86 topn 3.56528e-14
* device instance $1073 r0 *1 256,116.52 cap_mim_2f0_m4m5_noshield
C$1073 \$95 topn 3.56528e-14
* device instance $1074 r0 *1 262.4,116.52 cap_mim_2f0_m4m5_noshield
C$1074 \$86 topn 3.56528e-14
* device instance $1075 r0 *1 268.8,116.52 cap_mim_2f0_m4m5_noshield
C$1075 \$95 topn 3.56528e-14
* device instance $1076 r0 *1 275.2,116.52 cap_mim_2f0_m4m5_noshield
C$1076 \$86 topn 3.56528e-14
* device instance $1077 r0 *1 281.6,116.52 cap_mim_2f0_m4m5_noshield
C$1077 \$95 topn 3.56528e-14
* device instance $1078 r0 *1 288,116.52 cap_mim_2f0_m4m5_noshield
C$1078 \$86 topn 3.56528e-14
* device instance $1079 r0 *1 294.4,116.52 cap_mim_2f0_m4m5_noshield
C$1079 \$95 topn 3.56528e-14
* device instance $1080 r0 *1 300.8,116.52 cap_mim_2f0_m4m5_noshield
C$1080 \$86 topn 3.56528e-14
* device instance $1081 r0 *1 307.2,116.52 cap_mim_2f0_m4m5_noshield
C$1081 \$95 topn 3.56528e-14
* device instance $1082 r0 *1 313.6,116.52 cap_mim_2f0_m4m5_noshield
C$1082 \$86 topn 3.56528e-14
* device instance $1083 r0 *1 320,116.52 cap_mim_2f0_m4m5_noshield
C$1083 \$95 topn 3.56528e-14
* device instance $1084 r0 *1 326.4,116.52 cap_mim_2f0_m4m5_noshield
C$1084 \$86 topn 3.56528e-14
* device instance $1085 r0 *1 332.8,116.52 cap_mim_2f0_m4m5_noshield
C$1085 \$95 topn 3.56528e-14
* device instance $1086 r0 *1 339.2,116.52 cap_mim_2f0_m4m5_noshield
C$1086 \$86 topn 3.56528e-14
* device instance $1087 r0 *1 345.6,116.52 cap_mim_2f0_m4m5_noshield
C$1087 \$95 topn 3.56528e-14
* device instance $1088 r0 *1 352,116.52 cap_mim_2f0_m4m5_noshield
C$1088 \$86 topn 3.56528e-14
* device instance $1089 r0 *1 358.4,116.52 cap_mim_2f0_m4m5_noshield
C$1089 \$95 topn 3.56528e-14
* device instance $1090 r0 *1 364.8,116.52 cap_mim_2f0_m4m5_noshield
C$1090 \$86 topn 3.56528e-14
* device instance $1091 r0 *1 371.2,116.52 cap_mim_2f0_m4m5_noshield
C$1091 \$95 topn 3.56528e-14
* device instance $1092 r0 *1 377.6,116.52 cap_mim_2f0_m4m5_noshield
C$1092 \$86 topn 3.56528e-14
* device instance $1093 r0 *1 384,116.52 cap_mim_2f0_m4m5_noshield
C$1093 \$95 topn 3.56528e-14
* device instance $1094 r0 *1 390.4,116.52 cap_mim_2f0_m4m5_noshield
C$1094 \$86 topn 3.56528e-14
* device instance $1095 r0 *1 396.8,116.52 cap_mim_2f0_m4m5_noshield
C$1095 \$95 topn 3.56528e-14
* device instance $1096 r0 *1 403.2,116.52 cap_mim_2f0_m4m5_noshield
C$1096 \$86 topn 3.56528e-14
* device instance $1097 r0 *1 409.6,116.52 cap_mim_2f0_m4m5_noshield
C$1097 \$95 topn 3.56528e-14
* device instance $1098 r0 *1 416,116.52 cap_mim_2f0_m4m5_noshield
C$1098 \$86 topn 3.56528e-14
* device instance $1099 r0 *1 422.4,116.52 cap_mim_2f0_m4m5_noshield
C$1099 \$95 topn 3.56528e-14
* device instance $1100 r0 *1 2.6,122.92 cap_mim_2f0_m4m5_noshield
C$1100 \$6 topp 3.56528e-14
* device instance $1101 r0 *1 9,122.92 cap_mim_2f0_m4m5_noshield
C$1101 \$7 topp 3.56528e-14
* device instance $1102 r0 *1 15.4,122.92 cap_mim_2f0_m4m5_noshield
C$1102 \$6 topp 3.56528e-14
* device instance $1103 r0 *1 21.8,122.92 cap_mim_2f0_m4m5_noshield
C$1103 \$7 topp 3.56528e-14
* device instance $1104 r0 *1 28.2,122.92 cap_mim_2f0_m4m5_noshield
C$1104 \$6 topp 3.56528e-14
* device instance $1105 r0 *1 34.6,122.92 cap_mim_2f0_m4m5_noshield
C$1105 \$7 topp 3.56528e-14
* device instance $1106 r0 *1 41,122.92 cap_mim_2f0_m4m5_noshield
C$1106 \$6 topp 3.56528e-14
* device instance $1107 r0 *1 47.4,122.92 cap_mim_2f0_m4m5_noshield
C$1107 \$7 topp 3.56528e-14
* device instance $1108 r0 *1 53.8,122.92 cap_mim_2f0_m4m5_noshield
C$1108 \$6 topp 3.56528e-14
* device instance $1109 r0 *1 60.2,122.92 cap_mim_2f0_m4m5_noshield
C$1109 \$7 topp 3.56528e-14
* device instance $1110 r0 *1 66.6,122.92 cap_mim_2f0_m4m5_noshield
C$1110 \$6 topp 3.56528e-14
* device instance $1111 r0 *1 73,122.92 cap_mim_2f0_m4m5_noshield
C$1111 \$7 topp 3.56528e-14
* device instance $1112 r0 *1 79.4,122.92 cap_mim_2f0_m4m5_noshield
C$1112 \$6 topp 3.56528e-14
* device instance $1113 r0 *1 85.8,122.92 cap_mim_2f0_m4m5_noshield
C$1113 \$7 topp 3.56528e-14
* device instance $1114 r0 *1 92.2,122.92 cap_mim_2f0_m4m5_noshield
C$1114 \$6 topp 3.56528e-14
* device instance $1115 r0 *1 98.6,122.92 cap_mim_2f0_m4m5_noshield
C$1115 \$7 topp 3.56528e-14
* device instance $1116 r0 *1 105,122.92 cap_mim_2f0_m4m5_noshield
C$1116 \$6 topp 3.56528e-14
* device instance $1117 r0 *1 111.4,122.92 cap_mim_2f0_m4m5_noshield
C$1117 \$7 topp 3.56528e-14
* device instance $1118 r0 *1 117.8,122.92 cap_mim_2f0_m4m5_noshield
C$1118 \$6 topp 3.56528e-14
* device instance $1119 r0 *1 124.2,122.92 cap_mim_2f0_m4m5_noshield
C$1119 \$7 topp 3.56528e-14
* device instance $1120 r0 *1 130.6,122.92 cap_mim_2f0_m4m5_noshield
C$1120 \$6 topp 3.56528e-14
* device instance $1121 r0 *1 137,122.92 cap_mim_2f0_m4m5_noshield
C$1121 \$7 topp 3.56528e-14
* device instance $1122 r0 *1 143.4,122.92 cap_mim_2f0_m4m5_noshield
C$1122 \$6 topp 3.56528e-14
* device instance $1123 r0 *1 149.8,122.92 cap_mim_2f0_m4m5_noshield
C$1123 \$7 topp 3.56528e-14
* device instance $1124 r0 *1 156.2,122.92 cap_mim_2f0_m4m5_noshield
C$1124 \$6 topp 3.56528e-14
* device instance $1125 r0 *1 162.6,122.92 cap_mim_2f0_m4m5_noshield
C$1125 \$7 topp 3.56528e-14
* device instance $1126 r0 *1 169,122.92 cap_mim_2f0_m4m5_noshield
C$1126 \$6 topp 3.56528e-14
* device instance $1127 r0 *1 175.4,122.92 cap_mim_2f0_m4m5_noshield
C$1127 \$7 topp 3.56528e-14
* device instance $1128 r0 *1 181.8,122.92 cap_mim_2f0_m4m5_noshield
C$1128 \$6 topp 3.56528e-14
* device instance $1129 r0 *1 188.2,122.92 cap_mim_2f0_m4m5_noshield
C$1129 \$7 topp 3.56528e-14
* device instance $1130 r0 *1 194.6,122.92 cap_mim_2f0_m4m5_noshield
C$1130 \$6 topp 3.56528e-14
* device instance $1131 r0 *1 201,122.92 cap_mim_2f0_m4m5_noshield
C$1131 \$7 topp 3.56528e-14
* device instance $1132 r0 *1 224,122.92 cap_mim_2f0_m4m5_noshield
C$1132 \$86 topn 3.56528e-14
* device instance $1133 r0 *1 230.4,122.92 cap_mim_2f0_m4m5_noshield
C$1133 \$95 topn 3.56528e-14
* device instance $1134 r0 *1 236.8,122.92 cap_mim_2f0_m4m5_noshield
C$1134 \$86 topn 3.56528e-14
* device instance $1135 r0 *1 243.2,122.92 cap_mim_2f0_m4m5_noshield
C$1135 \$95 topn 3.56528e-14
* device instance $1136 r0 *1 249.6,122.92 cap_mim_2f0_m4m5_noshield
C$1136 \$86 topn 3.56528e-14
* device instance $1137 r0 *1 256,122.92 cap_mim_2f0_m4m5_noshield
C$1137 \$95 topn 3.56528e-14
* device instance $1138 r0 *1 262.4,122.92 cap_mim_2f0_m4m5_noshield
C$1138 \$86 topn 3.56528e-14
* device instance $1139 r0 *1 268.8,122.92 cap_mim_2f0_m4m5_noshield
C$1139 \$95 topn 3.56528e-14
* device instance $1140 r0 *1 275.2,122.92 cap_mim_2f0_m4m5_noshield
C$1140 \$86 topn 3.56528e-14
* device instance $1141 r0 *1 281.6,122.92 cap_mim_2f0_m4m5_noshield
C$1141 \$95 topn 3.56528e-14
* device instance $1142 r0 *1 288,122.92 cap_mim_2f0_m4m5_noshield
C$1142 \$86 topn 3.56528e-14
* device instance $1143 r0 *1 294.4,122.92 cap_mim_2f0_m4m5_noshield
C$1143 \$95 topn 3.56528e-14
* device instance $1144 r0 *1 300.8,122.92 cap_mim_2f0_m4m5_noshield
C$1144 \$86 topn 3.56528e-14
* device instance $1145 r0 *1 307.2,122.92 cap_mim_2f0_m4m5_noshield
C$1145 \$95 topn 3.56528e-14
* device instance $1146 r0 *1 313.6,122.92 cap_mim_2f0_m4m5_noshield
C$1146 \$86 topn 3.56528e-14
* device instance $1147 r0 *1 320,122.92 cap_mim_2f0_m4m5_noshield
C$1147 \$95 topn 3.56528e-14
* device instance $1148 r0 *1 326.4,122.92 cap_mim_2f0_m4m5_noshield
C$1148 \$86 topn 3.56528e-14
* device instance $1149 r0 *1 332.8,122.92 cap_mim_2f0_m4m5_noshield
C$1149 \$95 topn 3.56528e-14
* device instance $1150 r0 *1 339.2,122.92 cap_mim_2f0_m4m5_noshield
C$1150 \$86 topn 3.56528e-14
* device instance $1151 r0 *1 345.6,122.92 cap_mim_2f0_m4m5_noshield
C$1151 \$95 topn 3.56528e-14
* device instance $1152 r0 *1 352,122.92 cap_mim_2f0_m4m5_noshield
C$1152 \$86 topn 3.56528e-14
* device instance $1153 r0 *1 358.4,122.92 cap_mim_2f0_m4m5_noshield
C$1153 \$95 topn 3.56528e-14
* device instance $1154 r0 *1 364.8,122.92 cap_mim_2f0_m4m5_noshield
C$1154 \$86 topn 3.56528e-14
* device instance $1155 r0 *1 371.2,122.92 cap_mim_2f0_m4m5_noshield
C$1155 \$95 topn 3.56528e-14
* device instance $1156 r0 *1 377.6,122.92 cap_mim_2f0_m4m5_noshield
C$1156 \$86 topn 3.56528e-14
* device instance $1157 r0 *1 384,122.92 cap_mim_2f0_m4m5_noshield
C$1157 \$95 topn 3.56528e-14
* device instance $1158 r0 *1 390.4,122.92 cap_mim_2f0_m4m5_noshield
C$1158 \$86 topn 3.56528e-14
* device instance $1159 r0 *1 396.8,122.92 cap_mim_2f0_m4m5_noshield
C$1159 \$95 topn 3.56528e-14
* device instance $1160 r0 *1 403.2,122.92 cap_mim_2f0_m4m5_noshield
C$1160 \$86 topn 3.56528e-14
* device instance $1161 r0 *1 409.6,122.92 cap_mim_2f0_m4m5_noshield
C$1161 \$95 topn 3.56528e-14
* device instance $1162 r0 *1 416,122.92 cap_mim_2f0_m4m5_noshield
C$1162 \$86 topn 3.56528e-14
* device instance $1163 r0 *1 422.4,122.92 cap_mim_2f0_m4m5_noshield
C$1163 \$95 topn 3.56528e-14
* device instance $1164 r0 *1 2.6,129.32 cap_mim_2f0_m4m5_noshield
C$1164 \$7 topp 3.56528e-14
* device instance $1165 r0 *1 9,129.32 cap_mim_2f0_m4m5_noshield
C$1165 \$6 topp 3.56528e-14
* device instance $1166 r0 *1 15.4,129.32 cap_mim_2f0_m4m5_noshield
C$1166 \$7 topp 3.56528e-14
* device instance $1167 r0 *1 21.8,129.32 cap_mim_2f0_m4m5_noshield
C$1167 \$6 topp 3.56528e-14
* device instance $1168 r0 *1 28.2,129.32 cap_mim_2f0_m4m5_noshield
C$1168 \$7 topp 3.56528e-14
* device instance $1169 r0 *1 34.6,129.32 cap_mim_2f0_m4m5_noshield
C$1169 \$6 topp 3.56528e-14
* device instance $1170 r0 *1 41,129.32 cap_mim_2f0_m4m5_noshield
C$1170 \$7 topp 3.56528e-14
* device instance $1171 r0 *1 47.4,129.32 cap_mim_2f0_m4m5_noshield
C$1171 \$6 topp 3.56528e-14
* device instance $1172 r0 *1 53.8,129.32 cap_mim_2f0_m4m5_noshield
C$1172 \$7 topp 3.56528e-14
* device instance $1173 r0 *1 60.2,129.32 cap_mim_2f0_m4m5_noshield
C$1173 \$6 topp 3.56528e-14
* device instance $1174 r0 *1 66.6,129.32 cap_mim_2f0_m4m5_noshield
C$1174 \$7 topp 3.56528e-14
* device instance $1175 r0 *1 73,129.32 cap_mim_2f0_m4m5_noshield
C$1175 \$6 topp 3.56528e-14
* device instance $1176 r0 *1 79.4,129.32 cap_mim_2f0_m4m5_noshield
C$1176 \$7 topp 3.56528e-14
* device instance $1177 r0 *1 85.8,129.32 cap_mim_2f0_m4m5_noshield
C$1177 \$6 topp 3.56528e-14
* device instance $1178 r0 *1 92.2,129.32 cap_mim_2f0_m4m5_noshield
C$1178 \$7 topp 3.56528e-14
* device instance $1179 r0 *1 98.6,129.32 cap_mim_2f0_m4m5_noshield
C$1179 \$6 topp 3.56528e-14
* device instance $1180 r0 *1 105,129.32 cap_mim_2f0_m4m5_noshield
C$1180 \$7 topp 3.56528e-14
* device instance $1181 r0 *1 111.4,129.32 cap_mim_2f0_m4m5_noshield
C$1181 \$6 topp 3.56528e-14
* device instance $1182 r0 *1 117.8,129.32 cap_mim_2f0_m4m5_noshield
C$1182 \$7 topp 3.56528e-14
* device instance $1183 r0 *1 124.2,129.32 cap_mim_2f0_m4m5_noshield
C$1183 \$6 topp 3.56528e-14
* device instance $1184 r0 *1 130.6,129.32 cap_mim_2f0_m4m5_noshield
C$1184 \$7 topp 3.56528e-14
* device instance $1185 r0 *1 137,129.32 cap_mim_2f0_m4m5_noshield
C$1185 \$6 topp 3.56528e-14
* device instance $1186 r0 *1 143.4,129.32 cap_mim_2f0_m4m5_noshield
C$1186 \$7 topp 3.56528e-14
* device instance $1187 r0 *1 149.8,129.32 cap_mim_2f0_m4m5_noshield
C$1187 \$6 topp 3.56528e-14
* device instance $1188 r0 *1 156.2,129.32 cap_mim_2f0_m4m5_noshield
C$1188 \$7 topp 3.56528e-14
* device instance $1189 r0 *1 162.6,129.32 cap_mim_2f0_m4m5_noshield
C$1189 \$6 topp 3.56528e-14
* device instance $1190 r0 *1 169,129.32 cap_mim_2f0_m4m5_noshield
C$1190 \$7 topp 3.56528e-14
* device instance $1191 r0 *1 175.4,129.32 cap_mim_2f0_m4m5_noshield
C$1191 \$6 topp 3.56528e-14
* device instance $1192 r0 *1 181.8,129.32 cap_mim_2f0_m4m5_noshield
C$1192 \$7 topp 3.56528e-14
* device instance $1193 r0 *1 188.2,129.32 cap_mim_2f0_m4m5_noshield
C$1193 \$6 topp 3.56528e-14
* device instance $1194 r0 *1 194.6,129.32 cap_mim_2f0_m4m5_noshield
C$1194 \$7 topp 3.56528e-14
* device instance $1195 r0 *1 201,129.32 cap_mim_2f0_m4m5_noshield
C$1195 \$6 topp 3.56528e-14
* device instance $1196 r0 *1 224,129.32 cap_mim_2f0_m4m5_noshield
C$1196 \$95 topn 3.56528e-14
* device instance $1197 r0 *1 230.4,129.32 cap_mim_2f0_m4m5_noshield
C$1197 \$86 topn 3.56528e-14
* device instance $1198 r0 *1 236.8,129.32 cap_mim_2f0_m4m5_noshield
C$1198 \$95 topn 3.56528e-14
* device instance $1199 r0 *1 243.2,129.32 cap_mim_2f0_m4m5_noshield
C$1199 \$86 topn 3.56528e-14
* device instance $1200 r0 *1 249.6,129.32 cap_mim_2f0_m4m5_noshield
C$1200 \$95 topn 3.56528e-14
* device instance $1201 r0 *1 256,129.32 cap_mim_2f0_m4m5_noshield
C$1201 \$86 topn 3.56528e-14
* device instance $1202 r0 *1 262.4,129.32 cap_mim_2f0_m4m5_noshield
C$1202 \$95 topn 3.56528e-14
* device instance $1203 r0 *1 268.8,129.32 cap_mim_2f0_m4m5_noshield
C$1203 \$86 topn 3.56528e-14
* device instance $1204 r0 *1 275.2,129.32 cap_mim_2f0_m4m5_noshield
C$1204 \$95 topn 3.56528e-14
* device instance $1205 r0 *1 281.6,129.32 cap_mim_2f0_m4m5_noshield
C$1205 \$86 topn 3.56528e-14
* device instance $1206 r0 *1 288,129.32 cap_mim_2f0_m4m5_noshield
C$1206 \$95 topn 3.56528e-14
* device instance $1207 r0 *1 294.4,129.32 cap_mim_2f0_m4m5_noshield
C$1207 \$86 topn 3.56528e-14
* device instance $1208 r0 *1 300.8,129.32 cap_mim_2f0_m4m5_noshield
C$1208 \$95 topn 3.56528e-14
* device instance $1209 r0 *1 307.2,129.32 cap_mim_2f0_m4m5_noshield
C$1209 \$86 topn 3.56528e-14
* device instance $1210 r0 *1 313.6,129.32 cap_mim_2f0_m4m5_noshield
C$1210 \$95 topn 3.56528e-14
* device instance $1211 r0 *1 320,129.32 cap_mim_2f0_m4m5_noshield
C$1211 \$86 topn 3.56528e-14
* device instance $1212 r0 *1 326.4,129.32 cap_mim_2f0_m4m5_noshield
C$1212 \$95 topn 3.56528e-14
* device instance $1213 r0 *1 332.8,129.32 cap_mim_2f0_m4m5_noshield
C$1213 \$86 topn 3.56528e-14
* device instance $1214 r0 *1 339.2,129.32 cap_mim_2f0_m4m5_noshield
C$1214 \$95 topn 3.56528e-14
* device instance $1215 r0 *1 345.6,129.32 cap_mim_2f0_m4m5_noshield
C$1215 \$86 topn 3.56528e-14
* device instance $1216 r0 *1 352,129.32 cap_mim_2f0_m4m5_noshield
C$1216 \$95 topn 3.56528e-14
* device instance $1217 r0 *1 358.4,129.32 cap_mim_2f0_m4m5_noshield
C$1217 \$86 topn 3.56528e-14
* device instance $1218 r0 *1 364.8,129.32 cap_mim_2f0_m4m5_noshield
C$1218 \$95 topn 3.56528e-14
* device instance $1219 r0 *1 371.2,129.32 cap_mim_2f0_m4m5_noshield
C$1219 \$86 topn 3.56528e-14
* device instance $1220 r0 *1 377.6,129.32 cap_mim_2f0_m4m5_noshield
C$1220 \$95 topn 3.56528e-14
* device instance $1221 r0 *1 384,129.32 cap_mim_2f0_m4m5_noshield
C$1221 \$86 topn 3.56528e-14
* device instance $1222 r0 *1 390.4,129.32 cap_mim_2f0_m4m5_noshield
C$1222 \$95 topn 3.56528e-14
* device instance $1223 r0 *1 396.8,129.32 cap_mim_2f0_m4m5_noshield
C$1223 \$86 topn 3.56528e-14
* device instance $1224 r0 *1 403.2,129.32 cap_mim_2f0_m4m5_noshield
C$1224 \$95 topn 3.56528e-14
* device instance $1225 r0 *1 409.6,129.32 cap_mim_2f0_m4m5_noshield
C$1225 \$86 topn 3.56528e-14
* device instance $1226 r0 *1 416,129.32 cap_mim_2f0_m4m5_noshield
C$1226 \$95 topn 3.56528e-14
* device instance $1227 r0 *1 422.4,129.32 cap_mim_2f0_m4m5_noshield
C$1227 \$86 topn 3.56528e-14
* device instance $1228 r0 *1 2.6,135.72 cap_mim_2f0_m4m5_noshield
C$1228 \$7 topp 3.56528e-14
* device instance $1229 r0 *1 9,135.72 cap_mim_2f0_m4m5_noshield
C$1229 \$6 topp 3.56528e-14
* device instance $1230 r0 *1 15.4,135.72 cap_mim_2f0_m4m5_noshield
C$1230 \$7 topp 3.56528e-14
* device instance $1231 r0 *1 21.8,135.72 cap_mim_2f0_m4m5_noshield
C$1231 \$6 topp 3.56528e-14
* device instance $1232 r0 *1 28.2,135.72 cap_mim_2f0_m4m5_noshield
C$1232 \$7 topp 3.56528e-14
* device instance $1233 r0 *1 34.6,135.72 cap_mim_2f0_m4m5_noshield
C$1233 \$6 topp 3.56528e-14
* device instance $1234 r0 *1 41,135.72 cap_mim_2f0_m4m5_noshield
C$1234 \$7 topp 3.56528e-14
* device instance $1235 r0 *1 47.4,135.72 cap_mim_2f0_m4m5_noshield
C$1235 \$6 topp 3.56528e-14
* device instance $1236 r0 *1 53.8,135.72 cap_mim_2f0_m4m5_noshield
C$1236 \$7 topp 3.56528e-14
* device instance $1237 r0 *1 60.2,135.72 cap_mim_2f0_m4m5_noshield
C$1237 \$6 topp 3.56528e-14
* device instance $1238 r0 *1 66.6,135.72 cap_mim_2f0_m4m5_noshield
C$1238 \$7 topp 3.56528e-14
* device instance $1239 r0 *1 73,135.72 cap_mim_2f0_m4m5_noshield
C$1239 \$6 topp 3.56528e-14
* device instance $1240 r0 *1 79.4,135.72 cap_mim_2f0_m4m5_noshield
C$1240 \$7 topp 3.56528e-14
* device instance $1241 r0 *1 85.8,135.72 cap_mim_2f0_m4m5_noshield
C$1241 \$6 topp 3.56528e-14
* device instance $1242 r0 *1 92.2,135.72 cap_mim_2f0_m4m5_noshield
C$1242 \$7 topp 3.56528e-14
* device instance $1243 r0 *1 98.6,135.72 cap_mim_2f0_m4m5_noshield
C$1243 \$6 topp 3.56528e-14
* device instance $1244 r0 *1 105,135.72 cap_mim_2f0_m4m5_noshield
C$1244 \$7 topp 3.56528e-14
* device instance $1245 r0 *1 111.4,135.72 cap_mim_2f0_m4m5_noshield
C$1245 \$6 topp 3.56528e-14
* device instance $1246 r0 *1 117.8,135.72 cap_mim_2f0_m4m5_noshield
C$1246 \$7 topp 3.56528e-14
* device instance $1247 r0 *1 124.2,135.72 cap_mim_2f0_m4m5_noshield
C$1247 \$6 topp 3.56528e-14
* device instance $1248 r0 *1 130.6,135.72 cap_mim_2f0_m4m5_noshield
C$1248 \$7 topp 3.56528e-14
* device instance $1249 r0 *1 137,135.72 cap_mim_2f0_m4m5_noshield
C$1249 \$6 topp 3.56528e-14
* device instance $1250 r0 *1 143.4,135.72 cap_mim_2f0_m4m5_noshield
C$1250 \$7 topp 3.56528e-14
* device instance $1251 r0 *1 149.8,135.72 cap_mim_2f0_m4m5_noshield
C$1251 \$6 topp 3.56528e-14
* device instance $1252 r0 *1 156.2,135.72 cap_mim_2f0_m4m5_noshield
C$1252 \$7 topp 3.56528e-14
* device instance $1253 r0 *1 162.6,135.72 cap_mim_2f0_m4m5_noshield
C$1253 \$6 topp 3.56528e-14
* device instance $1254 r0 *1 169,135.72 cap_mim_2f0_m4m5_noshield
C$1254 \$7 topp 3.56528e-14
* device instance $1255 r0 *1 175.4,135.72 cap_mim_2f0_m4m5_noshield
C$1255 \$6 topp 3.56528e-14
* device instance $1256 r0 *1 181.8,135.72 cap_mim_2f0_m4m5_noshield
C$1256 \$7 topp 3.56528e-14
* device instance $1257 r0 *1 188.2,135.72 cap_mim_2f0_m4m5_noshield
C$1257 \$6 topp 3.56528e-14
* device instance $1258 r0 *1 194.6,135.72 cap_mim_2f0_m4m5_noshield
C$1258 \$7 topp 3.56528e-14
* device instance $1259 r0 *1 201,135.72 cap_mim_2f0_m4m5_noshield
C$1259 \$6 topp 3.56528e-14
* device instance $1260 r0 *1 224,135.72 cap_mim_2f0_m4m5_noshield
C$1260 \$95 topn 3.56528e-14
* device instance $1261 r0 *1 230.4,135.72 cap_mim_2f0_m4m5_noshield
C$1261 \$86 topn 3.56528e-14
* device instance $1262 r0 *1 236.8,135.72 cap_mim_2f0_m4m5_noshield
C$1262 \$95 topn 3.56528e-14
* device instance $1263 r0 *1 243.2,135.72 cap_mim_2f0_m4m5_noshield
C$1263 \$86 topn 3.56528e-14
* device instance $1264 r0 *1 249.6,135.72 cap_mim_2f0_m4m5_noshield
C$1264 \$95 topn 3.56528e-14
* device instance $1265 r0 *1 256,135.72 cap_mim_2f0_m4m5_noshield
C$1265 \$86 topn 3.56528e-14
* device instance $1266 r0 *1 262.4,135.72 cap_mim_2f0_m4m5_noshield
C$1266 \$95 topn 3.56528e-14
* device instance $1267 r0 *1 268.8,135.72 cap_mim_2f0_m4m5_noshield
C$1267 \$86 topn 3.56528e-14
* device instance $1268 r0 *1 275.2,135.72 cap_mim_2f0_m4m5_noshield
C$1268 \$95 topn 3.56528e-14
* device instance $1269 r0 *1 281.6,135.72 cap_mim_2f0_m4m5_noshield
C$1269 \$86 topn 3.56528e-14
* device instance $1270 r0 *1 288,135.72 cap_mim_2f0_m4m5_noshield
C$1270 \$95 topn 3.56528e-14
* device instance $1271 r0 *1 294.4,135.72 cap_mim_2f0_m4m5_noshield
C$1271 \$86 topn 3.56528e-14
* device instance $1272 r0 *1 300.8,135.72 cap_mim_2f0_m4m5_noshield
C$1272 \$95 topn 3.56528e-14
* device instance $1273 r0 *1 307.2,135.72 cap_mim_2f0_m4m5_noshield
C$1273 \$86 topn 3.56528e-14
* device instance $1274 r0 *1 313.6,135.72 cap_mim_2f0_m4m5_noshield
C$1274 \$95 topn 3.56528e-14
* device instance $1275 r0 *1 320,135.72 cap_mim_2f0_m4m5_noshield
C$1275 \$86 topn 3.56528e-14
* device instance $1276 r0 *1 326.4,135.72 cap_mim_2f0_m4m5_noshield
C$1276 \$95 topn 3.56528e-14
* device instance $1277 r0 *1 332.8,135.72 cap_mim_2f0_m4m5_noshield
C$1277 \$86 topn 3.56528e-14
* device instance $1278 r0 *1 339.2,135.72 cap_mim_2f0_m4m5_noshield
C$1278 \$95 topn 3.56528e-14
* device instance $1279 r0 *1 345.6,135.72 cap_mim_2f0_m4m5_noshield
C$1279 \$86 topn 3.56528e-14
* device instance $1280 r0 *1 352,135.72 cap_mim_2f0_m4m5_noshield
C$1280 \$95 topn 3.56528e-14
* device instance $1281 r0 *1 358.4,135.72 cap_mim_2f0_m4m5_noshield
C$1281 \$86 topn 3.56528e-14
* device instance $1282 r0 *1 364.8,135.72 cap_mim_2f0_m4m5_noshield
C$1282 \$95 topn 3.56528e-14
* device instance $1283 r0 *1 371.2,135.72 cap_mim_2f0_m4m5_noshield
C$1283 \$86 topn 3.56528e-14
* device instance $1284 r0 *1 377.6,135.72 cap_mim_2f0_m4m5_noshield
C$1284 \$95 topn 3.56528e-14
* device instance $1285 r0 *1 384,135.72 cap_mim_2f0_m4m5_noshield
C$1285 \$86 topn 3.56528e-14
* device instance $1286 r0 *1 390.4,135.72 cap_mim_2f0_m4m5_noshield
C$1286 \$95 topn 3.56528e-14
* device instance $1287 r0 *1 396.8,135.72 cap_mim_2f0_m4m5_noshield
C$1287 \$86 topn 3.56528e-14
* device instance $1288 r0 *1 403.2,135.72 cap_mim_2f0_m4m5_noshield
C$1288 \$95 topn 3.56528e-14
* device instance $1289 r0 *1 409.6,135.72 cap_mim_2f0_m4m5_noshield
C$1289 \$86 topn 3.56528e-14
* device instance $1290 r0 *1 416,135.72 cap_mim_2f0_m4m5_noshield
C$1290 \$95 topn 3.56528e-14
* device instance $1291 r0 *1 422.4,135.72 cap_mim_2f0_m4m5_noshield
C$1291 \$86 topn 3.56528e-14
* device instance $1292 r0 *1 2.6,142.12 cap_mim_2f0_m4m5_noshield
C$1292 \$8 topp 3.56528e-14
* device instance $1293 r0 *1 9,142.12 cap_mim_2f0_m4m5_noshield
C$1293 \$6 topp 3.56528e-14
* device instance $1294 r0 *1 15.4,142.12 cap_mim_2f0_m4m5_noshield
C$1294 \$8 topp 3.56528e-14
* device instance $1295 r0 *1 21.8,142.12 cap_mim_2f0_m4m5_noshield
C$1295 \$6 topp 3.56528e-14
* device instance $1296 r0 *1 28.2,142.12 cap_mim_2f0_m4m5_noshield
C$1296 \$8 topp 3.56528e-14
* device instance $1297 r0 *1 34.6,142.12 cap_mim_2f0_m4m5_noshield
C$1297 \$6 topp 3.56528e-14
* device instance $1298 r0 *1 41,142.12 cap_mim_2f0_m4m5_noshield
C$1298 \$8 topp 3.56528e-14
* device instance $1299 r0 *1 47.4,142.12 cap_mim_2f0_m4m5_noshield
C$1299 \$6 topp 3.56528e-14
* device instance $1300 r0 *1 53.8,142.12 cap_mim_2f0_m4m5_noshield
C$1300 \$8 topp 3.56528e-14
* device instance $1301 r0 *1 60.2,142.12 cap_mim_2f0_m4m5_noshield
C$1301 \$6 topp 3.56528e-14
* device instance $1302 r0 *1 66.6,142.12 cap_mim_2f0_m4m5_noshield
C$1302 \$8 topp 3.56528e-14
* device instance $1303 r0 *1 73,142.12 cap_mim_2f0_m4m5_noshield
C$1303 \$6 topp 3.56528e-14
* device instance $1304 r0 *1 79.4,142.12 cap_mim_2f0_m4m5_noshield
C$1304 \$8 topp 3.56528e-14
* device instance $1305 r0 *1 85.8,142.12 cap_mim_2f0_m4m5_noshield
C$1305 \$6 topp 3.56528e-14
* device instance $1306 r0 *1 92.2,142.12 cap_mim_2f0_m4m5_noshield
C$1306 \$8 topp 3.56528e-14
* device instance $1307 r0 *1 98.6,142.12 cap_mim_2f0_m4m5_noshield
C$1307 \$6 topp 3.56528e-14
* device instance $1308 r0 *1 105,142.12 cap_mim_2f0_m4m5_noshield
C$1308 \$8 topp 3.56528e-14
* device instance $1309 r0 *1 111.4,142.12 cap_mim_2f0_m4m5_noshield
C$1309 \$6 topp 3.56528e-14
* device instance $1310 r0 *1 117.8,142.12 cap_mim_2f0_m4m5_noshield
C$1310 \$8 topp 3.56528e-14
* device instance $1311 r0 *1 124.2,142.12 cap_mim_2f0_m4m5_noshield
C$1311 \$6 topp 3.56528e-14
* device instance $1312 r0 *1 130.6,142.12 cap_mim_2f0_m4m5_noshield
C$1312 \$8 topp 3.56528e-14
* device instance $1313 r0 *1 137,142.12 cap_mim_2f0_m4m5_noshield
C$1313 \$6 topp 3.56528e-14
* device instance $1314 r0 *1 143.4,142.12 cap_mim_2f0_m4m5_noshield
C$1314 \$8 topp 3.56528e-14
* device instance $1315 r0 *1 149.8,142.12 cap_mim_2f0_m4m5_noshield
C$1315 \$6 topp 3.56528e-14
* device instance $1316 r0 *1 156.2,142.12 cap_mim_2f0_m4m5_noshield
C$1316 \$8 topp 3.56528e-14
* device instance $1317 r0 *1 162.6,142.12 cap_mim_2f0_m4m5_noshield
C$1317 \$6 topp 3.56528e-14
* device instance $1318 r0 *1 169,142.12 cap_mim_2f0_m4m5_noshield
C$1318 \$8 topp 3.56528e-14
* device instance $1319 r0 *1 175.4,142.12 cap_mim_2f0_m4m5_noshield
C$1319 \$6 topp 3.56528e-14
* device instance $1320 r0 *1 181.8,142.12 cap_mim_2f0_m4m5_noshield
C$1320 \$8 topp 3.56528e-14
* device instance $1321 r0 *1 188.2,142.12 cap_mim_2f0_m4m5_noshield
C$1321 \$6 topp 3.56528e-14
* device instance $1322 r0 *1 194.6,142.12 cap_mim_2f0_m4m5_noshield
C$1322 \$8 topp 3.56528e-14
* device instance $1323 r0 *1 201,142.12 cap_mim_2f0_m4m5_noshield
C$1323 \$6 topp 3.56528e-14
* device instance $1324 r0 *1 224,142.12 cap_mim_2f0_m4m5_noshield
C$1324 \$103 topn 3.56528e-14
* device instance $1325 r0 *1 230.4,142.12 cap_mim_2f0_m4m5_noshield
C$1325 \$86 topn 3.56528e-14
* device instance $1326 r0 *1 236.8,142.12 cap_mim_2f0_m4m5_noshield
C$1326 \$103 topn 3.56528e-14
* device instance $1327 r0 *1 243.2,142.12 cap_mim_2f0_m4m5_noshield
C$1327 \$86 topn 3.56528e-14
* device instance $1328 r0 *1 249.6,142.12 cap_mim_2f0_m4m5_noshield
C$1328 \$103 topn 3.56528e-14
* device instance $1329 r0 *1 256,142.12 cap_mim_2f0_m4m5_noshield
C$1329 \$86 topn 3.56528e-14
* device instance $1330 r0 *1 262.4,142.12 cap_mim_2f0_m4m5_noshield
C$1330 \$103 topn 3.56528e-14
* device instance $1331 r0 *1 268.8,142.12 cap_mim_2f0_m4m5_noshield
C$1331 \$86 topn 3.56528e-14
* device instance $1332 r0 *1 275.2,142.12 cap_mim_2f0_m4m5_noshield
C$1332 \$103 topn 3.56528e-14
* device instance $1333 r0 *1 281.6,142.12 cap_mim_2f0_m4m5_noshield
C$1333 \$86 topn 3.56528e-14
* device instance $1334 r0 *1 288,142.12 cap_mim_2f0_m4m5_noshield
C$1334 \$103 topn 3.56528e-14
* device instance $1335 r0 *1 294.4,142.12 cap_mim_2f0_m4m5_noshield
C$1335 \$86 topn 3.56528e-14
* device instance $1336 r0 *1 300.8,142.12 cap_mim_2f0_m4m5_noshield
C$1336 \$103 topn 3.56528e-14
* device instance $1337 r0 *1 307.2,142.12 cap_mim_2f0_m4m5_noshield
C$1337 \$86 topn 3.56528e-14
* device instance $1338 r0 *1 313.6,142.12 cap_mim_2f0_m4m5_noshield
C$1338 \$103 topn 3.56528e-14
* device instance $1339 r0 *1 320,142.12 cap_mim_2f0_m4m5_noshield
C$1339 \$86 topn 3.56528e-14
* device instance $1340 r0 *1 326.4,142.12 cap_mim_2f0_m4m5_noshield
C$1340 \$103 topn 3.56528e-14
* device instance $1341 r0 *1 332.8,142.12 cap_mim_2f0_m4m5_noshield
C$1341 \$86 topn 3.56528e-14
* device instance $1342 r0 *1 339.2,142.12 cap_mim_2f0_m4m5_noshield
C$1342 \$103 topn 3.56528e-14
* device instance $1343 r0 *1 345.6,142.12 cap_mim_2f0_m4m5_noshield
C$1343 \$86 topn 3.56528e-14
* device instance $1344 r0 *1 352,142.12 cap_mim_2f0_m4m5_noshield
C$1344 \$103 topn 3.56528e-14
* device instance $1345 r0 *1 358.4,142.12 cap_mim_2f0_m4m5_noshield
C$1345 \$86 topn 3.56528e-14
* device instance $1346 r0 *1 364.8,142.12 cap_mim_2f0_m4m5_noshield
C$1346 \$103 topn 3.56528e-14
* device instance $1347 r0 *1 371.2,142.12 cap_mim_2f0_m4m5_noshield
C$1347 \$86 topn 3.56528e-14
* device instance $1348 r0 *1 377.6,142.12 cap_mim_2f0_m4m5_noshield
C$1348 \$103 topn 3.56528e-14
* device instance $1349 r0 *1 384,142.12 cap_mim_2f0_m4m5_noshield
C$1349 \$86 topn 3.56528e-14
* device instance $1350 r0 *1 390.4,142.12 cap_mim_2f0_m4m5_noshield
C$1350 \$103 topn 3.56528e-14
* device instance $1351 r0 *1 396.8,142.12 cap_mim_2f0_m4m5_noshield
C$1351 \$86 topn 3.56528e-14
* device instance $1352 r0 *1 403.2,142.12 cap_mim_2f0_m4m5_noshield
C$1352 \$103 topn 3.56528e-14
* device instance $1353 r0 *1 409.6,142.12 cap_mim_2f0_m4m5_noshield
C$1353 \$86 topn 3.56528e-14
* device instance $1354 r0 *1 416,142.12 cap_mim_2f0_m4m5_noshield
C$1354 \$103 topn 3.56528e-14
* device instance $1355 r0 *1 422.4,142.12 cap_mim_2f0_m4m5_noshield
C$1355 \$86 topn 3.56528e-14
* device instance $1356 r0 *1 2.6,148.52 cap_mim_2f0_m4m5_noshield
C$1356 \$9 topp 3.56528e-14
* device instance $1357 r0 *1 9,148.52 cap_mim_2f0_m4m5_noshield
C$1357 \$6 topp 3.56528e-14
* device instance $1358 r0 *1 15.4,148.52 cap_mim_2f0_m4m5_noshield
C$1358 \$9 topp 3.56528e-14
* device instance $1359 r0 *1 21.8,148.52 cap_mim_2f0_m4m5_noshield
C$1359 \$6 topp 3.56528e-14
* device instance $1360 r0 *1 28.2,148.52 cap_mim_2f0_m4m5_noshield
C$1360 \$9 topp 3.56528e-14
* device instance $1361 r0 *1 34.6,148.52 cap_mim_2f0_m4m5_noshield
C$1361 \$6 topp 3.56528e-14
* device instance $1362 r0 *1 41,148.52 cap_mim_2f0_m4m5_noshield
C$1362 \$9 topp 3.56528e-14
* device instance $1363 r0 *1 47.4,148.52 cap_mim_2f0_m4m5_noshield
C$1363 \$6 topp 3.56528e-14
* device instance $1364 r0 *1 53.8,148.52 cap_mim_2f0_m4m5_noshield
C$1364 \$9 topp 3.56528e-14
* device instance $1365 r0 *1 60.2,148.52 cap_mim_2f0_m4m5_noshield
C$1365 \$6 topp 3.56528e-14
* device instance $1366 r0 *1 66.6,148.52 cap_mim_2f0_m4m5_noshield
C$1366 \$9 topp 3.56528e-14
* device instance $1367 r0 *1 73,148.52 cap_mim_2f0_m4m5_noshield
C$1367 \$6 topp 3.56528e-14
* device instance $1368 r0 *1 79.4,148.52 cap_mim_2f0_m4m5_noshield
C$1368 \$9 topp 3.56528e-14
* device instance $1369 r0 *1 85.8,148.52 cap_mim_2f0_m4m5_noshield
C$1369 \$6 topp 3.56528e-14
* device instance $1370 r0 *1 92.2,148.52 cap_mim_2f0_m4m5_noshield
C$1370 \$9 topp 3.56528e-14
* device instance $1371 r0 *1 98.6,148.52 cap_mim_2f0_m4m5_noshield
C$1371 \$6 topp 3.56528e-14
* device instance $1372 r0 *1 105,148.52 cap_mim_2f0_m4m5_noshield
C$1372 \$10 topp 3.56528e-14
* device instance $1373 r0 *1 111.4,148.52 cap_mim_2f0_m4m5_noshield
C$1373 \$6 topp 3.56528e-14
* device instance $1374 r0 *1 117.8,148.52 cap_mim_2f0_m4m5_noshield
C$1374 \$10 topp 3.56528e-14
* device instance $1375 r0 *1 124.2,148.52 cap_mim_2f0_m4m5_noshield
C$1375 \$6 topp 3.56528e-14
* device instance $1376 r0 *1 130.6,148.52 cap_mim_2f0_m4m5_noshield
C$1376 \$10 topp 3.56528e-14
* device instance $1377 r0 *1 137,148.52 cap_mim_2f0_m4m5_noshield
C$1377 \$6 topp 3.56528e-14
* device instance $1378 r0 *1 143.4,148.52 cap_mim_2f0_m4m5_noshield
C$1378 \$10 topp 3.56528e-14
* device instance $1379 r0 *1 149.8,148.52 cap_mim_2f0_m4m5_noshield
C$1379 \$6 topp 3.56528e-14
* device instance $1380 r0 *1 156.2,148.52 cap_mim_2f0_m4m5_noshield
C$1380 \$11 topp 3.56528e-14
* device instance $1381 r0 *1 162.6,148.52 cap_mim_2f0_m4m5_noshield
C$1381 \$6 topp 3.56528e-14
* device instance $1382 r0 *1 169,148.52 cap_mim_2f0_m4m5_noshield
C$1382 \$11 topp 3.56528e-14
* device instance $1383 r0 *1 175.4,148.52 cap_mim_2f0_m4m5_noshield
C$1383 \$6 topp 3.56528e-14
* device instance $1384 r0 *1 181.8,148.52 cap_mim_2f0_m4m5_noshield
C$1384 \$12 topp 3.56528e-14
* device instance $1385 r0 *1 188.2,148.52 cap_mim_2f0_m4m5_noshield
C$1385 \$6 topp 3.56528e-14
* device instance $1386 r0 *1 194.6,148.52 cap_mim_2f0_m4m5_noshield
C$1386 \$13 topp 3.56528e-14
* device instance $1387 r0 *1 201,148.52 cap_mim_2f0_m4m5_noshield
C$1387 \$6 topp 3.56528e-14
* device instance $1388 r0 *1 224,148.52 cap_mim_2f0_m4m5_noshield
C$1388 \$111 topn 3.56528e-14
* device instance $1389 r0 *1 230.4,148.52 cap_mim_2f0_m4m5_noshield
C$1389 \$86 topn 3.56528e-14
* device instance $1390 r0 *1 236.8,148.52 cap_mim_2f0_m4m5_noshield
C$1390 \$111 topn 3.56528e-14
* device instance $1391 r0 *1 243.2,148.52 cap_mim_2f0_m4m5_noshield
C$1391 \$86 topn 3.56528e-14
* device instance $1392 r0 *1 249.6,148.52 cap_mim_2f0_m4m5_noshield
C$1392 \$111 topn 3.56528e-14
* device instance $1393 r0 *1 256,148.52 cap_mim_2f0_m4m5_noshield
C$1393 \$86 topn 3.56528e-14
* device instance $1394 r0 *1 262.4,148.52 cap_mim_2f0_m4m5_noshield
C$1394 \$111 topn 3.56528e-14
* device instance $1395 r0 *1 268.8,148.52 cap_mim_2f0_m4m5_noshield
C$1395 \$86 topn 3.56528e-14
* device instance $1396 r0 *1 275.2,148.52 cap_mim_2f0_m4m5_noshield
C$1396 \$111 topn 3.56528e-14
* device instance $1397 r0 *1 281.6,148.52 cap_mim_2f0_m4m5_noshield
C$1397 \$86 topn 3.56528e-14
* device instance $1398 r0 *1 288,148.52 cap_mim_2f0_m4m5_noshield
C$1398 \$111 topn 3.56528e-14
* device instance $1399 r0 *1 294.4,148.52 cap_mim_2f0_m4m5_noshield
C$1399 \$86 topn 3.56528e-14
* device instance $1400 r0 *1 300.8,148.52 cap_mim_2f0_m4m5_noshield
C$1400 \$111 topn 3.56528e-14
* device instance $1401 r0 *1 307.2,148.52 cap_mim_2f0_m4m5_noshield
C$1401 \$86 topn 3.56528e-14
* device instance $1402 r0 *1 313.6,148.52 cap_mim_2f0_m4m5_noshield
C$1402 \$111 topn 3.56528e-14
* device instance $1403 r0 *1 320,148.52 cap_mim_2f0_m4m5_noshield
C$1403 \$86 topn 3.56528e-14
* device instance $1404 r0 *1 326.4,148.52 cap_mim_2f0_m4m5_noshield
C$1404 \$119 topn 3.56528e-14
* device instance $1405 r0 *1 332.8,148.52 cap_mim_2f0_m4m5_noshield
C$1405 \$86 topn 3.56528e-14
* device instance $1406 r0 *1 339.2,148.52 cap_mim_2f0_m4m5_noshield
C$1406 \$119 topn 3.56528e-14
* device instance $1407 r0 *1 345.6,148.52 cap_mim_2f0_m4m5_noshield
C$1407 \$86 topn 3.56528e-14
* device instance $1408 r0 *1 352,148.52 cap_mim_2f0_m4m5_noshield
C$1408 \$119 topn 3.56528e-14
* device instance $1409 r0 *1 358.4,148.52 cap_mim_2f0_m4m5_noshield
C$1409 \$86 topn 3.56528e-14
* device instance $1410 r0 *1 364.8,148.52 cap_mim_2f0_m4m5_noshield
C$1410 \$119 topn 3.56528e-14
* device instance $1411 r0 *1 371.2,148.52 cap_mim_2f0_m4m5_noshield
C$1411 \$86 topn 3.56528e-14
* device instance $1412 r0 *1 377.6,148.52 cap_mim_2f0_m4m5_noshield
C$1412 \$127 topn 3.56528e-14
* device instance $1413 r0 *1 384,148.52 cap_mim_2f0_m4m5_noshield
C$1413 \$86 topn 3.56528e-14
* device instance $1414 r0 *1 390.4,148.52 cap_mim_2f0_m4m5_noshield
C$1414 \$127 topn 3.56528e-14
* device instance $1415 r0 *1 396.8,148.52 cap_mim_2f0_m4m5_noshield
C$1415 \$86 topn 3.56528e-14
* device instance $1416 r0 *1 403.2,148.52 cap_mim_2f0_m4m5_noshield
C$1416 \$135 topn 3.56528e-14
* device instance $1417 r0 *1 409.6,148.52 cap_mim_2f0_m4m5_noshield
C$1417 \$86 topn 3.56528e-14
* device instance $1418 r0 *1 416,148.52 cap_mim_2f0_m4m5_noshield
C$1418 \$143 topn 3.56528e-14
* device instance $1419 r0 *1 422.4,148.52 cap_mim_2f0_m4m5_noshield
C$1419 \$86 topn 3.56528e-14
* device instance $1420 r0 *1 577.68,64.805 ppolyf_u_1k
R$1420 vdd XCMP_pop vss 150000 ppolyf_u_1k L=150U W=1U
* device instance $1421 r0 *1 584.03,64.805 ppolyf_u_1k
R$1421 vdd XCMP_pon vss 150000 ppolyf_u_1k L=150U W=1U
.ENDS ADC_BLOCK
