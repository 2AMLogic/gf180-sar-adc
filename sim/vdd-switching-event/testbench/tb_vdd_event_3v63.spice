* tb_vdd_event_3v63 -- GENERATED by gen_requests.py, do not edit.
*
* sim/vdd-switching-event/ (issue #386), supply rail 3.63 V.
* Everything sim/harness/runner.compose_deck puts ahead of the shared
* netlist, so the circuit is the one sim/adc-power/ and
* sim/adc-rail-current/ record against; `klt sim` adds the corner's
* .lib sections and .temp card. See gen_requests.py for why the supply
* is a per-file .param rather than a corners.supply_v alter.

* ---- PVT parameters (harness: compose_deck) --------------------------
.param vdd_nom=3.3
.param vdd_val=3.63

* ---- gf180mcuD libs.tech/ngspice/design.ngspice, inlined verbatim ---
* (its only non-comment content; the harness .includes the same file)
.param
+  sw_stat_global = 0
+  sw_stat_mismatch = 0
+ mc_skew = 3
+ res_mc_skew = 3
+ cap_mc_skew = 3
+  fnoicor = 0

* ---- CDAC MIM unit-cap aliases (harness: mim_wrapper_subckts) --------
* variant gf180mcuD -> MIM between m4m5
.subckt mim_cap_1f0 1 2 c_width=10u c_length=10u dtemp=0
Xmim 1 2 cap_mim_1f0_m4m5_noshield c_width=c_width c_length=c_length dtemp=dtemp
.ends
.subckt mim_cap_1f5 1 2 c_width=10u c_length=10u dtemp=0
Xmim 1 2 cap_mim_1f5_m4m5_noshield c_width=c_width c_length=c_length dtemp=dtemp
.ends
.subckt mim_cap_2f0 1 2 c_width=10u c_length=10u dtemp=0
Xmim 1 2 cap_mim_2f0_m4m5_noshield c_width=c_width c_length=c_length dtemp=dtemp
.ends

* ---- integrator ------------------------------------------------------
* Gear, not ngspice's default trapezoidal: the trapezoidal run aborts
* (`Timestep too small`, node pa_00) at 7.71885 us with a 10 ps cap and
* at 15.3775 us with a 25 ps cap on every corner. See the investigation
* note, Finding 5. Gear keeps the window charges to <= 0.2 % of the
* trapezoidal value where both complete. Gear alone still aborted at
* 15.3775 us in the ff corners on the fleet (the same clock edge every
* time, `Timestep too small`), so the per-timepoint Newton iteration
* limit is raised from its default 10 (itl4=100): a convergence aid,
* not a model change.
.options method=gear itl4=100

* ---- the shared circuit, unmodified ---------------------------------
.include ../../adc-power/testbench/tb_adc_power.spice
