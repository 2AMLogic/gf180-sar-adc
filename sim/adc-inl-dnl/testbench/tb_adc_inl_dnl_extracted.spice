* ==================================================================
* tb_adc_inl_dnl_extracted -- static linearity of the extracted,
* PMOS-body-remediated, MiM-mapped ADC_TOP core over the PVT grid
* (issue #89 Scope item 1). GENERATED by
* layout/adc-top/parasitics/gen_extracted_inl_dnl_tb.py -- do not edit.
*
* Reuses sim/adc-inl-dnl/testbench/tb.json UNMODIFIED (via
* `run_corners.py --netlist ... --netlist-provenance extracted`): the
* input ladder and the ideal-shadow-DAC error/code nodes are byte-for-
* byte ports of design/adc-top/gen_adc_top.py's inl_netlist()/_core(),
* tagged `se_*` to match that manifest's measure/check expressions
* exactly. The ONLY thing that differs from the schematic deck is the
* analog core itself: one extracted ADC_TOP instance (both CDAC array
* sides + the per-side top-plate V_cm switch, PMOS-body-remediated to
* vdd, MiM-mapped to the native PDK subckt) in place of two
* adc_cdac_side instances + two adc_tp_sw instances. Comparator and
* rung-1 controller stay schematic-level (issue #89 Scope item 0).
* See gen_extracted_inl_dnl_tb.py's module docstring for the full
* rationale.
* ==================================================================

* ---- retained waveforms --------------------------------------------
* ngspice keeps a transient waveform for EVERY node unless told which
* ones matter. The in-path extraction splits every net into one leg
* node per device terminal, so the full store overruns what ngspice
* will allocate and the point dies before measuring anything. These
* are exactly the vectors this deck's manifest reads, derived from it
* rather than hand-listed. Retention only: no model, tolerance or
* timestep changes, and the measurements are bit-identical with and
* without this line. See gen_extracted_core_tb.saved_vectors_lines.
.save v(se_aerrh) v(se_code) v(se_err) v(vrefn)

* ---- ratiometric rails --------------------------------------------
* V_REF = V_DD. README.md note [c] makes V_REF <= V_DD a hard
* condition of the ratified spec, so a fixed 3.3 V reference is not
* legal at the 2.97 V corner; taking V_REF = V_DD keeps the deck legal
* at every point of the supply axis, and every figure below is in LSB
* of whatever full scale that point has.
.param vref={vdd_val}
.param vcm={vdd_val/2}
.param vth={vdd_val/2}
.param lsb={vdd_val/1024}

* ---- clocks --------------------------------------------------------
* DR-0003: one external clock pin at 16 x f_s. The comparator strobe
* is the same clock shifted half a bit cycle, so the CDAC settles in
* the first 31.25 ns and the comparator decides in the second -- the
* split spec/prior-art-survey.md Sec 1.4 allocates and
* sim/comparator-regeneration/ measured 863 ps of worst-case decision
* delay against.
vclk clk 0 pulse(0 {vdd_val} 0 100p 100p 31.25n 62.5n)
vcmpclk cmpclk 0 pulse(0 {vdd_val} 31.25n 100p 100p 31.25n 62.5n)
vcmpclkb cmpclkb 0 pulse({vdd_val} 0 31.25n 100p 100p 31.25n 62.5n)

* ---- supplies, split per block so power is attributable -----------
vddt vddt 0 dc {vdd_val}
vddd vddd 0 dc {vdd_val}
vddc vddc 0 dc {vdd_val}

* ---- reference network, DR-0002 -----------------------------------
* DR-0002 specifies an EXTERNAL V_REF pin with an effective source
* impedance <= 240 ohm IN THE SWITCHING BAND and >= 40 nF of external
* decoupling. Both halves of that sentence are modelled: the inductor
* in parallel with the 240 ohm makes the network 240 ohm at the
* switching band and DC-accurate below it, which is what an external
* reference buffer behind a decoupling capacitor actually is. A bare
* 240 ohm series resistor would instead assert a DC offset DR-0002
* never specified -- and, with 40 nF, a 9.6 us settling tail that
* would dominate any run shorter than ~50 us.
vrefs vrefs 0 dc {vref}
rref vrefs vrefn 240
lref vrefs vrefn 2.3873u
cref vrefn 0 40n
* V_cm generation is explicitly unbudgeted work (DR-0011
* Consequences: 'a new, currently-unbudgeted deliverable for a future
* issue'), so there is no ratified envelope to model it against and it
* is an IDEAL source here. That is a stated assumption of every record
* this deck produces, not a measured result -- see the known-
* limitations section of spec/testbench-suite-memo.md.
vcms vcmn 0 dc {vcm}

* ---- input: piecewise-constant ladder of probed transitions -------
* Identical to gen_adc_top.inl_netlist() -- same INL_TRANSITIONS,
* same schedule, same tag.
vsevinp se_vinp 0 pwl(
+ 0 {(1+0.25)*lsb} 2990.0n {(1+0.25)*lsb} 3000.0n {(2+0.25)*lsb} 3990.0n {(2+0.25)*lsb} 4000.0n {(128+0.25)*lsb} 4990.0n {(128+0.25)*lsb} 5000.0n {(129+0.25)*lsb} 5990.0n {(129+0.25)*lsb} 6000.0n {(255+0.25)*lsb} 6990.0n {(255+0.25)*lsb} 7000.0n {(256+0.25)*lsb} 7990.0n {(256+0.25)*lsb} 8000.0n {(257+0.25)*lsb} 8990.0n {(257+0.25)*lsb} 9000.0n {(384+0.25)*lsb} 9990.0n {(384+0.25)*lsb} 10000.0n {(511+0.25)*lsb} 10990.0n {(511+0.25)*lsb} 11000.0n {(512+0.25)*lsb} 11990.0n {(512+0.25)*lsb} 12000.0n {(513+0.25)*lsb} 12990.0n {(513+0.25)*lsb} 13000.0n {(640+0.25)*lsb} 13990.0n {(640+0.25)*lsb} 14000.0n {(767+0.25)*lsb} 14990.0n {(767+0.25)*lsb} 15000.0n {(768+0.25)*lsb} 15990.0n {(768+0.25)*lsb} 16000.0n {(769+0.25)*lsb} 16990.0n {(769+0.25)*lsb} 17000.0n {(896+0.25)*lsb} 17990.0n {(896+0.25)*lsb} 18000.0n {(1022+0.25)*lsb} 18990.0n {(1022+0.25)*lsb} 19000.0n {(1023+0.25)*lsb} 20000.0n {(1023+0.25)*lsb})
vsevinn se_vinn 0 dc {vcm}

* ---- library: comparator + SAR controller + extracted core -------
* --- COMPARATOR-NETLIST-BEGIN (verbatim-copied into every testbench) ---
.subckt preamp vinp vinn ibias pop pon vdd vss
* 1:1 NMOS current mirror; ibias is forced into the diode branch.
Xmb  ibias ibias vss vss nfet_03v3 w=20u l=2u
Xmt  ptail ibias vss vss nfet_03v3 w=20u l=2u
* Input pair. The device whose gate is vinp drives the INVERTING node
* pon, so v(pop) - v(pon) = +A_v * (v(vinp) - v(vinn)).
Xmip pon vinp ptail vss nfet_03v3 w=40u l=1u
Xmin pop vinn ptail vss nfet_03v3 w=40u l=1u
* Unsalicided 1 kohm/sq p+ poly loads, 150 squares = 150 kohm nominal.
* Third terminal is the substrate/body contact. `ppolyf_u_1k`, not the
* 2 kohm/sq `ppolyf_u_2k` an earlier revision assumed: issue #118 drew
* SAB(49/0)+RES_MK(110/5)+Resistor(62/0) markers over the load-resistor
* bodies so `klt extract`'s gf180mcu deck recognises them as real devices
* instead of a Poly2 short, and at this repo's pinned klt commit that
* marker geometry can only select `ppolyf_u_1k` (1000 ohm/sq) -- the
* `_2k`/`_3k` flavours share the identical drawn geometry and are chosen by
* a build-time deck option this curated deck does not implement
* (`2AMLogic/klayout-tools#595`, open). `r_length` is doubled (75u -> 150u)
* at the same `r_width=1u` to preserve the 150 kohm target at the new
* sheet-rho -- see layout/adc-top/README.md "Resistors".
Xrlp vdd pop vss ppolyf_u_1k r_width=1u r_length=150u
Xrln vdd pon vss ppolyf_u_1k r_width=1u r_length=150u
.ends preamp

.subckt sarlatch inp inn clk outp outn vdd vss
* clk low  -> tail off; outp/outn/dip/din precharged to vdd
* clk high -> tail on; the input pair discharges dip/din at rates set by
*             v(inp)/v(inn), then the cross-coupled pairs regenerate.
Xmlt ltail clk   vss   vss nfet_03v3 w=16u l=0.35u
Xmlp dip   inp   ltail vss nfet_03v3 w=8u  l=0.5u
Xmln din   inn   ltail vss nfet_03v3 w=8u  l=0.5u
Xmnp outn  outp  dip   vss nfet_03v3 w=6u  l=0.35u
Xmnn outp  outn  din   vss nfet_03v3 w=6u  l=0.35u
Xmpp outn  outp  vdd   vdd pfet_03v3 w=8u  l=0.35u
Xmpn outp  outn  vdd   vdd pfet_03v3 w=8u  l=0.35u
Xmrp outn  clk   vdd   vdd pfet_03v3 w=4u  l=0.35u
Xmrn outp  clk   vdd   vdd pfet_03v3 w=4u  l=0.35u
Xmrd dip   clk   vdd   vdd pfet_03v3 w=2u  l=0.35u
Xmre din   clk   vdd   vdd pfet_03v3 w=2u  l=0.35u
.ends sarlatch

* Minimum-ish isolation inverter. Deliberately small: it is the only
* thing the regeneration nodes drive, so its gate capacitance is added
* directly to the latch's own output nodes and shows up as regeneration
* time.
.subckt inv a y vdd vss
Xp y a vdd vdd pfet_03v3 w=2u   l=0.35u
Xn y a vss vss nfet_03v3 w=1u   l=0.35u
.ends inv

.subckt nor2 a b y vdd vss
Xp1 ps a vdd vdd pfet_03v3 w=8u l=0.35u
Xp2 y  b ps  vdd pfet_03v3 w=8u l=0.35u
Xn1 y  a vss vss nfet_03v3 w=4u l=0.35u
Xn2 y  b vss vss nfet_03v3 w=4u l=0.35u
.ends nor2

.subckt comparator vinp vinn clk ibias dout doutb vdd vss
Xpre preamp_in1 preamp_in2 ibias pop pon vdd vss preamp
Xlat pop pon clk outp outn vdd vss sarlatch
* THE ISOLATION INVERTERS ARE NOT OPTIONAL -- they fix a measured
* hysteresis defect. Both StrongARM outputs precharge HIGH, so the
* decision arrives as an active-low pulse on exactly one of them, and
* the obvious way to hold it is a NAND SR latch wired straight to
* outp/outn. That circuit was built first and MEASURED: after deciding
* one way it would not flip back until the input reached ~10 mV of the
* opposite polarity -- about 3 LSB of hysteresis, which in a SAR (where
* the same comparator makes ten successive decisions on a shrinking
* residue) is a code-dependent error, not an offset.
*
* The cause is that a NAND SR latch's HELD STATE loads the two
* regeneration nodes asymmetrically. Wired directly, the node driving
* the NAND whose output is LOW sees that output swing when it falls
* (Miller-multiplied C_gd, ~26 fF against a regeneration node of a few
* tens of fF), while its twin drives a NAND whose output is already
* HIGH and stays there. The latch is therefore biased toward keeping
* the answer it already holds.
*
* Interposing one small inverter per side removes the coupling: the
* inverters are identical, both of their inputs precharge to V_DD, and
* neither loading depends on what the SR latch is holding. The SR latch
* becomes NOR-type because the inverters make the decision pulses
* active-HIGH. dout goes HIGH when outn falls, i.e. when
* v(vinp) > v(vinn), exactly as before.
Xis outn sset vdd vss inv
Xir outp srst vdd vss inv
Xno1 srst doutb dout  vdd vss nor2
Xno2 sset dout  doutb vdd vss nor2
* Input pass-through (zero-volt sources) so a testbench can probe the
* current the comparator draws from each CDAC top plate directly.
Vpp preamp_in1 vinp dc 0
Vpn preamp_in2 vinn dc 0
.ends comparator
* --- COMPARATOR-NETLIST-END ---

* ------------------------------------------------------------------
* sar_ctrl.spice -- synchronous SAR control logic, rung-1 abstraction
*
* GENERATED by design/sar-logic/gen_sar_logic.py -- do not edit.
*
* Ideal XSPICE event-driven digital primitives (digital.cm: d_dff,
* d_and, d_or, d_inverter) plus adc_bridge/dac_bridge at the analog
* boundary. This is rung 1 of the fidelity ladder in DR-0010: it fixes
* the SEQUENCING and the SWITCH DECODE, and deliberately says nothing
* about gf180mcu gate delay (rung 3 / sim/sar-logic-cell-delay/ owns
* that).
*
* Conversion, M = 16 clocks (DR-0003), with DR-0014's TWO-PHASE
* BOTTOM-PLATE sample laid inside the same 4-clock sample window:
*   ph0..ph2   acquire  samp_tp and samp_bp both asserted: the top
*                       plate is held at Vcm by its own switch and
*                       every bottom plate tracks V_in through the
*                       cell's fourth leg
*   ph2->ph3   THE SAMPLING INSTANT -- samp_tp falls, the top-plate
*                       switch opens and the top node floats
*   ph3        the bottom plates stay on V_in one more clock
*   ph3->ph4   samp_bp falls a full bit cycle after the sampling
*                       instant: the bottom plates leave V_in for Vcm
*                       onto a node that is ALREADY isolated, which
*                       is the whole reason bottom-plate sampling is
*                       worth a fourth leg (DR-0014, README note [d])
*   ph4        trial 1  free MSB -- no array switching at all, the
*                       comparator decides the sign of the sampled
*                       residue (DR-0014 keeps DR-0011's free MSB)
*   ph5..ph13  trials 2..10, weights 256,128,...,1 engaged in turn
*   ph14       output register loads the 10 decisions
*   ph15       drdy asserted; array released back to Vcm
*
* Switch decode per weight w and side s -- FOUR one-hot legs per cell
* now, not three -- from the slice's own engage flag `eng`, the
* direction bit `dir` (= the decision of the PREVIOUS trial, which is
* also that trial's output bit) and the shared sample control `smp`:
*   in  = smp                      bottom plate on V_in (DR-0014)
*   rel = !eng & !smp              bottom plate parked at Vcm
*   p-side:  hi = eng &  dir       -> V_REF      lo = eng & !dir -> GND
*   n-side:  hi = eng & !dir       -> V_REF      lo = eng &  dir -> GND
*   n-side is additionally gated by `mode` (1 = differential): in
*   single-ended mode every n-side cell stays released to Vcm for the
*   whole conversion, per DR-0011 -- driving it too would double every
*   step and cost a bit of resolution. The `in` leg is NOT mode-gated:
*   both sides must acquire their own input pin, and DR-0011's mode
*   rule is about bit trials, not about the sample phase.
*   `eng` is zero for the whole sample window, so exactly one of the
*   four legs conducts at every instant -- the invariant
*   sim/sar-logic-functional/ measures directly as sw_conflict_*.
*
* Sign convention, RE-DERIVED FOR DR-0014 and the one place the
* superseded record's decode could not simply be carried forward.
* Sampling on the bottom plate INVERTS the residue with respect to the
* input: after the sample, top_p - top_n = -k*(V_inp - V_inn). The
* comparator is wired conventionally (cmp = 1 when top_p > top_n), so
* the controller inverts it ONCE at its own boundary --
*
*     dec = !cmp    = 1 when the sampled input is ABOVE the DAC's
*                     current estimate, i.e. 'add this weight'
*
* -- and `dir` therefore still holds the OUTPUT BIT of its position,
* exactly as under DR-0011, at the cost of the hi/lo assignment above
* being the mirror of DR-0011's. Inverting only one of the two would
* either diverge (right code polarity, wrong feedback direction) or
* emit the one's complement of the code (right feedback, wrong bits);
* both were checked against the closed loop before this form was
* chosen, and sim/sar-logic-functional/ falsifies either error on
* every one of the 1024 codes in both modes.
* ------------------------------------------------------------------

* --- ideal digital primitives -------------------------------------
.model sarl_dff d_dff(clk_delay=0.5n set_delay=0.5n
+ reset_delay=0.5n ic=0 rise_delay=0.5n fall_delay=0.5n)
.model sarl_dff1 d_dff(clk_delay=0.5n set_delay=0.5n
+ reset_delay=0.5n ic=1 rise_delay=0.5n fall_delay=0.5n)
.model sarl_and d_and(rise_delay=0.2n fall_delay=0.2n input_load=0)
.model sarl_or d_or(rise_delay=0.2n fall_delay=0.2n input_load=0)
.model sarl_inv d_inverter(rise_delay=0.2n fall_delay=0.2n
+ input_load=0)

* --- enabled bit register -----------------------------------------
* Captures `d` on the clock edge that ENDS the phase in which `en` is
* asserted, and holds otherwise. Written as an explicit D-mux rather
* than a gated clock: gating the clock with a phase signal that itself
* changes one gate delay after the clock edge creates a spurious
* rising edge on the gated clock, which is a real bug in a real
* implementation, not just in this model.
.subckt sar_bitreg clk d en q qb
a_inv en enb sarl_inv
a_sel [en d] dsel sarl_and
a_hold [enb q] dhold sarl_and
a_mux [dsel dhold] dnext sarl_or
a_ff dnext clk NULL NULL q qb sarl_dff
.ends sar_bitreg

* --- one bit slice: engage flag + direction bit + switch decode -----
* `arm`     one-hot phase pulse of the trial BEFORE this slice's own
*           trial: the slice engages on the edge entering its trial,
*           and the direction bit captures the decision made during
*           `arm` (which is also this bit position's output bit).
* `endconv` forces the engage flag low on the edge leaving the last
*           trial, releasing the whole array back to Vcm for the next
*           sample phase.
* `dec`     the comparator decision in OUTPUT-BIT polarity (= !cmp;
*           see the sign-convention note in the header).
* `smpb`    the inverse of the shared bottom-plate sample control,
*           distributed already-inverted so that all four legs of the
*           cell come out at the SAME logic depth. That is not
*           cosmetic: `rel` and the V_in leg are complementary during
*           the sample window, so a one-gate depth difference between
*           them opens a window in which a cell drives V_in and Vcm at
*           once -- which is exactly what the one-hot invariant is
*           there to catch, and it would catch this generator.
.subckt sar_slice clk dec mode arm endconv smpb dir dirb
+ rel_p hi_p lo_p rel_n hi_n lo_n
a_set [arm eng] eng_set sarl_or
a_ninv endconv nend sarl_inv
a_keep [eng_set nend] eng_d sarl_and
a_ff eng_d clk NULL NULL eng engb sarl_dff
xdir clk dec arm dir dirb sar_bitreg
* p side: always driven
a_relp [engb smpb] rel_p sarl_and
a_hip [eng dir] hi_p sarl_and
a_lop [eng dirb] lo_p sarl_and
* n side: driven only in differential mode (DR-0011). `engnb` is built
* as !eng | !mode rather than as an inverter on `engn`, so that it
* lands at the same depth as `engn` and rel_n/hi_n/lo_n switch
* together -- the same delay-balance argument as `smpb` above.
a_engn [eng mode] engn sarl_and
a_modeb mode modeb sarl_inv
a_engnb [engb modeb] engnb sarl_or
a_reln [engnb smpb] rel_n sarl_and
a_hin [engn dirb] hi_n sarl_and
a_lon [engn dir] lo_n sarl_and
.ends sar_slice

* --- 16-phase one-hot sequencer ------------------------------------
* A one-hot ring, seeded by ph15's ic=1 so the very first clock edge
* enters ph0 (sample) with exactly one token in the ring. `start`
* forces a synchronous restart: it sets stage 0 and clears every other
* stage on the same edge, so an asserted `start` cannot inject a
* SECOND token alongside the circulating one.
.subckt sar_seq clk start ph0 ph1 ph2 ph3 ph4 ph5 ph6 ph7 ph8 ph9 ph10 ph11 ph12 ph13 ph14 ph15
a_nstart start nstart sarl_inv
a_d0 [ph15 start] d0 sarl_or
a_ff0 d0 clk NULL NULL ph0 ph0b sarl_dff
a_d1 [ph0 nstart] d1 sarl_and
a_ff1 d1 clk NULL NULL ph1 ph1b sarl_dff
a_d2 [ph1 nstart] d2 sarl_and
a_ff2 d2 clk NULL NULL ph2 ph2b sarl_dff
a_d3 [ph2 nstart] d3 sarl_and
a_ff3 d3 clk NULL NULL ph3 ph3b sarl_dff
a_d4 [ph3 nstart] d4 sarl_and
a_ff4 d4 clk NULL NULL ph4 ph4b sarl_dff
a_d5 [ph4 nstart] d5 sarl_and
a_ff5 d5 clk NULL NULL ph5 ph5b sarl_dff
a_d6 [ph5 nstart] d6 sarl_and
a_ff6 d6 clk NULL NULL ph6 ph6b sarl_dff
a_d7 [ph6 nstart] d7 sarl_and
a_ff7 d7 clk NULL NULL ph7 ph7b sarl_dff
a_d8 [ph7 nstart] d8 sarl_and
a_ff8 d8 clk NULL NULL ph8 ph8b sarl_dff
a_d9 [ph8 nstart] d9 sarl_and
a_ff9 d9 clk NULL NULL ph9 ph9b sarl_dff
a_d10 [ph9 nstart] d10 sarl_and
a_ff10 d10 clk NULL NULL ph10 ph10b sarl_dff
a_d11 [ph10 nstart] d11 sarl_and
a_ff11 d11 clk NULL NULL ph11 ph11b sarl_dff
a_d12 [ph11 nstart] d12 sarl_and
a_ff12 d12 clk NULL NULL ph12 ph12b sarl_dff
a_d13 [ph12 nstart] d13 sarl_and
a_ff13 d13 clk NULL NULL ph13 ph13b sarl_dff
a_d14 [ph13 nstart] d14 sarl_and
a_ff14 d14 clk NULL NULL ph14 ph14b sarl_dff
a_d15 [ph14 nstart] d15 sarl_and
a_ff15 d15 clk NULL NULL ph15 ph15b sarl_dff1
.ends sar_seq

* --- digital top ----------------------------------------------------
.subckt sar_ctrl clk start mode cmp samp_tp samp_bp drdy b9 b8 b7 b6 b5 b4
+ b3 b2 b1 b0 rel_256p hi_256p lo_256p rel_128p hi_128p lo_128p rel_64p
+ hi_64p lo_64p rel_32p hi_32p lo_32p rel_16p hi_16p lo_16p rel_8p hi_8p
+ lo_8p rel_4p hi_4p lo_4p rel_2p hi_2p lo_2p rel_1p hi_1p lo_1p rel_256n
+ hi_256n lo_256n rel_128n hi_128n lo_128n rel_64n hi_64n lo_64n rel_32n
+ hi_32n lo_32n rel_16n hi_16n lo_16n rel_8n hi_8n lo_8n rel_4n hi_4n
+ lo_4n rel_2n hi_2n lo_2n rel_1n hi_1n lo_1n
xseq clk start ph0 ph1 ph2 ph3 ph4 ph5 ph6 ph7 ph8 ph9 ph10 ph11 ph12 ph13 ph14 ph15 sar_seq
* ---- DR-0014's two-phase sample ----------------------------------
* `samp_tp` closes the top-plate switch for ph0..ph2 and opens it on
* the edge into ph3: THAT edge is the sampling instant. `samp_bp`
* keeps every bottom plate on V_in for the whole 4-clock window, so
* the input legs turn off one full clock LATER, onto a top node that
* is already floating. Both are one-hot phase ORs off the same ring:
* one external clock, rising edges only (DR-0008), no gated or
* inverted clock anywhere in the sample path.
* `samp_bp` is emitted through smpb -> inverter rather than straight
* off the OR so that it lands at the SAME logic depth as each cell's
* `rel`, which is AND(engb, smpb). Those two legs are complementary
* across the sample boundary, so a one-gate depth difference would
* leave every cell driving V_in and V_cm together for 0.2 ns.
a_samp4 [ph0 ph1 ph2 ph3] samp4 sarl_or
a_samptp [ph0 ph1 ph2] samp_tp sarl_or
a_smpb samp4 smpb sarl_inv
a_sampbp smpb samp_bp sarl_inv
* The comparator decision, inverted once here into output-bit
* polarity: bottom-plate sampling inverts the residue with respect to
* the input (DR-0014). See the header's sign-convention note.
a_dec cmp dec sarl_inv
a_drdy ph15 drdy_n sarl_inv
a_drdy2 drdy_n drdy sarl_inv
xs256 clk dec mode ph4 ph13 smpb q9 q9b rel_256p hi_256p lo_256p rel_256n hi_256n lo_256n sar_slice
xs128 clk dec mode ph5 ph13 smpb q8 q8b rel_128p hi_128p lo_128p rel_128n hi_128n lo_128n sar_slice
xs64 clk dec mode ph6 ph13 smpb q7 q7b rel_64p hi_64p lo_64p rel_64n hi_64n lo_64n sar_slice
xs32 clk dec mode ph7 ph13 smpb q6 q6b rel_32p hi_32p lo_32p rel_32n hi_32n lo_32n sar_slice
xs16 clk dec mode ph8 ph13 smpb q5 q5b rel_16p hi_16p lo_16p rel_16n hi_16n lo_16n sar_slice
xs8 clk dec mode ph9 ph13 smpb q4 q4b rel_8p hi_8p lo_8p rel_8n hi_8n lo_8n sar_slice
xs4 clk dec mode ph10 ph13 smpb q3 q3b rel_4p hi_4p lo_4p rel_4n hi_4n lo_4n sar_slice
xs2 clk dec mode ph11 ph13 smpb q2 q2b rel_2p hi_2p lo_2p rel_2n hi_2n lo_2n sar_slice
xs1 clk dec mode ph12 ph13 smpb q1 q1b rel_1p hi_1p lo_1p rel_1n hi_1n lo_1n sar_slice
xb0 clk dec ph13 q0 q0b sar_bitreg
* 10-bit parallel output register (DR-0005: in scope, SPI deferred)
xo9 clk q9 ph14 b9 b9b sar_bitreg
xo8 clk q8 ph14 b8 b8b sar_bitreg
xo7 clk q7 ph14 b7 b7b sar_bitreg
xo6 clk q6 ph14 b6 b6b sar_bitreg
xo5 clk q5 ph14 b5 b5b sar_bitreg
xo4 clk q4 ph14 b4 b4b sar_bitreg
xo3 clk q3 ph14 b3 b3b sar_bitreg
xo2 clk q2 ph14 b2 b2b sar_bitreg
xo1 clk q1 ph14 b1 b1b sar_bitreg
xo0 clk q0 ph14 b0 b0b sar_bitreg
.ends sar_ctrl

* --- analog-boundary wrapper ----------------------------------------
* Presents the controller at the analog boundary with the port names
* design/cdac/cdac_array.sch uses, so the two connect directly. Only
* the NMOS-gate (active-high) half of each T-gate leg is routed out of
* the controller; `sar_tgate_drv` below makes the PMOS gate locally at
* the cell. Bridges are VECTOR instances on purpose: 54 scalar
* dac_bridges would put 54 separate sources in the analog matrix.
* DR-0014's two additions ride on the SCALAR bridge group with drdy
* and the code bits, not on the 54-wide array bus: `sel_in_n` is one
* broadcast net feeding every cell's fourth leg and `samp_tp_n` is the
* per-side top-plate switch, so the array control bus grows from 54 to
* 55 wires, not to 72.
.subckt sar_ctrl_a clk start mode cmp samp_tp_n sel_in_n drdy c9 c8 c7 c6
+ c5 c4 c3 c2 c1 c0 rel_n_256p sel_hi_n_256p sel_lo_n_256p rel_n_128p
+ sel_hi_n_128p sel_lo_n_128p rel_n_64p sel_hi_n_64p sel_lo_n_64p
+ rel_n_32p sel_hi_n_32p sel_lo_n_32p rel_n_16p sel_hi_n_16p sel_lo_n_16p
+ rel_n_8p sel_hi_n_8p sel_lo_n_8p rel_n_4p sel_hi_n_4p sel_lo_n_4p
+ rel_n_2p sel_hi_n_2p sel_lo_n_2p rel_n_1p sel_hi_n_1p sel_lo_n_1p
+ rel_n_256n sel_hi_n_256n sel_lo_n_256n rel_n_128n sel_hi_n_128n
+ sel_lo_n_128n rel_n_64n sel_hi_n_64n sel_lo_n_64n rel_n_32n sel_hi_n_32n
+ sel_lo_n_32n rel_n_16n sel_hi_n_16n sel_lo_n_16n rel_n_8n sel_hi_n_8n
+ sel_lo_n_8n rel_n_4n sel_hi_n_4n sel_lo_n_4n rel_n_2n sel_hi_n_2n
+ sel_lo_n_2n rel_n_1n sel_hi_n_1n sel_lo_n_1n
a_in [clk start mode cmp] [dclk dstart dmode dcmp] sarl_adc
xctrl dclk dstart dmode dcmp dsamp_tp dsamp_bp ddrdy db9 db8 db7 db6 db5
+ db4 db3 db2 db1 db0 drel_256p dhi_256p dlo_256p drel_128p dhi_128p
+ dlo_128p drel_64p dhi_64p dlo_64p drel_32p dhi_32p dlo_32p drel_16p
+ dhi_16p dlo_16p drel_8p dhi_8p dlo_8p drel_4p dhi_4p dlo_4p drel_2p
+ dhi_2p dlo_2p drel_1p dhi_1p dlo_1p drel_256n dhi_256n dlo_256n
+ drel_128n dhi_128n dlo_128n drel_64n dhi_64n dlo_64n drel_32n dhi_32n
+ dlo_32n drel_16n dhi_16n dlo_16n drel_8n dhi_8n dlo_8n drel_4n dhi_4n
+ dlo_4n drel_2n dhi_2n dlo_2n drel_1n dhi_1n dlo_1n sar_ctrl
a_dout [dsamp_tp dsamp_bp ddrdy db9 db8 db7 db6 db5 db4 db3 db2 db1 db0]
+ [samp_tp_n sel_in_n drdy c9 c8 c7 c6 c5 c4 c3 c2 c1 c0] sarl_dac
a_gn [drel_256p dhi_256p dlo_256p drel_128p dhi_128p dlo_128p drel_64p dhi_64p dlo_64p drel_32p dhi_32p dlo_32p drel_16p dhi_16p dlo_16p drel_8p dhi_8p dlo_8p drel_4p dhi_4p dlo_4p drel_2p dhi_2p dlo_2p drel_1p dhi_1p dlo_1p drel_256n dhi_256n dlo_256n drel_128n dhi_128n dlo_128n drel_64n dhi_64n dlo_64n drel_32n dhi_32n dlo_32n drel_16n dhi_16n dlo_16n drel_8n dhi_8n dlo_8n drel_4n dhi_4n dlo_4n drel_2n dhi_2n dlo_2n drel_1n dhi_1n dlo_1n]
+ [rel_n_256p sel_hi_n_256p sel_lo_n_256p rel_n_128p sel_hi_n_128p sel_lo_n_128p rel_n_64p sel_hi_n_64p sel_lo_n_64p rel_n_32p sel_hi_n_32p sel_lo_n_32p rel_n_16p sel_hi_n_16p sel_lo_n_16p rel_n_8p sel_hi_n_8p sel_lo_n_8p rel_n_4p sel_hi_n_4p sel_lo_n_4p rel_n_2p sel_hi_n_2p sel_lo_n_2p rel_n_1p sel_hi_n_1p sel_lo_n_1p rel_n_256n sel_hi_n_256n sel_lo_n_256n rel_n_128n sel_hi_n_128n sel_lo_n_128n rel_n_64n sel_hi_n_64n sel_lo_n_64n rel_n_32n sel_hi_n_32n sel_lo_n_32n rel_n_16n sel_hi_n_16n sel_lo_n_16n rel_n_8n sel_hi_n_8n sel_lo_n_8n rel_n_4n sel_hi_n_4n sel_lo_n_4n rel_n_2n sel_hi_n_2n sel_lo_n_2n rel_n_1n sel_hi_n_1n sel_lo_n_1n] sarl_dac
.ends sar_ctrl_a

* --- local T-gate driver -------------------------------------------
* One per T-gate leg, placed with the CDAC cell (#15/#16), not with
* the controller: `gn` is the controller's active-high control and
* `gp` the complementary PMOS gate. Modelled as an ideal inverter at
* rung 1; at rung 3 it is one standard-cell inverter.
.subckt sar_tgate_drv gn gp
a_adc gn dgn sarl_adc
a_inv dgn dgp sarl_inv
a_dac dgp gp sarl_dac
.ends sar_tgate_drv

* Bridge models. Thresholds and rails track the PVT point's supply, so
* the supply axis of the corner grid actually moves something in this
* otherwise PVT-invariant model.
.model sarl_adc adc_bridge(in_low={vdd_val*0.4} in_high={vdd_val*0.6})
.model sarl_dac dac_bridge(out_low=0 out_high={vdd_val}
+ out_undef={vdd_val/2} t_rise=0.3n t_fall=0.3n)

* REMEDIATED extracted core -- NOT raw `klt extract` output.
* Produced by layout/adc-top/parasitics/remediate_extracted.py:
*   - 148 PMOS body terminals retied to 'vdd'
*     (local remediation of the klt PMOS-body gap; upstream klayout-tools#555).
*   - input rails pinp/pinn promoted to pins vinp/vinn (sampled-input port gap).
*   - 1024 MiM caps left as native PDK 'cap_mim_2f0_m4m5_noshield' subckt calls.
* See remediate_extracted.py's module docstring for provenance.
* parasitic model (--parasitics):
* - capacitance: net-to-ground for every net's own (non-coupled) area/perimeter, plus net-to-net for the vertical-overlap coupling `coupling` describes below -- a coupled net pair gets a direct capacitor between their two hub nodes, not just capacitors to the deck's ground/substrate net
* - coupling: vertical overlap (crossover) unconditionally -- where one net's conductor on an adjacent metal level sits directly over another *distinct* net's conductor, that overlap area is charged between the two nets instead of to ground (issue #760) -- plus lateral (same-layer, sidewall) coupling, but only for a net pair naming one of the caller's declared `--critical-net` nets (issue #976): facing-edge length within that layer's own minimum-spacing lookback is charged between the two nets, *additively* (not deducted from either net's substrate fringe term, unlike the vertical case -- a known simplification). Any same-layer pair with neither side named `--critical-net`, and fringe shielding in general, are still not modelled
* - resistance: single lumped series resistance per net, distributed as a star across that net's device terminals (issue #592) -- not a per-segment, distributed RC ladder, *unless* `--distributed-rc` names this net via `--critical-net` (issue #977, Epic #709 Phase 2b): then the net's terminals are ordered along their approximate physical spread and its total R/C is broken into a chain of per-segment resistors (segment length proportional to inter-terminal distance) with a ground capacitor at each terminal node (proportional to its adjacent segment length/2), instead of one star hub -- still an approximation (terminal position is a device-placement proxy, not true per-segment routing geometry), but a strictly finer-grained one than the single-hub star
* - frequency: quasi-static -- one frequency-independent R and C per net; no skin effect, no distributed transmission-line behavior
* cell ADC_TOP
* pin hi_128_n
* pin hi_128_p
* pin hi_16_n
* pin hi_16_p
* pin hi_1_n
* pin hi_1_p
* pin hi_256_n
* pin hi_256_p
* pin hi_2_n
* pin hi_2_p
* pin hi_32_n
* pin hi_32_p
* pin hi_4_n
* pin hi_4_p
* pin hi_64_n
* pin hi_64_p
* pin hi_8_n
* pin hi_8_p
* pin lo_128_n
* pin lo_128_p
* pin lo_16_n
* pin lo_16_p
* pin lo_1_n
* pin lo_1_p
* pin lo_256_n
* pin lo_256_p
* pin lo_2_n
* pin lo_2_p
* pin lo_32_n
* pin lo_32_p
* pin lo_4_n
* pin lo_4_p
* pin lo_64_n
* pin lo_64_p
* pin lo_8_n
* pin lo_8_p
* pin pinn
* pin pinp
* pin rel_128_n
* pin rel_128_p
* pin rel_16_n
* pin rel_16_p
* pin rel_1_n
* pin rel_1_p
* pin rel_256_n
* pin rel_256_p
* pin rel_2_n
* pin rel_2_p
* pin rel_32_n
* pin rel_32_p
* pin rel_4_n
* pin rel_4_p
* pin rel_64_n
* pin rel_64_p
* pin rel_8_n
* pin rel_8_p
* pin sel_in
* pin topn
* pin topp
* pin tp_gn
* pin vcm
* pin vdd
* pin vref
* pin vss
* pin vsubs
.SUBCKT ADC_TOP hi_128_n hi_128_p hi_16_n hi_16_p hi_1_n hi_1_p hi_256_n hi_256_p hi_2_n hi_2_p hi_32_n hi_32_p hi_4_n hi_4_p hi_64_n hi_64_p hi_8_n hi_8_p lo_128_n lo_128_p lo_16_n lo_16_p lo_1_n lo_1_p lo_256_n lo_256_p lo_2_n lo_2_p lo_32_n lo_32_p lo_4_n lo_4_p lo_64_n lo_64_p lo_8_n lo_8_p rel_128_n rel_128_p rel_16_n rel_16_p rel_1_n rel_1_p rel_256_n rel_256_p rel_2_n rel_2_p rel_32_n rel_32_p rel_4_n rel_4_p rel_64_n rel_64_p rel_8_n rel_8_p sel_in topn topp tp_gn vcm vdd vref vss vsubs vinp vinn
* device instance $1 r0 *1 1.275,2 nfet
X$1 \$65__t0 sel_in__t0 vss__t0 vsubs nfet_03v3 L=0.35U W=4U AS=4.4P AD=4.4P PS=10.2U PD=10.2U
* device instance $2 r0 *1 4.225,2 nfet
X$2 \$27__t2 rel_256_p__t2 vss__t46 vsubs nfet_03v3 L=0.35U W=4U AS=4.4P AD=4.4P PS=10.2U PD=10.2U
* device instance $3 r0 *1 7.175,2 nfet
X$3 \$29__t2 hi_256_p__t2 vss__t45 vsubs nfet_03v3 L=0.35U W=4U AS=4.4P AD=4.4P PS=10.2U PD=10.2U
* device instance $4 r0 *1 10.125,2 nfet
X$4 \$9__t2 lo_256_p__t2 vss__t44 vsubs nfet_03v3 L=0.35U W=4U AS=4.4P AD=4.4P PS=10.2U PD=10.2U
* device instance $5 r0 *1 13.04,5 nfet
X$5 vinp__t0 sel_in__t1 \$10__t0 vsubs nfet_03v3 L=0.28U W=10U AS=11P AD=11P PS=22.2U PD=22.2U
* device instance $6 r0 *1 15.92,5 nfet
X$6 vcm__t27 rel_256_p__t1 \$10__t262 vsubs nfet_03v3 L=0.28U W=10U AS=11P AD=11P PS=22.2U PD=22.2U
* device instance $7 r0 *1 18.8,5 nfet
X$7 vref__t21 hi_256_p__t1 \$10__t261 vsubs nfet_03v3 L=0.28U W=10U AS=11P AD=11P PS=22.2U PD=22.2U
* device instance $8 r0 *1 21.68,5 nfet
X$8 vss__t24 lo_256_p__t1 \$10__t263 vsubs nfet_03v3 L=0.28U W=10U AS=11P AD=11P PS=22.2U PD=22.2U
* device instance $9 r0 *1 49.715,2 nfet
X$9 \$67__t2 sel_in__t50 vss__t94 vsubs nfet_03v3 L=0.35U W=4U AS=4.4P AD=4.4P PS=10.2U PD=10.2U
* device instance $10 r0 *1 52.665,2 nfet
X$10 \$31__t2 rel_128_p__t2 vss__t109 vsubs nfet_03v3 L=0.35U W=4U AS=4.4P AD=4.4P PS=10.2U PD=10.2U
* device instance $11 r0 *1 55.615,2 nfet
X$11 \$33__t2 hi_128_p__t2 vss__t96 vsubs nfet_03v3 L=0.35U W=4U AS=4.4P AD=4.4P PS=10.2U PD=10.2U
* device instance $12 r0 *1 58.565,2 nfet
X$12 \$11__t2 lo_128_p__t2 vss__t99 vsubs nfet_03v3 L=0.35U W=4U AS=4.4P AD=4.4P PS=10.2U PD=10.2U
* device instance $13 r0 *1 61.48,5 nfet
X$13 vinp__t12 sel_in__t25 \$12__t132 vsubs nfet_03v3 L=0.28U W=10U AS=11P AD=11P PS=22.2U PD=22.2U
* device instance $14 r0 *1 64.36,5 nfet
X$14 vcm__t30 rel_128_p__t1 \$12__t133 vsubs nfet_03v3 L=0.28U W=10U AS=11P AD=11P PS=22.2U PD=22.2U
* device instance $15 r0 *1 67.24,5 nfet
X$15 vref__t23 hi_128_p__t1 \$12__t134 vsubs nfet_03v3 L=0.28U W=10U AS=11P AD=11P PS=22.2U PD=22.2U
* device instance $16 r0 *1 70.12,5 nfet
X$16 vss__t25 lo_128_p__t1 \$12__t135 vsubs nfet_03v3 L=0.28U W=10U AS=11P AD=11P PS=22.2U PD=22.2U
* device instance $17 r0 *1 98.155,2 nfet
X$17 \$69__t2 sel_in__t52 vss__t102 vsubs nfet_03v3 L=0.35U W=4U AS=4.4P AD=4.4P PS=10.2U PD=10.2U
* device instance $18 r0 *1 101.105,2 nfet
X$18 \$35__t2 rel_64_p__t2 vss__t103 vsubs nfet_03v3 L=0.35U W=4U AS=4.4P AD=4.4P PS=10.2U PD=10.2U
* device instance $19 r0 *1 104.055,2 nfet
X$19 \$37__t2 hi_64_p__t2 vss__t104 vsubs nfet_03v3 L=0.35U W=4U AS=4.4P AD=4.4P PS=10.2U PD=10.2U
* device instance $20 r0 *1 107.005,2 nfet
X$20 \$13__t2 lo_64_p__t2 vss__t105 vsubs nfet_03v3 L=0.35U W=4U AS=4.4P AD=4.4P PS=10.2U PD=10.2U
* device instance $21 r0 *1 109.92,5 nfet
X$21 vinp__t13 sel_in__t26 \$14__t68 vsubs nfet_03v3 L=0.28U W=10U AS=11P AD=11P PS=22.2U PD=22.2U
* device instance $22 r0 *1 112.8,5 nfet
X$22 vcm__t31 rel_64_p__t1 \$14__t69 vsubs nfet_03v3 L=0.28U W=10U AS=11P AD=11P PS=22.2U PD=22.2U
* device instance $23 r0 *1 115.68,5 nfet
X$23 vref__t32 hi_64_p__t1 \$14__t71 vsubs nfet_03v3 L=0.28U W=10U AS=11P AD=11P PS=22.2U PD=22.2U
* device instance $24 r0 *1 118.56,5 nfet
X$24 vss__t29 lo_64_p__t1 \$14__t70 vsubs nfet_03v3 L=0.28U W=10U AS=11P AD=11P PS=22.2U PD=22.2U
* device instance $25 r0 *1 146.595,2 nfet
X$25 \$71__t2 sel_in__t46 vss__t76 vsubs nfet_03v3 L=0.35U W=4U AS=4.4P AD=4.4P PS=10.2U PD=10.2U
* device instance $26 r0 *1 149.545,2 nfet
X$26 \$39__t2 rel_32_p__t2 vss__t75 vsubs nfet_03v3 L=0.35U W=4U AS=4.4P AD=4.4P PS=10.2U PD=10.2U
* device instance $27 r0 *1 152.495,2 nfet
X$27 \$41__t2 hi_32_p__t2 vss__t65 vsubs nfet_03v3 L=0.35U W=4U AS=4.4P AD=4.4P PS=10.2U PD=10.2U
* device instance $28 r0 *1 155.445,2 nfet
X$28 \$15__t2 lo_32_p__t2 vss__t70 vsubs nfet_03v3 L=0.35U W=4U AS=4.4P AD=4.4P PS=10.2U PD=10.2U
* device instance $29 r0 *1 158.36,5 nfet
X$29 vinp__t16 sel_in__t31 \$16__t37 vsubs nfet_03v3 L=0.28U W=10U AS=11P AD=11P PS=22.2U PD=22.2U
* device instance $30 r0 *1 161.24,5 nfet
X$30 vcm__t35 rel_32_p__t1 \$16__t38 vsubs nfet_03v3 L=0.28U W=10U AS=11P AD=11P PS=22.2U PD=22.2U
* device instance $31 r0 *1 164.12,5 nfet
X$31 vref__t30 hi_32_p__t1 \$16__t39 vsubs nfet_03v3 L=0.28U W=10U AS=11P AD=11P PS=22.2U PD=22.2U
* device instance $32 r0 *1 167,5 nfet
X$32 vss__t28 lo_32_p__t1 \$16__t36 vsubs nfet_03v3 L=0.28U W=10U AS=11P AD=11P PS=22.2U PD=22.2U
* device instance $33 r0 *1 195.035,2 nfet
X$33 \$73__t2 sel_in__t45 vss__t71 vsubs nfet_03v3 L=0.35U W=4U AS=4.4P AD=4.4P PS=10.2U PD=10.2U
* device instance $34 r0 *1 197.985,2 nfet
X$34 \$43__t2 rel_16_p__t2 vss__t72 vsubs nfet_03v3 L=0.35U W=4U AS=4.4P AD=4.4P PS=10.2U PD=10.2U
* device instance $35 r0 *1 200.935,2 nfet
X$35 \$45__t2 hi_16_p__t2 vss__t73 vsubs nfet_03v3 L=0.35U W=4U AS=4.4P AD=4.4P PS=10.2U PD=10.2U
* device instance $36 r0 *1 203.885,2 nfet
X$36 \$17__t2 lo_16_p__t2 vss__t74 vsubs nfet_03v3 L=0.35U W=4U AS=4.4P AD=4.4P PS=10.2U PD=10.2U
* device instance $37 r0 *1 206.8,5 nfet
X$37 vinp__t17 sel_in__t32 \$18__t23 vsubs nfet_03v3 L=0.28U W=10U AS=11P AD=11P PS=22.2U PD=22.2U
* device instance $38 r0 *1 209.68,5 nfet
X$38 vcm__t33 rel_16_p__t1 \$18__t20 vsubs nfet_03v3 L=0.28U W=10U AS=11P AD=11P PS=22.2U PD=22.2U
* device instance $39 r0 *1 212.56,5 nfet
X$39 vref__t29 hi_16_p__t1 \$18__t21 vsubs nfet_03v3 L=0.28U W=10U AS=11P AD=11P PS=22.2U PD=22.2U
* device instance $40 r0 *1 215.44,5 nfet
X$40 vss__t32 lo_16_p__t1 \$18__t22 vsubs nfet_03v3 L=0.28U W=10U AS=11P AD=11P PS=22.2U PD=22.2U
* device instance $41 r0 *1 243.475,2 nfet
X$41 \$75__t2 sel_in__t38 vss__t41 vsubs nfet_03v3 L=0.35U W=4U AS=4.4P AD=4.4P PS=10.2U PD=10.2U
* device instance $42 r0 *1 246.425,2 nfet
X$42 \$47__t2 rel_8_p__t2 vss__t67 vsubs nfet_03v3 L=0.35U W=4U AS=4.4P AD=4.4P PS=10.2U PD=10.2U
* device instance $43 r0 *1 249.375,2 nfet
X$43 \$49__t2 hi_8_p__t2 vss__t83 vsubs nfet_03v3 L=0.35U W=4U AS=4.4P AD=4.4P PS=10.2U PD=10.2U
* device instance $44 r0 *1 252.325,2 nfet
X$44 \$19__t2 lo_8_p__t2 vss__t38 vsubs nfet_03v3 L=0.35U W=4U AS=4.4P AD=4.4P PS=10.2U PD=10.2U
* device instance $45 r0 *1 255.24,5 nfet
X$45 vinp__t11 sel_in__t24 \$20__t12 vsubs nfet_03v3 L=0.28U W=10U AS=11P AD=11P PS=22.2U PD=22.2U
* device instance $46 r0 *1 258.12,5 nfet
X$46 vcm__t26 rel_8_p__t1 \$20__t13 vsubs nfet_03v3 L=0.28U W=10U AS=11P AD=11P PS=22.2U PD=22.2U
* device instance $47 r0 *1 261,5 nfet
X$47 vref__t20 hi_8_p__t1 \$20__t14 vsubs nfet_03v3 L=0.28U W=10U AS=11P AD=11P PS=22.2U PD=22.2U
* device instance $48 r0 *1 263.88,5 nfet
X$48 vss__t22 lo_8_p__t1 \$20__t15 vsubs nfet_03v3 L=0.28U W=10U AS=11P AD=11P PS=22.2U PD=22.2U
* device instance $49 r0 *1 291.915,2 nfet
X$49 \$77__t2 sel_in__t51 vss__t101 vsubs nfet_03v3 L=0.35U W=4U AS=4.4P AD=4.4P PS=10.2U PD=10.2U
* device instance $50 r0 *1 294.865,2 nfet
X$50 \$51__t2 rel_4_p__t2 vss__t100 vsubs nfet_03v3 L=0.35U W=4U AS=4.4P AD=4.4P PS=10.2U PD=10.2U
* device instance $51 r0 *1 297.815,2 nfet
X$51 \$53__t2 hi_4_p__t2 vss__t98 vsubs nfet_03v3 L=0.35U W=4U AS=4.4P AD=4.4P PS=10.2U PD=10.2U
* device instance $52 r0 *1 300.765,2 nfet
X$52 \$21__t2 lo_4_p__t2 vss__t97 vsubs nfet_03v3 L=0.35U W=4U AS=4.4P AD=4.4P PS=10.2U PD=10.2U
* device instance $53 r0 *1 303.68,5 nfet
X$53 vinp__t14 sel_in__t28 \$22__t11 vsubs nfet_03v3 L=0.28U W=10U AS=11P AD=11P PS=22.2U PD=22.2U
* device instance $54 r0 *1 306.56,5 nfet
X$54 vcm__t28 rel_4_p__t1 \$22__t10 vsubs nfet_03v3 L=0.28U W=10U AS=11P AD=11P PS=22.2U PD=22.2U
* device instance $55 r0 *1 309.44,5 nfet
X$55 vref__t22 hi_4_p__t1 \$22__t9 vsubs nfet_03v3 L=0.28U W=10U AS=11P AD=11P PS=22.2U PD=22.2U
* device instance $56 r0 *1 312.32,5 nfet
X$56 vss__t23 lo_4_p__t1 \$22__t8 vsubs nfet_03v3 L=0.28U W=10U AS=11P AD=11P PS=22.2U PD=22.2U
* device instance $57 r0 *1 340.355,2 nfet
X$57 \$79__t2 sel_in__t49 vss__t93 vsubs nfet_03v3 L=0.35U W=4U AS=4.4P AD=4.4P PS=10.2U PD=10.2U
* device instance $58 r0 *1 343.305,2 nfet
X$58 \$55__t2 rel_2_p__t2 vss__t92 vsubs nfet_03v3 L=0.35U W=4U AS=4.4P AD=4.4P PS=10.2U PD=10.2U
* device instance $59 r0 *1 346.255,2 nfet
X$59 \$57__t2 hi_2_p__t2 vss__t85 vsubs nfet_03v3 L=0.35U W=4U AS=4.4P AD=4.4P PS=10.2U PD=10.2U
* device instance $60 r0 *1 349.205,2 nfet
X$60 \$23__t2 lo_2_p__t2 vss__t84 vsubs nfet_03v3 L=0.35U W=4U AS=4.4P AD=4.4P PS=10.2U PD=10.2U
* device instance $61 r0 *1 352.12,5 nfet
X$61 vinp__t10 sel_in__t23 \$24__t6 vsubs nfet_03v3 L=0.28U W=10U AS=11P AD=11P PS=22.2U PD=22.2U
* device instance $62 r0 *1 355,5 nfet
X$62 vcm__t32 rel_2_p__t1 \$24__t7 vsubs nfet_03v3 L=0.28U W=10U AS=11P AD=11P PS=22.2U PD=22.2U
* device instance $63 r0 *1 357.88,5 nfet
X$63 vref__t27 hi_2_p__t1 \$24__t8 vsubs nfet_03v3 L=0.28U W=10U AS=11P AD=11P PS=22.2U PD=22.2U
* device instance $64 r0 *1 360.76,5 nfet
X$64 vss__t30 lo_2_p__t1 \$24__t9 vsubs nfet_03v3 L=0.28U W=10U AS=11P AD=11P PS=22.2U PD=22.2U
* device instance $65 r0 *1 388.795,2 nfet
X$65 \$81__t2 sel_in__t39 vss__t48 vsubs nfet_03v3 L=0.35U W=4U AS=4.4P AD=4.4P PS=10.2U PD=10.2U
* device instance $66 r0 *1 391.745,2 nfet
X$66 \$59__t2 rel_1_p__t2 vss__t47 vsubs nfet_03v3 L=0.35U W=4U AS=4.4P AD=4.4P PS=10.2U PD=10.2U
* device instance $67 r0 *1 394.695,2 nfet
X$67 \$61__t2 hi_1_p__t2 vss__t43 vsubs nfet_03v3 L=0.35U W=4U AS=4.4P AD=4.4P PS=10.2U PD=10.2U
* device instance $68 r0 *1 397.645,2 nfet
X$68 \$25__t2 lo_1_p__t2 vss__t42 vsubs nfet_03v3 L=0.35U W=4U AS=4.4P AD=4.4P PS=10.2U PD=10.2U
* device instance $69 r0 *1 400.56,5 nfet
X$69 vinp__t15 sel_in__t30 \$26__t8 vsubs nfet_03v3 L=0.28U W=10U AS=11P AD=11P PS=22.2U PD=22.2U
* device instance $70 r0 *1 403.44,5 nfet
X$70 vcm__t34 rel_1_p__t1 \$26__t7 vsubs nfet_03v3 L=0.28U W=10U AS=11P AD=11P PS=22.2U PD=22.2U
* device instance $71 r0 *1 406.32,5 nfet
X$71 vref__t28 hi_1_p__t1 \$26__t6 vsubs nfet_03v3 L=0.28U W=10U AS=11P AD=11P PS=22.2U PD=22.2U
* device instance $72 r0 *1 409.2,5 nfet
X$72 vss__t21 lo_1_p__t1 \$26__t5 vsubs nfet_03v3 L=0.28U W=10U AS=11P AD=11P PS=22.2U PD=22.2U
* device instance $73 r0 *1 1.275,35.15 nfet
X$73 \$83__t2 sel_in__t53 vss__t107 vsubs nfet_03v3 L=0.35U W=4U AS=4.4P AD=4.4P PS=10.2U PD=10.2U
* device instance $74 r0 *1 4.225,35.15 nfet
X$74 \$85__t2 rel_256_n__t2 vss__t108 vsubs nfet_03v3 L=0.35U W=4U AS=4.4P AD=4.4P PS=10.2U PD=10.2U
* device instance $75 r0 *1 7.175,35.15 nfet
X$75 \$87__t2 hi_256_n__t2 vss__t95 vsubs nfet_03v3 L=0.35U W=4U AS=4.4P AD=4.4P PS=10.2U PD=10.2U
* device instance $76 r0 *1 10.125,35.15 nfet
X$76 \$89__t2 lo_256_n__t2 vss__t55 vsubs nfet_03v3 L=0.35U W=4U AS=4.4P AD=4.4P PS=10.2U PD=10.2U
* device instance $77 r0 *1 13.04,38.15 nfet
X$77 vinn__t13 sel_in__t29 \$90__t261 vsubs nfet_03v3 L=0.28U W=10U AS=11P AD=11P PS=22.2U PD=22.2U
* device instance $78 r0 *1 15.92,38.15 nfet
X$78 vcm__t41 rel_256_n__t1 \$90__t263 vsubs nfet_03v3 L=0.28U W=10U AS=11P AD=11P PS=22.2U PD=22.2U
* device instance $79 r0 *1 18.8,38.15 nfet
X$79 vref__t26 hi_256_n__t1 \$90__t260 vsubs nfet_03v3 L=0.28U W=10U AS=11P AD=11P PS=22.2U PD=22.2U
* device instance $80 r0 *1 21.68,38.15 nfet
X$80 vss__t31 lo_256_n__t1 \$90__t262 vsubs nfet_03v3 L=0.28U W=10U AS=11P AD=11P PS=22.2U PD=22.2U
* device instance $81 r0 *1 49.715,35.15 nfet
X$81 \$92__t2 sel_in__t43 vss__t62 vsubs nfet_03v3 L=0.35U W=4U AS=4.4P AD=4.4P PS=10.2U PD=10.2U
* device instance $82 r0 *1 52.665,35.15 nfet
X$82 \$94__t2 rel_128_n__t2 vss__t63 vsubs nfet_03v3 L=0.35U W=4U AS=4.4P AD=4.4P PS=10.2U PD=10.2U
* device instance $83 r0 *1 55.615,35.15 nfet
X$83 \$96__t2 hi_128_n__t2 vss__t64 vsubs nfet_03v3 L=0.35U W=4U AS=4.4P AD=4.4P PS=10.2U PD=10.2U
* device instance $84 r0 *1 58.565,35.15 nfet
X$84 \$98__t2 lo_128_n__t2 vss__t106 vsubs nfet_03v3 L=0.35U W=4U AS=4.4P AD=4.4P PS=10.2U PD=10.2U
* device instance $85 r0 *1 61.48,38.15 nfet
X$85 vinn__t17 sel_in__t36 \$99__t135 vsubs nfet_03v3 L=0.28U W=10U AS=11P AD=11P PS=22.2U PD=22.2U
* device instance $86 r0 *1 64.36,38.15 nfet
X$86 vcm__t40 rel_128_n__t1 \$99__t134 vsubs nfet_03v3 L=0.28U W=10U AS=11P AD=11P PS=22.2U PD=22.2U
* device instance $87 r0 *1 67.24,38.15 nfet
X$87 vref__t31 hi_128_n__t1 \$99__t133 vsubs nfet_03v3 L=0.28U W=10U AS=11P AD=11P PS=22.2U PD=22.2U
* device instance $88 r0 *1 70.12,38.15 nfet
X$88 vss__t33 lo_128_n__t1 \$99__t132 vsubs nfet_03v3 L=0.28U W=10U AS=11P AD=11P PS=22.2U PD=22.2U
* device instance $89 r0 *1 98.155,35.15 nfet
X$89 \$100__t2 sel_in__t42 vss__t56 vsubs nfet_03v3 L=0.35U W=4U AS=4.4P AD=4.4P PS=10.2U PD=10.2U
* device instance $90 r0 *1 101.105,35.15 nfet
X$90 \$102__t2 rel_64_n__t2 vss__t59 vsubs nfet_03v3 L=0.35U W=4U AS=4.4P AD=4.4P PS=10.2U PD=10.2U
* device instance $91 r0 *1 104.055,35.15 nfet
X$91 \$104__t2 hi_64_n__t2 vss__t60 vsubs nfet_03v3 L=0.35U W=4U AS=4.4P AD=4.4P PS=10.2U PD=10.2U
* device instance $92 r0 *1 107.005,35.15 nfet
X$92 \$106__t2 lo_64_n__t2 vss__t61 vsubs nfet_03v3 L=0.35U W=4U AS=4.4P AD=4.4P PS=10.2U PD=10.2U
* device instance $93 r0 *1 109.92,38.15 nfet
X$93 vinn__t14 sel_in__t33 \$107__t71 vsubs nfet_03v3 L=0.28U W=10U AS=11P AD=11P PS=22.2U PD=22.2U
* device instance $94 r0 *1 112.8,38.15 nfet
X$94 vcm__t36 rel_64_n__t1 \$107__t70 vsubs nfet_03v3 L=0.28U W=10U AS=11P AD=11P PS=22.2U PD=22.2U
* device instance $95 r0 *1 115.68,38.15 nfet
X$95 vref__t25 hi_64_n__t1 \$107__t68 vsubs nfet_03v3 L=0.28U W=10U AS=11P AD=11P PS=22.2U PD=22.2U
* device instance $96 r0 *1 118.56,38.15 nfet
X$96 vss__t26 lo_64_n__t1 \$107__t69 vsubs nfet_03v3 L=0.28U W=10U AS=11P AD=11P PS=22.2U PD=22.2U
* device instance $97 r0 *1 146.595,35.15 nfet
X$97 \$108__t2 sel_in__t47 vss__t77 vsubs nfet_03v3 L=0.35U W=4U AS=4.4P AD=4.4P PS=10.2U PD=10.2U
* device instance $98 r0 *1 149.545,35.15 nfet
X$98 \$110__t2 rel_32_n__t2 vss__t78 vsubs nfet_03v3 L=0.35U W=4U AS=4.4P AD=4.4P PS=10.2U PD=10.2U
* device instance $99 r0 *1 152.495,35.15 nfet
X$99 \$112__t2 hi_32_n__t2 vss__t79 vsubs nfet_03v3 L=0.35U W=4U AS=4.4P AD=4.4P PS=10.2U PD=10.2U
* device instance $100 r0 *1 155.445,35.15 nfet
X$100 \$114__t2 lo_32_n__t2 vss__t80 vsubs nfet_03v3 L=0.35U W=4U AS=4.4P AD=4.4P PS=10.2U PD=10.2U
* device instance $101 r0 *1 158.36,38.15 nfet
X$101 vinn__t12 sel_in__t27 \$115__t39 vsubs nfet_03v3 L=0.28U W=10U AS=11P AD=11P PS=22.2U PD=22.2U
* device instance $102 r0 *1 161.24,38.15 nfet
X$102 vcm__t29 rel_32_n__t1 \$115__t37 vsubs nfet_03v3 L=0.28U W=10U AS=11P AD=11P PS=22.2U PD=22.2U
* device instance $103 r0 *1 164.12,38.15 nfet
X$103 vref__t24 hi_32_n__t1 \$115__t38 vsubs nfet_03v3 L=0.28U W=10U AS=11P AD=11P PS=22.2U PD=22.2U
* device instance $104 r0 *1 167,38.15 nfet
X$104 vss__t20 lo_32_n__t1 \$115__t36 vsubs nfet_03v3 L=0.28U W=10U AS=11P AD=11P PS=22.2U PD=22.2U
* device instance $105 r0 *1 195.035,35.15 nfet
X$105 \$116__t2 sel_in__t44 vss__t66 vsubs nfet_03v3 L=0.35U W=4U AS=4.4P AD=4.4P PS=10.2U PD=10.2U
* device instance $106 r0 *1 197.985,35.15 nfet
X$106 \$118__t2 rel_16_n__t2 vss__t81 vsubs nfet_03v3 L=0.35U W=4U AS=4.4P AD=4.4P PS=10.2U PD=10.2U
* device instance $107 r0 *1 200.935,35.15 nfet
X$107 \$120__t2 hi_16_n__t2 vss__t68 vsubs nfet_03v3 L=0.35U W=4U AS=4.4P AD=4.4P PS=10.2U PD=10.2U
* device instance $108 r0 *1 203.885,35.15 nfet
X$108 \$122__t2 lo_16_n__t2 vss__t69 vsubs nfet_03v3 L=0.35U W=4U AS=4.4P AD=4.4P PS=10.2U PD=10.2U
* device instance $109 r0 *1 206.8,38.15 nfet
X$109 vinn__t9 sel_in__t20 \$123__t22 vsubs nfet_03v3 L=0.28U W=10U AS=11P AD=11P PS=22.2U PD=22.2U
* device instance $110 r0 *1 209.68,38.15 nfet
X$110 vcm__t23 rel_16_n__t1 \$123__t20 vsubs nfet_03v3 L=0.28U W=10U AS=11P AD=11P PS=22.2U PD=22.2U
* device instance $111 r0 *1 212.56,38.15 nfet
X$111 vref__t18 hi_16_n__t1 \$123__t21 vsubs nfet_03v3 L=0.28U W=10U AS=11P AD=11P PS=22.2U PD=22.2U
* device instance $112 r0 *1 215.44,38.15 nfet
X$112 vss__t27 lo_16_n__t1 \$123__t23 vsubs nfet_03v3 L=0.28U W=10U AS=11P AD=11P PS=22.2U PD=22.2U
* device instance $113 r0 *1 243.475,35.15 nfet
X$113 \$124__t2 sel_in__t48 vss__t82 vsubs nfet_03v3 L=0.35U W=4U AS=4.4P AD=4.4P PS=10.2U PD=10.2U
* device instance $114 r0 *1 246.425,35.15 nfet
X$114 \$126__t2 rel_8_n__t2 vss__t91 vsubs nfet_03v3 L=0.35U W=4U AS=4.4P AD=4.4P PS=10.2U PD=10.2U
* device instance $115 r0 *1 249.375,35.15 nfet
X$115 \$128__t2 hi_8_n__t2 vss__t90 vsubs nfet_03v3 L=0.35U W=4U AS=4.4P AD=4.4P PS=10.2U PD=10.2U
* device instance $116 r0 *1 252.325,35.15 nfet
X$116 \$130__t2 lo_8_n__t2 vss__t89 vsubs nfet_03v3 L=0.35U W=4U AS=4.4P AD=4.4P PS=10.2U PD=10.2U
* device instance $117 r0 *1 255.24,38.15 nfet
X$117 vinn__t16 sel_in__t35 \$131__t15 vsubs nfet_03v3 L=0.28U W=10U AS=11P AD=11P PS=22.2U PD=22.2U
* device instance $118 r0 *1 258.12,38.15 nfet
X$118 vcm__t39 rel_8_n__t1 \$131__t14 vsubs nfet_03v3 L=0.28U W=10U AS=11P AD=11P PS=22.2U PD=22.2U
* device instance $119 r0 *1 261,38.15 nfet
X$119 vref__t35 hi_8_n__t1 \$131__t13 vsubs nfet_03v3 L=0.28U W=10U AS=11P AD=11P PS=22.2U PD=22.2U
* device instance $120 r0 *1 263.88,38.15 nfet
X$120 vss__t36 lo_8_n__t1 \$131__t12 vsubs nfet_03v3 L=0.28U W=10U AS=11P AD=11P PS=22.2U PD=22.2U
* device instance $121 r0 *1 291.915,35.15 nfet
X$121 \$132__t2 sel_in__t41 vss__t54 vsubs nfet_03v3 L=0.35U W=4U AS=4.4P AD=4.4P PS=10.2U PD=10.2U
* device instance $122 r0 *1 294.865,35.15 nfet
X$122 \$134__t2 rel_4_n__t2 vss__t88 vsubs nfet_03v3 L=0.35U W=4U AS=4.4P AD=4.4P PS=10.2U PD=10.2U
* device instance $123 r0 *1 297.815,35.15 nfet
X$123 \$136__t2 hi_4_n__t2 vss__t87 vsubs nfet_03v3 L=0.35U W=4U AS=4.4P AD=4.4P PS=10.2U PD=10.2U
* device instance $124 r0 *1 300.765,35.15 nfet
X$124 \$138__t2 lo_4_n__t2 vss__t86 vsubs nfet_03v3 L=0.35U W=4U AS=4.4P AD=4.4P PS=10.2U PD=10.2U
* device instance $125 r0 *1 303.68,38.15 nfet
X$125 vinn__t10 sel_in__t21 \$139__t11 vsubs nfet_03v3 L=0.28U W=10U AS=11P AD=11P PS=22.2U PD=22.2U
* device instance $126 r0 *1 306.56,38.15 nfet
X$126 vcm__t25 rel_4_n__t1 \$139__t10 vsubs nfet_03v3 L=0.28U W=10U AS=11P AD=11P PS=22.2U PD=22.2U
* device instance $127 r0 *1 309.44,38.15 nfet
X$127 vref__t19 hi_4_n__t1 \$139__t9 vsubs nfet_03v3 L=0.28U W=10U AS=11P AD=11P PS=22.2U PD=22.2U
* device instance $128 r0 *1 312.32,38.15 nfet
X$128 vss__t19 lo_4_n__t1 \$139__t8 vsubs nfet_03v3 L=0.28U W=10U AS=11P AD=11P PS=22.2U PD=22.2U
* device instance $129 r0 *1 340.355,35.15 nfet
X$129 \$140__t2 sel_in__t37 vss__t37 vsubs nfet_03v3 L=0.35U W=4U AS=4.4P AD=4.4P PS=10.2U PD=10.2U
* device instance $130 r0 *1 343.305,35.15 nfet
X$130 \$142__t2 rel_2_n__t2 vss__t53 vsubs nfet_03v3 L=0.35U W=4U AS=4.4P AD=4.4P PS=10.2U PD=10.2U
* device instance $131 r0 *1 346.255,35.15 nfet
X$131 \$144__t2 hi_2_n__t2 vss__t40 vsubs nfet_03v3 L=0.35U W=4U AS=4.4P AD=4.4P PS=10.2U PD=10.2U
* device instance $132 r0 *1 349.205,35.15 nfet
X$132 \$146__t2 lo_2_n__t2 vss__t39 vsubs nfet_03v3 L=0.35U W=4U AS=4.4P AD=4.4P PS=10.2U PD=10.2U
* device instance $133 r0 *1 352.12,38.15 nfet
X$133 vinn__t11 sel_in__t22 \$147__t6 vsubs nfet_03v3 L=0.28U W=10U AS=11P AD=11P PS=22.2U PD=22.2U
* device instance $134 r0 *1 355,38.15 nfet
X$134 vcm__t38 rel_2_n__t1 \$147__t9 vsubs nfet_03v3 L=0.28U W=10U AS=11P AD=11P PS=22.2U PD=22.2U
* device instance $135 r0 *1 357.88,38.15 nfet
X$135 vref__t34 hi_2_n__t1 \$147__t8 vsubs nfet_03v3 L=0.28U W=10U AS=11P AD=11P PS=22.2U PD=22.2U
* device instance $136 r0 *1 360.76,38.15 nfet
X$136 vss__t35 lo_2_n__t1 \$147__t7 vsubs nfet_03v3 L=0.28U W=10U AS=11P AD=11P PS=22.2U PD=22.2U
* device instance $137 r0 *1 388.795,35.15 nfet
X$137 \$148__t2 sel_in__t40 vss__t49 vsubs nfet_03v3 L=0.35U W=4U AS=4.4P AD=4.4P PS=10.2U PD=10.2U
* device instance $138 r0 *1 391.745,35.15 nfet
X$138 \$150__t2 rel_1_n__t2 vss__t50 vsubs nfet_03v3 L=0.35U W=4U AS=4.4P AD=4.4P PS=10.2U PD=10.2U
* device instance $139 r0 *1 394.695,35.15 nfet
X$139 \$152__t2 hi_1_n__t2 vss__t51 vsubs nfet_03v3 L=0.35U W=4U AS=4.4P AD=4.4P PS=10.2U PD=10.2U
* device instance $140 r0 *1 397.645,35.15 nfet
X$140 \$154__t2 lo_1_n__t2 vss__t52 vsubs nfet_03v3 L=0.35U W=4U AS=4.4P AD=4.4P PS=10.2U PD=10.2U
* device instance $141 r0 *1 400.56,38.15 nfet
X$141 vinn__t15 sel_in__t34 \$155__t8 vsubs nfet_03v3 L=0.28U W=10U AS=11P AD=11P PS=22.2U PD=22.2U
* device instance $142 r0 *1 403.44,38.15 nfet
X$142 vcm__t37 rel_1_n__t1 \$155__t7 vsubs nfet_03v3 L=0.28U W=10U AS=11P AD=11P PS=22.2U PD=22.2U
* device instance $143 r0 *1 406.32,38.15 nfet
X$143 vref__t33 hi_1_n__t1 \$155__t6 vsubs nfet_03v3 L=0.28U W=10U AS=11P AD=11P PS=22.2U PD=22.2U
* device instance $144 r0 *1 409.2,38.15 nfet
X$144 vss__t34 lo_1_n__t1 \$155__t5 vsubs nfet_03v3 L=0.28U W=10U AS=11P AD=11P PS=22.2U PD=22.2U
* device instance $145 r0 *1 444.075,68.3 nfet
X$145 \$166__t2 tp_gn__t4 vss__t57 vsubs nfet_03v3 L=0.35U W=4U AS=4.4P AD=4.4P PS=10.2U PD=10.2U
* device instance $146 r0 *1 446.99,71.3 nfet
X$146 vcm__t24 tp_gn__t3 topp__t513 vsubs nfet_03v3 L=0.28U W=10U AS=11P AD=11P PS=22.2U PD=22.2U
* device instance $147 r0 *1 457.535,68.3 nfet
X$147 \$167__t2 tp_gn__t5 vss__t58 vsubs nfet_03v3 L=0.35U W=4U AS=4.4P AD=4.4P PS=10.2U PD=10.2U
* device instance $148 r0 *1 460.45,71.3 nfet
X$148 vcm__t22 tp_gn__t2 topn__t513 vsubs nfet_03v3 L=0.28U W=10U AS=11P AD=11P PS=22.2U PD=22.2U
* device instance $149 r0 *1 25.495,4 pfet
X$149 \$65__t1 sel_in__t2 vdd__t0 vdd pfet_03v3 L=0.35U W=8U AS=8.8P AD=8.8P PS=18.2U PD=18.2U
* device instance $150 r0 *1 28.445,4 pfet
X$150 \$27__t1 rel_256_p__t0 vdd__t61 vdd pfet_03v3 L=0.35U W=8U AS=8.8P AD=8.8P PS=18.2U PD=18.2U
* device instance $151 r0 *1 31.395,4 pfet
X$151 \$29__t1 hi_256_p__t0 vdd__t60 vdd pfet_03v3 L=0.35U W=8U AS=8.8P AD=8.8P PS=18.2U PD=18.2U
* device instance $152 r0 *1 34.345,4 pfet
X$152 \$9__t1 lo_256_p__t0 vdd__t70 vdd pfet_03v3 L=0.35U W=8U AS=8.8P AD=8.8P PS=18.2U PD=18.2U
* device instance $153 r0 *1 37.26,10 pfet
X$153 vinp__t1 \$65__t2 \$10__t1 vdd pfet_03v3 L=0.28U W=20U AS=22P AD=22P PS=42.2U PD=42.2U
* device instance $154 r0 *1 40.14,10 pfet
X$154 vcm__t21 \$27__t0 \$10__t260 vdd pfet_03v3 L=0.28U W=20U AS=22P AD=22P PS=42.2U PD=42.2U
* device instance $155 r0 *1 43.02,10 pfet
X$155 vref__t3 \$29__t0 \$10__t258 vdd pfet_03v3 L=0.28U W=20U AS=22P AD=22P PS=42.2U PD=42.2U
* device instance $156 r0 *1 45.9,10 pfet
X$156 vss__t5 \$9__t0 \$10__t259 vdd pfet_03v3 L=0.28U W=20U AS=22P AD=22P PS=42.2U PD=42.2U
* device instance $157 r0 *1 73.935,4 pfet
X$157 \$67__t1 sel_in__t19 vdd__t72 vdd pfet_03v3 L=0.35U W=8U AS=8.8P AD=8.8P PS=18.2U PD=18.2U
* device instance $158 r0 *1 76.885,4 pfet
X$158 \$31__t1 rel_128_p__t0 vdd__t71 vdd pfet_03v3 L=0.35U W=8U AS=8.8P AD=8.8P PS=18.2U PD=18.2U
* device instance $159 r0 *1 79.835,4 pfet
X$159 \$33__t1 hi_128_p__t0 vdd__t58 vdd pfet_03v3 L=0.35U W=8U AS=8.8P AD=8.8P PS=18.2U PD=18.2U
* device instance $160 r0 *1 82.785,4 pfet
X$160 \$11__t1 lo_128_p__t0 vdd__t59 vdd pfet_03v3 L=0.35U W=8U AS=8.8P AD=8.8P PS=18.2U PD=18.2U
* device instance $161 r0 *1 85.7,10 pfet
X$161 vinp__t6 \$67__t0 \$12__t131 vdd pfet_03v3 L=0.28U W=20U AS=22P AD=22P PS=42.2U PD=42.2U
* device instance $162 r0 *1 88.58,10 pfet
X$162 vcm__t6 \$31__t0 \$12__t130 vdd pfet_03v3 L=0.28U W=20U AS=22P AD=22P PS=42.2U PD=42.2U
* device instance $163 r0 *1 91.46,10 pfet
X$163 vref__t4 \$33__t0 \$12__t129 vdd pfet_03v3 L=0.28U W=20U AS=22P AD=22P PS=42.2U PD=42.2U
* device instance $164 r0 *1 94.34,10 pfet
X$164 vss__t2 \$11__t0 \$12__t128 vdd pfet_03v3 L=0.28U W=20U AS=22P AD=22P PS=42.2U PD=42.2U
* device instance $165 r0 *1 122.375,4 pfet
X$165 \$69__t1 sel_in__t16 vdd__t62 vdd pfet_03v3 L=0.35U W=8U AS=8.8P AD=8.8P PS=18.2U PD=18.2U
* device instance $166 r0 *1 125.325,4 pfet
X$166 \$35__t1 rel_64_p__t0 vdd__t53 vdd pfet_03v3 L=0.35U W=8U AS=8.8P AD=8.8P PS=18.2U PD=18.2U
* device instance $167 r0 *1 128.275,4 pfet
X$167 \$37__t1 hi_64_p__t0 vdd__t69 vdd pfet_03v3 L=0.35U W=8U AS=8.8P AD=8.8P PS=18.2U PD=18.2U
* device instance $168 r0 *1 131.225,4 pfet
X$168 \$13__t1 lo_64_p__t0 vdd__t3 vdd pfet_03v3 L=0.35U W=8U AS=8.8P AD=8.8P PS=18.2U PD=18.2U
* device instance $169 r0 *1 134.14,10 pfet
X$169 vinp__t9 \$69__t0 \$14__t67 vdd pfet_03v3 L=0.28U W=20U AS=22P AD=22P PS=42.2U PD=42.2U
* device instance $170 r0 *1 137.02,10 pfet
X$170 vcm__t18 \$35__t0 \$14__t66 vdd pfet_03v3 L=0.28U W=20U AS=22P AD=22P PS=42.2U PD=42.2U
* device instance $171 r0 *1 139.9,10 pfet
X$171 vref__t15 \$37__t0 \$14__t65 vdd pfet_03v3 L=0.28U W=20U AS=22P AD=22P PS=42.2U PD=42.2U
* device instance $172 r0 *1 142.78,10 pfet
X$172 vss__t4 \$13__t0 \$14__t64 vdd pfet_03v3 L=0.28U W=20U AS=22P AD=22P PS=42.2U PD=42.2U
* device instance $173 r0 *1 170.815,4 pfet
X$173 \$71__t1 sel_in__t4 vdd__t8 vdd pfet_03v3 L=0.35U W=8U AS=8.8P AD=8.8P PS=18.2U PD=18.2U
* device instance $174 r0 *1 173.765,4 pfet
X$174 \$39__t1 rel_32_p__t0 vdd__t10 vdd pfet_03v3 L=0.35U W=8U AS=8.8P AD=8.8P PS=18.2U PD=18.2U
* device instance $175 r0 *1 176.715,4 pfet
X$175 \$41__t1 hi_32_p__t0 vdd__t12 vdd pfet_03v3 L=0.35U W=8U AS=8.8P AD=8.8P PS=18.2U PD=18.2U
* device instance $176 r0 *1 179.665,4 pfet
X$176 \$15__t1 lo_32_p__t0 vdd__t13 vdd pfet_03v3 L=0.35U W=8U AS=8.8P AD=8.8P PS=18.2U PD=18.2U
* device instance $177 r0 *1 182.58,10 pfet
X$177 vinp__t3 \$71__t0 \$16__t32 vdd pfet_03v3 L=0.28U W=20U AS=22P AD=22P PS=42.2U PD=42.2U
* device instance $178 r0 *1 185.46,10 pfet
X$178 vcm__t13 \$39__t0 \$16__t33 vdd pfet_03v3 L=0.28U W=20U AS=22P AD=22P PS=42.2U PD=42.2U
* device instance $179 r0 *1 188.34,10 pfet
X$179 vref__t10 \$41__t0 \$16__t34 vdd pfet_03v3 L=0.28U W=20U AS=22P AD=22P PS=42.2U PD=42.2U
* device instance $180 r0 *1 191.22,10 pfet
X$180 vss__t12 \$15__t0 \$16__t35 vdd pfet_03v3 L=0.28U W=20U AS=22P AD=22P PS=42.2U PD=42.2U
* device instance $181 r0 *1 219.255,4 pfet
X$181 \$73__t1 sel_in__t18 vdd__t67 vdd pfet_03v3 L=0.35U W=8U AS=8.8P AD=8.8P PS=18.2U PD=18.2U
* device instance $182 r0 *1 222.205,4 pfet
X$182 \$43__t1 rel_16_p__t0 vdd__t68 vdd pfet_03v3 L=0.35U W=8U AS=8.8P AD=8.8P PS=18.2U PD=18.2U
* device instance $183 r0 *1 225.155,4 pfet
X$183 \$45__t1 hi_16_p__t0 vdd__t6 vdd pfet_03v3 L=0.35U W=8U AS=8.8P AD=8.8P PS=18.2U PD=18.2U
* device instance $184 r0 *1 228.105,4 pfet
X$184 \$17__t1 lo_16_p__t0 vdd__t7 vdd pfet_03v3 L=0.35U W=8U AS=8.8P AD=8.8P PS=18.2U PD=18.2U
* device instance $185 r0 *1 231.02,10 pfet
X$185 vinp__t7 \$73__t0 \$18__t19 vdd pfet_03v3 L=0.28U W=20U AS=22P AD=22P PS=42.2U PD=42.2U
* device instance $186 r0 *1 233.9,10 pfet
X$186 vcm__t4 \$43__t0 \$18__t16 vdd pfet_03v3 L=0.28U W=20U AS=22P AD=22P PS=42.2U PD=42.2U
* device instance $187 r0 *1 236.78,10 pfet
X$187 vref__t2 \$45__t0 \$18__t17 vdd pfet_03v3 L=0.28U W=20U AS=22P AD=22P PS=42.2U PD=42.2U
* device instance $188 r0 *1 239.66,10 pfet
X$188 vss__t6 \$17__t0 \$18__t18 vdd pfet_03v3 L=0.28U W=20U AS=22P AD=22P PS=42.2U PD=42.2U
* device instance $189 r0 *1 267.695,4 pfet
X$189 \$75__t1 sel_in__t14 vdd__t50 vdd pfet_03v3 L=0.35U W=8U AS=8.8P AD=8.8P PS=18.2U PD=18.2U
* device instance $190 r0 *1 270.645,4 pfet
X$190 \$47__t1 rel_8_p__t0 vdd__t51 vdd pfet_03v3 L=0.35U W=8U AS=8.8P AD=8.8P PS=18.2U PD=18.2U
* device instance $191 r0 *1 273.595,4 pfet
X$191 \$49__t1 hi_8_p__t0 vdd__t43 vdd pfet_03v3 L=0.35U W=8U AS=8.8P AD=8.8P PS=18.2U PD=18.2U
* device instance $192 r0 *1 276.545,4 pfet
X$192 \$19__t1 lo_8_p__t0 vdd__t19 vdd pfet_03v3 L=0.35U W=8U AS=8.8P AD=8.8P PS=18.2U PD=18.2U
* device instance $193 r0 *1 279.46,10 pfet
X$193 vinp__t4 \$75__t0 \$20__t8 vdd pfet_03v3 L=0.28U W=20U AS=22P AD=22P PS=42.2U PD=42.2U
* device instance $194 r0 *1 282.34,10 pfet
X$194 vcm__t12 \$47__t0 \$20__t9 vdd pfet_03v3 L=0.28U W=20U AS=22P AD=22P PS=42.2U PD=42.2U
* device instance $195 r0 *1 285.22,10 pfet
X$195 vref__t9 \$49__t0 \$20__t10 vdd pfet_03v3 L=0.28U W=20U AS=22P AD=22P PS=42.2U PD=42.2U
* device instance $196 r0 *1 288.1,10 pfet
X$196 vss__t11 \$19__t0 \$20__t11 vdd pfet_03v3 L=0.28U W=20U AS=22P AD=22P PS=42.2U PD=42.2U
* device instance $197 r0 *1 316.135,4 pfet
X$197 \$77__t1 sel_in__t11 vdd__t38 vdd pfet_03v3 L=0.35U W=8U AS=8.8P AD=8.8P PS=18.2U PD=18.2U
* device instance $198 r0 *1 319.085,4 pfet
X$198 \$51__t1 rel_4_p__t0 vdd__t39 vdd pfet_03v3 L=0.35U W=8U AS=8.8P AD=8.8P PS=18.2U PD=18.2U
* device instance $199 r0 *1 322.035,4 pfet
X$199 \$53__t1 hi_4_p__t0 vdd__t40 vdd pfet_03v3 L=0.35U W=8U AS=8.8P AD=8.8P PS=18.2U PD=18.2U
* device instance $200 r0 *1 324.985,4 pfet
X$200 \$21__t1 lo_4_p__t0 vdd__t41 vdd pfet_03v3 L=0.35U W=8U AS=8.8P AD=8.8P PS=18.2U PD=18.2U
* device instance $201 r0 *1 327.9,10 pfet
X$201 vinp__t2 \$77__t0 \$22__t4 vdd pfet_03v3 L=0.28U W=20U AS=22P AD=22P PS=42.2U PD=42.2U
* device instance $202 r0 *1 330.78,10 pfet
X$202 vcm__t5 \$51__t0 \$22__t5 vdd pfet_03v3 L=0.28U W=20U AS=22P AD=22P PS=42.2U PD=42.2U
* device instance $203 r0 *1 333.66,10 pfet
X$203 vref__t1 \$53__t0 \$22__t6 vdd pfet_03v3 L=0.28U W=20U AS=22P AD=22P PS=42.2U PD=42.2U
* device instance $204 r0 *1 336.54,10 pfet
X$204 vss__t1 \$21__t0 \$22__t7 vdd pfet_03v3 L=0.28U W=20U AS=22P AD=22P PS=42.2U PD=42.2U
* device instance $205 r0 *1 364.575,4 pfet
X$205 \$79__t1 sel_in__t10 vdd__t35 vdd pfet_03v3 L=0.35U W=8U AS=8.8P AD=8.8P PS=18.2U PD=18.2U
* device instance $206 r0 *1 367.525,4 pfet
X$206 \$55__t1 rel_2_p__t0 vdd__t31 vdd pfet_03v3 L=0.35U W=8U AS=8.8P AD=8.8P PS=18.2U PD=18.2U
* device instance $207 r0 *1 370.475,4 pfet
X$207 \$57__t1 hi_2_p__t0 vdd__t32 vdd pfet_03v3 L=0.35U W=8U AS=8.8P AD=8.8P PS=18.2U PD=18.2U
* device instance $208 r0 *1 373.425,4 pfet
X$208 \$23__t1 lo_2_p__t0 vdd__t33 vdd pfet_03v3 L=0.35U W=8U AS=8.8P AD=8.8P PS=18.2U PD=18.2U
* device instance $209 r0 *1 376.34,10 pfet
X$209 vinp__t8 \$79__t0 \$24__t2 vdd pfet_03v3 L=0.28U W=20U AS=22P AD=22P PS=42.2U PD=42.2U
* device instance $210 r0 *1 379.22,10 pfet
X$210 vcm__t14 \$55__t0 \$24__t3 vdd pfet_03v3 L=0.28U W=20U AS=22P AD=22P PS=42.2U PD=42.2U
* device instance $211 r0 *1 382.1,10 pfet
X$211 vref__t11 \$57__t0 \$24__t4 vdd pfet_03v3 L=0.28U W=20U AS=22P AD=22P PS=42.2U PD=42.2U
* device instance $212 r0 *1 384.98,10 pfet
X$212 vss__t13 \$23__t0 \$24__t5 vdd pfet_03v3 L=0.28U W=20U AS=22P AD=22P PS=42.2U PD=42.2U
* device instance $213 r0 *1 413.015,4 pfet
X$213 \$81__t1 sel_in__t9 vdd__t34 vdd pfet_03v3 L=0.35U W=8U AS=8.8P AD=8.8P PS=18.2U PD=18.2U
* device instance $214 r0 *1 415.965,4 pfet
X$214 \$59__t1 rel_1_p__t0 vdd__t54 vdd pfet_03v3 L=0.35U W=8U AS=8.8P AD=8.8P PS=18.2U PD=18.2U
* device instance $215 r0 *1 418.915,4 pfet
X$215 \$61__t1 hi_1_p__t0 vdd__t20 vdd pfet_03v3 L=0.35U W=8U AS=8.8P AD=8.8P PS=18.2U PD=18.2U
* device instance $216 r0 *1 421.865,4 pfet
X$216 \$25__t1 lo_1_p__t0 vdd__t21 vdd pfet_03v3 L=0.35U W=8U AS=8.8P AD=8.8P PS=18.2U PD=18.2U
* device instance $217 r0 *1 424.78,10 pfet
X$217 vinp__t5 \$81__t0 \$26__t1 vdd pfet_03v3 L=0.28U W=20U AS=22P AD=22P PS=42.2U PD=42.2U
* device instance $218 r0 *1 427.66,10 pfet
X$218 vcm__t7 \$59__t0 \$26__t2 vdd pfet_03v3 L=0.28U W=20U AS=22P AD=22P PS=42.2U PD=42.2U
* device instance $219 r0 *1 430.54,10 pfet
X$219 vref__t12 \$61__t0 \$26__t3 vdd pfet_03v3 L=0.28U W=20U AS=22P AD=22P PS=42.2U PD=42.2U
* device instance $220 r0 *1 433.42,10 pfet
X$220 vss__t16 \$25__t0 \$26__t4 vdd pfet_03v3 L=0.28U W=20U AS=22P AD=22P PS=42.2U PD=42.2U
* device instance $221 r0 *1 25.495,37.15 pfet
X$221 \$83__t1 sel_in__t17 vdd__t66 vdd pfet_03v3 L=0.35U W=8U AS=8.8P AD=8.8P PS=18.2U PD=18.2U
* device instance $222 r0 *1 28.445,37.15 pfet
X$222 \$85__t1 rel_256_n__t0 vdd__t65 vdd pfet_03v3 L=0.35U W=8U AS=8.8P AD=8.8P PS=18.2U PD=18.2U
* device instance $223 r0 *1 31.395,37.15 pfet
X$223 \$87__t1 hi_256_n__t0 vdd__t64 vdd pfet_03v3 L=0.35U W=8U AS=8.8P AD=8.8P PS=18.2U PD=18.2U
* device instance $224 r0 *1 34.345,37.15 pfet
X$224 \$89__t1 lo_256_n__t0 vdd__t63 vdd pfet_03v3 L=0.35U W=8U AS=8.8P AD=8.8P PS=18.2U PD=18.2U
* device instance $225 r0 *1 37.26,43.15 pfet
X$225 vinn__t7 \$83__t0 \$90__t256 vdd pfet_03v3 L=0.28U W=20U AS=22P AD=22P PS=42.2U PD=42.2U
* device instance $226 r0 *1 40.14,43.15 pfet
X$226 vcm__t19 \$85__t0 \$90__t257 vdd pfet_03v3 L=0.28U W=20U AS=22P AD=22P PS=42.2U PD=42.2U
* device instance $227 r0 *1 43.02,43.15 pfet
X$227 vref__t16 \$87__t0 \$90__t258 vdd pfet_03v3 L=0.28U W=20U AS=22P AD=22P PS=42.2U PD=42.2U
* device instance $228 r0 *1 45.9,43.15 pfet
X$228 vss__t17 \$89__t0 \$90__t259 vdd pfet_03v3 L=0.28U W=20U AS=22P AD=22P PS=42.2U PD=42.2U
* device instance $229 r0 *1 73.935,37.15 pfet
X$229 \$92__t1 sel_in__t15 vdd__t57 vdd pfet_03v3 L=0.35U W=8U AS=8.8P AD=8.8P PS=18.2U PD=18.2U
* device instance $230 r0 *1 76.885,37.15 pfet
X$230 \$94__t1 rel_128_n__t0 vdd__t56 vdd pfet_03v3 L=0.35U W=8U AS=8.8P AD=8.8P PS=18.2U PD=18.2U
* device instance $231 r0 *1 79.835,37.15 pfet
X$231 \$96__t1 hi_128_n__t0 vdd__t55 vdd pfet_03v3 L=0.35U W=8U AS=8.8P AD=8.8P PS=18.2U PD=18.2U
* device instance $232 r0 *1 82.785,37.15 pfet
X$232 \$98__t1 lo_128_n__t0 vdd__t73 vdd pfet_03v3 L=0.35U W=8U AS=8.8P AD=8.8P PS=18.2U PD=18.2U
* device instance $233 r0 *1 85.7,43.15 pfet
X$233 vinn__t8 \$92__t0 \$99__t128 vdd pfet_03v3 L=0.28U W=20U AS=22P AD=22P PS=42.2U PD=42.2U
* device instance $234 r0 *1 88.58,43.15 pfet
X$234 vcm__t20 \$94__t0 \$99__t129 vdd pfet_03v3 L=0.28U W=20U AS=22P AD=22P PS=42.2U PD=42.2U
* device instance $235 r0 *1 91.46,43.15 pfet
X$235 vref__t17 \$96__t0 \$99__t130 vdd pfet_03v3 L=0.28U W=20U AS=22P AD=22P PS=42.2U PD=42.2U
* device instance $236 r0 *1 94.34,43.15 pfet
X$236 vss__t18 \$98__t0 \$99__t131 vdd pfet_03v3 L=0.28U W=20U AS=22P AD=22P PS=42.2U PD=42.2U
* device instance $237 r0 *1 122.375,37.15 pfet
X$237 \$100__t1 sel_in__t7 vdd__t26 vdd pfet_03v3 L=0.35U W=8U AS=8.8P AD=8.8P PS=18.2U PD=18.2U
* device instance $238 r0 *1 125.325,37.15 pfet
X$238 \$102__t1 rel_64_n__t0 vdd__t5 vdd pfet_03v3 L=0.35U W=8U AS=8.8P AD=8.8P PS=18.2U PD=18.2U
* device instance $239 r0 *1 128.275,37.15 pfet
X$239 \$104__t1 hi_64_n__t0 vdd__t11 vdd pfet_03v3 L=0.35U W=8U AS=8.8P AD=8.8P PS=18.2U PD=18.2U
* device instance $240 r0 *1 131.225,37.15 pfet
X$240 \$106__t1 lo_64_n__t0 vdd__t14 vdd pfet_03v3 L=0.35U W=8U AS=8.8P AD=8.8P PS=18.2U PD=18.2U
* device instance $241 r0 *1 134.14,43.15 pfet
X$241 vinn__t6 \$100__t0 \$107__t67 vdd pfet_03v3 L=0.28U W=20U AS=22P AD=22P PS=42.2U PD=42.2U
* device instance $242 r0 *1 137.02,43.15 pfet
X$242 vcm__t16 \$102__t0 \$107__t66 vdd pfet_03v3 L=0.28U W=20U AS=22P AD=22P PS=42.2U PD=42.2U
* device instance $243 r0 *1 139.9,43.15 pfet
X$243 vref__t14 \$104__t0 \$107__t65 vdd pfet_03v3 L=0.28U W=20U AS=22P AD=22P PS=42.2U PD=42.2U
* device instance $244 r0 *1 142.78,43.15 pfet
X$244 vss__t15 \$106__t0 \$107__t64 vdd pfet_03v3 L=0.28U W=20U AS=22P AD=22P PS=42.2U PD=42.2U
* device instance $245 r0 *1 170.815,37.15 pfet
X$245 \$108__t1 sel_in__t3 vdd__t1 vdd pfet_03v3 L=0.35U W=8U AS=8.8P AD=8.8P PS=18.2U PD=18.2U
* device instance $246 r0 *1 173.765,37.15 pfet
X$246 \$110__t1 rel_32_n__t0 vdd__t4 vdd pfet_03v3 L=0.35U W=8U AS=8.8P AD=8.8P PS=18.2U PD=18.2U
* device instance $247 r0 *1 176.715,37.15 pfet
X$247 \$112__t1 hi_32_n__t0 vdd__t2 vdd pfet_03v3 L=0.35U W=8U AS=8.8P AD=8.8P PS=18.2U PD=18.2U
* device instance $248 r0 *1 179.665,37.15 pfet
X$248 \$114__t1 lo_32_n__t0 vdd__t18 vdd pfet_03v3 L=0.35U W=8U AS=8.8P AD=8.8P PS=18.2U PD=18.2U
* device instance $249 r0 *1 182.58,43.15 pfet
X$249 vinn__t5 \$108__t0 \$115__t35 vdd pfet_03v3 L=0.28U W=20U AS=22P AD=22P PS=42.2U PD=42.2U
* device instance $250 r0 *1 185.46,43.15 pfet
X$250 vcm__t15 \$110__t0 \$115__t34 vdd pfet_03v3 L=0.28U W=20U AS=22P AD=22P PS=42.2U PD=42.2U
* device instance $251 r0 *1 188.34,43.15 pfet
X$251 vref__t13 \$112__t0 \$115__t33 vdd pfet_03v3 L=0.28U W=20U AS=22P AD=22P PS=42.2U PD=42.2U
* device instance $252 r0 *1 191.22,43.15 pfet
X$252 vss__t14 \$114__t0 \$115__t32 vdd pfet_03v3 L=0.28U W=20U AS=22P AD=22P PS=42.2U PD=42.2U
* device instance $253 r0 *1 219.255,37.15 pfet
X$253 \$116__t1 sel_in__t5 vdd__t17 vdd pfet_03v3 L=0.35U W=8U AS=8.8P AD=8.8P PS=18.2U PD=18.2U
* device instance $254 r0 *1 222.205,37.15 pfet
X$254 \$118__t1 rel_16_n__t0 vdd__t16 vdd pfet_03v3 L=0.35U W=8U AS=8.8P AD=8.8P PS=18.2U PD=18.2U
* device instance $255 r0 *1 225.155,37.15 pfet
X$255 \$120__t1 hi_16_n__t0 vdd__t15 vdd pfet_03v3 L=0.35U W=8U AS=8.8P AD=8.8P PS=18.2U PD=18.2U
* device instance $256 r0 *1 228.105,37.15 pfet
X$256 \$122__t1 lo_16_n__t0 vdd__t9 vdd pfet_03v3 L=0.35U W=8U AS=8.8P AD=8.8P PS=18.2U PD=18.2U
* device instance $257 r0 *1 231.02,43.15 pfet
X$257 vinn__t4 \$116__t0 \$123__t18 vdd pfet_03v3 L=0.28U W=20U AS=22P AD=22P PS=42.2U PD=42.2U
* device instance $258 r0 *1 233.9,43.15 pfet
X$258 vcm__t17 \$118__t0 \$123__t19 vdd pfet_03v3 L=0.28U W=20U AS=22P AD=22P PS=42.2U PD=42.2U
* device instance $259 r0 *1 236.78,43.15 pfet
X$259 vref__t0 \$120__t0 \$123__t16 vdd pfet_03v3 L=0.28U W=20U AS=22P AD=22P PS=42.2U PD=42.2U
* device instance $260 r0 *1 239.66,43.15 pfet
X$260 vss__t9 \$122__t0 \$123__t17 vdd pfet_03v3 L=0.28U W=20U AS=22P AD=22P PS=42.2U PD=42.2U
* device instance $261 r0 *1 267.695,37.15 pfet
X$261 \$124__t1 sel_in__t12 vdd__t42 vdd pfet_03v3 L=0.35U W=8U AS=8.8P AD=8.8P PS=18.2U PD=18.2U
* device instance $262 r0 *1 270.645,37.15 pfet
X$262 \$126__t1 rel_8_n__t0 vdd__t52 vdd pfet_03v3 L=0.35U W=8U AS=8.8P AD=8.8P PS=18.2U PD=18.2U
* device instance $263 r0 *1 273.595,37.15 pfet
X$263 \$128__t1 hi_8_n__t0 vdd__t44 vdd pfet_03v3 L=0.35U W=8U AS=8.8P AD=8.8P PS=18.2U PD=18.2U
* device instance $264 r0 *1 276.545,37.15 pfet
X$264 \$130__t1 lo_8_n__t0 vdd__t45 vdd pfet_03v3 L=0.35U W=8U AS=8.8P AD=8.8P PS=18.2U PD=18.2U
* device instance $265 r0 *1 279.46,43.15 pfet
X$265 vinn__t2 \$124__t0 \$131__t11 vdd pfet_03v3 L=0.28U W=20U AS=22P AD=22P PS=42.2U PD=42.2U
* device instance $266 r0 *1 282.34,43.15 pfet
X$266 vcm__t11 \$126__t0 \$131__t10 vdd pfet_03v3 L=0.28U W=20U AS=22P AD=22P PS=42.2U PD=42.2U
* device instance $267 r0 *1 285.22,43.15 pfet
X$267 vref__t8 \$128__t0 \$131__t9 vdd pfet_03v3 L=0.28U W=20U AS=22P AD=22P PS=42.2U PD=42.2U
* device instance $268 r0 *1 288.1,43.15 pfet
X$268 vss__t3 \$130__t0 \$131__t8 vdd pfet_03v3 L=0.28U W=20U AS=22P AD=22P PS=42.2U PD=42.2U
* device instance $269 r0 *1 316.135,37.15 pfet
X$269 \$132__t1 sel_in__t13 vdd__t46 vdd pfet_03v3 L=0.35U W=8U AS=8.8P AD=8.8P PS=18.2U PD=18.2U
* device instance $270 r0 *1 319.085,37.15 pfet
X$270 \$134__t1 rel_4_n__t0 vdd__t47 vdd pfet_03v3 L=0.35U W=8U AS=8.8P AD=8.8P PS=18.2U PD=18.2U
* device instance $271 r0 *1 322.035,37.15 pfet
X$271 \$136__t1 hi_4_n__t0 vdd__t48 vdd pfet_03v3 L=0.35U W=8U AS=8.8P AD=8.8P PS=18.2U PD=18.2U
* device instance $272 r0 *1 324.985,37.15 pfet
X$272 \$138__t1 lo_4_n__t0 vdd__t49 vdd pfet_03v3 L=0.35U W=8U AS=8.8P AD=8.8P PS=18.2U PD=18.2U
* device instance $273 r0 *1 327.9,43.15 pfet
X$273 vinn__t0 \$132__t0 \$139__t4 vdd pfet_03v3 L=0.28U W=20U AS=22P AD=22P PS=42.2U PD=42.2U
* device instance $274 r0 *1 330.78,43.15 pfet
X$274 vcm__t8 \$134__t0 \$139__t5 vdd pfet_03v3 L=0.28U W=20U AS=22P AD=22P PS=42.2U PD=42.2U
* device instance $275 r0 *1 333.66,43.15 pfet
X$275 vref__t5 \$136__t0 \$139__t6 vdd pfet_03v3 L=0.28U W=20U AS=22P AD=22P PS=42.2U PD=42.2U
* device instance $276 r0 *1 336.54,43.15 pfet
X$276 vss__t7 \$138__t0 \$139__t7 vdd pfet_03v3 L=0.28U W=20U AS=22P AD=22P PS=42.2U PD=42.2U
* device instance $277 r0 *1 364.575,37.15 pfet
X$277 \$140__t1 sel_in__t6 vdd__t22 vdd pfet_03v3 L=0.35U W=8U AS=8.8P AD=8.8P PS=18.2U PD=18.2U
* device instance $278 r0 *1 367.525,37.15 pfet
X$278 \$142__t1 rel_2_n__t0 vdd__t23 vdd pfet_03v3 L=0.35U W=8U AS=8.8P AD=8.8P PS=18.2U PD=18.2U
* device instance $279 r0 *1 370.475,37.15 pfet
X$279 \$144__t1 hi_2_n__t0 vdd__t24 vdd pfet_03v3 L=0.35U W=8U AS=8.8P AD=8.8P PS=18.2U PD=18.2U
* device instance $280 r0 *1 373.425,37.15 pfet
X$280 \$146__t1 lo_2_n__t0 vdd__t25 vdd pfet_03v3 L=0.35U W=8U AS=8.8P AD=8.8P PS=18.2U PD=18.2U
* device instance $281 r0 *1 376.34,43.15 pfet
X$281 vinn__t1 \$140__t0 \$147__t2 vdd pfet_03v3 L=0.28U W=20U AS=22P AD=22P PS=42.2U PD=42.2U
* device instance $282 r0 *1 379.22,43.15 pfet
X$282 vcm__t9 \$142__t0 \$147__t3 vdd pfet_03v3 L=0.28U W=20U AS=22P AD=22P PS=42.2U PD=42.2U
* device instance $283 r0 *1 382.1,43.15 pfet
X$283 vref__t6 \$144__t0 \$147__t4 vdd pfet_03v3 L=0.28U W=20U AS=22P AD=22P PS=42.2U PD=42.2U
* device instance $284 r0 *1 384.98,43.15 pfet
X$284 vss__t8 \$146__t0 \$147__t5 vdd pfet_03v3 L=0.28U W=20U AS=22P AD=22P PS=42.2U PD=42.2U
* device instance $285 r0 *1 413.015,37.15 pfet
X$285 \$148__t1 sel_in__t8 vdd__t27 vdd pfet_03v3 L=0.35U W=8U AS=8.8P AD=8.8P PS=18.2U PD=18.2U
* device instance $286 r0 *1 415.965,37.15 pfet
X$286 \$150__t1 rel_1_n__t0 vdd__t28 vdd pfet_03v3 L=0.35U W=8U AS=8.8P AD=8.8P PS=18.2U PD=18.2U
* device instance $287 r0 *1 418.915,37.15 pfet
X$287 \$152__t1 hi_1_n__t0 vdd__t29 vdd pfet_03v3 L=0.35U W=8U AS=8.8P AD=8.8P PS=18.2U PD=18.2U
* device instance $288 r0 *1 421.865,37.15 pfet
X$288 \$154__t1 lo_1_n__t0 vdd__t30 vdd pfet_03v3 L=0.35U W=8U AS=8.8P AD=8.8P PS=18.2U PD=18.2U
* device instance $289 r0 *1 424.78,43.15 pfet
X$289 vinn__t3 \$148__t0 \$155__t4 vdd pfet_03v3 L=0.28U W=20U AS=22P AD=22P PS=42.2U PD=42.2U
* device instance $290 r0 *1 427.66,43.15 pfet
X$290 vcm__t10 \$150__t0 \$155__t1 vdd pfet_03v3 L=0.28U W=20U AS=22P AD=22P PS=42.2U PD=42.2U
* device instance $291 r0 *1 430.54,43.15 pfet
X$291 vref__t7 \$152__t0 \$155__t2 vdd pfet_03v3 L=0.28U W=20U AS=22P AD=22P PS=42.2U PD=42.2U
* device instance $292 r0 *1 433.42,43.15 pfet
X$292 vss__t10 \$154__t0 \$155__t3 vdd pfet_03v3 L=0.28U W=20U AS=22P AD=22P PS=42.2U PD=42.2U
* device instance $293 r0 *1 450.805,70.3 pfet
X$293 \$166__t1 tp_gn__t0 vdd__t36 vdd pfet_03v3 L=0.35U W=8U AS=8.8P AD=8.8P PS=18.2U PD=18.2U
* device instance $294 r0 *1 453.72,76.3 pfet
X$294 vcm__t3 \$166__t0 topp__t512 vdd pfet_03v3 L=0.28U W=20U AS=22P AD=22P PS=42.2U PD=42.2U
* device instance $295 r0 *1 464.265,70.3 pfet
X$295 \$167__t1 tp_gn__t1 vdd__t37 vdd pfet_03v3 L=0.35U W=8U AS=8.8P AD=8.8P PS=18.2U PD=18.2U
* device instance $296 r0 *1 467.18,76.3 pfet
X$296 vcm__t2 \$167__t0 topn__t512 vdd pfet_03v3 L=0.28U W=20U AS=22P AD=22P PS=42.2U PD=42.2U
* device instance $297 r0 *1 2.6,68.9 cap_mim_2f0_m4m5_noshield
X$297 \$10__t248 topp__t0 cap_mim_2f0_m4m5_noshield c_length=4U c_width=4U
* device instance $298 r0 *1 9,68.9 cap_mim_2f0_m4m5_noshield
X$298 \$24__t1 topp__t494 cap_mim_2f0_m4m5_noshield c_length=4U c_width=4U
* device instance $299 r0 *1 15.4,68.9 cap_mim_2f0_m4m5_noshield
X$299 \$10__t247 topp__t493 cap_mim_2f0_m4m5_noshield c_length=4U c_width=4U
* device instance $300 r0 *1 21.8,68.9 cap_mim_2f0_m4m5_noshield
X$300 \$22__t3 topp__t492 cap_mim_2f0_m4m5_noshield c_length=4U c_width=4U
* device instance $301 r0 *1 28.2,68.9 cap_mim_2f0_m4m5_noshield
X$301 \$10__t246 topp__t491 cap_mim_2f0_m4m5_noshield c_length=4U c_width=4U
* device instance $302 r0 *1 34.6,68.9 cap_mim_2f0_m4m5_noshield
X$302 \$20__t7 topp__t490 cap_mim_2f0_m4m5_noshield c_length=4U c_width=4U
* device instance $303 r0 *1 41,68.9 cap_mim_2f0_m4m5_noshield
X$303 \$10__t245 topp__t489 cap_mim_2f0_m4m5_noshield c_length=4U c_width=4U
* device instance $304 r0 *1 47.4,68.9 cap_mim_2f0_m4m5_noshield
X$304 \$20__t6 topp__t488 cap_mim_2f0_m4m5_noshield c_length=4U c_width=4U
* device instance $305 r0 *1 53.8,68.9 cap_mim_2f0_m4m5_noshield
X$305 \$10__t244 topp__t487 cap_mim_2f0_m4m5_noshield c_length=4U c_width=4U
* device instance $306 r0 *1 60.2,68.9 cap_mim_2f0_m4m5_noshield
X$306 \$18__t15 topp__t486 cap_mim_2f0_m4m5_noshield c_length=4U c_width=4U
* device instance $307 r0 *1 66.6,68.9 cap_mim_2f0_m4m5_noshield
X$307 \$10__t243 topp__t485 cap_mim_2f0_m4m5_noshield c_length=4U c_width=4U
* device instance $308 r0 *1 73,68.9 cap_mim_2f0_m4m5_noshield
X$308 \$18__t14 topp__t484 cap_mim_2f0_m4m5_noshield c_length=4U c_width=4U
* device instance $309 r0 *1 79.4,68.9 cap_mim_2f0_m4m5_noshield
X$309 \$10__t242 topp__t483 cap_mim_2f0_m4m5_noshield c_length=4U c_width=4U
* device instance $310 r0 *1 85.8,68.9 cap_mim_2f0_m4m5_noshield
X$310 \$18__t13 topp__t482 cap_mim_2f0_m4m5_noshield c_length=4U c_width=4U
* device instance $311 r0 *1 92.2,68.9 cap_mim_2f0_m4m5_noshield
X$311 \$10__t249 topp__t496 cap_mim_2f0_m4m5_noshield c_length=4U c_width=4U
* device instance $312 r0 *1 98.6,68.9 cap_mim_2f0_m4m5_noshield
X$312 \$18__t12 topp__t450 cap_mim_2f0_m4m5_noshield c_length=4U c_width=4U
* device instance $313 r0 *1 105,68.9 cap_mim_2f0_m4m5_noshield
X$313 \$10__t257 topp__t511 cap_mim_2f0_m4m5_noshield c_length=4U c_width=4U
* device instance $314 r0 *1 111.4,68.9 cap_mim_2f0_m4m5_noshield
X$314 \$16__t30 topp__t495 cap_mim_2f0_m4m5_noshield c_length=4U c_width=4U
* device instance $315 r0 *1 117.8,68.9 cap_mim_2f0_m4m5_noshield
X$315 \$10__t198 topp__t392 cap_mim_2f0_m4m5_noshield c_length=4U c_width=4U
* device instance $316 r0 *1 124.2,68.9 cap_mim_2f0_m4m5_noshield
X$316 \$16__t27 topp__t476 cap_mim_2f0_m4m5_noshield c_length=4U c_width=4U
* device instance $317 r0 *1 130.6,68.9 cap_mim_2f0_m4m5_noshield
X$317 \$10__t233 topp__t462 cap_mim_2f0_m4m5_noshield c_length=4U c_width=4U
* device instance $318 r0 *1 137,68.9 cap_mim_2f0_m4m5_noshield
X$318 \$16__t25 topp__t461 cap_mim_2f0_m4m5_noshield c_length=4U c_width=4U
* device instance $319 r0 *1 143.4,68.9 cap_mim_2f0_m4m5_noshield
X$319 \$10__t232 topp__t460 cap_mim_2f0_m4m5_noshield c_length=4U c_width=4U
* device instance $320 r0 *1 149.8,68.9 cap_mim_2f0_m4m5_noshield
X$320 \$16__t24 topp__t459 cap_mim_2f0_m4m5_noshield c_length=4U c_width=4U
* device instance $321 r0 *1 156.2,68.9 cap_mim_2f0_m4m5_noshield
X$321 \$10__t231 topp__t458 cap_mim_2f0_m4m5_noshield c_length=4U c_width=4U
* device instance $322 r0 *1 162.6,68.9 cap_mim_2f0_m4m5_noshield
X$322 \$16__t26 topp__t471 cap_mim_2f0_m4m5_noshield c_length=4U c_width=4U
* device instance $323 r0 *1 169,68.9 cap_mim_2f0_m4m5_noshield
X$323 \$10__t256 topp__t510 cap_mim_2f0_m4m5_noshield c_length=4U c_width=4U
* device instance $324 r0 *1 175.4,68.9 cap_mim_2f0_m4m5_noshield
X$324 \$16__t31 topp__t497 cap_mim_2f0_m4m5_noshield c_length=4U c_width=4U
* device instance $325 r0 *1 181.8,68.9 cap_mim_2f0_m4m5_noshield
X$325 \$10__t241 topp__t480 cap_mim_2f0_m4m5_noshield c_length=4U c_width=4U
* device instance $326 r0 *1 188.2,68.9 cap_mim_2f0_m4m5_noshield
X$326 \$16__t29 topp__t479 cap_mim_2f0_m4m5_noshield c_length=4U c_width=4U
* device instance $327 r0 *1 194.6,68.9 cap_mim_2f0_m4m5_noshield
X$327 \$10__t240 topp__t478 cap_mim_2f0_m4m5_noshield c_length=4U c_width=4U
* device instance $328 r0 *1 201,68.9 cap_mim_2f0_m4m5_noshield
X$328 \$16__t28 topp__t477 cap_mim_2f0_m4m5_noshield c_length=4U c_width=4U
* device instance $329 r0 *1 224,68.9 cap_mim_2f0_m4m5_noshield
X$329 \$90__t252 topn__t506 cap_mim_2f0_m4m5_noshield c_length=4U c_width=4U
* device instance $330 r0 *1 230.4,68.9 cap_mim_2f0_m4m5_noshield
X$330 \$147__t1 topn__t505 cap_mim_2f0_m4m5_noshield c_length=4U c_width=4U
* device instance $331 r0 *1 236.8,68.9 cap_mim_2f0_m4m5_noshield
X$331 \$90__t173 topn__t346 cap_mim_2f0_m4m5_noshield c_length=4U c_width=4U
* device instance $332 r0 *1 243.2,68.9 cap_mim_2f0_m4m5_noshield
X$332 \$139__t3 topn__t345 cap_mim_2f0_m4m5_noshield c_length=4U c_width=4U
* device instance $333 r0 *1 249.6,68.9 cap_mim_2f0_m4m5_noshield
X$333 \$90__t172 topn__t344 cap_mim_2f0_m4m5_noshield c_length=4U c_width=4U
* device instance $334 r0 *1 256,68.9 cap_mim_2f0_m4m5_noshield
X$334 \$131__t7 topn__t343 cap_mim_2f0_m4m5_noshield c_length=4U c_width=4U
* device instance $335 r0 *1 262.4,68.9 cap_mim_2f0_m4m5_noshield
X$335 \$90__t171 topn__t342 cap_mim_2f0_m4m5_noshield c_length=4U c_width=4U
* device instance $336 r0 *1 268.8,68.9 cap_mim_2f0_m4m5_noshield
X$336 \$131__t6 topn__t341 cap_mim_2f0_m4m5_noshield c_length=4U c_width=4U
* device instance $337 r0 *1 275.2,68.9 cap_mim_2f0_m4m5_noshield
X$337 \$90__t170 topn__t340 cap_mim_2f0_m4m5_noshield c_length=4U c_width=4U
* device instance $338 r0 *1 281.6,68.9 cap_mim_2f0_m4m5_noshield
X$338 \$123__t9 topn__t339 cap_mim_2f0_m4m5_noshield c_length=4U c_width=4U
* device instance $339 r0 *1 288,68.9 cap_mim_2f0_m4m5_noshield
X$339 \$90__t169 topn__t338 cap_mim_2f0_m4m5_noshield c_length=4U c_width=4U
* device instance $340 r0 *1 294.4,68.9 cap_mim_2f0_m4m5_noshield
X$340 \$123__t12 topn__t385 cap_mim_2f0_m4m5_noshield c_length=4U c_width=4U
* device instance $341 r0 *1 300.8,68.9 cap_mim_2f0_m4m5_noshield
X$341 \$90__t199 topn__t400 cap_mim_2f0_m4m5_noshield c_length=4U c_width=4U
* device instance $342 r0 *1 307.2,68.9 cap_mim_2f0_m4m5_noshield
X$342 \$123__t7 topn__t211 cap_mim_2f0_m4m5_noshield c_length=4U c_width=4U
* device instance $343 r0 *1 313.6,68.9 cap_mim_2f0_m4m5_noshield
X$343 \$90__t176 topn__t352 cap_mim_2f0_m4m5_noshield c_length=4U c_width=4U
* device instance $344 r0 *1 320,68.9 cap_mim_2f0_m4m5_noshield
X$344 \$123__t10 topn__t351 cap_mim_2f0_m4m5_noshield c_length=4U c_width=4U
* device instance $345 r0 *1 326.4,68.9 cap_mim_2f0_m4m5_noshield
X$345 \$90__t175 topn__t350 cap_mim_2f0_m4m5_noshield c_length=4U c_width=4U
* device instance $346 r0 *1 332.8,68.9 cap_mim_2f0_m4m5_noshield
X$346 \$115__t22 topn__t349 cap_mim_2f0_m4m5_noshield c_length=4U c_width=4U
* device instance $347 r0 *1 339.2,68.9 cap_mim_2f0_m4m5_noshield
X$347 \$90__t174 topn__t348 cap_mim_2f0_m4m5_noshield c_length=4U c_width=4U
* device instance $348 r0 *1 345.6,68.9 cap_mim_2f0_m4m5_noshield
X$348 \$115__t21 topn__t347 cap_mim_2f0_m4m5_noshield c_length=4U c_width=4U
* device instance $349 r0 *1 352,68.9 cap_mim_2f0_m4m5_noshield
X$349 \$90__t137 topn__t277 cap_mim_2f0_m4m5_noshield c_length=4U c_width=4U
* device instance $350 r0 *1 358.4,68.9 cap_mim_2f0_m4m5_noshield
X$350 \$115__t15 topn__t214 cap_mim_2f0_m4m5_noshield c_length=4U c_width=4U
* device instance $351 r0 *1 364.8,68.9 cap_mim_2f0_m4m5_noshield
X$351 \$90__t113 topn__t230 cap_mim_2f0_m4m5_noshield c_length=4U c_width=4U
* device instance $352 r0 *1 371.2,68.9 cap_mim_2f0_m4m5_noshield
X$352 \$115__t19 topn__t229 cap_mim_2f0_m4m5_noshield c_length=4U c_width=4U
* device instance $353 r0 *1 377.6,68.9 cap_mim_2f0_m4m5_noshield
X$353 \$90__t112 topn__t228 cap_mim_2f0_m4m5_noshield c_length=4U c_width=4U
* device instance $354 r0 *1 384,68.9 cap_mim_2f0_m4m5_noshield
X$354 \$115__t18 topn__t227 cap_mim_2f0_m4m5_noshield c_length=4U c_width=4U
* device instance $355 r0 *1 390.4,68.9 cap_mim_2f0_m4m5_noshield
X$355 \$90__t111 topn__t226 cap_mim_2f0_m4m5_noshield c_length=4U c_width=4U
* device instance $356 r0 *1 396.8,68.9 cap_mim_2f0_m4m5_noshield
X$356 \$115__t20 topn__t241 cap_mim_2f0_m4m5_noshield c_length=4U c_width=4U
* device instance $357 r0 *1 403.2,68.9 cap_mim_2f0_m4m5_noshield
X$357 \$90__t109 topn__t224 cap_mim_2f0_m4m5_noshield c_length=4U c_width=4U
* device instance $358 r0 *1 409.6,68.9 cap_mim_2f0_m4m5_noshield
X$358 \$115__t17 topn__t218 cap_mim_2f0_m4m5_noshield c_length=4U c_width=4U
* device instance $359 r0 *1 416,68.9 cap_mim_2f0_m4m5_noshield
X$359 \$90__t105 topn__t216 cap_mim_2f0_m4m5_noshield c_length=4U c_width=4U
* device instance $360 r0 *1 422.4,68.9 cap_mim_2f0_m4m5_noshield
X$360 \$115__t16 topn__t215 cap_mim_2f0_m4m5_noshield c_length=4U c_width=4U
* device instance $361 r0 *1 2.6,75.3 cap_mim_2f0_m4m5_noshield
X$361 \$10__t229 topp__t456 cap_mim_2f0_m4m5_noshield c_length=4U c_width=4U
* device instance $362 r0 *1 9,75.3 cap_mim_2f0_m4m5_noshield
X$362 \$14__t50 topp__t455 cap_mim_2f0_m4m5_noshield c_length=4U c_width=4U
* device instance $363 r0 *1 15.4,75.3 cap_mim_2f0_m4m5_noshield
X$363 \$10__t228 topp__t454 cap_mim_2f0_m4m5_noshield c_length=4U c_width=4U
* device instance $364 r0 *1 21.8,75.3 cap_mim_2f0_m4m5_noshield
X$364 \$14__t49 topp__t453 cap_mim_2f0_m4m5_noshield c_length=4U c_width=4U
* device instance $365 r0 *1 28.2,75.3 cap_mim_2f0_m4m5_noshield
X$365 \$10__t227 topp__t452 cap_mim_2f0_m4m5_noshield c_length=4U c_width=4U
* device instance $366 r0 *1 34.6,75.3 cap_mim_2f0_m4m5_noshield
X$366 \$14__t48 topp__t451 cap_mim_2f0_m4m5_noshield c_length=4U c_width=4U
* device instance $367 r0 *1 41,75.3 cap_mim_2f0_m4m5_noshield
X$367 \$10__t250 topp__t498 cap_mim_2f0_m4m5_noshield c_length=4U c_width=4U
* device instance $368 r0 *1 47.4,75.3 cap_mim_2f0_m4m5_noshield
X$368 \$14__t58 topp__t499 cap_mim_2f0_m4m5_noshield c_length=4U c_width=4U
* device instance $369 r0 *1 53.8,75.3 cap_mim_2f0_m4m5_noshield
X$369 \$10__t251 topp__t500 cap_mim_2f0_m4m5_noshield c_length=4U c_width=4U
* device instance $370 r0 *1 60.2,75.3 cap_mim_2f0_m4m5_noshield
X$370 \$14__t59 topp__t501 cap_mim_2f0_m4m5_noshield c_length=4U c_width=4U
* device instance $371 r0 *1 66.6,75.3 cap_mim_2f0_m4m5_noshield
X$371 \$10__t252 topp__t502 cap_mim_2f0_m4m5_noshield c_length=4U c_width=4U
* device instance $372 r0 *1 73,75.3 cap_mim_2f0_m4m5_noshield
X$372 \$14__t60 topp__t503 cap_mim_2f0_m4m5_noshield c_length=4U c_width=4U
* device instance $373 r0 *1 79.4,75.3 cap_mim_2f0_m4m5_noshield
X$373 \$10__t253 topp__t504 cap_mim_2f0_m4m5_noshield c_length=4U c_width=4U
* device instance $374 r0 *1 85.8,75.3 cap_mim_2f0_m4m5_noshield
X$374 \$14__t61 topp__t505 cap_mim_2f0_m4m5_noshield c_length=4U c_width=4U
* device instance $375 r0 *1 92.2,75.3 cap_mim_2f0_m4m5_noshield
X$375 \$10__t254 topp__t506 cap_mim_2f0_m4m5_noshield c_length=4U c_width=4U
* device instance $376 r0 *1 98.6,75.3 cap_mim_2f0_m4m5_noshield
X$376 \$14__t62 topp__t507 cap_mim_2f0_m4m5_noshield c_length=4U c_width=4U
* device instance $377 r0 *1 105,75.3 cap_mim_2f0_m4m5_noshield
X$377 \$10__t255 topp__t508 cap_mim_2f0_m4m5_noshield c_length=4U c_width=4U
* device instance $378 r0 *1 111.4,75.3 cap_mim_2f0_m4m5_noshield
X$378 \$14__t63 topp__t509 cap_mim_2f0_m4m5_noshield c_length=4U c_width=4U
* device instance $379 r0 *1 117.8,75.3 cap_mim_2f0_m4m5_noshield
X$379 \$10__t197 topp__t391 cap_mim_2f0_m4m5_noshield c_length=4U c_width=4U
* device instance $380 r0 *1 124.2,75.3 cap_mim_2f0_m4m5_noshield
X$380 \$14__t56 topp__t475 cap_mim_2f0_m4m5_noshield c_length=4U c_width=4U
* device instance $381 r0 *1 130.6,75.3 cap_mim_2f0_m4m5_noshield
X$381 \$10__t239 topp__t474 cap_mim_2f0_m4m5_noshield c_length=4U c_width=4U
* device instance $382 r0 *1 137,75.3 cap_mim_2f0_m4m5_noshield
X$382 \$14__t55 topp__t473 cap_mim_2f0_m4m5_noshield c_length=4U c_width=4U
* device instance $383 r0 *1 143.4,75.3 cap_mim_2f0_m4m5_noshield
X$383 \$10__t238 topp__t472 cap_mim_2f0_m4m5_noshield c_length=4U c_width=4U
* device instance $384 r0 *1 149.8,75.3 cap_mim_2f0_m4m5_noshield
X$384 \$14__t57 topp__t481 cap_mim_2f0_m4m5_noshield c_length=4U c_width=4U
* device instance $385 r0 *1 156.2,75.3 cap_mim_2f0_m4m5_noshield
X$385 \$10__t237 topp__t470 cap_mim_2f0_m4m5_noshield c_length=4U c_width=4U
* device instance $386 r0 *1 162.6,75.3 cap_mim_2f0_m4m5_noshield
X$386 \$14__t54 topp__t469 cap_mim_2f0_m4m5_noshield c_length=4U c_width=4U
* device instance $387 r0 *1 169,75.3 cap_mim_2f0_m4m5_noshield
X$387 \$10__t236 topp__t468 cap_mim_2f0_m4m5_noshield c_length=4U c_width=4U
* device instance $388 r0 *1 175.4,75.3 cap_mim_2f0_m4m5_noshield
X$388 \$14__t53 topp__t467 cap_mim_2f0_m4m5_noshield c_length=4U c_width=4U
* device instance $389 r0 *1 181.8,75.3 cap_mim_2f0_m4m5_noshield
X$389 \$10__t235 topp__t466 cap_mim_2f0_m4m5_noshield c_length=4U c_width=4U
* device instance $390 r0 *1 188.2,75.3 cap_mim_2f0_m4m5_noshield
X$390 \$14__t52 topp__t465 cap_mim_2f0_m4m5_noshield c_length=4U c_width=4U
* device instance $391 r0 *1 194.6,75.3 cap_mim_2f0_m4m5_noshield
X$391 \$10__t234 topp__t464 cap_mim_2f0_m4m5_noshield c_length=4U c_width=4U
* device instance $392 r0 *1 201,75.3 cap_mim_2f0_m4m5_noshield
X$392 \$14__t51 topp__t463 cap_mim_2f0_m4m5_noshield c_length=4U c_width=4U
* device instance $393 r0 *1 224,75.3 cap_mim_2f0_m4m5_noshield
X$393 \$90__t251 topn__t504 cap_mim_2f0_m4m5_noshield c_length=4U c_width=4U
* device instance $394 r0 *1 230.4,75.3 cap_mim_2f0_m4m5_noshield
X$394 \$107__t63 topn__t503 cap_mim_2f0_m4m5_noshield c_length=4U c_width=4U
* device instance $395 r0 *1 236.8,75.3 cap_mim_2f0_m4m5_noshield
X$395 \$90__t103 topn__t210 cap_mim_2f0_m4m5_noshield c_length=4U c_width=4U
* device instance $396 r0 *1 243.2,75.3 cap_mim_2f0_m4m5_noshield
X$396 \$107__t31 topn__t321 cap_mim_2f0_m4m5_noshield c_length=4U c_width=4U
* device instance $397 r0 *1 249.6,75.3 cap_mim_2f0_m4m5_noshield
X$397 \$90__t184 topn__t368 cap_mim_2f0_m4m5_noshield c_length=4U c_width=4U
* device instance $398 r0 *1 256,75.3 cap_mim_2f0_m4m5_noshield
X$398 \$107__t38 topn__t367 cap_mim_2f0_m4m5_noshield c_length=4U c_width=4U
* device instance $399 r0 *1 262.4,75.3 cap_mim_2f0_m4m5_noshield
X$399 \$90__t183 topn__t366 cap_mim_2f0_m4m5_noshield c_length=4U c_width=4U
* device instance $400 r0 *1 268.8,75.3 cap_mim_2f0_m4m5_noshield
X$400 \$107__t37 topn__t365 cap_mim_2f0_m4m5_noshield c_length=4U c_width=4U
* device instance $401 r0 *1 275.2,75.3 cap_mim_2f0_m4m5_noshield
X$401 \$90__t182 topn__t364 cap_mim_2f0_m4m5_noshield c_length=4U c_width=4U
* device instance $402 r0 *1 281.6,75.3 cap_mim_2f0_m4m5_noshield
X$402 \$107__t36 topn__t363 cap_mim_2f0_m4m5_noshield c_length=4U c_width=4U
* device instance $403 r0 *1 288,75.3 cap_mim_2f0_m4m5_noshield
X$403 \$90__t181 topn__t362 cap_mim_2f0_m4m5_noshield c_length=4U c_width=4U
* device instance $404 r0 *1 294.4,75.3 cap_mim_2f0_m4m5_noshield
X$404 \$107__t35 topn__t361 cap_mim_2f0_m4m5_noshield c_length=4U c_width=4U
* device instance $405 r0 *1 300.8,75.3 cap_mim_2f0_m4m5_noshield
X$405 \$90__t180 topn__t360 cap_mim_2f0_m4m5_noshield c_length=4U c_width=4U
* device instance $406 r0 *1 307.2,75.3 cap_mim_2f0_m4m5_noshield
X$406 \$107__t34 topn__t359 cap_mim_2f0_m4m5_noshield c_length=4U c_width=4U
* device instance $407 r0 *1 313.6,75.3 cap_mim_2f0_m4m5_noshield
X$407 \$90__t179 topn__t358 cap_mim_2f0_m4m5_noshield c_length=4U c_width=4U
* device instance $408 r0 *1 320,75.3 cap_mim_2f0_m4m5_noshield
X$408 \$107__t33 topn__t357 cap_mim_2f0_m4m5_noshield c_length=4U c_width=4U
* device instance $409 r0 *1 326.4,75.3 cap_mim_2f0_m4m5_noshield
X$409 \$90__t178 topn__t356 cap_mim_2f0_m4m5_noshield c_length=4U c_width=4U
* device instance $410 r0 *1 332.8,75.3 cap_mim_2f0_m4m5_noshield
X$410 \$107__t32 topn__t355 cap_mim_2f0_m4m5_noshield c_length=4U c_width=4U
* device instance $411 r0 *1 339.2,75.3 cap_mim_2f0_m4m5_noshield
X$411 \$90__t177 topn__t354 cap_mim_2f0_m4m5_noshield c_length=4U c_width=4U
* device instance $412 r0 *1 345.6,75.3 cap_mim_2f0_m4m5_noshield
X$412 \$107__t39 topn__t369 cap_mim_2f0_m4m5_noshield c_length=4U c_width=4U
* device instance $413 r0 *1 352,75.3 cap_mim_2f0_m4m5_noshield
X$413 \$90__t136 topn__t276 cap_mim_2f0_m4m5_noshield c_length=4U c_width=4U
* device instance $414 r0 *1 358.4,75.3 cap_mim_2f0_m4m5_noshield
X$414 \$107__t17 topn__t213 cap_mim_2f0_m4m5_noshield c_length=4U c_width=4U
* device instance $415 r0 *1 364.8,75.3 cap_mim_2f0_m4m5_noshield
X$415 \$90__t104 topn__t212 cap_mim_2f0_m4m5_noshield c_length=4U c_width=4U
* device instance $416 r0 *1 371.2,75.3 cap_mim_2f0_m4m5_noshield
X$416 \$107__t25 topn__t239 cap_mim_2f0_m4m5_noshield c_length=4U c_width=4U
* device instance $417 r0 *1 377.6,75.3 cap_mim_2f0_m4m5_noshield
X$417 \$90__t117 topn__t238 cap_mim_2f0_m4m5_noshield c_length=4U c_width=4U
* device instance $418 r0 *1 384,75.3 cap_mim_2f0_m4m5_noshield
X$418 \$107__t24 topn__t237 cap_mim_2f0_m4m5_noshield c_length=4U c_width=4U
* device instance $419 r0 *1 390.4,75.3 cap_mim_2f0_m4m5_noshield
X$419 \$90__t116 topn__t236 cap_mim_2f0_m4m5_noshield c_length=4U c_width=4U
* device instance $420 r0 *1 396.8,75.3 cap_mim_2f0_m4m5_noshield
X$420 \$107__t23 topn__t235 cap_mim_2f0_m4m5_noshield c_length=4U c_width=4U
* device instance $421 r0 *1 403.2,75.3 cap_mim_2f0_m4m5_noshield
X$421 \$90__t115 topn__t234 cap_mim_2f0_m4m5_noshield c_length=4U c_width=4U
* device instance $422 r0 *1 409.6,75.3 cap_mim_2f0_m4m5_noshield
X$422 \$107__t22 topn__t233 cap_mim_2f0_m4m5_noshield c_length=4U c_width=4U
* device instance $423 r0 *1 416,75.3 cap_mim_2f0_m4m5_noshield
X$423 \$90__t114 topn__t232 cap_mim_2f0_m4m5_noshield c_length=4U c_width=4U
* device instance $424 r0 *1 422.4,75.3 cap_mim_2f0_m4m5_noshield
X$424 \$107__t21 topn__t231 cap_mim_2f0_m4m5_noshield c_length=4U c_width=4U
* device instance $425 r0 *1 2.6,81.7 cap_mim_2f0_m4m5_noshield
X$425 \$10__t168 topp__t335 cap_mim_2f0_m4m5_noshield c_length=4U c_width=4U
* device instance $426 r0 *1 9,81.7 cap_mim_2f0_m4m5_noshield
X$426 \$12__t91 topp__t336 cap_mim_2f0_m4m5_noshield c_length=4U c_width=4U
* device instance $427 r0 *1 15.4,81.7 cap_mim_2f0_m4m5_noshield
X$427 \$10__t169 topp__t337 cap_mim_2f0_m4m5_noshield c_length=4U c_width=4U
* device instance $428 r0 *1 21.8,81.7 cap_mim_2f0_m4m5_noshield
X$428 \$12__t92 topp__t338 cap_mim_2f0_m4m5_noshield c_length=4U c_width=4U
* device instance $429 r0 *1 28.2,81.7 cap_mim_2f0_m4m5_noshield
X$429 \$10__t170 topp__t339 cap_mim_2f0_m4m5_noshield c_length=4U c_width=4U
* device instance $430 r0 *1 34.6,81.7 cap_mim_2f0_m4m5_noshield
X$430 \$12__t93 topp__t340 cap_mim_2f0_m4m5_noshield c_length=4U c_width=4U
* device instance $431 r0 *1 41,81.7 cap_mim_2f0_m4m5_noshield
X$431 \$10__t171 topp__t341 cap_mim_2f0_m4m5_noshield c_length=4U c_width=4U
* device instance $432 r0 *1 47.4,81.7 cap_mim_2f0_m4m5_noshield
X$432 \$12__t94 topp__t342 cap_mim_2f0_m4m5_noshield c_length=4U c_width=4U
* device instance $433 r0 *1 53.8,81.7 cap_mim_2f0_m4m5_noshield
X$433 \$10__t172 topp__t343 cap_mim_2f0_m4m5_noshield c_length=4U c_width=4U
* device instance $434 r0 *1 60.2,81.7 cap_mim_2f0_m4m5_noshield
X$434 \$12__t95 topp__t344 cap_mim_2f0_m4m5_noshield c_length=4U c_width=4U
* device instance $435 r0 *1 66.6,81.7 cap_mim_2f0_m4m5_noshield
X$435 \$10__t173 topp__t345 cap_mim_2f0_m4m5_noshield c_length=4U c_width=4U
* device instance $436 r0 *1 73,81.7 cap_mim_2f0_m4m5_noshield
X$436 \$12__t96 topp__t346 cap_mim_2f0_m4m5_noshield c_length=4U c_width=4U
* device instance $437 r0 *1 79.4,81.7 cap_mim_2f0_m4m5_noshield
X$437 \$10__t174 topp__t347 cap_mim_2f0_m4m5_noshield c_length=4U c_width=4U
* device instance $438 r0 *1 85.8,81.7 cap_mim_2f0_m4m5_noshield
X$438 \$12__t97 topp__t348 cap_mim_2f0_m4m5_noshield c_length=4U c_width=4U
* device instance $439 r0 *1 92.2,81.7 cap_mim_2f0_m4m5_noshield
X$439 \$10__t175 topp__t349 cap_mim_2f0_m4m5_noshield c_length=4U c_width=4U
* device instance $440 r0 *1 98.6,81.7 cap_mim_2f0_m4m5_noshield
X$440 \$12__t106 topp__t366 cap_mim_2f0_m4m5_noshield c_length=4U c_width=4U
* device instance $441 r0 *1 105,81.7 cap_mim_2f0_m4m5_noshield
X$441 \$10__t176 topp__t351 cap_mim_2f0_m4m5_noshield c_length=4U c_width=4U
* device instance $442 r0 *1 111.4,81.7 cap_mim_2f0_m4m5_noshield
X$442 \$12__t99 topp__t352 cap_mim_2f0_m4m5_noshield c_length=4U c_width=4U
* device instance $443 r0 *1 117.8,81.7 cap_mim_2f0_m4m5_noshield
X$443 \$10__t177 topp__t353 cap_mim_2f0_m4m5_noshield c_length=4U c_width=4U
* device instance $444 r0 *1 124.2,81.7 cap_mim_2f0_m4m5_noshield
X$444 \$12__t100 topp__t354 cap_mim_2f0_m4m5_noshield c_length=4U c_width=4U
* device instance $445 r0 *1 130.6,81.7 cap_mim_2f0_m4m5_noshield
X$445 \$10__t178 topp__t355 cap_mim_2f0_m4m5_noshield c_length=4U c_width=4U
* device instance $446 r0 *1 137,81.7 cap_mim_2f0_m4m5_noshield
X$446 \$12__t101 topp__t356 cap_mim_2f0_m4m5_noshield c_length=4U c_width=4U
* device instance $447 r0 *1 143.4,81.7 cap_mim_2f0_m4m5_noshield
X$447 \$10__t179 topp__t357 cap_mim_2f0_m4m5_noshield c_length=4U c_width=4U
* device instance $448 r0 *1 149.8,81.7 cap_mim_2f0_m4m5_noshield
X$448 \$12__t102 topp__t358 cap_mim_2f0_m4m5_noshield c_length=4U c_width=4U
* device instance $449 r0 *1 156.2,81.7 cap_mim_2f0_m4m5_noshield
X$449 \$10__t180 topp__t359 cap_mim_2f0_m4m5_noshield c_length=4U c_width=4U
* device instance $450 r0 *1 162.6,81.7 cap_mim_2f0_m4m5_noshield
X$450 \$12__t103 topp__t360 cap_mim_2f0_m4m5_noshield c_length=4U c_width=4U
* device instance $451 r0 *1 169,81.7 cap_mim_2f0_m4m5_noshield
X$451 \$10__t181 topp__t361 cap_mim_2f0_m4m5_noshield c_length=4U c_width=4U
* device instance $452 r0 *1 175.4,81.7 cap_mim_2f0_m4m5_noshield
X$452 \$12__t104 topp__t362 cap_mim_2f0_m4m5_noshield c_length=4U c_width=4U
* device instance $453 r0 *1 181.8,81.7 cap_mim_2f0_m4m5_noshield
X$453 \$10__t182 topp__t363 cap_mim_2f0_m4m5_noshield c_length=4U c_width=4U
* device instance $454 r0 *1 188.2,81.7 cap_mim_2f0_m4m5_noshield
X$454 \$12__t105 topp__t364 cap_mim_2f0_m4m5_noshield c_length=4U c_width=4U
* device instance $455 r0 *1 194.6,81.7 cap_mim_2f0_m4m5_noshield
X$455 \$10__t183 topp__t365 cap_mim_2f0_m4m5_noshield c_length=4U c_width=4U
* device instance $456 r0 *1 201,81.7 cap_mim_2f0_m4m5_noshield
X$456 \$12__t98 topp__t350 cap_mim_2f0_m4m5_noshield c_length=4U c_width=4U
* device instance $457 r0 *1 224,81.7 cap_mim_2f0_m4m5_noshield
X$457 \$90__t153 topn__t306 cap_mim_2f0_m4m5_noshield c_length=4U c_width=4U
* device instance $458 r0 *1 230.4,81.7 cap_mim_2f0_m4m5_noshield
X$458 \$99__t81 topn__t307 cap_mim_2f0_m4m5_noshield c_length=4U c_width=4U
* device instance $459 r0 *1 236.8,81.7 cap_mim_2f0_m4m5_noshield
X$459 \$90__t154 topn__t308 cap_mim_2f0_m4m5_noshield c_length=4U c_width=4U
* device instance $460 r0 *1 243.2,81.7 cap_mim_2f0_m4m5_noshield
X$460 \$99__t82 topn__t309 cap_mim_2f0_m4m5_noshield c_length=4U c_width=4U
* device instance $461 r0 *1 249.6,81.7 cap_mim_2f0_m4m5_noshield
X$461 \$90__t155 topn__t310 cap_mim_2f0_m4m5_noshield c_length=4U c_width=4U
* device instance $462 r0 *1 256,81.7 cap_mim_2f0_m4m5_noshield
X$462 \$99__t83 topn__t311 cap_mim_2f0_m4m5_noshield c_length=4U c_width=4U
* device instance $463 r0 *1 262.4,81.7 cap_mim_2f0_m4m5_noshield
X$463 \$90__t156 topn__t312 cap_mim_2f0_m4m5_noshield c_length=4U c_width=4U
* device instance $464 r0 *1 268.8,81.7 cap_mim_2f0_m4m5_noshield
X$464 \$99__t84 topn__t313 cap_mim_2f0_m4m5_noshield c_length=4U c_width=4U
* device instance $465 r0 *1 275.2,81.7 cap_mim_2f0_m4m5_noshield
X$465 \$90__t157 topn__t314 cap_mim_2f0_m4m5_noshield c_length=4U c_width=4U
* device instance $466 r0 *1 281.6,81.7 cap_mim_2f0_m4m5_noshield
X$466 \$99__t85 topn__t315 cap_mim_2f0_m4m5_noshield c_length=4U c_width=4U
* device instance $467 r0 *1 288,81.7 cap_mim_2f0_m4m5_noshield
X$467 \$90__t158 topn__t316 cap_mim_2f0_m4m5_noshield c_length=4U c_width=4U
* device instance $468 r0 *1 294.4,81.7 cap_mim_2f0_m4m5_noshield
X$468 \$99__t86 topn__t317 cap_mim_2f0_m4m5_noshield c_length=4U c_width=4U
* device instance $469 r0 *1 300.8,81.7 cap_mim_2f0_m4m5_noshield
X$469 \$90__t159 topn__t318 cap_mim_2f0_m4m5_noshield c_length=4U c_width=4U
* device instance $470 r0 *1 307.2,81.7 cap_mim_2f0_m4m5_noshield
X$470 \$99__t87 topn__t319 cap_mim_2f0_m4m5_noshield c_length=4U c_width=4U
* device instance $471 r0 *1 313.6,81.7 cap_mim_2f0_m4m5_noshield
X$471 \$90__t160 topn__t320 cap_mim_2f0_m4m5_noshield c_length=4U c_width=4U
* device instance $472 r0 *1 320,81.7 cap_mim_2f0_m4m5_noshield
X$472 \$99__t95 topn__t337 cap_mim_2f0_m4m5_noshield c_length=4U c_width=4U
* device instance $473 r0 *1 326.4,81.7 cap_mim_2f0_m4m5_noshield
X$473 \$90__t161 topn__t322 cap_mim_2f0_m4m5_noshield c_length=4U c_width=4U
* device instance $474 r0 *1 332.8,81.7 cap_mim_2f0_m4m5_noshield
X$474 \$99__t88 topn__t323 cap_mim_2f0_m4m5_noshield c_length=4U c_width=4U
* device instance $475 r0 *1 339.2,81.7 cap_mim_2f0_m4m5_noshield
X$475 \$90__t162 topn__t324 cap_mim_2f0_m4m5_noshield c_length=4U c_width=4U
* device instance $476 r0 *1 345.6,81.7 cap_mim_2f0_m4m5_noshield
X$476 \$99__t89 topn__t325 cap_mim_2f0_m4m5_noshield c_length=4U c_width=4U
* device instance $477 r0 *1 352,81.7 cap_mim_2f0_m4m5_noshield
X$477 \$90__t163 topn__t326 cap_mim_2f0_m4m5_noshield c_length=4U c_width=4U
* device instance $478 r0 *1 358.4,81.7 cap_mim_2f0_m4m5_noshield
X$478 \$99__t90 topn__t327 cap_mim_2f0_m4m5_noshield c_length=4U c_width=4U
* device instance $479 r0 *1 364.8,81.7 cap_mim_2f0_m4m5_noshield
X$479 \$90__t164 topn__t328 cap_mim_2f0_m4m5_noshield c_length=4U c_width=4U
* device instance $480 r0 *1 371.2,81.7 cap_mim_2f0_m4m5_noshield
X$480 \$99__t91 topn__t329 cap_mim_2f0_m4m5_noshield c_length=4U c_width=4U
* device instance $481 r0 *1 377.6,81.7 cap_mim_2f0_m4m5_noshield
X$481 \$90__t165 topn__t330 cap_mim_2f0_m4m5_noshield c_length=4U c_width=4U
* device instance $482 r0 *1 384,81.7 cap_mim_2f0_m4m5_noshield
X$482 \$99__t92 topn__t331 cap_mim_2f0_m4m5_noshield c_length=4U c_width=4U
* device instance $483 r0 *1 390.4,81.7 cap_mim_2f0_m4m5_noshield
X$483 \$90__t166 topn__t332 cap_mim_2f0_m4m5_noshield c_length=4U c_width=4U
* device instance $484 r0 *1 396.8,81.7 cap_mim_2f0_m4m5_noshield
X$484 \$99__t93 topn__t333 cap_mim_2f0_m4m5_noshield c_length=4U c_width=4U
* device instance $485 r0 *1 403.2,81.7 cap_mim_2f0_m4m5_noshield
X$485 \$90__t167 topn__t334 cap_mim_2f0_m4m5_noshield c_length=4U c_width=4U
* device instance $486 r0 *1 409.6,81.7 cap_mim_2f0_m4m5_noshield
X$486 \$99__t94 topn__t335 cap_mim_2f0_m4m5_noshield c_length=4U c_width=4U
* device instance $487 r0 *1 416,81.7 cap_mim_2f0_m4m5_noshield
X$487 \$90__t168 topn__t336 cap_mim_2f0_m4m5_noshield c_length=4U c_width=4U
* device instance $488 r0 *1 422.4,81.7 cap_mim_2f0_m4m5_noshield
X$488 \$99__t96 topn__t353 cap_mim_2f0_m4m5_noshield c_length=4U c_width=4U
* device instance $489 r0 *1 2.6,88.1 cap_mim_2f0_m4m5_noshield
X$489 \$10__t66 topp__t129 cap_mim_2f0_m4m5_noshield c_length=4U c_width=4U
* device instance $490 r0 *1 9,88.1 cap_mim_2f0_m4m5_noshield
X$490 \$12__t34 topp__t128 cap_mim_2f0_m4m5_noshield c_length=4U c_width=4U
* device instance $491 r0 *1 15.4,88.1 cap_mim_2f0_m4m5_noshield
X$491 \$10__t67 topp__t131 cap_mim_2f0_m4m5_noshield c_length=4U c_width=4U
* device instance $492 r0 *1 21.8,88.1 cap_mim_2f0_m4m5_noshield
X$492 \$12__t35 topp__t130 cap_mim_2f0_m4m5_noshield c_length=4U c_width=4U
* device instance $493 r0 *1 28.2,88.1 cap_mim_2f0_m4m5_noshield
X$493 \$10__t65 topp__t127 cap_mim_2f0_m4m5_noshield c_length=4U c_width=4U
* device instance $494 r0 *1 34.6,88.1 cap_mim_2f0_m4m5_noshield
X$494 \$12__t33 topp__t126 cap_mim_2f0_m4m5_noshield c_length=4U c_width=4U
* device instance $495 r0 *1 41,88.1 cap_mim_2f0_m4m5_noshield
X$495 \$10__t92 topp__t182 cap_mim_2f0_m4m5_noshield c_length=4U c_width=4U
* device instance $496 r0 *1 47.4,88.1 cap_mim_2f0_m4m5_noshield
X$496 \$12__t36 topp__t133 cap_mim_2f0_m4m5_noshield c_length=4U c_width=4U
* device instance $497 r0 *1 53.8,88.1 cap_mim_2f0_m4m5_noshield
X$497 \$10__t68 topp__t132 cap_mim_2f0_m4m5_noshield c_length=4U c_width=4U
* device instance $498 r0 *1 60.2,88.1 cap_mim_2f0_m4m5_noshield
X$498 \$12__t53 topp__t190 cap_mim_2f0_m4m5_noshield c_length=4U c_width=4U
* device instance $499 r0 *1 66.6,88.1 cap_mim_2f0_m4m5_noshield
X$499 \$10__t87 topp__t170 cap_mim_2f0_m4m5_noshield c_length=4U c_width=4U
* device instance $500 r0 *1 73,88.1 cap_mim_2f0_m4m5_noshield
X$500 \$12__t42 topp__t164 cap_mim_2f0_m4m5_noshield c_length=4U c_width=4U
* device instance $501 r0 *1 79.4,88.1 cap_mim_2f0_m4m5_noshield
X$501 \$10__t81 topp__t158 cap_mim_2f0_m4m5_noshield c_length=4U c_width=4U
* device instance $502 r0 *1 85.8,88.1 cap_mim_2f0_m4m5_noshield
X$502 \$12__t46 topp__t171 cap_mim_2f0_m4m5_noshield c_length=4U c_width=4U
* device instance $503 r0 *1 92.2,88.1 cap_mim_2f0_m4m5_noshield
X$503 \$10__t84 topp__t163 cap_mim_2f0_m4m5_noshield c_length=4U c_width=4U
* device instance $504 r0 *1 98.6,88.1 cap_mim_2f0_m4m5_noshield
X$504 \$12__t41 topp__t162 cap_mim_2f0_m4m5_noshield c_length=4U c_width=4U
* device instance $505 r0 *1 105,88.1 cap_mim_2f0_m4m5_noshield
X$505 \$10__t83 topp__t161 cap_mim_2f0_m4m5_noshield c_length=4U c_width=4U
* device instance $506 r0 *1 111.4,88.1 cap_mim_2f0_m4m5_noshield
X$506 \$12__t40 topp__t160 cap_mim_2f0_m4m5_noshield c_length=4U c_width=4U
* device instance $507 r0 *1 117.8,88.1 cap_mim_2f0_m4m5_noshield
X$507 \$10__t136 topp__t273 cap_mim_2f0_m4m5_noshield c_length=4U c_width=4U
* device instance $508 r0 *1 124.2,88.1 cap_mim_2f0_m4m5_noshield
X$508 \$12__t117 topp__t414 cap_mim_2f0_m4m5_noshield c_length=4U c_width=4U
* device instance $509 r0 *1 130.6,88.1 cap_mim_2f0_m4m5_noshield
X$509 \$10__t199 topp__t394 cap_mim_2f0_m4m5_noshield c_length=4U c_width=4U
* device instance $510 r0 *1 137,88.1 cap_mim_2f0_m4m5_noshield
X$510 \$12__t112 topp__t393 cap_mim_2f0_m4m5_noshield c_length=4U c_width=4U
* device instance $511 r0 *1 143.4,88.1 cap_mim_2f0_m4m5_noshield
X$511 \$10__t218 topp__t433 cap_mim_2f0_m4m5_noshield c_length=4U c_width=4U
* device instance $512 r0 *1 149.8,88.1 cap_mim_2f0_m4m5_noshield
X$512 \$12__t126 topp__t445 cap_mim_2f0_m4m5_noshield c_length=4U c_width=4U
* device instance $513 r0 *1 156.2,88.1 cap_mim_2f0_m4m5_noshield
X$513 \$10__t223 topp__t444 cap_mim_2f0_m4m5_noshield c_length=4U c_width=4U
* device instance $514 r0 *1 162.6,88.1 cap_mim_2f0_m4m5_noshield
X$514 \$12__t125 topp__t443 cap_mim_2f0_m4m5_noshield c_length=4U c_width=4U
* device instance $515 r0 *1 169,88.1 cap_mim_2f0_m4m5_noshield
X$515 \$10__t194 topp__t386 cap_mim_2f0_m4m5_noshield c_length=4U c_width=4U
* device instance $516 r0 *1 175.4,88.1 cap_mim_2f0_m4m5_noshield
X$516 \$12__t109 topp__t385 cap_mim_2f0_m4m5_noshield c_length=4U c_width=4U
* device instance $517 r0 *1 181.8,88.1 cap_mim_2f0_m4m5_noshield
X$517 \$10__t193 topp__t384 cap_mim_2f0_m4m5_noshield c_length=4U c_width=4U
* device instance $518 r0 *1 188.2,88.1 cap_mim_2f0_m4m5_noshield
X$518 \$12__t108 topp__t383 cap_mim_2f0_m4m5_noshield c_length=4U c_width=4U
* device instance $519 r0 *1 194.6,88.1 cap_mim_2f0_m4m5_noshield
X$519 \$10__t192 topp__t382 cap_mim_2f0_m4m5_noshield c_length=4U c_width=4U
* device instance $520 r0 *1 201,88.1 cap_mim_2f0_m4m5_noshield
X$520 \$12__t107 topp__t381 cap_mim_2f0_m4m5_noshield c_length=4U c_width=4U
* device instance $521 r0 *1 224,88.1 cap_mim_2f0_m4m5_noshield
X$521 \$90__t202 topn__t406 cap_mim_2f0_m4m5_noshield c_length=4U c_width=4U
* device instance $522 r0 *1 230.4,88.1 cap_mim_2f0_m4m5_noshield
X$522 \$99__t99 topn__t405 cap_mim_2f0_m4m5_noshield c_length=4U c_width=4U
* device instance $523 r0 *1 236.8,88.1 cap_mim_2f0_m4m5_noshield
X$523 \$90__t56 topn__t115 cap_mim_2f0_m4m5_noshield c_length=4U c_width=4U
* device instance $524 r0 *1 243.2,88.1 cap_mim_2f0_m4m5_noshield
X$524 \$99__t29 topn__t87 cap_mim_2f0_m4m5_noshield c_length=4U c_width=4U
* device instance $525 r0 *1 249.6,88.1 cap_mim_2f0_m4m5_noshield
X$525 \$90__t58 topn__t118 cap_mim_2f0_m4m5_noshield c_length=4U c_width=4U
* device instance $526 r0 *1 256,88.1 cap_mim_2f0_m4m5_noshield
X$526 \$99__t14 topn__t34 cap_mim_2f0_m4m5_noshield c_length=4U c_width=4U
* device instance $527 r0 *1 262.4,88.1 cap_mim_2f0_m4m5_noshield
X$527 \$90__t51 topn__t106 cap_mim_2f0_m4m5_noshield c_length=4U c_width=4U
* device instance $528 r0 *1 268.8,88.1 cap_mim_2f0_m4m5_noshield
X$528 \$99__t35 topn__t116 cap_mim_2f0_m4m5_noshield c_length=4U c_width=4U
* device instance $529 r0 *1 275.2,88.1 cap_mim_2f0_m4m5_noshield
X$529 \$90__t50 topn__t104 cap_mim_2f0_m4m5_noshield c_length=4U c_width=4U
* device instance $530 r0 *1 281.6,88.1 cap_mim_2f0_m4m5_noshield
X$530 \$99__t36 topn__t135 cap_mim_2f0_m4m5_noshield c_length=4U c_width=4U
* device instance $531 r0 *1 288,88.1 cap_mim_2f0_m4m5_noshield
X$531 \$90__t57 topn__t117 cap_mim_2f0_m4m5_noshield c_length=4U c_width=4U
* device instance $532 r0 *1 294.4,88.1 cap_mim_2f0_m4m5_noshield
X$532 \$99__t112 topn__t433 cap_mim_2f0_m4m5_noshield c_length=4U c_width=4U
* device instance $533 r0 *1 300.8,88.1 cap_mim_2f0_m4m5_noshield
X$533 \$90__t11 topn__t23 cap_mim_2f0_m4m5_noshield c_length=4U c_width=4U
* device instance $534 r0 *1 307.2,88.1 cap_mim_2f0_m4m5_noshield
X$534 \$99__t8 topn__t22 cap_mim_2f0_m4m5_noshield c_length=4U c_width=4U
* device instance $535 r0 *1 313.6,88.1 cap_mim_2f0_m4m5_noshield
X$535 \$90__t10 topn__t21 cap_mim_2f0_m4m5_noshield c_length=4U c_width=4U
* device instance $536 r0 *1 320,88.1 cap_mim_2f0_m4m5_noshield
X$536 \$99__t10 topn__t27 cap_mim_2f0_m4m5_noshield c_length=4U c_width=4U
* device instance $537 r0 *1 326.4,88.1 cap_mim_2f0_m4m5_noshield
X$537 \$90__t13 topn__t26 cap_mim_2f0_m4m5_noshield c_length=4U c_width=4U
* device instance $538 r0 *1 332.8,88.1 cap_mim_2f0_m4m5_noshield
X$538 \$99__t9 topn__t25 cap_mim_2f0_m4m5_noshield c_length=4U c_width=4U
* device instance $539 r0 *1 339.2,88.1 cap_mim_2f0_m4m5_noshield
X$539 \$90__t12 topn__t24 cap_mim_2f0_m4m5_noshield c_length=4U c_width=4U
* device instance $540 r0 *1 345.6,88.1 cap_mim_2f0_m4m5_noshield
X$540 \$99__t17 topn__t39 cap_mim_2f0_m4m5_noshield c_length=4U c_width=4U
* device instance $541 r0 *1 352,88.1 cap_mim_2f0_m4m5_noshield
X$541 \$90__t185 topn__t370 cap_mim_2f0_m4m5_noshield c_length=4U c_width=4U
* device instance $542 r0 *1 358.4,88.1 cap_mim_2f0_m4m5_noshield
X$542 \$99__t19 topn__t43 cap_mim_2f0_m4m5_noshield c_length=4U c_width=4U
* device instance $543 r0 *1 364.8,88.1 cap_mim_2f0_m4m5_noshield
X$543 \$90__t20 topn__t42 cap_mim_2f0_m4m5_noshield c_length=4U c_width=4U
* device instance $544 r0 *1 371.2,88.1 cap_mim_2f0_m4m5_noshield
X$544 \$99__t18 topn__t41 cap_mim_2f0_m4m5_noshield c_length=4U c_width=4U
* device instance $545 r0 *1 377.6,88.1 cap_mim_2f0_m4m5_noshield
X$545 \$90__t19 topn__t40 cap_mim_2f0_m4m5_noshield c_length=4U c_width=4U
* device instance $546 r0 *1 384,88.1 cap_mim_2f0_m4m5_noshield
X$546 \$99__t37 topn__t136 cap_mim_2f0_m4m5_noshield c_length=4U c_width=4U
* device instance $547 r0 *1 390.4,88.1 cap_mim_2f0_m4m5_noshield
X$547 \$90__t84 topn__t170 cap_mim_2f0_m4m5_noshield c_length=4U c_width=4U
* device instance $548 r0 *1 396.8,88.1 cap_mim_2f0_m4m5_noshield
X$548 \$99__t43 topn__t169 cap_mim_2f0_m4m5_noshield c_length=4U c_width=4U
* device instance $549 r0 *1 403.2,88.1 cap_mim_2f0_m4m5_noshield
X$549 \$90__t83 topn__t168 cap_mim_2f0_m4m5_noshield c_length=4U c_width=4U
* device instance $550 r0 *1 409.6,88.1 cap_mim_2f0_m4m5_noshield
X$550 \$99__t22 topn__t57 cap_mim_2f0_m4m5_noshield c_length=4U c_width=4U
* device instance $551 r0 *1 416,88.1 cap_mim_2f0_m4m5_noshield
X$551 \$90__t26 topn__t56 cap_mim_2f0_m4m5_noshield c_length=4U c_width=4U
* device instance $552 r0 *1 422.4,88.1 cap_mim_2f0_m4m5_noshield
X$552 \$99__t20 topn__t44 cap_mim_2f0_m4m5_noshield c_length=4U c_width=4U
* device instance $553 r0 *1 2.6,94.5 cap_mim_2f0_m4m5_noshield
X$553 \$12__t0 topp__t181 cap_mim_2f0_m4m5_noshield c_length=4U c_width=4U
* device instance $554 r0 *1 9,94.5 cap_mim_2f0_m4m5_noshield
X$554 \$10__t91 topp__t180 cap_mim_2f0_m4m5_noshield c_length=4U c_width=4U
* device instance $555 r0 *1 15.4,94.5 cap_mim_2f0_m4m5_noshield
X$555 \$12__t51 topp__t179 cap_mim_2f0_m4m5_noshield c_length=4U c_width=4U
* device instance $556 r0 *1 21.8,94.5 cap_mim_2f0_m4m5_noshield
X$556 \$10__t90 topp__t178 cap_mim_2f0_m4m5_noshield c_length=4U c_width=4U
* device instance $557 r0 *1 28.2,94.5 cap_mim_2f0_m4m5_noshield
X$557 \$12__t50 topp__t177 cap_mim_2f0_m4m5_noshield c_length=4U c_width=4U
* device instance $558 r0 *1 34.6,94.5 cap_mim_2f0_m4m5_noshield
X$558 \$10__t89 topp__t176 cap_mim_2f0_m4m5_noshield c_length=4U c_width=4U
* device instance $559 r0 *1 41,94.5 cap_mim_2f0_m4m5_noshield
X$559 \$12__t49 topp__t175 cap_mim_2f0_m4m5_noshield c_length=4U c_width=4U
* device instance $560 r0 *1 47.4,94.5 cap_mim_2f0_m4m5_noshield
X$560 \$10__t88 topp__t174 cap_mim_2f0_m4m5_noshield c_length=4U c_width=4U
* device instance $561 r0 *1 53.8,94.5 cap_mim_2f0_m4m5_noshield
X$561 \$12__t48 topp__t173 cap_mim_2f0_m4m5_noshield c_length=4U c_width=4U
* device instance $562 r0 *1 60.2,94.5 cap_mim_2f0_m4m5_noshield
X$562 \$10__t94 topp__t186 cap_mim_2f0_m4m5_noshield c_length=4U c_width=4U
* device instance $563 r0 *1 66.6,94.5 cap_mim_2f0_m4m5_noshield
X$563 \$12__t39 topp__t157 cap_mim_2f0_m4m5_noshield c_length=4U c_width=4U
* device instance $564 r0 *1 73,94.5 cap_mim_2f0_m4m5_noshield
X$564 \$10__t80 topp__t156 cap_mim_2f0_m4m5_noshield c_length=4U c_width=4U
* device instance $565 r0 *1 79.4,94.5 cap_mim_2f0_m4m5_noshield
X$565 \$12__t38 topp__t155 cap_mim_2f0_m4m5_noshield c_length=4U c_width=4U
* device instance $566 r0 *1 85.8,94.5 cap_mim_2f0_m4m5_noshield
X$566 \$10__t79 topp__t154 cap_mim_2f0_m4m5_noshield c_length=4U c_width=4U
* device instance $567 r0 *1 92.2,94.5 cap_mim_2f0_m4m5_noshield
X$567 \$12__t43 topp__t165 cap_mim_2f0_m4m5_noshield c_length=4U c_width=4U
* device instance $568 r0 *1 98.6,94.5 cap_mim_2f0_m4m5_noshield
X$568 \$10__t82 topp__t159 cap_mim_2f0_m4m5_noshield c_length=4U c_width=4U
* device instance $569 r0 *1 105,94.5 cap_mim_2f0_m4m5_noshield
X$569 \$12__t52 topp__t183 cap_mim_2f0_m4m5_noshield c_length=4U c_width=4U
* device instance $570 r0 *1 111.4,94.5 cap_mim_2f0_m4m5_noshield
X$570 \$10__t85 topp__t166 cap_mim_2f0_m4m5_noshield c_length=4U c_width=4U
* device instance $571 r0 *1 117.8,94.5 cap_mim_2f0_m4m5_noshield
X$571 \$12__t90 topp__t308 cap_mim_2f0_m4m5_noshield c_length=4U c_width=4U
* device instance $572 r0 *1 124.2,94.5 cap_mim_2f0_m4m5_noshield
X$572 \$10__t208 topp__t415 cap_mim_2f0_m4m5_noshield c_length=4U c_width=4U
* device instance $573 r0 *1 130.6,94.5 cap_mim_2f0_m4m5_noshield
X$573 \$12__t124 topp__t442 cap_mim_2f0_m4m5_noshield c_length=4U c_width=4U
* device instance $574 r0 *1 137,94.5 cap_mim_2f0_m4m5_noshield
X$574 \$10__t222 topp__t441 cap_mim_2f0_m4m5_noshield c_length=4U c_width=4U
* device instance $575 r0 *1 143.4,94.5 cap_mim_2f0_m4m5_noshield
X$575 \$12__t123 topp__t440 cap_mim_2f0_m4m5_noshield c_length=4U c_width=4U
* device instance $576 r0 *1 149.8,94.5 cap_mim_2f0_m4m5_noshield
X$576 \$10__t191 topp__t380 cap_mim_2f0_m4m5_noshield c_length=4U c_width=4U
* device instance $577 r0 *1 156.2,94.5 cap_mim_2f0_m4m5_noshield
X$577 \$12__t111 topp__t390 cap_mim_2f0_m4m5_noshield c_length=4U c_width=4U
* device instance $578 r0 *1 162.6,94.5 cap_mim_2f0_m4m5_noshield
X$578 \$10__t190 topp__t379 cap_mim_2f0_m4m5_noshield c_length=4U c_width=4U
* device instance $579 r0 *1 169,94.5 cap_mim_2f0_m4m5_noshield
X$579 \$12__t122 topp__t426 cap_mim_2f0_m4m5_noshield c_length=4U c_width=4U
* device instance $580 r0 *1 175.4,94.5 cap_mim_2f0_m4m5_noshield
X$580 \$10__t214 topp__t425 cap_mim_2f0_m4m5_noshield c_length=4U c_width=4U
* device instance $581 r0 *1 181.8,94.5 cap_mim_2f0_m4m5_noshield
X$581 \$12__t121 topp__t424 cap_mim_2f0_m4m5_noshield c_length=4U c_width=4U
* device instance $582 r0 *1 188.2,94.5 cap_mim_2f0_m4m5_noshield
X$582 \$10__t213 topp__t423 cap_mim_2f0_m4m5_noshield c_length=4U c_width=4U
* device instance $583 r0 *1 194.6,94.5 cap_mim_2f0_m4m5_noshield
X$583 \$12__t120 topp__t422 cap_mim_2f0_m4m5_noshield c_length=4U c_width=4U
* device instance $584 r0 *1 201,94.5 cap_mim_2f0_m4m5_noshield
X$584 \$10__t212 topp__t421 cap_mim_2f0_m4m5_noshield c_length=4U c_width=4U
* device instance $585 r0 *1 224,94.5 cap_mim_2f0_m4m5_noshield
X$585 \$99__t113 topn__t444 cap_mim_2f0_m4m5_noshield c_length=4U c_width=4U
* device instance $586 r0 *1 230.4,94.5 cap_mim_2f0_m4m5_noshield
X$586 \$90__t203 topn__t407 cap_mim_2f0_m4m5_noshield c_length=4U c_width=4U
* device instance $587 r0 *1 236.8,94.5 cap_mim_2f0_m4m5_noshield
X$587 \$99__t34 topn__t114 cap_mim_2f0_m4m5_noshield c_length=4U c_width=4U
* device instance $588 r0 *1 243.2,94.5 cap_mim_2f0_m4m5_noshield
X$588 \$90__t55 topn__t113 cap_mim_2f0_m4m5_noshield c_length=4U c_width=4U
* device instance $589 r0 *1 249.6,94.5 cap_mim_2f0_m4m5_noshield
X$589 \$99__t33 topn__t112 cap_mim_2f0_m4m5_noshield c_length=4U c_width=4U
* device instance $590 r0 *1 256,94.5 cap_mim_2f0_m4m5_noshield
X$590 \$90__t54 topn__t111 cap_mim_2f0_m4m5_noshield c_length=4U c_width=4U
* device instance $591 r0 *1 262.4,94.5 cap_mim_2f0_m4m5_noshield
X$591 \$99__t32 topn__t110 cap_mim_2f0_m4m5_noshield c_length=4U c_width=4U
* device instance $592 r0 *1 268.8,94.5 cap_mim_2f0_m4m5_noshield
X$592 \$90__t53 topn__t109 cap_mim_2f0_m4m5_noshield c_length=4U c_width=4U
* device instance $593 r0 *1 275.2,94.5 cap_mim_2f0_m4m5_noshield
X$593 \$99__t31 topn__t108 cap_mim_2f0_m4m5_noshield c_length=4U c_width=4U
* device instance $594 r0 *1 281.6,94.5 cap_mim_2f0_m4m5_noshield
X$594 \$90__t52 topn__t107 cap_mim_2f0_m4m5_noshield c_length=4U c_width=4U
* device instance $595 r0 *1 288,94.5 cap_mim_2f0_m4m5_noshield
X$595 \$99__t30 topn__t105 cap_mim_2f0_m4m5_noshield c_length=4U c_width=4U
* device instance $596 r0 *1 294.4,94.5 cap_mim_2f0_m4m5_noshield
X$596 \$90__t217 topn__t434 cap_mim_2f0_m4m5_noshield c_length=4U c_width=4U
* device instance $597 r0 *1 300.8,94.5 cap_mim_2f0_m4m5_noshield
X$597 \$99__t7 topn__t20 cap_mim_2f0_m4m5_noshield c_length=4U c_width=4U
* device instance $598 r0 *1 307.2,94.5 cap_mim_2f0_m4m5_noshield
X$598 \$90__t9 topn__t19 cap_mim_2f0_m4m5_noshield c_length=4U c_width=4U
* device instance $599 r0 *1 313.6,94.5 cap_mim_2f0_m4m5_noshield
X$599 \$99__t6 topn__t18 cap_mim_2f0_m4m5_noshield c_length=4U c_width=4U
* device instance $600 r0 *1 320,94.5 cap_mim_2f0_m4m5_noshield
X$600 \$90__t4 topn__t9 cap_mim_2f0_m4m5_noshield c_length=4U c_width=4U
* device instance $601 r0 *1 326.4,94.5 cap_mim_2f0_m4m5_noshield
X$601 \$99__t21 topn__t55 cap_mim_2f0_m4m5_noshield c_length=4U c_width=4U
* device instance $602 r0 *1 332.8,94.5 cap_mim_2f0_m4m5_noshield
X$602 \$90__t33 topn__t70 cap_mim_2f0_m4m5_noshield c_length=4U c_width=4U
* device instance $603 r0 *1 339.2,94.5 cap_mim_2f0_m4m5_noshield
X$603 \$99__t28 topn__t69 cap_mim_2f0_m4m5_noshield c_length=4U c_width=4U
* device instance $604 r0 *1 345.6,94.5 cap_mim_2f0_m4m5_noshield
X$604 \$90__t14 topn__t28 cap_mim_2f0_m4m5_noshield c_length=4U c_width=4U
* device instance $605 r0 *1 352,94.5 cap_mim_2f0_m4m5_noshield
X$605 \$99__t97 topn__t371 cap_mim_2f0_m4m5_noshield c_length=4U c_width=4U
* device instance $606 r0 *1 358.4,94.5 cap_mim_2f0_m4m5_noshield
X$606 \$90__t82 topn__t167 cap_mim_2f0_m4m5_noshield c_length=4U c_width=4U
* device instance $607 r0 *1 364.8,94.5 cap_mim_2f0_m4m5_noshield
X$607 \$99__t42 topn__t166 cap_mim_2f0_m4m5_noshield c_length=4U c_width=4U
* device instance $608 r0 *1 371.2,94.5 cap_mim_2f0_m4m5_noshield
X$608 \$90__t81 topn__t165 cap_mim_2f0_m4m5_noshield c_length=4U c_width=4U
* device instance $609 r0 *1 377.6,94.5 cap_mim_2f0_m4m5_noshield
X$609 \$99__t41 topn__t164 cap_mim_2f0_m4m5_noshield c_length=4U c_width=4U
* device instance $610 r0 *1 384,94.5 cap_mim_2f0_m4m5_noshield
X$610 \$90__t80 topn__t163 cap_mim_2f0_m4m5_noshield c_length=4U c_width=4U
* device instance $611 r0 *1 390.4,94.5 cap_mim_2f0_m4m5_noshield
X$611 \$99__t40 topn__t141 cap_mim_2f0_m4m5_noshield c_length=4U c_width=4U
* device instance $612 r0 *1 396.8,94.5 cap_mim_2f0_m4m5_noshield
X$612 \$90__t86 topn__t174 cap_mim_2f0_m4m5_noshield c_length=4U c_width=4U
* device instance $613 r0 *1 403.2,94.5 cap_mim_2f0_m4m5_noshield
X$613 \$99__t44 topn__t175 cap_mim_2f0_m4m5_noshield c_length=4U c_width=4U
* device instance $614 r0 *1 409.6,94.5 cap_mim_2f0_m4m5_noshield
X$614 \$90__t28 topn__t60 cap_mim_2f0_m4m5_noshield c_length=4U c_width=4U
* device instance $615 r0 *1 416,94.5 cap_mim_2f0_m4m5_noshield
X$615 \$99__t23 topn__t59 cap_mim_2f0_m4m5_noshield c_length=4U c_width=4U
* device instance $616 r0 *1 422.4,94.5 cap_mim_2f0_m4m5_noshield
X$616 \$90__t27 topn__t58 cap_mim_2f0_m4m5_noshield c_length=4U c_width=4U
* device instance $617 r0 *1 2.6,100.9 cap_mim_2f0_m4m5_noshield
X$617 \$12__t47 topp__t172 cap_mim_2f0_m4m5_noshield c_length=4U c_width=4U
* device instance $618 r0 *1 9,100.9 cap_mim_2f0_m4m5_noshield
X$618 \$10__t69 topp__t134 cap_mim_2f0_m4m5_noshield c_length=4U c_width=4U
* device instance $619 r0 *1 15.4,100.9 cap_mim_2f0_m4m5_noshield
X$619 \$12__t32 topp__t125 cap_mim_2f0_m4m5_noshield c_length=4U c_width=4U
* device instance $620 r0 *1 21.8,100.9 cap_mim_2f0_m4m5_noshield
X$620 \$10__t64 topp__t124 cap_mim_2f0_m4m5_noshield c_length=4U c_width=4U
* device instance $621 r0 *1 28.2,100.9 cap_mim_2f0_m4m5_noshield
X$621 \$12__t31 topp__t123 cap_mim_2f0_m4m5_noshield c_length=4U c_width=4U
* device instance $622 r0 *1 34.6,100.9 cap_mim_2f0_m4m5_noshield
X$622 \$10__t63 topp__t122 cap_mim_2f0_m4m5_noshield c_length=4U c_width=4U
* device instance $623 r0 *1 41,100.9 cap_mim_2f0_m4m5_noshield
X$623 \$12__t30 topp__t121 cap_mim_2f0_m4m5_noshield c_length=4U c_width=4U
* device instance $624 r0 *1 47.4,100.9 cap_mim_2f0_m4m5_noshield
X$624 \$10__t62 topp__t120 cap_mim_2f0_m4m5_noshield c_length=4U c_width=4U
* device instance $625 r0 *1 53.8,100.9 cap_mim_2f0_m4m5_noshield
X$625 \$12__t44 topp__t167 cap_mim_2f0_m4m5_noshield c_length=4U c_width=4U
* device instance $626 r0 *1 60.2,100.9 cap_mim_2f0_m4m5_noshield
X$626 \$10__t95 topp__t187 cap_mim_2f0_m4m5_noshield c_length=4U c_width=4U
* device instance $627 r0 *1 66.6,100.9 cap_mim_2f0_m4m5_noshield
X$627 \$12__t45 topp__t169 cap_mim_2f0_m4m5_noshield c_length=4U c_width=4U
* device instance $628 r0 *1 73,100.9 cap_mim_2f0_m4m5_noshield
X$628 \$10__t86 topp__t168 cap_mim_2f0_m4m5_noshield c_length=4U c_width=4U
* device instance $629 r0 *1 79.4,100.9 cap_mim_2f0_m4m5_noshield
X$629 \$12__t37 topp__t153 cap_mim_2f0_m4m5_noshield c_length=4U c_width=4U
* device instance $630 r0 *1 85.8,100.9 cap_mim_2f0_m4m5_noshield
X$630 \$10__t78 topp__t152 cap_mim_2f0_m4m5_noshield c_length=4U c_width=4U
* device instance $631 r0 *1 92.2,100.9 cap_mim_2f0_m4m5_noshield
X$631 \$12__t119 topp__t419 cap_mim_2f0_m4m5_noshield c_length=4U c_width=4U
* device instance $632 r0 *1 98.6,100.9 cap_mim_2f0_m4m5_noshield
X$632 \$10__t230 topp__t457 cap_mim_2f0_m4m5_noshield c_length=4U c_width=4U
* device instance $633 r0 *1 105,100.9 cap_mim_2f0_m4m5_noshield
X$633 \$12__t118 topp__t418 cap_mim_2f0_m4m5_noshield c_length=4U c_width=4U
* device instance $634 r0 *1 111.4,100.9 cap_mim_2f0_m4m5_noshield
X$634 \$10__t210 topp__t417 cap_mim_2f0_m4m5_noshield c_length=4U c_width=4U
* device instance $635 r0 *1 117.8,100.9 cap_mim_2f0_m4m5_noshield
X$635 \$12__t74 topp__t271 cap_mim_2f0_m4m5_noshield c_length=4U c_width=4U
* device instance $636 r0 *1 124.2,100.9 cap_mim_2f0_m4m5_noshield
X$636 \$10__t225 topp__t448 cap_mim_2f0_m4m5_noshield c_length=4U c_width=4U
* device instance $637 r0 *1 130.6,100.9 cap_mim_2f0_m4m5_noshield
X$637 \$12__t127 topp__t447 cap_mim_2f0_m4m5_noshield c_length=4U c_width=4U
* device instance $638 r0 *1 137,100.9 cap_mim_2f0_m4m5_noshield
X$638 \$10__t224 topp__t446 cap_mim_2f0_m4m5_noshield c_length=4U c_width=4U
* device instance $639 r0 *1 143.4,100.9 cap_mim_2f0_m4m5_noshield
X$639 \$12__t115 topp__t400 cap_mim_2f0_m4m5_noshield c_length=4U c_width=4U
* device instance $640 r0 *1 149.8,100.9 cap_mim_2f0_m4m5_noshield
X$640 \$10__t202 topp__t399 cap_mim_2f0_m4m5_noshield c_length=4U c_width=4U
* device instance $641 r0 *1 156.2,100.9 cap_mim_2f0_m4m5_noshield
X$641 \$12__t114 topp__t398 cap_mim_2f0_m4m5_noshield c_length=4U c_width=4U
* device instance $642 r0 *1 162.6,100.9 cap_mim_2f0_m4m5_noshield
X$642 \$10__t201 topp__t397 cap_mim_2f0_m4m5_noshield c_length=4U c_width=4U
* device instance $643 r0 *1 169,100.9 cap_mim_2f0_m4m5_noshield
X$643 \$12__t113 topp__t396 cap_mim_2f0_m4m5_noshield c_length=4U c_width=4U
* device instance $644 r0 *1 175.4,100.9 cap_mim_2f0_m4m5_noshield
X$644 \$10__t200 topp__t395 cap_mim_2f0_m4m5_noshield c_length=4U c_width=4U
* device instance $645 r0 *1 181.8,100.9 cap_mim_2f0_m4m5_noshield
X$645 \$12__t116 topp__t406 cap_mim_2f0_m4m5_noshield c_length=4U c_width=4U
* device instance $646 r0 *1 188.2,100.9 cap_mim_2f0_m4m5_noshield
X$646 \$10__t196 topp__t389 cap_mim_2f0_m4m5_noshield c_length=4U c_width=4U
* device instance $647 r0 *1 194.6,100.9 cap_mim_2f0_m4m5_noshield
X$647 \$12__t110 topp__t388 cap_mim_2f0_m4m5_noshield c_length=4U c_width=4U
* device instance $648 r0 *1 201,100.9 cap_mim_2f0_m4m5_noshield
X$648 \$10__t195 topp__t387 cap_mim_2f0_m4m5_noshield c_length=4U c_width=4U
* device instance $649 r0 *1 224,100.9 cap_mim_2f0_m4m5_noshield
X$649 \$99__t100 topn__t409 cap_mim_2f0_m4m5_noshield c_length=4U c_width=4U
* device instance $650 r0 *1 230.4,100.9 cap_mim_2f0_m4m5_noshield
X$650 \$90__t204 topn__t408 cap_mim_2f0_m4m5_noshield c_length=4U c_width=4U
* device instance $651 r0 *1 236.8,100.9 cap_mim_2f0_m4m5_noshield
X$651 \$99__t16 topn__t38 cap_mim_2f0_m4m5_noshield c_length=4U c_width=4U
* device instance $652 r0 *1 243.2,100.9 cap_mim_2f0_m4m5_noshield
X$652 \$90__t18 topn__t37 cap_mim_2f0_m4m5_noshield c_length=4U c_width=4U
* device instance $653 r0 *1 249.6,100.9 cap_mim_2f0_m4m5_noshield
X$653 \$99__t15 topn__t36 cap_mim_2f0_m4m5_noshield c_length=4U c_width=4U
* device instance $654 r0 *1 256,100.9 cap_mim_2f0_m4m5_noshield
X$654 \$90__t17 topn__t35 cap_mim_2f0_m4m5_noshield c_length=4U c_width=4U
* device instance $655 r0 *1 262.4,100.9 cap_mim_2f0_m4m5_noshield
X$655 \$99__t13 topn__t33 cap_mim_2f0_m4m5_noshield c_length=4U c_width=4U
* device instance $656 r0 *1 268.8,100.9 cap_mim_2f0_m4m5_noshield
X$656 \$90__t16 topn__t32 cap_mim_2f0_m4m5_noshield c_length=4U c_width=4U
* device instance $657 r0 *1 275.2,100.9 cap_mim_2f0_m4m5_noshield
X$657 \$99__t12 topn__t31 cap_mim_2f0_m4m5_noshield c_length=4U c_width=4U
* device instance $658 r0 *1 281.6,100.9 cap_mim_2f0_m4m5_noshield
X$658 \$90__t15 topn__t30 cap_mim_2f0_m4m5_noshield c_length=4U c_width=4U
* device instance $659 r0 *1 288,100.9 cap_mim_2f0_m4m5_noshield
X$659 \$99__t11 topn__t29 cap_mim_2f0_m4m5_noshield c_length=4U c_width=4U
* device instance $660 r0 *1 294.4,100.9 cap_mim_2f0_m4m5_noshield
X$660 \$90__t218 topn__t435 cap_mim_2f0_m4m5_noshield c_length=4U c_width=4U
* device instance $661 r0 *1 300.8,100.9 cap_mim_2f0_m4m5_noshield
X$661 \$99__t5 topn__t17 cap_mim_2f0_m4m5_noshield c_length=4U c_width=4U
* device instance $662 r0 *1 307.2,100.9 cap_mim_2f0_m4m5_noshield
X$662 \$90__t8 topn__t16 cap_mim_2f0_m4m5_noshield c_length=4U c_width=4U
* device instance $663 r0 *1 313.6,100.9 cap_mim_2f0_m4m5_noshield
X$663 \$99__t4 topn__t15 cap_mim_2f0_m4m5_noshield c_length=4U c_width=4U
* device instance $664 r0 *1 320,100.9 cap_mim_2f0_m4m5_noshield
X$664 \$90__t7 topn__t14 cap_mim_2f0_m4m5_noshield c_length=4U c_width=4U
* device instance $665 r0 *1 326.4,100.9 cap_mim_2f0_m4m5_noshield
X$665 \$99__t3 topn__t13 cap_mim_2f0_m4m5_noshield c_length=4U c_width=4U
* device instance $666 r0 *1 332.8,100.9 cap_mim_2f0_m4m5_noshield
X$666 \$90__t6 topn__t12 cap_mim_2f0_m4m5_noshield c_length=4U c_width=4U
* device instance $667 r0 *1 339.2,100.9 cap_mim_2f0_m4m5_noshield
X$667 \$99__t2 topn__t11 cap_mim_2f0_m4m5_noshield c_length=4U c_width=4U
* device instance $668 r0 *1 345.6,100.9 cap_mim_2f0_m4m5_noshield
X$668 \$90__t5 topn__t10 cap_mim_2f0_m4m5_noshield c_length=4U c_width=4U
* device instance $669 r0 *1 352,100.9 cap_mim_2f0_m4m5_noshield
X$669 \$99__t98 topn__t372 cap_mim_2f0_m4m5_noshield c_length=4U c_width=4U
* device instance $670 r0 *1 358.4,100.9 cap_mim_2f0_m4m5_noshield
X$670 \$90__t87 topn__t176 cap_mim_2f0_m4m5_noshield c_length=4U c_width=4U
* device instance $671 r0 *1 364.8,100.9 cap_mim_2f0_m4m5_noshield
X$671 \$99__t45 topn__t177 cap_mim_2f0_m4m5_noshield c_length=4U c_width=4U
* device instance $672 r0 *1 371.2,100.9 cap_mim_2f0_m4m5_noshield
X$672 \$90__t88 topn__t178 cap_mim_2f0_m4m5_noshield c_length=4U c_width=4U
* device instance $673 r0 *1 377.6,100.9 cap_mim_2f0_m4m5_noshield
X$673 \$99__t27 topn__t68 cap_mim_2f0_m4m5_noshield c_length=4U c_width=4U
* device instance $674 r0 *1 384,100.9 cap_mim_2f0_m4m5_noshield
X$674 \$90__t32 topn__t67 cap_mim_2f0_m4m5_noshield c_length=4U c_width=4U
* device instance $675 r0 *1 390.4,100.9 cap_mim_2f0_m4m5_noshield
X$675 \$99__t26 topn__t66 cap_mim_2f0_m4m5_noshield c_length=4U c_width=4U
* device instance $676 r0 *1 396.8,100.9 cap_mim_2f0_m4m5_noshield
X$676 \$90__t31 topn__t65 cap_mim_2f0_m4m5_noshield c_length=4U c_width=4U
* device instance $677 r0 *1 403.2,100.9 cap_mim_2f0_m4m5_noshield
X$677 \$99__t25 topn__t64 cap_mim_2f0_m4m5_noshield c_length=4U c_width=4U
* device instance $678 r0 *1 409.6,100.9 cap_mim_2f0_m4m5_noshield
X$678 \$90__t30 topn__t63 cap_mim_2f0_m4m5_noshield c_length=4U c_width=4U
* device instance $679 r0 *1 416,100.9 cap_mim_2f0_m4m5_noshield
X$679 \$99__t24 topn__t62 cap_mim_2f0_m4m5_noshield c_length=4U c_width=4U
* device instance $680 r0 *1 422.4,100.9 cap_mim_2f0_m4m5_noshield
X$680 \$90__t29 topn__t61 cap_mim_2f0_m4m5_noshield c_length=4U c_width=4U
* device instance $681 r0 *1 2.6,107.3 cap_mim_2f0_m4m5_noshield
X$681 \$14__t19 topp__t147 cap_mim_2f0_m4m5_noshield c_length=4U c_width=4U
* device instance $682 r0 *1 9,107.3 cap_mim_2f0_m4m5_noshield
X$682 \$10__t75 topp__t146 cap_mim_2f0_m4m5_noshield c_length=4U c_width=4U
* device instance $683 r0 *1 15.4,107.3 cap_mim_2f0_m4m5_noshield
X$683 \$14__t18 topp__t145 cap_mim_2f0_m4m5_noshield c_length=4U c_width=4U
* device instance $684 r0 *1 21.8,107.3 cap_mim_2f0_m4m5_noshield
X$684 \$10__t74 topp__t144 cap_mim_2f0_m4m5_noshield c_length=4U c_width=4U
* device instance $685 r0 *1 28.2,107.3 cap_mim_2f0_m4m5_noshield
X$685 \$14__t17 topp__t143 cap_mim_2f0_m4m5_noshield c_length=4U c_width=4U
* device instance $686 r0 *1 34.6,107.3 cap_mim_2f0_m4m5_noshield
X$686 \$10__t73 topp__t142 cap_mim_2f0_m4m5_noshield c_length=4U c_width=4U
* device instance $687 r0 *1 41,107.3 cap_mim_2f0_m4m5_noshield
X$687 \$14__t16 topp__t141 cap_mim_2f0_m4m5_noshield c_length=4U c_width=4U
* device instance $688 r0 *1 47.4,107.3 cap_mim_2f0_m4m5_noshield
X$688 \$10__t72 topp__t140 cap_mim_2f0_m4m5_noshield c_length=4U c_width=4U
* device instance $689 r0 *1 53.8,107.3 cap_mim_2f0_m4m5_noshield
X$689 \$14__t15 topp__t139 cap_mim_2f0_m4m5_noshield c_length=4U c_width=4U
* device instance $690 r0 *1 60.2,107.3 cap_mim_2f0_m4m5_noshield
X$690 \$10__t96 topp__t188 cap_mim_2f0_m4m5_noshield c_length=4U c_width=4U
* device instance $691 r0 *1 66.6,107.3 cap_mim_2f0_m4m5_noshield
X$691 \$14__t22 topp__t228 cap_mim_2f0_m4m5_noshield c_length=4U c_width=4U
* device instance $692 r0 *1 73,107.3 cap_mim_2f0_m4m5_noshield
X$692 \$10__t118 topp__t231 cap_mim_2f0_m4m5_noshield c_length=4U c_width=4U
* device instance $693 r0 *1 79.4,107.3 cap_mim_2f0_m4m5_noshield
X$693 \$14__t23 topp__t234 cap_mim_2f0_m4m5_noshield c_length=4U c_width=4U
* device instance $694 r0 *1 85.8,107.3 cap_mim_2f0_m4m5_noshield
X$694 \$10__t116 topp__t229 cap_mim_2f0_m4m5_noshield c_length=4U c_width=4U
* device instance $695 r0 *1 92.2,107.3 cap_mim_2f0_m4m5_noshield
X$695 \$14__t21 topp__t227 cap_mim_2f0_m4m5_noshield c_length=4U c_width=4U
* device instance $696 r0 *1 98.6,107.3 cap_mim_2f0_m4m5_noshield
X$696 \$10__t115 topp__t226 cap_mim_2f0_m4m5_noshield c_length=4U c_width=4U
* device instance $697 r0 *1 105,107.3 cap_mim_2f0_m4m5_noshield
X$697 \$14__t20 topp__t185 cap_mim_2f0_m4m5_noshield c_length=4U c_width=4U
* device instance $698 r0 *1 111.4,107.3 cap_mim_2f0_m4m5_noshield
X$698 \$10__t93 topp__t184 cap_mim_2f0_m4m5_noshield c_length=4U c_width=4U
* device instance $699 r0 *1 117.8,107.3 cap_mim_2f0_m4m5_noshield
X$699 \$14__t28 topp__t277 cap_mim_2f0_m4m5_noshield c_length=4U c_width=4U
* device instance $700 r0 *1 124.2,107.3 cap_mim_2f0_m4m5_noshield
X$700 \$10__t221 topp__t439 cap_mim_2f0_m4m5_noshield c_length=4U c_width=4U
* device instance $701 r0 *1 130.6,107.3 cap_mim_2f0_m4m5_noshield
X$701 \$14__t47 topp__t438 cap_mim_2f0_m4m5_noshield c_length=4U c_width=4U
* device instance $702 r0 *1 137,107.3 cap_mim_2f0_m4m5_noshield
X$702 \$10__t220 topp__t437 cap_mim_2f0_m4m5_noshield c_length=4U c_width=4U
* device instance $703 r0 *1 143.4,107.3 cap_mim_2f0_m4m5_noshield
X$703 \$14__t46 topp__t436 cap_mim_2f0_m4m5_noshield c_length=4U c_width=4U
* device instance $704 r0 *1 149.8,107.3 cap_mim_2f0_m4m5_noshield
X$704 \$10__t219 topp__t435 cap_mim_2f0_m4m5_noshield c_length=4U c_width=4U
* device instance $705 r0 *1 156.2,107.3 cap_mim_2f0_m4m5_noshield
X$705 \$14__t45 topp__t434 cap_mim_2f0_m4m5_noshield c_length=4U c_width=4U
* device instance $706 r0 *1 162.6,107.3 cap_mim_2f0_m4m5_noshield
X$706 \$10__t226 topp__t449 cap_mim_2f0_m4m5_noshield c_length=4U c_width=4U
* device instance $707 r0 *1 169,107.3 cap_mim_2f0_m4m5_noshield
X$707 \$14__t44 topp__t432 cap_mim_2f0_m4m5_noshield c_length=4U c_width=4U
* device instance $708 r0 *1 175.4,107.3 cap_mim_2f0_m4m5_noshield
X$708 \$10__t217 topp__t431 cap_mim_2f0_m4m5_noshield c_length=4U c_width=4U
* device instance $709 r0 *1 181.8,107.3 cap_mim_2f0_m4m5_noshield
X$709 \$14__t43 topp__t430 cap_mim_2f0_m4m5_noshield c_length=4U c_width=4U
* device instance $710 r0 *1 188.2,107.3 cap_mim_2f0_m4m5_noshield
X$710 \$10__t216 topp__t429 cap_mim_2f0_m4m5_noshield c_length=4U c_width=4U
* device instance $711 r0 *1 194.6,107.3 cap_mim_2f0_m4m5_noshield
X$711 \$14__t42 topp__t428 cap_mim_2f0_m4m5_noshield c_length=4U c_width=4U
* device instance $712 r0 *1 201,107.3 cap_mim_2f0_m4m5_noshield
X$712 \$10__t215 topp__t427 cap_mim_2f0_m4m5_noshield c_length=4U c_width=4U
* device instance $713 r0 *1 224,107.3 cap_mim_2f0_m4m5_noshield
X$713 \$107__t53 topn__t446 cap_mim_2f0_m4m5_noshield c_length=4U c_width=4U
* device instance $714 r0 *1 230.4,107.3 cap_mim_2f0_m4m5_noshield
X$714 \$90__t224 topn__t445 cap_mim_2f0_m4m5_noshield c_length=4U c_width=4U
* device instance $715 r0 *1 236.8,107.3 cap_mim_2f0_m4m5_noshield
X$715 \$107__t4 topn__t77 cap_mim_2f0_m4m5_noshield c_length=4U c_width=4U
* device instance $716 r0 *1 243.2,107.3 cap_mim_2f0_m4m5_noshield
X$716 \$90__t37 topn__t76 cap_mim_2f0_m4m5_noshield c_length=4U c_width=4U
* device instance $717 r0 *1 249.6,107.3 cap_mim_2f0_m4m5_noshield
X$717 \$107__t3 topn__t75 cap_mim_2f0_m4m5_noshield c_length=4U c_width=4U
* device instance $718 r0 *1 256,107.3 cap_mim_2f0_m4m5_noshield
X$718 \$90__t36 topn__t74 cap_mim_2f0_m4m5_noshield c_length=4U c_width=4U
* device instance $719 r0 *1 262.4,107.3 cap_mim_2f0_m4m5_noshield
X$719 \$107__t2 topn__t73 cap_mim_2f0_m4m5_noshield c_length=4U c_width=4U
* device instance $720 r0 *1 268.8,107.3 cap_mim_2f0_m4m5_noshield
X$720 \$90__t35 topn__t72 cap_mim_2f0_m4m5_noshield c_length=4U c_width=4U
* device instance $721 r0 *1 275.2,107.3 cap_mim_2f0_m4m5_noshield
X$721 \$107__t8 topn__t119 cap_mim_2f0_m4m5_noshield c_length=4U c_width=4U
* device instance $722 r0 *1 281.6,107.3 cap_mim_2f0_m4m5_noshield
X$722 \$90__t66 topn__t134 cap_mim_2f0_m4m5_noshield c_length=4U c_width=4U
* device instance $723 r0 *1 288,107.3 cap_mim_2f0_m4m5_noshield
X$723 \$107__t9 topn__t133 cap_mim_2f0_m4m5_noshield c_length=4U c_width=4U
* device instance $724 r0 *1 294.4,107.3 cap_mim_2f0_m4m5_noshield
X$724 \$90__t219 topn__t436 cap_mim_2f0_m4m5_noshield c_length=4U c_width=4U
* device instance $725 r0 *1 300.8,107.3 cap_mim_2f0_m4m5_noshield
X$725 \$107__t0 topn__t0 cap_mim_2f0_m4m5_noshield c_length=4U c_width=4U
* device instance $726 r0 *1 307.2,107.3 cap_mim_2f0_m4m5_noshield
X$726 \$90__t48 topn__t102 cap_mim_2f0_m4m5_noshield c_length=4U c_width=4U
* device instance $727 r0 *1 313.6,107.3 cap_mim_2f0_m4m5_noshield
X$727 \$107__t7 topn__t101 cap_mim_2f0_m4m5_noshield c_length=4U c_width=4U
* device instance $728 r0 *1 320,107.3 cap_mim_2f0_m4m5_noshield
X$728 \$90__t47 topn__t100 cap_mim_2f0_m4m5_noshield c_length=4U c_width=4U
* device instance $729 r0 *1 326.4,107.3 cap_mim_2f0_m4m5_noshield
X$729 \$107__t6 topn__t99 cap_mim_2f0_m4m5_noshield c_length=4U c_width=4U
* device instance $730 r0 *1 332.8,107.3 cap_mim_2f0_m4m5_noshield
X$730 \$90__t46 topn__t98 cap_mim_2f0_m4m5_noshield c_length=4U c_width=4U
* device instance $731 r0 *1 339.2,107.3 cap_mim_2f0_m4m5_noshield
X$731 \$107__t5 topn__t97 cap_mim_2f0_m4m5_noshield c_length=4U c_width=4U
* device instance $732 r0 *1 345.6,107.3 cap_mim_2f0_m4m5_noshield
X$732 \$90__t45 topn__t96 cap_mim_2f0_m4m5_noshield c_length=4U c_width=4U
* device instance $733 r0 *1 352,107.3 cap_mim_2f0_m4m5_noshield
X$733 \$107__t40 topn__t373 cap_mim_2f0_m4m5_noshield c_length=4U c_width=4U
* device instance $734 r0 *1 358.4,107.3 cap_mim_2f0_m4m5_noshield
X$734 \$90__t79 topn__t162 cap_mim_2f0_m4m5_noshield c_length=4U c_width=4U
* device instance $735 r0 *1 364.8,107.3 cap_mim_2f0_m4m5_noshield
X$735 \$107__t14 topn__t161 cap_mim_2f0_m4m5_noshield c_length=4U c_width=4U
* device instance $736 r0 *1 371.2,107.3 cap_mim_2f0_m4m5_noshield
X$736 \$90__t78 topn__t160 cap_mim_2f0_m4m5_noshield c_length=4U c_width=4U
* device instance $737 r0 *1 377.6,107.3 cap_mim_2f0_m4m5_noshield
X$737 \$107__t13 topn__t159 cap_mim_2f0_m4m5_noshield c_length=4U c_width=4U
* device instance $738 r0 *1 384,107.3 cap_mim_2f0_m4m5_noshield
X$738 \$90__t77 topn__t158 cap_mim_2f0_m4m5_noshield c_length=4U c_width=4U
* device instance $739 r0 *1 390.4,107.3 cap_mim_2f0_m4m5_noshield
X$739 \$107__t12 topn__t147 cap_mim_2f0_m4m5_noshield c_length=4U c_width=4U
* device instance $740 r0 *1 396.8,107.3 cap_mim_2f0_m4m5_noshield
X$740 \$90__t71 topn__t146 cap_mim_2f0_m4m5_noshield c_length=4U c_width=4U
* device instance $741 r0 *1 403.2,107.3 cap_mim_2f0_m4m5_noshield
X$741 \$107__t11 topn__t145 cap_mim_2f0_m4m5_noshield c_length=4U c_width=4U
* device instance $742 r0 *1 409.6,107.3 cap_mim_2f0_m4m5_noshield
X$742 \$90__t70 topn__t144 cap_mim_2f0_m4m5_noshield c_length=4U c_width=4U
* device instance $743 r0 *1 416,107.3 cap_mim_2f0_m4m5_noshield
X$743 \$107__t10 topn__t143 cap_mim_2f0_m4m5_noshield c_length=4U c_width=4U
* device instance $744 r0 *1 422.4,107.3 cap_mim_2f0_m4m5_noshield
X$744 \$90__t69 topn__t142 cap_mim_2f0_m4m5_noshield c_length=4U c_width=4U
* device instance $745 r0 *1 2.6,113.7 cap_mim_2f0_m4m5_noshield
X$745 \$16__t10 topp__t199 cap_mim_2f0_m4m5_noshield c_length=4U c_width=4U
* device instance $746 r0 *1 9,113.7 cap_mim_2f0_m4m5_noshield
X$746 \$10__t77 topp__t150 cap_mim_2f0_m4m5_noshield c_length=4U c_width=4U
* device instance $747 r0 *1 15.4,113.7 cap_mim_2f0_m4m5_noshield
X$747 \$16__t9 topp__t149 cap_mim_2f0_m4m5_noshield c_length=4U c_width=4U
* device instance $748 r0 *1 21.8,113.7 cap_mim_2f0_m4m5_noshield
X$748 \$10__t76 topp__t148 cap_mim_2f0_m4m5_noshield c_length=4U c_width=4U
* device instance $749 r0 *1 28.2,113.7 cap_mim_2f0_m4m5_noshield
X$749 \$16__t8 topp__t138 cap_mim_2f0_m4m5_noshield c_length=4U c_width=4U
* device instance $750 r0 *1 34.6,113.7 cap_mim_2f0_m4m5_noshield
X$750 \$10__t111 topp__t220 cap_mim_2f0_m4m5_noshield c_length=4U c_width=4U
* device instance $751 r0 *1 41,113.7 cap_mim_2f0_m4m5_noshield
X$751 \$16__t12 topp__t219 cap_mim_2f0_m4m5_noshield c_length=4U c_width=4U
* device instance $752 r0 *1 47.4,113.7 cap_mim_2f0_m4m5_noshield
X$752 \$10__t110 topp__t218 cap_mim_2f0_m4m5_noshield c_length=4U c_width=4U
* device instance $753 r0 *1 53.8,113.7 cap_mim_2f0_m4m5_noshield
X$753 \$16__t11 topp__t217 cap_mim_2f0_m4m5_noshield c_length=4U c_width=4U
* device instance $754 r0 *1 60.2,113.7 cap_mim_2f0_m4m5_noshield
X$754 \$10__t97 topp__t189 cap_mim_2f0_m4m5_noshield c_length=4U c_width=4U
* device instance $755 r0 *1 66.6,113.7 cap_mim_2f0_m4m5_noshield
X$755 \$16__t13 topp__t233 cap_mim_2f0_m4m5_noshield c_length=4U c_width=4U
* device instance $756 r0 *1 73,113.7 cap_mim_2f0_m4m5_noshield
X$756 \$10__t119 topp__t232 cap_mim_2f0_m4m5_noshield c_length=4U c_width=4U
* device instance $757 r0 *1 79.4,113.7 cap_mim_2f0_m4m5_noshield
X$757 \$16__t16 topp__t247 cap_mim_2f0_m4m5_noshield c_length=4U c_width=4U
* device instance $758 r0 *1 85.8,113.7 cap_mim_2f0_m4m5_noshield
X$758 \$10__t117 topp__t230 cap_mim_2f0_m4m5_noshield c_length=4U c_width=4U
* device instance $759 r0 *1 92.2,113.7 cap_mim_2f0_m4m5_noshield
X$759 \$16__t15 topp__t246 cap_mim_2f0_m4m5_noshield c_length=4U c_width=4U
* device instance $760 r0 *1 98.6,113.7 cap_mim_2f0_m4m5_noshield
X$760 \$10__t125 topp__t245 cap_mim_2f0_m4m5_noshield c_length=4U c_width=4U
* device instance $761 r0 *1 105,113.7 cap_mim_2f0_m4m5_noshield
X$761 \$18__t7 topp__t244 cap_mim_2f0_m4m5_noshield c_length=4U c_width=4U
* device instance $762 r0 *1 111.4,113.7 cap_mim_2f0_m4m5_noshield
X$762 \$10__t124 topp__t243 cap_mim_2f0_m4m5_noshield c_length=4U c_width=4U
* device instance $763 r0 *1 117.8,113.7 cap_mim_2f0_m4m5_noshield
X$763 \$18__t9 topp__t274 cap_mim_2f0_m4m5_noshield c_length=4U c_width=4U
* device instance $764 r0 *1 124.2,113.7 cap_mim_2f0_m4m5_noshield
X$764 \$10__t189 topp__t378 cap_mim_2f0_m4m5_noshield c_length=4U c_width=4U
* device instance $765 r0 *1 130.6,113.7 cap_mim_2f0_m4m5_noshield
X$765 \$18__t11 topp__t377 cap_mim_2f0_m4m5_noshield c_length=4U c_width=4U
* device instance $766 r0 *1 137,113.7 cap_mim_2f0_m4m5_noshield
X$766 \$10__t188 topp__t376 cap_mim_2f0_m4m5_noshield c_length=4U c_width=4U
* device instance $767 r0 *1 143.4,113.7 cap_mim_2f0_m4m5_noshield
X$767 \$18__t10 topp__t375 cap_mim_2f0_m4m5_noshield c_length=4U c_width=4U
* device instance $768 r0 *1 149.8,113.7 cap_mim_2f0_m4m5_noshield
X$768 \$10__t187 topp__t374 cap_mim_2f0_m4m5_noshield c_length=4U c_width=4U
* device instance $769 r0 *1 156.2,113.7 cap_mim_2f0_m4m5_noshield
X$769 \$20__t5 topp__t373 cap_mim_2f0_m4m5_noshield c_length=4U c_width=4U
* device instance $770 r0 *1 162.6,113.7 cap_mim_2f0_m4m5_noshield
X$770 \$10__t186 topp__t372 cap_mim_2f0_m4m5_noshield c_length=4U c_width=4U
* device instance $771 r0 *1 169,113.7 cap_mim_2f0_m4m5_noshield
X$771 \$20__t4 topp__t371 cap_mim_2f0_m4m5_noshield c_length=4U c_width=4U
* device instance $772 r0 *1 175.4,113.7 cap_mim_2f0_m4m5_noshield
X$772 \$10__t185 topp__t370 cap_mim_2f0_m4m5_noshield c_length=4U c_width=4U
* device instance $773 r0 *1 181.8,113.7 cap_mim_2f0_m4m5_noshield
X$773 \$22__t2 topp__t369 cap_mim_2f0_m4m5_noshield c_length=4U c_width=4U
* device instance $774 r0 *1 188.2,113.7 cap_mim_2f0_m4m5_noshield
X$774 \$10__t184 topp__t368 cap_mim_2f0_m4m5_noshield c_length=4U c_width=4U
* device instance $775 r0 *1 194.6,113.7 cap_mim_2f0_m4m5_noshield
X$775 \$26__t0 topp__t367 cap_mim_2f0_m4m5_noshield c_length=4U c_width=4U
* device instance $776 r0 *1 201,113.7 cap_mim_2f0_m4m5_noshield
X$776 \$10__t209 topp__t416 cap_mim_2f0_m4m5_noshield c_length=4U c_width=4U
* device instance $777 r0 *1 224,113.7 cap_mim_2f0_m4m5_noshield
X$777 \$115__t24 topn__t443 cap_mim_2f0_m4m5_noshield c_length=4U c_width=4U
* device instance $778 r0 *1 230.4,113.7 cap_mim_2f0_m4m5_noshield
X$778 \$90__t223 topn__t442 cap_mim_2f0_m4m5_noshield c_length=4U c_width=4U
* device instance $779 r0 *1 236.8,113.7 cap_mim_2f0_m4m5_noshield
X$779 \$115__t8 topn__t123 cap_mim_2f0_m4m5_noshield c_length=4U c_width=4U
* device instance $780 r0 *1 243.2,113.7 cap_mim_2f0_m4m5_noshield
X$780 \$90__t60 topn__t122 cap_mim_2f0_m4m5_noshield c_length=4U c_width=4U
* device instance $781 r0 *1 249.6,113.7 cap_mim_2f0_m4m5_noshield
X$781 \$115__t7 topn__t121 cap_mim_2f0_m4m5_noshield c_length=4U c_width=4U
* device instance $782 r0 *1 256,113.7 cap_mim_2f0_m4m5_noshield
X$782 \$90__t59 topn__t120 cap_mim_2f0_m4m5_noshield c_length=4U c_width=4U
* device instance $783 r0 *1 262.4,113.7 cap_mim_2f0_m4m5_noshield
X$783 \$115__t3 topn__t82 cap_mim_2f0_m4m5_noshield c_length=4U c_width=4U
* device instance $784 r0 *1 268.8,113.7 cap_mim_2f0_m4m5_noshield
X$784 \$90__t39 topn__t81 cap_mim_2f0_m4m5_noshield c_length=4U c_width=4U
* device instance $785 r0 *1 275.2,113.7 cap_mim_2f0_m4m5_noshield
X$785 \$115__t2 topn__t80 cap_mim_2f0_m4m5_noshield c_length=4U c_width=4U
* device instance $786 r0 *1 281.6,113.7 cap_mim_2f0_m4m5_noshield
X$786 \$90__t38 topn__t79 cap_mim_2f0_m4m5_noshield c_length=4U c_width=4U
* device instance $787 r0 *1 288,113.7 cap_mim_2f0_m4m5_noshield
X$787 \$115__t1 topn__t78 cap_mim_2f0_m4m5_noshield c_length=4U c_width=4U
* device instance $788 r0 *1 294.4,113.7 cap_mim_2f0_m4m5_noshield
X$788 \$90__t220 topn__t437 cap_mim_2f0_m4m5_noshield c_length=4U c_width=4U
* device instance $789 r0 *1 300.8,113.7 cap_mim_2f0_m4m5_noshield
X$789 \$115__t5 topn__t94 cap_mim_2f0_m4m5_noshield c_length=4U c_width=4U
* device instance $790 r0 *1 307.2,113.7 cap_mim_2f0_m4m5_noshield
X$790 \$90__t44 topn__t93 cap_mim_2f0_m4m5_noshield c_length=4U c_width=4U
* device instance $791 r0 *1 313.6,113.7 cap_mim_2f0_m4m5_noshield
X$791 \$115__t4 topn__t92 cap_mim_2f0_m4m5_noshield c_length=4U c_width=4U
* device instance $792 r0 *1 320,113.7 cap_mim_2f0_m4m5_noshield
X$792 \$90__t43 topn__t91 cap_mim_2f0_m4m5_noshield c_length=4U c_width=4U
* device instance $793 r0 *1 326.4,113.7 cap_mim_2f0_m4m5_noshield
X$793 \$123__t4 topn__t90 cap_mim_2f0_m4m5_noshield c_length=4U c_width=4U
* device instance $794 r0 *1 332.8,113.7 cap_mim_2f0_m4m5_noshield
X$794 \$90__t42 topn__t89 cap_mim_2f0_m4m5_noshield c_length=4U c_width=4U
* device instance $795 r0 *1 339.2,113.7 cap_mim_2f0_m4m5_noshield
X$795 \$123__t3 topn__t88 cap_mim_2f0_m4m5_noshield c_length=4U c_width=4U
* device instance $796 r0 *1 345.6,113.7 cap_mim_2f0_m4m5_noshield
X$796 \$90__t49 topn__t103 cap_mim_2f0_m4m5_noshield c_length=4U c_width=4U
* device instance $797 r0 *1 352,113.7 cap_mim_2f0_m4m5_noshield
X$797 \$123__t11 topn__t374 cap_mim_2f0_m4m5_noshield c_length=4U c_width=4U
* device instance $798 r0 *1 358.4,113.7 cap_mim_2f0_m4m5_noshield
X$798 \$90__t34 topn__t71 cap_mim_2f0_m4m5_noshield c_length=4U c_width=4U
* device instance $799 r0 *1 364.8,113.7 cap_mim_2f0_m4m5_noshield
X$799 \$123__t0 topn__t54 cap_mim_2f0_m4m5_noshield c_length=4U c_width=4U
* device instance $800 r0 *1 371.2,113.7 cap_mim_2f0_m4m5_noshield
X$800 \$90__t25 topn__t53 cap_mim_2f0_m4m5_noshield c_length=4U c_width=4U
* device instance $801 r0 *1 377.6,113.7 cap_mim_2f0_m4m5_noshield
X$801 \$131__t1 topn__t52 cap_mim_2f0_m4m5_noshield c_length=4U c_width=4U
* device instance $802 r0 *1 384,113.7 cap_mim_2f0_m4m5_noshield
X$802 \$90__t24 topn__t51 cap_mim_2f0_m4m5_noshield c_length=4U c_width=4U
* device instance $803 r0 *1 390.4,113.7 cap_mim_2f0_m4m5_noshield
X$803 \$131__t0 topn__t50 cap_mim_2f0_m4m5_noshield c_length=4U c_width=4U
* device instance $804 r0 *1 396.8,113.7 cap_mim_2f0_m4m5_noshield
X$804 \$90__t23 topn__t49 cap_mim_2f0_m4m5_noshield c_length=4U c_width=4U
* device instance $805 r0 *1 403.2,113.7 cap_mim_2f0_m4m5_noshield
X$805 \$139__t0 topn__t48 cap_mim_2f0_m4m5_noshield c_length=4U c_width=4U
* device instance $806 r0 *1 409.6,113.7 cap_mim_2f0_m4m5_noshield
X$806 \$90__t22 topn__t47 cap_mim_2f0_m4m5_noshield c_length=4U c_width=4U
* device instance $807 r0 *1 416,113.7 cap_mim_2f0_m4m5_noshield
X$807 \$155__t0 topn__t46 cap_mim_2f0_m4m5_noshield c_length=4U c_width=4U
* device instance $808 r0 *1 422.4,113.7 cap_mim_2f0_m4m5_noshield
X$808 \$90__t21 topn__t45 cap_mim_2f0_m4m5_noshield c_length=4U c_width=4U
* device instance $809 r0 *1 2.6,120.1 cap_mim_2f0_m4m5_noshield
X$809 \$10__t112 topp__t222 cap_mim_2f0_m4m5_noshield c_length=4U c_width=4U
* device instance $810 r0 *1 9,120.1 cap_mim_2f0_m4m5_noshield
X$810 vcm__t0 topp__t221 cap_mim_2f0_m4m5_noshield c_length=4U c_width=4U
* device instance $811 r0 *1 15.4,120.1 cap_mim_2f0_m4m5_noshield
X$811 \$10__t109 topp__t216 cap_mim_2f0_m4m5_noshield c_length=4U c_width=4U
* device instance $812 r0 *1 21.8,120.1 cap_mim_2f0_m4m5_noshield
X$812 \$22__t1 topp__t137 cap_mim_2f0_m4m5_noshield c_length=4U c_width=4U
* device instance $813 r0 *1 28.2,120.1 cap_mim_2f0_m4m5_noshield
X$813 \$10__t71 topp__t136 cap_mim_2f0_m4m5_noshield c_length=4U c_width=4U
* device instance $814 r0 *1 34.6,120.1 cap_mim_2f0_m4m5_noshield
X$814 \$20__t2 topp__t151 cap_mim_2f0_m4m5_noshield c_length=4U c_width=4U
* device instance $815 r0 *1 41,120.1 cap_mim_2f0_m4m5_noshield
X$815 \$10__t114 topp__t225 cap_mim_2f0_m4m5_noshield c_length=4U c_width=4U
* device instance $816 r0 *1 47.4,120.1 cap_mim_2f0_m4m5_noshield
X$816 \$20__t3 topp__t224 cap_mim_2f0_m4m5_noshield c_length=4U c_width=4U
* device instance $817 r0 *1 53.8,120.1 cap_mim_2f0_m4m5_noshield
X$817 \$10__t113 topp__t223 cap_mim_2f0_m4m5_noshield c_length=4U c_width=4U
* device instance $818 r0 *1 60.2,120.1 cap_mim_2f0_m4m5_noshield
X$818 \$18__t3 topp__t191 cap_mim_2f0_m4m5_noshield c_length=4U c_width=4U
* device instance $819 r0 *1 66.6,120.1 cap_mim_2f0_m4m5_noshield
X$819 \$10__t123 topp__t242 cap_mim_2f0_m4m5_noshield c_length=4U c_width=4U
* device instance $820 r0 *1 73,120.1 cap_mim_2f0_m4m5_noshield
X$820 \$18__t6 topp__t241 cap_mim_2f0_m4m5_noshield c_length=4U c_width=4U
* device instance $821 r0 *1 79.4,120.1 cap_mim_2f0_m4m5_noshield
X$821 \$10__t122 topp__t240 cap_mim_2f0_m4m5_noshield c_length=4U c_width=4U
* device instance $822 r0 *1 85.8,120.1 cap_mim_2f0_m4m5_noshield
X$822 \$18__t5 topp__t239 cap_mim_2f0_m4m5_noshield c_length=4U c_width=4U
* device instance $823 r0 *1 92.2,120.1 cap_mim_2f0_m4m5_noshield
X$823 \$10__t121 topp__t238 cap_mim_2f0_m4m5_noshield c_length=4U c_width=4U
* device instance $824 r0 *1 98.6,120.1 cap_mim_2f0_m4m5_noshield
X$824 \$18__t4 topp__t237 cap_mim_2f0_m4m5_noshield c_length=4U c_width=4U
* device instance $825 r0 *1 105,120.1 cap_mim_2f0_m4m5_noshield
X$825 \$10__t120 topp__t236 cap_mim_2f0_m4m5_noshield c_length=4U c_width=4U
* device instance $826 r0 *1 111.4,120.1 cap_mim_2f0_m4m5_noshield
X$826 \$16__t14 topp__t235 cap_mim_2f0_m4m5_noshield c_length=4U c_width=4U
* device instance $827 r0 *1 117.8,120.1 cap_mim_2f0_m4m5_noshield
X$827 \$10__t135 topp__t269 cap_mim_2f0_m4m5_noshield c_length=4U c_width=4U
* device instance $828 r0 *1 124.2,120.1 cap_mim_2f0_m4m5_noshield
X$828 \$16__t23 topp__t413 cap_mim_2f0_m4m5_noshield c_length=4U c_width=4U
* device instance $829 r0 *1 130.6,120.1 cap_mim_2f0_m4m5_noshield
X$829 \$10__t207 topp__t412 cap_mim_2f0_m4m5_noshield c_length=4U c_width=4U
* device instance $830 r0 *1 137,120.1 cap_mim_2f0_m4m5_noshield
X$830 \$16__t22 topp__t411 cap_mim_2f0_m4m5_noshield c_length=4U c_width=4U
* device instance $831 r0 *1 143.4,120.1 cap_mim_2f0_m4m5_noshield
X$831 \$10__t206 topp__t410 cap_mim_2f0_m4m5_noshield c_length=4U c_width=4U
* device instance $832 r0 *1 149.8,120.1 cap_mim_2f0_m4m5_noshield
X$832 \$16__t21 topp__t409 cap_mim_2f0_m4m5_noshield c_length=4U c_width=4U
* device instance $833 r0 *1 156.2,120.1 cap_mim_2f0_m4m5_noshield
X$833 \$10__t205 topp__t408 cap_mim_2f0_m4m5_noshield c_length=4U c_width=4U
* device instance $834 r0 *1 162.6,120.1 cap_mim_2f0_m4m5_noshield
X$834 \$16__t20 topp__t407 cap_mim_2f0_m4m5_noshield c_length=4U c_width=4U
* device instance $835 r0 *1 169,120.1 cap_mim_2f0_m4m5_noshield
X$835 \$10__t211 topp__t420 cap_mim_2f0_m4m5_noshield c_length=4U c_width=4U
* device instance $836 r0 *1 175.4,120.1 cap_mim_2f0_m4m5_noshield
X$836 \$16__t19 topp__t405 cap_mim_2f0_m4m5_noshield c_length=4U c_width=4U
* device instance $837 r0 *1 181.8,120.1 cap_mim_2f0_m4m5_noshield
X$837 \$10__t204 topp__t404 cap_mim_2f0_m4m5_noshield c_length=4U c_width=4U
* device instance $838 r0 *1 188.2,120.1 cap_mim_2f0_m4m5_noshield
X$838 \$16__t18 topp__t403 cap_mim_2f0_m4m5_noshield c_length=4U c_width=4U
* device instance $839 r0 *1 194.6,120.1 cap_mim_2f0_m4m5_noshield
X$839 \$10__t203 topp__t402 cap_mim_2f0_m4m5_noshield c_length=4U c_width=4U
* device instance $840 r0 *1 201,120.1 cap_mim_2f0_m4m5_noshield
X$840 \$16__t17 topp__t401 cap_mim_2f0_m4m5_noshield c_length=4U c_width=4U
* device instance $841 r0 *1 224,120.1 cap_mim_2f0_m4m5_noshield
X$841 \$90__t222 topn__t441 cap_mim_2f0_m4m5_noshield c_length=4U c_width=4U
* device instance $842 r0 *1 230.4,120.1 cap_mim_2f0_m4m5_noshield
X$842 vcm__t1 topn__t440 cap_mim_2f0_m4m5_noshield c_length=4U c_width=4U
* device instance $843 r0 *1 236.8,120.1 cap_mim_2f0_m4m5_noshield
X$843 \$90__t65 topn__t132 cap_mim_2f0_m4m5_noshield c_length=4U c_width=4U
* device instance $844 r0 *1 243.2,120.1 cap_mim_2f0_m4m5_noshield
X$844 \$139__t1 topn__t131 cap_mim_2f0_m4m5_noshield c_length=4U c_width=4U
* device instance $845 r0 *1 249.6,120.1 cap_mim_2f0_m4m5_noshield
X$845 \$90__t64 topn__t130 cap_mim_2f0_m4m5_noshield c_length=4U c_width=4U
* device instance $846 r0 *1 256,120.1 cap_mim_2f0_m4m5_noshield
X$846 \$131__t3 topn__t129 cap_mim_2f0_m4m5_noshield c_length=4U c_width=4U
* device instance $847 r0 *1 262.4,120.1 cap_mim_2f0_m4m5_noshield
X$847 \$90__t63 topn__t128 cap_mim_2f0_m4m5_noshield c_length=4U c_width=4U
* device instance $848 r0 *1 268.8,120.1 cap_mim_2f0_m4m5_noshield
X$848 \$131__t2 topn__t127 cap_mim_2f0_m4m5_noshield c_length=4U c_width=4U
* device instance $849 r0 *1 275.2,120.1 cap_mim_2f0_m4m5_noshield
X$849 \$90__t62 topn__t126 cap_mim_2f0_m4m5_noshield c_length=4U c_width=4U
* device instance $850 r0 *1 281.6,120.1 cap_mim_2f0_m4m5_noshield
X$850 \$123__t5 topn__t125 cap_mim_2f0_m4m5_noshield c_length=4U c_width=4U
* device instance $851 r0 *1 288,120.1 cap_mim_2f0_m4m5_noshield
X$851 \$90__t61 topn__t124 cap_mim_2f0_m4m5_noshield c_length=4U c_width=4U
* device instance $852 r0 *1 294.4,120.1 cap_mim_2f0_m4m5_noshield
X$852 \$123__t13 topn__t438 cap_mim_2f0_m4m5_noshield c_length=4U c_width=4U
* device instance $853 r0 *1 300.8,120.1 cap_mim_2f0_m4m5_noshield
X$853 \$90__t41 topn__t85 cap_mim_2f0_m4m5_noshield c_length=4U c_width=4U
* device instance $854 r0 *1 307.2,120.1 cap_mim_2f0_m4m5_noshield
X$854 \$123__t1 topn__t84 cap_mim_2f0_m4m5_noshield c_length=4U c_width=4U
* device instance $855 r0 *1 313.6,120.1 cap_mim_2f0_m4m5_noshield
X$855 \$90__t40 topn__t83 cap_mim_2f0_m4m5_noshield c_length=4U c_width=4U
* device instance $856 r0 *1 320,120.1 cap_mim_2f0_m4m5_noshield
X$856 \$123__t2 topn__t86 cap_mim_2f0_m4m5_noshield c_length=4U c_width=4U
* device instance $857 r0 *1 326.4,120.1 cap_mim_2f0_m4m5_noshield
X$857 \$90__t212 topn__t423 cap_mim_2f0_m4m5_noshield c_length=4U c_width=4U
* device instance $858 r0 *1 332.8,120.1 cap_mim_2f0_m4m5_noshield
X$858 \$115__t23 topn__t402 cap_mim_2f0_m4m5_noshield c_length=4U c_width=4U
* device instance $859 r0 *1 339.2,120.1 cap_mim_2f0_m4m5_noshield
X$859 \$90__t200 topn__t403 cap_mim_2f0_m4m5_noshield c_length=4U c_width=4U
* device instance $860 r0 *1 345.6,120.1 cap_mim_2f0_m4m5_noshield
X$860 \$115__t6 topn__t95 cap_mim_2f0_m4m5_noshield c_length=4U c_width=4U
* device instance $861 r0 *1 352,120.1 cap_mim_2f0_m4m5_noshield
X$861 \$90__t186 topn__t375 cap_mim_2f0_m4m5_noshield c_length=4U c_width=4U
* device instance $862 r0 *1 358.4,120.1 cap_mim_2f0_m4m5_noshield
X$862 \$115__t13 topn__t157 cap_mim_2f0_m4m5_noshield c_length=4U c_width=4U
* device instance $863 r0 *1 364.8,120.1 cap_mim_2f0_m4m5_noshield
X$863 \$90__t76 topn__t156 cap_mim_2f0_m4m5_noshield c_length=4U c_width=4U
* device instance $864 r0 *1 371.2,120.1 cap_mim_2f0_m4m5_noshield
X$864 \$115__t14 topn__t171 cap_mim_2f0_m4m5_noshield c_length=4U c_width=4U
* device instance $865 r0 *1 377.6,120.1 cap_mim_2f0_m4m5_noshield
X$865 \$90__t75 topn__t155 cap_mim_2f0_m4m5_noshield c_length=4U c_width=4U
* device instance $866 r0 *1 384,120.1 cap_mim_2f0_m4m5_noshield
X$866 \$115__t12 topn__t154 cap_mim_2f0_m4m5_noshield c_length=4U c_width=4U
* device instance $867 r0 *1 390.4,120.1 cap_mim_2f0_m4m5_noshield
X$867 \$90__t74 topn__t153 cap_mim_2f0_m4m5_noshield c_length=4U c_width=4U
* device instance $868 r0 *1 396.8,120.1 cap_mim_2f0_m4m5_noshield
X$868 \$115__t11 topn__t152 cap_mim_2f0_m4m5_noshield c_length=4U c_width=4U
* device instance $869 r0 *1 403.2,120.1 cap_mim_2f0_m4m5_noshield
X$869 \$90__t73 topn__t151 cap_mim_2f0_m4m5_noshield c_length=4U c_width=4U
* device instance $870 r0 *1 409.6,120.1 cap_mim_2f0_m4m5_noshield
X$870 \$115__t10 topn__t150 cap_mim_2f0_m4m5_noshield c_length=4U c_width=4U
* device instance $871 r0 *1 416,120.1 cap_mim_2f0_m4m5_noshield
X$871 \$90__t72 topn__t149 cap_mim_2f0_m4m5_noshield c_length=4U c_width=4U
* device instance $872 r0 *1 422.4,120.1 cap_mim_2f0_m4m5_noshield
X$872 \$115__t9 topn__t148 cap_mim_2f0_m4m5_noshield c_length=4U c_width=4U
* device instance $873 r0 *1 2.6,126.5 cap_mim_2f0_m4m5_noshield
X$873 \$10__t134 topp__t267 cap_mim_2f0_m4m5_noshield c_length=4U c_width=4U
* device instance $874 r0 *1 9,126.5 cap_mim_2f0_m4m5_noshield
X$874 \$14__t26 topp__t266 cap_mim_2f0_m4m5_noshield c_length=4U c_width=4U
* device instance $875 r0 *1 15.4,126.5 cap_mim_2f0_m4m5_noshield
X$875 \$10__t133 topp__t265 cap_mim_2f0_m4m5_noshield c_length=4U c_width=4U
* device instance $876 r0 *1 21.8,126.5 cap_mim_2f0_m4m5_noshield
X$876 \$14__t25 topp__t264 cap_mim_2f0_m4m5_noshield c_length=4U c_width=4U
* device instance $877 r0 *1 28.2,126.5 cap_mim_2f0_m4m5_noshield
X$877 \$10__t139 topp__t279 cap_mim_2f0_m4m5_noshield c_length=4U c_width=4U
* device instance $878 r0 *1 34.6,126.5 cap_mim_2f0_m4m5_noshield
X$878 \$14__t24 topp__t263 cap_mim_2f0_m4m5_noshield c_length=4U c_width=4U
* device instance $879 r0 *1 41,126.5 cap_mim_2f0_m4m5_noshield
X$879 \$10__t161 topp__t322 cap_mim_2f0_m4m5_noshield c_length=4U c_width=4U
* device instance $880 r0 *1 47.4,126.5 cap_mim_2f0_m4m5_noshield
X$880 \$14__t36 topp__t323 cap_mim_2f0_m4m5_noshield c_length=4U c_width=4U
* device instance $881 r0 *1 53.8,126.5 cap_mim_2f0_m4m5_noshield
X$881 \$10__t162 topp__t324 cap_mim_2f0_m4m5_noshield c_length=4U c_width=4U
* device instance $882 r0 *1 60.2,126.5 cap_mim_2f0_m4m5_noshield
X$882 \$14__t41 topp__t334 cap_mim_2f0_m4m5_noshield c_length=4U c_width=4U
* device instance $883 r0 *1 66.6,126.5 cap_mim_2f0_m4m5_noshield
X$883 \$10__t164 topp__t326 cap_mim_2f0_m4m5_noshield c_length=4U c_width=4U
* device instance $884 r0 *1 73,126.5 cap_mim_2f0_m4m5_noshield
X$884 \$14__t37 topp__t327 cap_mim_2f0_m4m5_noshield c_length=4U c_width=4U
* device instance $885 r0 *1 79.4,126.5 cap_mim_2f0_m4m5_noshield
X$885 \$10__t165 topp__t328 cap_mim_2f0_m4m5_noshield c_length=4U c_width=4U
* device instance $886 r0 *1 85.8,126.5 cap_mim_2f0_m4m5_noshield
X$886 \$14__t38 topp__t329 cap_mim_2f0_m4m5_noshield c_length=4U c_width=4U
* device instance $887 r0 *1 92.2,126.5 cap_mim_2f0_m4m5_noshield
X$887 \$10__t166 topp__t330 cap_mim_2f0_m4m5_noshield c_length=4U c_width=4U
* device instance $888 r0 *1 98.6,126.5 cap_mim_2f0_m4m5_noshield
X$888 \$14__t39 topp__t331 cap_mim_2f0_m4m5_noshield c_length=4U c_width=4U
* device instance $889 r0 *1 105,126.5 cap_mim_2f0_m4m5_noshield
X$889 \$10__t167 topp__t332 cap_mim_2f0_m4m5_noshield c_length=4U c_width=4U
* device instance $890 r0 *1 111.4,126.5 cap_mim_2f0_m4m5_noshield
X$890 \$14__t40 topp__t333 cap_mim_2f0_m4m5_noshield c_length=4U c_width=4U
* device instance $891 r0 *1 117.8,126.5 cap_mim_2f0_m4m5_noshield
X$891 \$10__t163 topp__t325 cap_mim_2f0_m4m5_noshield c_length=4U c_width=4U
* device instance $892 r0 *1 124.2,126.5 cap_mim_2f0_m4m5_noshield
X$892 \$14__t35 topp__t321 cap_mim_2f0_m4m5_noshield c_length=4U c_width=4U
* device instance $893 r0 *1 130.6,126.5 cap_mim_2f0_m4m5_noshield
X$893 \$10__t160 topp__t320 cap_mim_2f0_m4m5_noshield c_length=4U c_width=4U
* device instance $894 r0 *1 137,126.5 cap_mim_2f0_m4m5_noshield
X$894 \$14__t34 topp__t319 cap_mim_2f0_m4m5_noshield c_length=4U c_width=4U
* device instance $895 r0 *1 143.4,126.5 cap_mim_2f0_m4m5_noshield
X$895 \$10__t159 topp__t318 cap_mim_2f0_m4m5_noshield c_length=4U c_width=4U
* device instance $896 r0 *1 149.8,126.5 cap_mim_2f0_m4m5_noshield
X$896 \$14__t33 topp__t317 cap_mim_2f0_m4m5_noshield c_length=4U c_width=4U
* device instance $897 r0 *1 156.2,126.5 cap_mim_2f0_m4m5_noshield
X$897 \$10__t158 topp__t316 cap_mim_2f0_m4m5_noshield c_length=4U c_width=4U
* device instance $898 r0 *1 162.6,126.5 cap_mim_2f0_m4m5_noshield
X$898 \$14__t32 topp__t315 cap_mim_2f0_m4m5_noshield c_length=4U c_width=4U
* device instance $899 r0 *1 169,126.5 cap_mim_2f0_m4m5_noshield
X$899 \$10__t157 topp__t314 cap_mim_2f0_m4m5_noshield c_length=4U c_width=4U
* device instance $900 r0 *1 175.4,126.5 cap_mim_2f0_m4m5_noshield
X$900 \$14__t31 topp__t313 cap_mim_2f0_m4m5_noshield c_length=4U c_width=4U
* device instance $901 r0 *1 181.8,126.5 cap_mim_2f0_m4m5_noshield
X$901 \$10__t156 topp__t312 cap_mim_2f0_m4m5_noshield c_length=4U c_width=4U
* device instance $902 r0 *1 188.2,126.5 cap_mim_2f0_m4m5_noshield
X$902 \$14__t30 topp__t311 cap_mim_2f0_m4m5_noshield c_length=4U c_width=4U
* device instance $903 r0 *1 194.6,126.5 cap_mim_2f0_m4m5_noshield
X$903 \$10__t155 topp__t310 cap_mim_2f0_m4m5_noshield c_length=4U c_width=4U
* device instance $904 r0 *1 201,126.5 cap_mim_2f0_m4m5_noshield
X$904 \$14__t29 topp__t309 cap_mim_2f0_m4m5_noshield c_length=4U c_width=4U
* device instance $905 r0 *1 224,126.5 cap_mim_2f0_m4m5_noshield
X$905 \$90__t85 topn__t173 cap_mim_2f0_m4m5_noshield c_length=4U c_width=4U
* device instance $906 r0 *1 230.4,126.5 cap_mim_2f0_m4m5_noshield
X$906 \$107__t15 topn__t172 cap_mim_2f0_m4m5_noshield c_length=4U c_width=4U
* device instance $907 r0 *1 236.8,126.5 cap_mim_2f0_m4m5_noshield
X$907 \$90__t187 topn__t376 cap_mim_2f0_m4m5_noshield c_length=4U c_width=4U
* device instance $908 r0 *1 243.2,126.5 cap_mim_2f0_m4m5_noshield
X$908 \$107__t41 topn__t377 cap_mim_2f0_m4m5_noshield c_length=4U c_width=4U
* device instance $909 r0 *1 249.6,126.5 cap_mim_2f0_m4m5_noshield
X$909 \$90__t188 topn__t378 cap_mim_2f0_m4m5_noshield c_length=4U c_width=4U
* device instance $910 r0 *1 256,126.5 cap_mim_2f0_m4m5_noshield
X$910 \$107__t42 topn__t379 cap_mim_2f0_m4m5_noshield c_length=4U c_width=4U
* device instance $911 r0 *1 262.4,126.5 cap_mim_2f0_m4m5_noshield
X$911 \$90__t189 topn__t380 cap_mim_2f0_m4m5_noshield c_length=4U c_width=4U
* device instance $912 r0 *1 268.8,126.5 cap_mim_2f0_m4m5_noshield
X$912 \$107__t43 topn__t381 cap_mim_2f0_m4m5_noshield c_length=4U c_width=4U
* device instance $913 r0 *1 275.2,126.5 cap_mim_2f0_m4m5_noshield
X$913 \$90__t190 topn__t382 cap_mim_2f0_m4m5_noshield c_length=4U c_width=4U
* device instance $914 r0 *1 281.6,126.5 cap_mim_2f0_m4m5_noshield
X$914 \$107__t44 topn__t383 cap_mim_2f0_m4m5_noshield c_length=4U c_width=4U
* device instance $915 r0 *1 288,126.5 cap_mim_2f0_m4m5_noshield
X$915 \$90__t191 topn__t384 cap_mim_2f0_m4m5_noshield c_length=4U c_width=4U
* device instance $916 r0 *1 294.4,126.5 cap_mim_2f0_m4m5_noshield
X$916 \$107__t52 topn__t401 cap_mim_2f0_m4m5_noshield c_length=4U c_width=4U
* device instance $917 r0 *1 300.8,126.5 cap_mim_2f0_m4m5_noshield
X$917 \$90__t192 topn__t386 cap_mim_2f0_m4m5_noshield c_length=4U c_width=4U
* device instance $918 r0 *1 307.2,126.5 cap_mim_2f0_m4m5_noshield
X$918 \$107__t45 topn__t387 cap_mim_2f0_m4m5_noshield c_length=4U c_width=4U
* device instance $919 r0 *1 313.6,126.5 cap_mim_2f0_m4m5_noshield
X$919 \$90__t193 topn__t388 cap_mim_2f0_m4m5_noshield c_length=4U c_width=4U
* device instance $920 r0 *1 320,126.5 cap_mim_2f0_m4m5_noshield
X$920 \$107__t46 topn__t389 cap_mim_2f0_m4m5_noshield c_length=4U c_width=4U
* device instance $921 r0 *1 326.4,126.5 cap_mim_2f0_m4m5_noshield
X$921 \$90__t194 topn__t390 cap_mim_2f0_m4m5_noshield c_length=4U c_width=4U
* device instance $922 r0 *1 332.8,126.5 cap_mim_2f0_m4m5_noshield
X$922 \$107__t47 topn__t391 cap_mim_2f0_m4m5_noshield c_length=4U c_width=4U
* device instance $923 r0 *1 339.2,126.5 cap_mim_2f0_m4m5_noshield
X$923 \$90__t195 topn__t392 cap_mim_2f0_m4m5_noshield c_length=4U c_width=4U
* device instance $924 r0 *1 345.6,126.5 cap_mim_2f0_m4m5_noshield
X$924 \$107__t48 topn__t393 cap_mim_2f0_m4m5_noshield c_length=4U c_width=4U
* device instance $925 r0 *1 352,126.5 cap_mim_2f0_m4m5_noshield
X$925 \$90__t196 topn__t394 cap_mim_2f0_m4m5_noshield c_length=4U c_width=4U
* device instance $926 r0 *1 358.4,126.5 cap_mim_2f0_m4m5_noshield
X$926 \$107__t49 topn__t395 cap_mim_2f0_m4m5_noshield c_length=4U c_width=4U
* device instance $927 r0 *1 364.8,126.5 cap_mim_2f0_m4m5_noshield
X$927 \$90__t197 topn__t396 cap_mim_2f0_m4m5_noshield c_length=4U c_width=4U
* device instance $928 r0 *1 371.2,126.5 cap_mim_2f0_m4m5_noshield
X$928 \$107__t50 topn__t397 cap_mim_2f0_m4m5_noshield c_length=4U c_width=4U
* device instance $929 r0 *1 377.6,126.5 cap_mim_2f0_m4m5_noshield
X$929 \$90__t198 topn__t398 cap_mim_2f0_m4m5_noshield c_length=4U c_width=4U
* device instance $930 r0 *1 384,126.5 cap_mim_2f0_m4m5_noshield
X$930 \$107__t51 topn__t399 cap_mim_2f0_m4m5_noshield c_length=4U c_width=4U
* device instance $931 r0 *1 390.4,126.5 cap_mim_2f0_m4m5_noshield
X$931 \$90__t106 topn__t217 cap_mim_2f0_m4m5_noshield c_length=4U c_width=4U
* device instance $932 r0 *1 396.8,126.5 cap_mim_2f0_m4m5_noshield
X$932 \$107__t18 topn__t219 cap_mim_2f0_m4m5_noshield c_length=4U c_width=4U
* device instance $933 r0 *1 403.2,126.5 cap_mim_2f0_m4m5_noshield
X$933 \$90__t107 topn__t220 cap_mim_2f0_m4m5_noshield c_length=4U c_width=4U
* device instance $934 r0 *1 409.6,126.5 cap_mim_2f0_m4m5_noshield
X$934 \$107__t19 topn__t221 cap_mim_2f0_m4m5_noshield c_length=4U c_width=4U
* device instance $935 r0 *1 416,126.5 cap_mim_2f0_m4m5_noshield
X$935 \$90__t108 topn__t222 cap_mim_2f0_m4m5_noshield c_length=4U c_width=4U
* device instance $936 r0 *1 422.4,126.5 cap_mim_2f0_m4m5_noshield
X$936 \$107__t20 topn__t223 cap_mim_2f0_m4m5_noshield c_length=4U c_width=4U
* device instance $937 r0 *1 2.6,132.9 cap_mim_2f0_m4m5_noshield
X$937 \$10__t19 topp__t36 cap_mim_2f0_m4m5_noshield c_length=4U c_width=4U
* device instance $938 r0 *1 9,132.9 cap_mim_2f0_m4m5_noshield
X$938 \$12__t63 topp__t210 cap_mim_2f0_m4m5_noshield c_length=4U c_width=4U
* device instance $939 r0 *1 15.4,132.9 cap_mim_2f0_m4m5_noshield
X$939 \$10__t105 topp__t209 cap_mim_2f0_m4m5_noshield c_length=4U c_width=4U
* device instance $940 r0 *1 21.8,132.9 cap_mim_2f0_m4m5_noshield
X$940 \$12__t62 topp__t208 cap_mim_2f0_m4m5_noshield c_length=4U c_width=4U
* device instance $941 r0 *1 28.2,132.9 cap_mim_2f0_m4m5_noshield
X$941 \$10__t22 topp__t41 cap_mim_2f0_m4m5_noshield c_length=4U c_width=4U
* device instance $942 r0 *1 34.6,132.9 cap_mim_2f0_m4m5_noshield
X$942 \$12__t10 topp__t40 cap_mim_2f0_m4m5_noshield c_length=4U c_width=4U
* device instance $943 r0 *1 41,132.9 cap_mim_2f0_m4m5_noshield
X$943 \$10__t21 topp__t39 cap_mim_2f0_m4m5_noshield c_length=4U c_width=4U
* device instance $944 r0 *1 47.4,132.9 cap_mim_2f0_m4m5_noshield
X$944 \$12__t9 topp__t38 cap_mim_2f0_m4m5_noshield c_length=4U c_width=4U
* device instance $945 r0 *1 53.8,132.9 cap_mim_2f0_m4m5_noshield
X$945 \$10__t20 topp__t37 cap_mim_2f0_m4m5_noshield c_length=4U c_width=4U
* device instance $946 r0 *1 60.2,132.9 cap_mim_2f0_m4m5_noshield
X$946 \$12__t26 topp__t110 cap_mim_2f0_m4m5_noshield c_length=4U c_width=4U
* device instance $947 r0 *1 66.6,132.9 cap_mim_2f0_m4m5_noshield
X$947 \$10__t104 topp__t207 cap_mim_2f0_m4m5_noshield c_length=4U c_width=4U
* device instance $948 r0 *1 73,132.9 cap_mim_2f0_m4m5_noshield
X$948 \$12__t61 topp__t205 cap_mim_2f0_m4m5_noshield c_length=4U c_width=4U
* device instance $949 r0 *1 79.4,132.9 cap_mim_2f0_m4m5_noshield
X$949 \$10__t102 topp__t204 cap_mim_2f0_m4m5_noshield c_length=4U c_width=4U
* device instance $950 r0 *1 85.8,132.9 cap_mim_2f0_m4m5_noshield
X$950 \$12__t60 topp__t203 cap_mim_2f0_m4m5_noshield c_length=4U c_width=4U
* device instance $951 r0 *1 92.2,132.9 cap_mim_2f0_m4m5_noshield
X$951 \$10__t103 topp__t206 cap_mim_2f0_m4m5_noshield c_length=4U c_width=4U
* device instance $952 r0 *1 98.6,132.9 cap_mim_2f0_m4m5_noshield
X$952 \$12__t58 topp__t201 cap_mim_2f0_m4m5_noshield c_length=4U c_width=4U
* device instance $953 r0 *1 105,132.9 cap_mim_2f0_m4m5_noshield
X$953 \$10__t101 topp__t200 cap_mim_2f0_m4m5_noshield c_length=4U c_width=4U
* device instance $954 r0 *1 111.4,132.9 cap_mim_2f0_m4m5_noshield
X$954 \$12__t54 topp__t193 cap_mim_2f0_m4m5_noshield c_length=4U c_width=4U
* device instance $955 r0 *1 117.8,132.9 cap_mim_2f0_m4m5_noshield
X$955 \$10__t138 topp__t278 cap_mim_2f0_m4m5_noshield c_length=4U c_width=4U
* device instance $956 r0 *1 124.2,132.9 cap_mim_2f0_m4m5_noshield
X$956 \$12__t27 topp__t112 cap_mim_2f0_m4m5_noshield c_length=4U c_width=4U
* device instance $957 r0 *1 130.6,132.9 cap_mim_2f0_m4m5_noshield
X$957 \$10__t132 topp__t262 cap_mim_2f0_m4m5_noshield c_length=4U c_width=4U
* device instance $958 r0 *1 137,132.9 cap_mim_2f0_m4m5_noshield
X$958 \$12__t89 topp__t307 cap_mim_2f0_m4m5_noshield c_length=4U c_width=4U
* device instance $959 r0 *1 143.4,132.9 cap_mim_2f0_m4m5_noshield
X$959 \$10__t147 topp__t293 cap_mim_2f0_m4m5_noshield c_length=4U c_width=4U
* device instance $960 r0 *1 149.8,132.9 cap_mim_2f0_m4m5_noshield
X$960 \$12__t82 topp__t292 cap_mim_2f0_m4m5_noshield c_length=4U c_width=4U
* device instance $961 r0 *1 156.2,132.9 cap_mim_2f0_m4m5_noshield
X$961 \$10__t146 topp__t291 cap_mim_2f0_m4m5_noshield c_length=4U c_width=4U
* device instance $962 r0 *1 162.6,132.9 cap_mim_2f0_m4m5_noshield
X$962 \$12__t17 topp__t89 cap_mim_2f0_m4m5_noshield c_length=4U c_width=4U
* device instance $963 r0 *1 169,132.9 cap_mim_2f0_m4m5_noshield
X$963 \$10__t45 topp__t88 cap_mim_2f0_m4m5_noshield c_length=4U c_width=4U
* device instance $964 r0 *1 175.4,132.9 cap_mim_2f0_m4m5_noshield
X$964 \$12__t15 topp__t74 cap_mim_2f0_m4m5_noshield c_length=4U c_width=4U
* device instance $965 r0 *1 181.8,132.9 cap_mim_2f0_m4m5_noshield
X$965 \$10__t38 topp__t73 cap_mim_2f0_m4m5_noshield c_length=4U c_width=4U
* device instance $966 r0 *1 188.2,132.9 cap_mim_2f0_m4m5_noshield
X$966 \$12__t29 topp__t115 cap_mim_2f0_m4m5_noshield c_length=4U c_width=4U
* device instance $967 r0 *1 194.6,132.9 cap_mim_2f0_m4m5_noshield
X$967 \$10__t58 topp__t114 cap_mim_2f0_m4m5_noshield c_length=4U c_width=4U
* device instance $968 r0 *1 201,132.9 cap_mim_2f0_m4m5_noshield
X$968 \$12__t28 topp__t113 cap_mim_2f0_m4m5_noshield c_length=4U c_width=4U
* device instance $969 r0 *1 224,132.9 cap_mim_2f0_m4m5_noshield
X$969 \$90__t2 topn__t6 cap_mim_2f0_m4m5_noshield c_length=4U c_width=4U
* device instance $970 r0 *1 230.4,132.9 cap_mim_2f0_m4m5_noshield
X$970 \$99__t1 topn__t5 cap_mim_2f0_m4m5_noshield c_length=4U c_width=4U
* device instance $971 r0 *1 236.8,132.9 cap_mim_2f0_m4m5_noshield
X$971 \$90__t233 topn__t465 cap_mim_2f0_m4m5_noshield c_length=4U c_width=4U
* device instance $972 r0 *1 243.2,132.9 cap_mim_2f0_m4m5_noshield
X$972 \$99__t118 topn__t466 cap_mim_2f0_m4m5_noshield c_length=4U c_width=4U
* device instance $973 r0 *1 249.6,132.9 cap_mim_2f0_m4m5_noshield
X$973 \$90__t234 topn__t467 cap_mim_2f0_m4m5_noshield c_length=4U c_width=4U
* device instance $974 r0 *1 256,132.9 cap_mim_2f0_m4m5_noshield
X$974 \$99__t119 topn__t468 cap_mim_2f0_m4m5_noshield c_length=4U c_width=4U
* device instance $975 r0 *1 262.4,132.9 cap_mim_2f0_m4m5_noshield
X$975 \$90__t235 topn__t469 cap_mim_2f0_m4m5_noshield c_length=4U c_width=4U
* device instance $976 r0 *1 268.8,132.9 cap_mim_2f0_m4m5_noshield
X$976 \$99__t120 topn__t470 cap_mim_2f0_m4m5_noshield c_length=4U c_width=4U
* device instance $977 r0 *1 275.2,132.9 cap_mim_2f0_m4m5_noshield
X$977 \$90__t206 topn__t412 cap_mim_2f0_m4m5_noshield c_length=4U c_width=4U
* device instance $978 r0 *1 281.6,132.9 cap_mim_2f0_m4m5_noshield
X$978 \$99__t101 topn__t410 cap_mim_2f0_m4m5_noshield c_length=4U c_width=4U
* device instance $979 r0 *1 288,132.9 cap_mim_2f0_m4m5_noshield
X$979 \$90__t205 topn__t411 cap_mim_2f0_m4m5_noshield c_length=4U c_width=4U
* device instance $980 r0 *1 294.4,132.9 cap_mim_2f0_m4m5_noshield
X$980 \$99__t72 topn__t273 cap_mim_2f0_m4m5_noshield c_length=4U c_width=4U
* device instance $981 r0 *1 300.8,132.9 cap_mim_2f0_m4m5_noshield
X$981 \$90__t216 topn__t431 cap_mim_2f0_m4m5_noshield c_length=4U c_width=4U
* device instance $982 r0 *1 307.2,132.9 cap_mim_2f0_m4m5_noshield
X$982 \$99__t111 topn__t432 cap_mim_2f0_m4m5_noshield c_length=4U c_width=4U
* device instance $983 r0 *1 313.6,132.9 cap_mim_2f0_m4m5_noshield
X$983 \$90__t221 topn__t439 cap_mim_2f0_m4m5_noshield c_length=4U c_width=4U
* device instance $984 r0 *1 320,132.9 cap_mim_2f0_m4m5_noshield
X$984 \$99__t107 topn__t424 cap_mim_2f0_m4m5_noshield c_length=4U c_width=4U
* device instance $985 r0 *1 326.4,132.9 cap_mim_2f0_m4m5_noshield
X$985 \$90__t213 topn__t425 cap_mim_2f0_m4m5_noshield c_length=4U c_width=4U
* device instance $986 r0 *1 332.8,132.9 cap_mim_2f0_m4m5_noshield
X$986 \$99__t108 topn__t426 cap_mim_2f0_m4m5_noshield c_length=4U c_width=4U
* device instance $987 r0 *1 339.2,132.9 cap_mim_2f0_m4m5_noshield
X$987 \$90__t214 topn__t427 cap_mim_2f0_m4m5_noshield c_length=4U c_width=4U
* device instance $988 r0 *1 345.6,132.9 cap_mim_2f0_m4m5_noshield
X$988 \$99__t109 topn__t428 cap_mim_2f0_m4m5_noshield c_length=4U c_width=4U
* device instance $989 r0 *1 352,132.9 cap_mim_2f0_m4m5_noshield
X$989 \$90__t118 topn__t240 cap_mim_2f0_m4m5_noshield c_length=4U c_width=4U
* device instance $990 r0 *1 358.4,132.9 cap_mim_2f0_m4m5_noshield
X$990 \$99__t51 topn__t189 cap_mim_2f0_m4m5_noshield c_length=4U c_width=4U
* device instance $991 r0 *1 364.8,132.9 cap_mim_2f0_m4m5_noshield
X$991 \$90__t97 topn__t201 cap_mim_2f0_m4m5_noshield c_length=4U c_width=4U
* device instance $992 r0 *1 371.2,132.9 cap_mim_2f0_m4m5_noshield
X$992 \$99__t74 topn__t279 cap_mim_2f0_m4m5_noshield c_length=4U c_width=4U
* device instance $993 r0 *1 377.6,132.9 cap_mim_2f0_m4m5_noshield
X$993 \$90__t145 topn__t291 cap_mim_2f0_m4m5_noshield c_length=4U c_width=4U
* device instance $994 r0 *1 384,132.9 cap_mim_2f0_m4m5_noshield
X$994 \$99__t79 topn__t303 cap_mim_2f0_m4m5_noshield c_length=4U c_width=4U
* device instance $995 r0 *1 390.4,132.9 cap_mim_2f0_m4m5_noshield
X$995 \$90__t89 topn__t183 cap_mim_2f0_m4m5_noshield c_length=4U c_width=4U
* device instance $996 r0 *1 396.8,132.9 cap_mim_2f0_m4m5_noshield
X$996 \$99__t48 topn__t184 cap_mim_2f0_m4m5_noshield c_length=4U c_width=4U
* device instance $997 r0 *1 403.2,132.9 cap_mim_2f0_m4m5_noshield
X$997 \$90__t90 topn__t185 cap_mim_2f0_m4m5_noshield c_length=4U c_width=4U
* device instance $998 r0 *1 409.6,132.9 cap_mim_2f0_m4m5_noshield
X$998 \$99__t49 topn__t186 cap_mim_2f0_m4m5_noshield c_length=4U c_width=4U
* device instance $999 r0 *1 416,132.9 cap_mim_2f0_m4m5_noshield
X$999 \$90__t91 topn__t187 cap_mim_2f0_m4m5_noshield c_length=4U c_width=4U
* device instance $1000 r0 *1 422.4,132.9 cap_mim_2f0_m4m5_noshield
X$1000 \$99__t50 topn__t188 cap_mim_2f0_m4m5_noshield c_length=4U c_width=4U
* device instance $1001 r0 *1 2.6,139.3 cap_mim_2f0_m4m5_noshield
X$1001 \$10__t18 topp__t35 cap_mim_2f0_m4m5_noshield c_length=4U c_width=4U
* device instance $1002 r0 *1 9,139.3 cap_mim_2f0_m4m5_noshield
X$1002 \$12__t8 topp__t34 cap_mim_2f0_m4m5_noshield c_length=4U c_width=4U
* device instance $1003 r0 *1 15.4,139.3 cap_mim_2f0_m4m5_noshield
X$1003 \$10__t17 topp__t33 cap_mim_2f0_m4m5_noshield c_length=4U c_width=4U
* device instance $1004 r0 *1 21.8,139.3 cap_mim_2f0_m4m5_noshield
X$1004 \$12__t7 topp__t32 cap_mim_2f0_m4m5_noshield c_length=4U c_width=4U
* device instance $1005 r0 *1 28.2,139.3 cap_mim_2f0_m4m5_noshield
X$1005 \$10__t70 topp__t135 cap_mim_2f0_m4m5_noshield c_length=4U c_width=4U
* device instance $1006 r0 *1 34.6,139.3 cap_mim_2f0_m4m5_noshield
X$1006 \$12__t65 topp__t214 cap_mim_2f0_m4m5_noshield c_length=4U c_width=4U
* device instance $1007 r0 *1 41,139.3 cap_mim_2f0_m4m5_noshield
X$1007 \$10__t107 topp__t213 cap_mim_2f0_m4m5_noshield c_length=4U c_width=4U
* device instance $1008 r0 *1 47.4,139.3 cap_mim_2f0_m4m5_noshield
X$1008 \$12__t64 topp__t212 cap_mim_2f0_m4m5_noshield c_length=4U c_width=4U
* device instance $1009 r0 *1 53.8,139.3 cap_mim_2f0_m4m5_noshield
X$1009 \$10__t106 topp__t211 cap_mim_2f0_m4m5_noshield c_length=4U c_width=4U
* device instance $1010 r0 *1 60.2,139.3 cap_mim_2f0_m4m5_noshield
X$1010 \$12__t6 topp__t29 cap_mim_2f0_m4m5_noshield c_length=4U c_width=4U
* device instance $1011 r0 *1 66.6,139.3 cap_mim_2f0_m4m5_noshield
X$1011 \$10__t108 topp__t215 cap_mim_2f0_m4m5_noshield c_length=4U c_width=4U
* device instance $1012 r0 *1 73,139.3 cap_mim_2f0_m4m5_noshield
X$1012 \$12__t57 topp__t198 cap_mim_2f0_m4m5_noshield c_length=4U c_width=4U
* device instance $1013 r0 *1 79.4,139.3 cap_mim_2f0_m4m5_noshield
X$1013 \$10__t100 topp__t197 cap_mim_2f0_m4m5_noshield c_length=4U c_width=4U
* device instance $1014 r0 *1 85.8,139.3 cap_mim_2f0_m4m5_noshield
X$1014 \$12__t56 topp__t196 cap_mim_2f0_m4m5_noshield c_length=4U c_width=4U
* device instance $1015 r0 *1 92.2,139.3 cap_mim_2f0_m4m5_noshield
X$1015 \$10__t99 topp__t195 cap_mim_2f0_m4m5_noshield c_length=4U c_width=4U
* device instance $1016 r0 *1 98.6,139.3 cap_mim_2f0_m4m5_noshield
X$1016 \$12__t55 topp__t194 cap_mim_2f0_m4m5_noshield c_length=4U c_width=4U
* device instance $1017 r0 *1 105,139.3 cap_mim_2f0_m4m5_noshield
X$1017 \$10__t98 topp__t192 cap_mim_2f0_m4m5_noshield c_length=4U c_width=4U
* device instance $1018 r0 *1 111.4,139.3 cap_mim_2f0_m4m5_noshield
X$1018 \$12__t59 topp__t202 cap_mim_2f0_m4m5_noshield c_length=4U c_width=4U
* device instance $1019 r0 *1 117.8,139.3 cap_mim_2f0_m4m5_noshield
X$1019 \$10__t137 topp__t276 cap_mim_2f0_m4m5_noshield c_length=4U c_width=4U
* device instance $1020 r0 *1 124.2,139.3 cap_mim_2f0_m4m5_noshield
X$1020 \$12__t73 topp__t261 cap_mim_2f0_m4m5_noshield c_length=4U c_width=4U
* device instance $1021 r0 *1 130.6,139.3 cap_mim_2f0_m4m5_noshield
X$1021 \$10__t131 topp__t260 cap_mim_2f0_m4m5_noshield c_length=4U c_width=4U
* device instance $1022 r0 *1 137,139.3 cap_mim_2f0_m4m5_noshield
X$1022 \$12__t72 topp__t259 cap_mim_2f0_m4m5_noshield c_length=4U c_width=4U
* device instance $1023 r0 *1 143.4,139.3 cap_mim_2f0_m4m5_noshield
X$1023 \$10__t130 topp__t258 cap_mim_2f0_m4m5_noshield c_length=4U c_width=4U
* device instance $1024 r0 *1 149.8,139.3 cap_mim_2f0_m4m5_noshield
X$1024 \$12__t71 topp__t257 cap_mim_2f0_m4m5_noshield c_length=4U c_width=4U
* device instance $1025 r0 *1 156.2,139.3 cap_mim_2f0_m4m5_noshield
X$1025 \$10__t129 topp__t256 cap_mim_2f0_m4m5_noshield c_length=4U c_width=4U
* device instance $1026 r0 *1 162.6,139.3 cap_mim_2f0_m4m5_noshield
X$1026 \$12__t70 topp__t255 cap_mim_2f0_m4m5_noshield c_length=4U c_width=4U
* device instance $1027 r0 *1 169,139.3 cap_mim_2f0_m4m5_noshield
X$1027 \$10__t128 topp__t254 cap_mim_2f0_m4m5_noshield c_length=4U c_width=4U
* device instance $1028 r0 *1 175.4,139.3 cap_mim_2f0_m4m5_noshield
X$1028 \$12__t69 topp__t253 cap_mim_2f0_m4m5_noshield c_length=4U c_width=4U
* device instance $1029 r0 *1 181.8,139.3 cap_mim_2f0_m4m5_noshield
X$1029 \$10__t127 topp__t252 cap_mim_2f0_m4m5_noshield c_length=4U c_width=4U
* device instance $1030 r0 *1 188.2,139.3 cap_mim_2f0_m4m5_noshield
X$1030 \$12__t68 topp__t251 cap_mim_2f0_m4m5_noshield c_length=4U c_width=4U
* device instance $1031 r0 *1 194.6,139.3 cap_mim_2f0_m4m5_noshield
X$1031 \$10__t126 topp__t250 cap_mim_2f0_m4m5_noshield c_length=4U c_width=4U
* device instance $1032 r0 *1 201,139.3 cap_mim_2f0_m4m5_noshield
X$1032 \$12__t67 topp__t249 cap_mim_2f0_m4m5_noshield c_length=4U c_width=4U
* device instance $1033 r0 *1 224,139.3 cap_mim_2f0_m4m5_noshield
X$1033 \$90__t68 topn__t138 cap_mim_2f0_m4m5_noshield c_length=4U c_width=4U
* device instance $1034 r0 *1 230.4,139.3 cap_mim_2f0_m4m5_noshield
X$1034 \$99__t38 topn__t139 cap_mim_2f0_m4m5_noshield c_length=4U c_width=4U
* device instance $1035 r0 *1 236.8,139.3 cap_mim_2f0_m4m5_noshield
X$1035 \$90__t207 topn__t413 cap_mim_2f0_m4m5_noshield c_length=4U c_width=4U
* device instance $1036 r0 *1 243.2,139.3 cap_mim_2f0_m4m5_noshield
X$1036 \$99__t102 topn__t414 cap_mim_2f0_m4m5_noshield c_length=4U c_width=4U
* device instance $1037 r0 *1 249.6,139.3 cap_mim_2f0_m4m5_noshield
X$1037 \$90__t208 topn__t415 cap_mim_2f0_m4m5_noshield c_length=4U c_width=4U
* device instance $1038 r0 *1 256,139.3 cap_mim_2f0_m4m5_noshield
X$1038 \$99__t103 topn__t416 cap_mim_2f0_m4m5_noshield c_length=4U c_width=4U
* device instance $1039 r0 *1 262.4,139.3 cap_mim_2f0_m4m5_noshield
X$1039 \$90__t253 topn__t507 cap_mim_2f0_m4m5_noshield c_length=4U c_width=4U
* device instance $1040 r0 *1 268.8,139.3 cap_mim_2f0_m4m5_noshield
X$1040 \$99__t126 topn__t508 cap_mim_2f0_m4m5_noshield c_length=4U c_width=4U
* device instance $1041 r0 *1 275.2,139.3 cap_mim_2f0_m4m5_noshield
X$1041 \$90__t254 topn__t509 cap_mim_2f0_m4m5_noshield c_length=4U c_width=4U
* device instance $1042 r0 *1 281.6,139.3 cap_mim_2f0_m4m5_noshield
X$1042 \$99__t127 topn__t511 cap_mim_2f0_m4m5_noshield c_length=4U c_width=4U
* device instance $1043 r0 *1 288,139.3 cap_mim_2f0_m4m5_noshield
X$1043 \$90__t201 topn__t404 cap_mim_2f0_m4m5_noshield c_length=4U c_width=4U
* device instance $1044 r0 *1 294.4,139.3 cap_mim_2f0_m4m5_noshield
X$1044 \$99__t65 topn__t259 cap_mim_2f0_m4m5_noshield c_length=4U c_width=4U
* device instance $1045 r0 *1 300.8,139.3 cap_mim_2f0_m4m5_noshield
X$1045 \$90__t209 topn__t417 cap_mim_2f0_m4m5_noshield c_length=4U c_width=4U
* device instance $1046 r0 *1 307.2,139.3 cap_mim_2f0_m4m5_noshield
X$1046 \$99__t104 topn__t418 cap_mim_2f0_m4m5_noshield c_length=4U c_width=4U
* device instance $1047 r0 *1 313.6,139.3 cap_mim_2f0_m4m5_noshield
X$1047 \$90__t210 topn__t419 cap_mim_2f0_m4m5_noshield c_length=4U c_width=4U
* device instance $1048 r0 *1 320,139.3 cap_mim_2f0_m4m5_noshield
X$1048 \$99__t105 topn__t420 cap_mim_2f0_m4m5_noshield c_length=4U c_width=4U
* device instance $1049 r0 *1 326.4,139.3 cap_mim_2f0_m4m5_noshield
X$1049 \$90__t211 topn__t421 cap_mim_2f0_m4m5_noshield c_length=4U c_width=4U
* device instance $1050 r0 *1 332.8,139.3 cap_mim_2f0_m4m5_noshield
X$1050 \$99__t106 topn__t422 cap_mim_2f0_m4m5_noshield c_length=4U c_width=4U
* device instance $1051 r0 *1 339.2,139.3 cap_mim_2f0_m4m5_noshield
X$1051 \$90__t215 topn__t429 cap_mim_2f0_m4m5_noshield c_length=4U c_width=4U
* device instance $1052 r0 *1 345.6,139.3 cap_mim_2f0_m4m5_noshield
X$1052 \$99__t110 topn__t430 cap_mim_2f0_m4m5_noshield c_length=4U c_width=4U
* device instance $1053 r0 *1 352,139.3 cap_mim_2f0_m4m5_noshield
X$1053 \$90__t110 topn__t225 cap_mim_2f0_m4m5_noshield c_length=4U c_width=4U
* device instance $1054 r0 *1 358.4,139.3 cap_mim_2f0_m4m5_noshield
X$1054 \$99__t52 topn__t190 cap_mim_2f0_m4m5_noshield c_length=4U c_width=4U
* device instance $1055 r0 *1 364.8,139.3 cap_mim_2f0_m4m5_noshield
X$1055 \$90__t92 topn__t191 cap_mim_2f0_m4m5_noshield c_length=4U c_width=4U
* device instance $1056 r0 *1 371.2,139.3 cap_mim_2f0_m4m5_noshield
X$1056 \$99__t53 topn__t192 cap_mim_2f0_m4m5_noshield c_length=4U c_width=4U
* device instance $1057 r0 *1 377.6,139.3 cap_mim_2f0_m4m5_noshield
X$1057 \$90__t102 topn__t209 cap_mim_2f0_m4m5_noshield c_length=4U c_width=4U
* device instance $1058 r0 *1 384,139.3 cap_mim_2f0_m4m5_noshield
X$1058 \$99__t54 topn__t194 cap_mim_2f0_m4m5_noshield c_length=4U c_width=4U
* device instance $1059 r0 *1 390.4,139.3 cap_mim_2f0_m4m5_noshield
X$1059 \$90__t94 topn__t195 cap_mim_2f0_m4m5_noshield c_length=4U c_width=4U
* device instance $1060 r0 *1 396.8,139.3 cap_mim_2f0_m4m5_noshield
X$1060 \$99__t55 topn__t196 cap_mim_2f0_m4m5_noshield c_length=4U c_width=4U
* device instance $1061 r0 *1 403.2,139.3 cap_mim_2f0_m4m5_noshield
X$1061 \$90__t95 topn__t197 cap_mim_2f0_m4m5_noshield c_length=4U c_width=4U
* device instance $1062 r0 *1 409.6,139.3 cap_mim_2f0_m4m5_noshield
X$1062 \$99__t56 topn__t198 cap_mim_2f0_m4m5_noshield c_length=4U c_width=4U
* device instance $1063 r0 *1 416,139.3 cap_mim_2f0_m4m5_noshield
X$1063 \$90__t96 topn__t199 cap_mim_2f0_m4m5_noshield c_length=4U c_width=4U
* device instance $1064 r0 *1 422.4,139.3 cap_mim_2f0_m4m5_noshield
X$1064 \$99__t57 topn__t200 cap_mim_2f0_m4m5_noshield c_length=4U c_width=4U
* device instance $1065 r0 *1 2.6,145.7 cap_mim_2f0_m4m5_noshield
X$1065 \$12__t25 topp__t108 cap_mim_2f0_m4m5_noshield c_length=4U c_width=4U
* device instance $1066 r0 *1 9,145.7 cap_mim_2f0_m4m5_noshield
X$1066 \$10__t61 topp__t119 cap_mim_2f0_m4m5_noshield c_length=4U c_width=4U
* device instance $1067 r0 *1 15.4,145.7 cap_mim_2f0_m4m5_noshield
X$1067 \$12__t24 topp__t106 cap_mim_2f0_m4m5_noshield c_length=4U c_width=4U
* device instance $1068 r0 *1 21.8,145.7 cap_mim_2f0_m4m5_noshield
X$1068 \$10__t55 topp__t105 cap_mim_2f0_m4m5_noshield c_length=4U c_width=4U
* device instance $1069 r0 *1 28.2,145.7 cap_mim_2f0_m4m5_noshield
X$1069 \$12__t23 topp__t104 cap_mim_2f0_m4m5_noshield c_length=4U c_width=4U
* device instance $1070 r0 *1 34.6,145.7 cap_mim_2f0_m4m5_noshield
X$1070 \$10__t54 topp__t103 cap_mim_2f0_m4m5_noshield c_length=4U c_width=4U
* device instance $1071 r0 *1 41,145.7 cap_mim_2f0_m4m5_noshield
X$1071 \$12__t22 topp__t102 cap_mim_2f0_m4m5_noshield c_length=4U c_width=4U
* device instance $1072 r0 *1 47.4,145.7 cap_mim_2f0_m4m5_noshield
X$1072 \$10__t53 topp__t101 cap_mim_2f0_m4m5_noshield c_length=4U c_width=4U
* device instance $1073 r0 *1 53.8,145.7 cap_mim_2f0_m4m5_noshield
X$1073 \$12__t21 topp__t100 cap_mim_2f0_m4m5_noshield c_length=4U c_width=4U
* device instance $1074 r0 *1 60.2,145.7 cap_mim_2f0_m4m5_noshield
X$1074 \$10__t52 topp__t99 cap_mim_2f0_m4m5_noshield c_length=4U c_width=4U
* device instance $1075 r0 *1 66.6,145.7 cap_mim_2f0_m4m5_noshield
X$1075 \$12__t20 topp__t98 cap_mim_2f0_m4m5_noshield c_length=4U c_width=4U
* device instance $1076 r0 *1 73,145.7 cap_mim_2f0_m4m5_noshield
X$1076 \$10__t51 topp__t97 cap_mim_2f0_m4m5_noshield c_length=4U c_width=4U
* device instance $1077 r0 *1 79.4,145.7 cap_mim_2f0_m4m5_noshield
X$1077 \$12__t19 topp__t96 cap_mim_2f0_m4m5_noshield c_length=4U c_width=4U
* device instance $1078 r0 *1 85.8,145.7 cap_mim_2f0_m4m5_noshield
X$1078 \$10__t50 topp__t95 cap_mim_2f0_m4m5_noshield c_length=4U c_width=4U
* device instance $1079 r0 *1 92.2,145.7 cap_mim_2f0_m4m5_noshield
X$1079 \$12__t18 topp__t94 cap_mim_2f0_m4m5_noshield c_length=4U c_width=4U
* device instance $1080 r0 *1 98.6,145.7 cap_mim_2f0_m4m5_noshield
X$1080 \$10__t49 topp__t93 cap_mim_2f0_m4m5_noshield c_length=4U c_width=4U
* device instance $1081 r0 *1 105,145.7 cap_mim_2f0_m4m5_noshield
X$1081 \$12__t16 topp__t77 cap_mim_2f0_m4m5_noshield c_length=4U c_width=4U
* device instance $1082 r0 *1 111.4,145.7 cap_mim_2f0_m4m5_noshield
X$1082 \$10__t16 topp__t30 cap_mim_2f0_m4m5_noshield c_length=4U c_width=4U
* device instance $1083 r0 *1 117.8,145.7 cap_mim_2f0_m4m5_noshield
X$1083 \$12__t76 topp__t275 cap_mim_2f0_m4m5_noshield c_length=4U c_width=4U
* device instance $1084 r0 *1 124.2,145.7 cap_mim_2f0_m4m5_noshield
X$1084 \$10__t154 topp__t306 cap_mim_2f0_m4m5_noshield c_length=4U c_width=4U
* device instance $1085 r0 *1 130.6,145.7 cap_mim_2f0_m4m5_noshield
X$1085 \$12__t88 topp__t305 cap_mim_2f0_m4m5_noshield c_length=4U c_width=4U
* device instance $1086 r0 *1 137,145.7 cap_mim_2f0_m4m5_noshield
X$1086 \$10__t153 topp__t304 cap_mim_2f0_m4m5_noshield c_length=4U c_width=4U
* device instance $1087 r0 *1 143.4,145.7 cap_mim_2f0_m4m5_noshield
X$1087 \$12__t87 topp__t303 cap_mim_2f0_m4m5_noshield c_length=4U c_width=4U
* device instance $1088 r0 *1 149.8,145.7 cap_mim_2f0_m4m5_noshield
X$1088 \$10__t152 topp__t302 cap_mim_2f0_m4m5_noshield c_length=4U c_width=4U
* device instance $1089 r0 *1 156.2,145.7 cap_mim_2f0_m4m5_noshield
X$1089 \$12__t86 topp__t301 cap_mim_2f0_m4m5_noshield c_length=4U c_width=4U
* device instance $1090 r0 *1 162.6,145.7 cap_mim_2f0_m4m5_noshield
X$1090 \$10__t151 topp__t300 cap_mim_2f0_m4m5_noshield c_length=4U c_width=4U
* device instance $1091 r0 *1 169,145.7 cap_mim_2f0_m4m5_noshield
X$1091 \$12__t85 topp__t299 cap_mim_2f0_m4m5_noshield c_length=4U c_width=4U
* device instance $1092 r0 *1 175.4,145.7 cap_mim_2f0_m4m5_noshield
X$1092 \$10__t150 topp__t298 cap_mim_2f0_m4m5_noshield c_length=4U c_width=4U
* device instance $1093 r0 *1 181.8,145.7 cap_mim_2f0_m4m5_noshield
X$1093 \$12__t84 topp__t297 cap_mim_2f0_m4m5_noshield c_length=4U c_width=4U
* device instance $1094 r0 *1 188.2,145.7 cap_mim_2f0_m4m5_noshield
X$1094 \$10__t149 topp__t296 cap_mim_2f0_m4m5_noshield c_length=4U c_width=4U
* device instance $1095 r0 *1 194.6,145.7 cap_mim_2f0_m4m5_noshield
X$1095 \$12__t83 topp__t295 cap_mim_2f0_m4m5_noshield c_length=4U c_width=4U
* device instance $1096 r0 *1 201,145.7 cap_mim_2f0_m4m5_noshield
X$1096 \$10__t148 topp__t294 cap_mim_2f0_m4m5_noshield c_length=4U c_width=4U
* device instance $1097 r0 *1 224,145.7 cap_mim_2f0_m4m5_noshield
X$1097 \$99__t39 topn__t140 cap_mim_2f0_m4m5_noshield c_length=4U c_width=4U
* device instance $1098 r0 *1 230.4,145.7 cap_mim_2f0_m4m5_noshield
X$1098 \$90__t67 topn__t137 cap_mim_2f0_m4m5_noshield c_length=4U c_width=4U
* device instance $1099 r0 *1 236.8,145.7 cap_mim_2f0_m4m5_noshield
X$1099 \$99__t66 topn__t262 cap_mim_2f0_m4m5_noshield c_length=4U c_width=4U
* device instance $1100 r0 *1 243.2,145.7 cap_mim_2f0_m4m5_noshield
X$1100 \$90__t130 topn__t263 cap_mim_2f0_m4m5_noshield c_length=4U c_width=4U
* device instance $1101 r0 *1 249.6,145.7 cap_mim_2f0_m4m5_noshield
X$1101 \$99__t67 topn__t264 cap_mim_2f0_m4m5_noshield c_length=4U c_width=4U
* device instance $1102 r0 *1 256,145.7 cap_mim_2f0_m4m5_noshield
X$1102 \$90__t131 topn__t265 cap_mim_2f0_m4m5_noshield c_length=4U c_width=4U
* device instance $1103 r0 *1 262.4,145.7 cap_mim_2f0_m4m5_noshield
X$1103 \$99__t68 topn__t266 cap_mim_2f0_m4m5_noshield c_length=4U c_width=4U
* device instance $1104 r0 *1 268.8,145.7 cap_mim_2f0_m4m5_noshield
X$1104 \$90__t132 topn__t267 cap_mim_2f0_m4m5_noshield c_length=4U c_width=4U
* device instance $1105 r0 *1 275.2,145.7 cap_mim_2f0_m4m5_noshield
X$1105 \$99__t69 topn__t268 cap_mim_2f0_m4m5_noshield c_length=4U c_width=4U
* device instance $1106 r0 *1 281.6,145.7 cap_mim_2f0_m4m5_noshield
X$1106 \$90__t133 topn__t269 cap_mim_2f0_m4m5_noshield c_length=4U c_width=4U
* device instance $1107 r0 *1 288,145.7 cap_mim_2f0_m4m5_noshield
X$1107 \$99__t70 topn__t270 cap_mim_2f0_m4m5_noshield c_length=4U c_width=4U
* device instance $1108 r0 *1 294.4,145.7 cap_mim_2f0_m4m5_noshield
X$1108 \$90__t134 topn__t271 cap_mim_2f0_m4m5_noshield c_length=4U c_width=4U
* device instance $1109 r0 *1 300.8,145.7 cap_mim_2f0_m4m5_noshield
X$1109 \$99__t71 topn__t272 cap_mim_2f0_m4m5_noshield c_length=4U c_width=4U
* device instance $1110 r0 *1 307.2,145.7 cap_mim_2f0_m4m5_noshield
X$1110 \$90__t93 topn__t193 cap_mim_2f0_m4m5_noshield c_length=4U c_width=4U
* device instance $1111 r0 *1 313.6,145.7 cap_mim_2f0_m4m5_noshield
X$1111 \$99__t61 topn__t251 cap_mim_2f0_m4m5_noshield c_length=4U c_width=4U
* device instance $1112 r0 *1 320,145.7 cap_mim_2f0_m4m5_noshield
X$1112 \$90__t124 topn__t252 cap_mim_2f0_m4m5_noshield c_length=4U c_width=4U
* device instance $1113 r0 *1 326.4,145.7 cap_mim_2f0_m4m5_noshield
X$1113 \$99__t62 topn__t253 cap_mim_2f0_m4m5_noshield c_length=4U c_width=4U
* device instance $1114 r0 *1 332.8,145.7 cap_mim_2f0_m4m5_noshield
X$1114 \$90__t125 topn__t254 cap_mim_2f0_m4m5_noshield c_length=4U c_width=4U
* device instance $1115 r0 *1 339.2,145.7 cap_mim_2f0_m4m5_noshield
X$1115 \$99__t63 topn__t255 cap_mim_2f0_m4m5_noshield c_length=4U c_width=4U
* device instance $1116 r0 *1 345.6,145.7 cap_mim_2f0_m4m5_noshield
X$1116 \$90__t126 topn__t256 cap_mim_2f0_m4m5_noshield c_length=4U c_width=4U
* device instance $1117 r0 *1 352,145.7 cap_mim_2f0_m4m5_noshield
X$1117 \$99__t46 topn__t179 cap_mim_2f0_m4m5_noshield c_length=4U c_width=4U
* device instance $1118 r0 *1 358.4,145.7 cap_mim_2f0_m4m5_noshield
X$1118 \$90__t98 topn__t202 cap_mim_2f0_m4m5_noshield c_length=4U c_width=4U
* device instance $1119 r0 *1 364.8,145.7 cap_mim_2f0_m4m5_noshield
X$1119 \$99__t58 topn__t203 cap_mim_2f0_m4m5_noshield c_length=4U c_width=4U
* device instance $1120 r0 *1 371.2,145.7 cap_mim_2f0_m4m5_noshield
X$1120 \$90__t99 topn__t204 cap_mim_2f0_m4m5_noshield c_length=4U c_width=4U
* device instance $1121 r0 *1 377.6,145.7 cap_mim_2f0_m4m5_noshield
X$1121 \$99__t59 topn__t205 cap_mim_2f0_m4m5_noshield c_length=4U c_width=4U
* device instance $1122 r0 *1 384,145.7 cap_mim_2f0_m4m5_noshield
X$1122 \$90__t100 topn__t206 cap_mim_2f0_m4m5_noshield c_length=4U c_width=4U
* device instance $1123 r0 *1 390.4,145.7 cap_mim_2f0_m4m5_noshield
X$1123 \$99__t60 topn__t207 cap_mim_2f0_m4m5_noshield c_length=4U c_width=4U
* device instance $1124 r0 *1 396.8,145.7 cap_mim_2f0_m4m5_noshield
X$1124 \$90__t101 topn__t208 cap_mim_2f0_m4m5_noshield c_length=4U c_width=4U
* device instance $1125 r0 *1 403.2,145.7 cap_mim_2f0_m4m5_noshield
X$1125 \$99__t64 topn__t257 cap_mim_2f0_m4m5_noshield c_length=4U c_width=4U
* device instance $1126 r0 *1 409.6,145.7 cap_mim_2f0_m4m5_noshield
X$1126 \$90__t135 topn__t274 cap_mim_2f0_m4m5_noshield c_length=4U c_width=4U
* device instance $1127 r0 *1 416,145.7 cap_mim_2f0_m4m5_noshield
X$1127 \$99__t73 topn__t275 cap_mim_2f0_m4m5_noshield c_length=4U c_width=4U
* device instance $1128 r0 *1 422.4,145.7 cap_mim_2f0_m4m5_noshield
X$1128 \$90__t138 topn__t278 cap_mim_2f0_m4m5_noshield c_length=4U c_width=4U
* device instance $1129 r0 *1 2.6,152.1 cap_mim_2f0_m4m5_noshield
X$1129 \$12__t11 topp__t43 cap_mim_2f0_m4m5_noshield c_length=4U c_width=4U
* device instance $1130 r0 *1 9,152.1 cap_mim_2f0_m4m5_noshield
X$1130 \$10__t23 topp__t42 cap_mim_2f0_m4m5_noshield c_length=4U c_width=4U
* device instance $1131 r0 *1 15.4,152.1 cap_mim_2f0_m4m5_noshield
X$1131 \$12__t12 topp__t44 cap_mim_2f0_m4m5_noshield c_length=4U c_width=4U
* device instance $1132 r0 *1 21.8,152.1 cap_mim_2f0_m4m5_noshield
X$1132 \$10__t3 topp__t5 cap_mim_2f0_m4m5_noshield c_length=4U c_width=4U
* device instance $1133 r0 *1 28.2,152.1 cap_mim_2f0_m4m5_noshield
X$1133 \$12__t1 topp__t4 cap_mim_2f0_m4m5_noshield c_length=4U c_width=4U
* device instance $1134 r0 *1 34.6,152.1 cap_mim_2f0_m4m5_noshield
X$1134 \$10__t26 topp__t48 cap_mim_2f0_m4m5_noshield c_length=4U c_width=4U
* device instance $1135 r0 *1 41,152.1 cap_mim_2f0_m4m5_noshield
X$1135 \$12__t14 topp__t63 cap_mim_2f0_m4m5_noshield c_length=4U c_width=4U
* device instance $1136 r0 *1 47.4,152.1 cap_mim_2f0_m4m5_noshield
X$1136 \$10__t24 topp__t46 cap_mim_2f0_m4m5_noshield c_length=4U c_width=4U
* device instance $1137 r0 *1 53.8,152.1 cap_mim_2f0_m4m5_noshield
X$1137 \$12__t13 topp__t45 cap_mim_2f0_m4m5_noshield c_length=4U c_width=4U
* device instance $1138 r0 *1 60.2,152.1 cap_mim_2f0_m4m5_noshield
X$1138 \$10__t57 topp__t111 cap_mim_2f0_m4m5_noshield c_length=4U c_width=4U
* device instance $1139 r0 *1 66.6,152.1 cap_mim_2f0_m4m5_noshield
X$1139 \$12__t4 topp__t26 cap_mim_2f0_m4m5_noshield c_length=4U c_width=4U
* device instance $1140 r0 *1 73,152.1 cap_mim_2f0_m4m5_noshield
X$1140 \$10__t14 topp__t25 cap_mim_2f0_m4m5_noshield c_length=4U c_width=4U
* device instance $1141 r0 *1 79.4,152.1 cap_mim_2f0_m4m5_noshield
X$1141 \$12__t3 topp__t16 cap_mim_2f0_m4m5_noshield c_length=4U c_width=4U
* device instance $1142 r0 *1 85.8,152.1 cap_mim_2f0_m4m5_noshield
X$1142 \$10__t5 topp__t8 cap_mim_2f0_m4m5_noshield c_length=4U c_width=4U
* device instance $1143 r0 *1 92.2,152.1 cap_mim_2f0_m4m5_noshield
X$1143 \$12__t2 topp__t7 cap_mim_2f0_m4m5_noshield c_length=4U c_width=4U
* device instance $1144 r0 *1 98.6,152.1 cap_mim_2f0_m4m5_noshield
X$1144 \$10__t4 topp__t6 cap_mim_2f0_m4m5_noshield c_length=4U c_width=4U
* device instance $1145 r0 *1 105,152.1 cap_mim_2f0_m4m5_noshield
X$1145 \$12__t5 topp__t28 cap_mim_2f0_m4m5_noshield c_length=4U c_width=4U
* device instance $1146 r0 *1 111.4,152.1 cap_mim_2f0_m4m5_noshield
X$1146 \$10__t15 topp__t27 cap_mim_2f0_m4m5_noshield c_length=4U c_width=4U
* device instance $1147 r0 *1 117.8,152.1 cap_mim_2f0_m4m5_noshield
X$1147 \$12__t75 topp__t272 cap_mim_2f0_m4m5_noshield c_length=4U c_width=4U
* device instance $1148 r0 *1 124.2,152.1 cap_mim_2f0_m4m5_noshield
X$1148 \$10__t145 topp__t290 cap_mim_2f0_m4m5_noshield c_length=4U c_width=4U
* device instance $1149 r0 *1 130.6,152.1 cap_mim_2f0_m4m5_noshield
X$1149 \$12__t81 topp__t289 cap_mim_2f0_m4m5_noshield c_length=4U c_width=4U
* device instance $1150 r0 *1 137,152.1 cap_mim_2f0_m4m5_noshield
X$1150 \$10__t144 topp__t288 cap_mim_2f0_m4m5_noshield c_length=4U c_width=4U
* device instance $1151 r0 *1 143.4,152.1 cap_mim_2f0_m4m5_noshield
X$1151 \$12__t80 topp__t287 cap_mim_2f0_m4m5_noshield c_length=4U c_width=4U
* device instance $1152 r0 *1 149.8,152.1 cap_mim_2f0_m4m5_noshield
X$1152 \$10__t143 topp__t286 cap_mim_2f0_m4m5_noshield c_length=4U c_width=4U
* device instance $1153 r0 *1 156.2,152.1 cap_mim_2f0_m4m5_noshield
X$1153 \$12__t79 topp__t285 cap_mim_2f0_m4m5_noshield c_length=4U c_width=4U
* device instance $1154 r0 *1 162.6,152.1 cap_mim_2f0_m4m5_noshield
X$1154 \$10__t142 topp__t284 cap_mim_2f0_m4m5_noshield c_length=4U c_width=4U
* device instance $1155 r0 *1 169,152.1 cap_mim_2f0_m4m5_noshield
X$1155 \$12__t78 topp__t283 cap_mim_2f0_m4m5_noshield c_length=4U c_width=4U
* device instance $1156 r0 *1 175.4,152.1 cap_mim_2f0_m4m5_noshield
X$1156 \$10__t141 topp__t282 cap_mim_2f0_m4m5_noshield c_length=4U c_width=4U
* device instance $1157 r0 *1 181.8,152.1 cap_mim_2f0_m4m5_noshield
X$1157 \$12__t77 topp__t281 cap_mim_2f0_m4m5_noshield c_length=4U c_width=4U
* device instance $1158 r0 *1 188.2,152.1 cap_mim_2f0_m4m5_noshield
X$1158 \$10__t140 topp__t280 cap_mim_2f0_m4m5_noshield c_length=4U c_width=4U
* device instance $1159 r0 *1 194.6,152.1 cap_mim_2f0_m4m5_noshield
X$1159 \$12__t66 topp__t248 cap_mim_2f0_m4m5_noshield c_length=4U c_width=4U
* device instance $1160 r0 *1 201,152.1 cap_mim_2f0_m4m5_noshield
X$1160 \$10__t46 topp__t90 cap_mim_2f0_m4m5_noshield c_length=4U c_width=4U
* device instance $1161 r0 *1 224,152.1 cap_mim_2f0_m4m5_noshield
X$1161 \$99__t0 topn__t4 cap_mim_2f0_m4m5_noshield c_length=4U c_width=4U
* device instance $1162 r0 *1 230.4,152.1 cap_mim_2f0_m4m5_noshield
X$1162 \$90__t1 topn__t3 cap_mim_2f0_m4m5_noshield c_length=4U c_width=4U
* device instance $1163 r0 *1 236.8,152.1 cap_mim_2f0_m4m5_noshield
X$1163 \$99__t121 topn__t471 cap_mim_2f0_m4m5_noshield c_length=4U c_width=4U
* device instance $1164 r0 *1 243.2,152.1 cap_mim_2f0_m4m5_noshield
X$1164 \$90__t228 topn__t454 cap_mim_2f0_m4m5_noshield c_length=4U c_width=4U
* device instance $1165 r0 *1 249.6,152.1 cap_mim_2f0_m4m5_noshield
X$1165 \$99__t114 topn__t455 cap_mim_2f0_m4m5_noshield c_length=4U c_width=4U
* device instance $1166 r0 *1 256,152.1 cap_mim_2f0_m4m5_noshield
X$1166 \$90__t229 topn__t456 cap_mim_2f0_m4m5_noshield c_length=4U c_width=4U
* device instance $1167 r0 *1 262.4,152.1 cap_mim_2f0_m4m5_noshield
X$1167 \$99__t115 topn__t457 cap_mim_2f0_m4m5_noshield c_length=4U c_width=4U
* device instance $1168 r0 *1 268.8,152.1 cap_mim_2f0_m4m5_noshield
X$1168 \$90__t230 topn__t458 cap_mim_2f0_m4m5_noshield c_length=4U c_width=4U
* device instance $1169 r0 *1 275.2,152.1 cap_mim_2f0_m4m5_noshield
X$1169 \$99__t116 topn__t459 cap_mim_2f0_m4m5_noshield c_length=4U c_width=4U
* device instance $1170 r0 *1 281.6,152.1 cap_mim_2f0_m4m5_noshield
X$1170 \$90__t231 topn__t460 cap_mim_2f0_m4m5_noshield c_length=4U c_width=4U
* device instance $1171 r0 *1 288,152.1 cap_mim_2f0_m4m5_noshield
X$1171 \$99__t117 topn__t461 cap_mim_2f0_m4m5_noshield c_length=4U c_width=4U
* device instance $1172 r0 *1 294.4,152.1 cap_mim_2f0_m4m5_noshield
X$1172 \$90__t127 topn__t258 cap_mim_2f0_m4m5_noshield c_length=4U c_width=4U
* device instance $1173 r0 *1 300.8,152.1 cap_mim_2f0_m4m5_noshield
X$1173 \$99__t124 topn__t488 cap_mim_2f0_m4m5_noshield c_length=4U c_width=4U
* device instance $1174 r0 *1 307.2,152.1 cap_mim_2f0_m4m5_noshield
X$1174 \$90__t245 topn__t489 cap_mim_2f0_m4m5_noshield c_length=4U c_width=4U
* device instance $1175 r0 *1 313.6,152.1 cap_mim_2f0_m4m5_noshield
X$1175 \$99__t122 topn__t474 cap_mim_2f0_m4m5_noshield c_length=4U c_width=4U
* device instance $1176 r0 *1 320,152.1 cap_mim_2f0_m4m5_noshield
X$1176 \$90__t241 topn__t483 cap_mim_2f0_m4m5_noshield c_length=4U c_width=4U
* device instance $1177 r0 *1 326.4,152.1 cap_mim_2f0_m4m5_noshield
X$1177 \$99__t123 topn__t484 cap_mim_2f0_m4m5_noshield c_length=4U c_width=4U
* device instance $1178 r0 *1 332.8,152.1 cap_mim_2f0_m4m5_noshield
X$1178 \$90__t242 topn__t485 cap_mim_2f0_m4m5_noshield c_length=4U c_width=4U
* device instance $1179 r0 *1 339.2,152.1 cap_mim_2f0_m4m5_noshield
X$1179 \$99__t125 topn__t502 cap_mim_2f0_m4m5_noshield c_length=4U c_width=4U
* device instance $1180 r0 *1 345.6,152.1 cap_mim_2f0_m4m5_noshield
X$1180 \$90__t244 topn__t487 cap_mim_2f0_m4m5_noshield c_length=4U c_width=4U
* device instance $1181 r0 *1 352,152.1 cap_mim_2f0_m4m5_noshield
X$1181 \$99__t47 topn__t180 cap_mim_2f0_m4m5_noshield c_length=4U c_width=4U
* device instance $1182 r0 *1 358.4,152.1 cap_mim_2f0_m4m5_noshield
X$1182 \$90__t139 topn__t280 cap_mim_2f0_m4m5_noshield c_length=4U c_width=4U
* device instance $1183 r0 *1 364.8,152.1 cap_mim_2f0_m4m5_noshield
X$1183 \$99__t75 topn__t281 cap_mim_2f0_m4m5_noshield c_length=4U c_width=4U
* device instance $1184 r0 *1 371.2,152.1 cap_mim_2f0_m4m5_noshield
X$1184 \$90__t140 topn__t282 cap_mim_2f0_m4m5_noshield c_length=4U c_width=4U
* device instance $1185 r0 *1 377.6,152.1 cap_mim_2f0_m4m5_noshield
X$1185 \$99__t76 topn__t283 cap_mim_2f0_m4m5_noshield c_length=4U c_width=4U
* device instance $1186 r0 *1 384,152.1 cap_mim_2f0_m4m5_noshield
X$1186 \$90__t141 topn__t284 cap_mim_2f0_m4m5_noshield c_length=4U c_width=4U
* device instance $1187 r0 *1 390.4,152.1 cap_mim_2f0_m4m5_noshield
X$1187 \$99__t77 topn__t285 cap_mim_2f0_m4m5_noshield c_length=4U c_width=4U
* device instance $1188 r0 *1 396.8,152.1 cap_mim_2f0_m4m5_noshield
X$1188 \$90__t142 topn__t286 cap_mim_2f0_m4m5_noshield c_length=4U c_width=4U
* device instance $1189 r0 *1 403.2,152.1 cap_mim_2f0_m4m5_noshield
X$1189 \$99__t78 topn__t287 cap_mim_2f0_m4m5_noshield c_length=4U c_width=4U
* device instance $1190 r0 *1 409.6,152.1 cap_mim_2f0_m4m5_noshield
X$1190 \$90__t143 topn__t288 cap_mim_2f0_m4m5_noshield c_length=4U c_width=4U
* device instance $1191 r0 *1 416,152.1 cap_mim_2f0_m4m5_noshield
X$1191 \$99__t80 topn__t305 cap_mim_2f0_m4m5_noshield c_length=4U c_width=4U
* device instance $1192 r0 *1 422.4,152.1 cap_mim_2f0_m4m5_noshield
X$1192 \$90__t144 topn__t290 cap_mim_2f0_m4m5_noshield c_length=4U c_width=4U
* device instance $1193 r0 *1 2.6,158.5 cap_mim_2f0_m4m5_noshield
X$1193 \$14__t0 topp__t3 cap_mim_2f0_m4m5_noshield c_length=4U c_width=4U
* device instance $1194 r0 *1 9,158.5 cap_mim_2f0_m4m5_noshield
X$1194 \$10__t2 topp__t2 cap_mim_2f0_m4m5_noshield c_length=4U c_width=4U
* device instance $1195 r0 *1 15.4,158.5 cap_mim_2f0_m4m5_noshield
X$1195 \$14__t8 topp__t55 cap_mim_2f0_m4m5_noshield c_length=4U c_width=4U
* device instance $1196 r0 *1 21.8,158.5 cap_mim_2f0_m4m5_noshield
X$1196 \$10__t29 topp__t54 cap_mim_2f0_m4m5_noshield c_length=4U c_width=4U
* device instance $1197 r0 *1 28.2,158.5 cap_mim_2f0_m4m5_noshield
X$1197 \$14__t7 topp__t53 cap_mim_2f0_m4m5_noshield c_length=4U c_width=4U
* device instance $1198 r0 *1 34.6,158.5 cap_mim_2f0_m4m5_noshield
X$1198 \$10__t28 topp__t52 cap_mim_2f0_m4m5_noshield c_length=4U c_width=4U
* device instance $1199 r0 *1 41,158.5 cap_mim_2f0_m4m5_noshield
X$1199 \$14__t6 topp__t51 cap_mim_2f0_m4m5_noshield c_length=4U c_width=4U
* device instance $1200 r0 *1 47.4,158.5 cap_mim_2f0_m4m5_noshield
X$1200 \$10__t27 topp__t50 cap_mim_2f0_m4m5_noshield c_length=4U c_width=4U
* device instance $1201 r0 *1 53.8,158.5 cap_mim_2f0_m4m5_noshield
X$1201 \$14__t5 topp__t49 cap_mim_2f0_m4m5_noshield c_length=4U c_width=4U
* device instance $1202 r0 *1 60.2,158.5 cap_mim_2f0_m4m5_noshield
X$1202 \$10__t56 topp__t109 cap_mim_2f0_m4m5_noshield c_length=4U c_width=4U
* device instance $1203 r0 *1 66.6,158.5 cap_mim_2f0_m4m5_noshield
X$1203 \$14__t4 topp__t24 cap_mim_2f0_m4m5_noshield c_length=4U c_width=4U
* device instance $1204 r0 *1 73,158.5 cap_mim_2f0_m4m5_noshield
X$1204 \$10__t13 topp__t23 cap_mim_2f0_m4m5_noshield c_length=4U c_width=4U
* device instance $1205 r0 *1 79.4,158.5 cap_mim_2f0_m4m5_noshield
X$1205 \$14__t3 topp__t22 cap_mim_2f0_m4m5_noshield c_length=4U c_width=4U
* device instance $1206 r0 *1 85.8,158.5 cap_mim_2f0_m4m5_noshield
X$1206 \$10__t12 topp__t21 cap_mim_2f0_m4m5_noshield c_length=4U c_width=4U
* device instance $1207 r0 *1 92.2,158.5 cap_mim_2f0_m4m5_noshield
X$1207 \$14__t2 topp__t20 cap_mim_2f0_m4m5_noshield c_length=4U c_width=4U
* device instance $1208 r0 *1 98.6,158.5 cap_mim_2f0_m4m5_noshield
X$1208 \$10__t11 topp__t19 cap_mim_2f0_m4m5_noshield c_length=4U c_width=4U
* device instance $1209 r0 *1 105,158.5 cap_mim_2f0_m4m5_noshield
X$1209 \$14__t1 topp__t18 cap_mim_2f0_m4m5_noshield c_length=4U c_width=4U
* device instance $1210 r0 *1 111.4,158.5 cap_mim_2f0_m4m5_noshield
X$1210 \$10__t10 topp__t17 cap_mim_2f0_m4m5_noshield c_length=4U c_width=4U
* device instance $1211 r0 *1 117.8,158.5 cap_mim_2f0_m4m5_noshield
X$1211 \$14__t27 topp__t270 cap_mim_2f0_m4m5_noshield c_length=4U c_width=4U
* device instance $1212 r0 *1 124.2,158.5 cap_mim_2f0_m4m5_noshield
X$1212 \$10__t44 topp__t87 cap_mim_2f0_m4m5_noshield c_length=4U c_width=4U
* device instance $1213 r0 *1 130.6,158.5 cap_mim_2f0_m4m5_noshield
X$1213 \$14__t14 topp__t86 cap_mim_2f0_m4m5_noshield c_length=4U c_width=4U
* device instance $1214 r0 *1 137,158.5 cap_mim_2f0_m4m5_noshield
X$1214 \$10__t43 topp__t85 cap_mim_2f0_m4m5_noshield c_length=4U c_width=4U
* device instance $1215 r0 *1 143.4,158.5 cap_mim_2f0_m4m5_noshield
X$1215 \$14__t13 topp__t84 cap_mim_2f0_m4m5_noshield c_length=4U c_width=4U
* device instance $1216 r0 *1 149.8,158.5 cap_mim_2f0_m4m5_noshield
X$1216 \$10__t42 topp__t83 cap_mim_2f0_m4m5_noshield c_length=4U c_width=4U
* device instance $1217 r0 *1 156.2,158.5 cap_mim_2f0_m4m5_noshield
X$1217 \$14__t12 topp__t82 cap_mim_2f0_m4m5_noshield c_length=4U c_width=4U
* device instance $1218 r0 *1 162.6,158.5 cap_mim_2f0_m4m5_noshield
X$1218 \$10__t41 topp__t81 cap_mim_2f0_m4m5_noshield c_length=4U c_width=4U
* device instance $1219 r0 *1 169,158.5 cap_mim_2f0_m4m5_noshield
X$1219 \$14__t11 topp__t80 cap_mim_2f0_m4m5_noshield c_length=4U c_width=4U
* device instance $1220 r0 *1 175.4,158.5 cap_mim_2f0_m4m5_noshield
X$1220 \$10__t40 topp__t79 cap_mim_2f0_m4m5_noshield c_length=4U c_width=4U
* device instance $1221 r0 *1 181.8,158.5 cap_mim_2f0_m4m5_noshield
X$1221 \$14__t10 topp__t78 cap_mim_2f0_m4m5_noshield c_length=4U c_width=4U
* device instance $1222 r0 *1 188.2,158.5 cap_mim_2f0_m4m5_noshield
X$1222 \$10__t47 topp__t91 cap_mim_2f0_m4m5_noshield c_length=4U c_width=4U
* device instance $1223 r0 *1 194.6,158.5 cap_mim_2f0_m4m5_noshield
X$1223 \$14__t9 topp__t76 cap_mim_2f0_m4m5_noshield c_length=4U c_width=4U
* device instance $1224 r0 *1 201,158.5 cap_mim_2f0_m4m5_noshield
X$1224 \$10__t39 topp__t75 cap_mim_2f0_m4m5_noshield c_length=4U c_width=4U
* device instance $1225 r0 *1 224,158.5 cap_mim_2f0_m4m5_noshield
X$1225 \$107__t1 topn__t2 cap_mim_2f0_m4m5_noshield c_length=4U c_width=4U
* device instance $1226 r0 *1 230.4,158.5 cap_mim_2f0_m4m5_noshield
X$1226 \$90__t0 topn__t1 cap_mim_2f0_m4m5_noshield c_length=4U c_width=4U
* device instance $1227 r0 *1 236.8,158.5 cap_mim_2f0_m4m5_noshield
X$1227 \$107__t62 topn__t501 cap_mim_2f0_m4m5_noshield c_length=4U c_width=4U
* device instance $1228 r0 *1 243.2,158.5 cap_mim_2f0_m4m5_noshield
X$1228 \$90__t243 topn__t486 cap_mim_2f0_m4m5_noshield c_length=4U c_width=4U
* device instance $1229 r0 *1 249.6,158.5 cap_mim_2f0_m4m5_noshield
X$1229 \$107__t54 topn__t447 cap_mim_2f0_m4m5_noshield c_length=4U c_width=4U
* device instance $1230 r0 *1 256,158.5 cap_mim_2f0_m4m5_noshield
X$1230 \$90__t225 topn__t448 cap_mim_2f0_m4m5_noshield c_length=4U c_width=4U
* device instance $1231 r0 *1 262.4,158.5 cap_mim_2f0_m4m5_noshield
X$1231 \$107__t55 topn__t449 cap_mim_2f0_m4m5_noshield c_length=4U c_width=4U
* device instance $1232 r0 *1 268.8,158.5 cap_mim_2f0_m4m5_noshield
X$1232 \$90__t226 topn__t450 cap_mim_2f0_m4m5_noshield c_length=4U c_width=4U
* device instance $1233 r0 *1 275.2,158.5 cap_mim_2f0_m4m5_noshield
X$1233 \$107__t56 topn__t451 cap_mim_2f0_m4m5_noshield c_length=4U c_width=4U
* device instance $1234 r0 *1 281.6,158.5 cap_mim_2f0_m4m5_noshield
X$1234 \$90__t227 topn__t452 cap_mim_2f0_m4m5_noshield c_length=4U c_width=4U
* device instance $1235 r0 *1 288,158.5 cap_mim_2f0_m4m5_noshield
X$1235 \$107__t57 topn__t453 cap_mim_2f0_m4m5_noshield c_length=4U c_width=4U
* device instance $1236 r0 *1 294.4,158.5 cap_mim_2f0_m4m5_noshield
X$1236 \$90__t128 topn__t260 cap_mim_2f0_m4m5_noshield c_length=4U c_width=4U
* device instance $1237 r0 *1 300.8,158.5 cap_mim_2f0_m4m5_noshield
X$1237 \$107__t59 topn__t490 cap_mim_2f0_m4m5_noshield c_length=4U c_width=4U
* device instance $1238 r0 *1 307.2,158.5 cap_mim_2f0_m4m5_noshield
X$1238 \$90__t246 topn__t491 cap_mim_2f0_m4m5_noshield c_length=4U c_width=4U
* device instance $1239 r0 *1 313.6,158.5 cap_mim_2f0_m4m5_noshield
X$1239 \$107__t60 topn__t492 cap_mim_2f0_m4m5_noshield c_length=4U c_width=4U
* device instance $1240 r0 *1 320,158.5 cap_mim_2f0_m4m5_noshield
X$1240 \$90__t247 topn__t493 cap_mim_2f0_m4m5_noshield c_length=4U c_width=4U
* device instance $1241 r0 *1 326.4,158.5 cap_mim_2f0_m4m5_noshield
X$1241 \$107__t61 topn__t494 cap_mim_2f0_m4m5_noshield c_length=4U c_width=4U
* device instance $1242 r0 *1 332.8,158.5 cap_mim_2f0_m4m5_noshield
X$1242 \$90__t255 topn__t510 cap_mim_2f0_m4m5_noshield c_length=4U c_width=4U
* device instance $1243 r0 *1 339.2,158.5 cap_mim_2f0_m4m5_noshield
X$1243 \$107__t58 topn__t472 cap_mim_2f0_m4m5_noshield c_length=4U c_width=4U
* device instance $1244 r0 *1 345.6,158.5 cap_mim_2f0_m4m5_noshield
X$1244 \$90__t236 topn__t473 cap_mim_2f0_m4m5_noshield c_length=4U c_width=4U
* device instance $1245 r0 *1 352,158.5 cap_mim_2f0_m4m5_noshield
X$1245 \$107__t16 topn__t181 cap_mim_2f0_m4m5_noshield c_length=4U c_width=4U
* device instance $1246 r0 *1 358.4,158.5 cap_mim_2f0_m4m5_noshield
X$1246 \$90__t146 topn__t292 cap_mim_2f0_m4m5_noshield c_length=4U c_width=4U
* device instance $1247 r0 *1 364.8,158.5 cap_mim_2f0_m4m5_noshield
X$1247 \$107__t26 topn__t293 cap_mim_2f0_m4m5_noshield c_length=4U c_width=4U
* device instance $1248 r0 *1 371.2,158.5 cap_mim_2f0_m4m5_noshield
X$1248 \$90__t147 topn__t294 cap_mim_2f0_m4m5_noshield c_length=4U c_width=4U
* device instance $1249 r0 *1 377.6,158.5 cap_mim_2f0_m4m5_noshield
X$1249 \$107__t27 topn__t295 cap_mim_2f0_m4m5_noshield c_length=4U c_width=4U
* device instance $1250 r0 *1 384,158.5 cap_mim_2f0_m4m5_noshield
X$1250 \$90__t148 topn__t296 cap_mim_2f0_m4m5_noshield c_length=4U c_width=4U
* device instance $1251 r0 *1 390.4,158.5 cap_mim_2f0_m4m5_noshield
X$1251 \$107__t28 topn__t297 cap_mim_2f0_m4m5_noshield c_length=4U c_width=4U
* device instance $1252 r0 *1 396.8,158.5 cap_mim_2f0_m4m5_noshield
X$1252 \$90__t149 topn__t298 cap_mim_2f0_m4m5_noshield c_length=4U c_width=4U
* device instance $1253 r0 *1 403.2,158.5 cap_mim_2f0_m4m5_noshield
X$1253 \$107__t29 topn__t299 cap_mim_2f0_m4m5_noshield c_length=4U c_width=4U
* device instance $1254 r0 *1 409.6,158.5 cap_mim_2f0_m4m5_noshield
X$1254 \$90__t150 topn__t300 cap_mim_2f0_m4m5_noshield c_length=4U c_width=4U
* device instance $1255 r0 *1 416,158.5 cap_mim_2f0_m4m5_noshield
X$1255 \$107__t30 topn__t301 cap_mim_2f0_m4m5_noshield c_length=4U c_width=4U
* device instance $1256 r0 *1 422.4,158.5 cap_mim_2f0_m4m5_noshield
X$1256 \$90__t151 topn__t302 cap_mim_2f0_m4m5_noshield c_length=4U c_width=4U
* device instance $1257 r0 *1 2.6,164.9 cap_mim_2f0_m4m5_noshield
X$1257 \$16__t0 topp__t1 cap_mim_2f0_m4m5_noshield c_length=4U c_width=4U
* device instance $1258 r0 *1 9,164.9 cap_mim_2f0_m4m5_noshield
X$1258 \$10__t25 topp__t47 cap_mim_2f0_m4m5_noshield c_length=4U c_width=4U
* device instance $1259 r0 *1 15.4,164.9 cap_mim_2f0_m4m5_noshield
X$1259 \$16__t7 topp__t62 cap_mim_2f0_m4m5_noshield c_length=4U c_width=4U
* device instance $1260 r0 *1 21.8,164.9 cap_mim_2f0_m4m5_noshield
X$1260 \$10__t32 topp__t61 cap_mim_2f0_m4m5_noshield c_length=4U c_width=4U
* device instance $1261 r0 *1 28.2,164.9 cap_mim_2f0_m4m5_noshield
X$1261 \$16__t6 topp__t60 cap_mim_2f0_m4m5_noshield c_length=4U c_width=4U
* device instance $1262 r0 *1 34.6,164.9 cap_mim_2f0_m4m5_noshield
X$1262 \$10__t31 topp__t59 cap_mim_2f0_m4m5_noshield c_length=4U c_width=4U
* device instance $1263 r0 *1 41,164.9 cap_mim_2f0_m4m5_noshield
X$1263 \$16__t5 topp__t58 cap_mim_2f0_m4m5_noshield c_length=4U c_width=4U
* device instance $1264 r0 *1 47.4,164.9 cap_mim_2f0_m4m5_noshield
X$1264 \$10__t30 topp__t57 cap_mim_2f0_m4m5_noshield c_length=4U c_width=4U
* device instance $1265 r0 *1 53.8,164.9 cap_mim_2f0_m4m5_noshield
X$1265 \$16__t4 topp__t56 cap_mim_2f0_m4m5_noshield c_length=4U c_width=4U
* device instance $1266 r0 *1 60.2,164.9 cap_mim_2f0_m4m5_noshield
X$1266 \$10__t48 topp__t92 cap_mim_2f0_m4m5_noshield c_length=4U c_width=4U
* device instance $1267 r0 *1 66.6,164.9 cap_mim_2f0_m4m5_noshield
X$1267 \$16__t3 topp__t31 cap_mim_2f0_m4m5_noshield c_length=4U c_width=4U
* device instance $1268 r0 *1 73,164.9 cap_mim_2f0_m4m5_noshield
X$1268 \$10__t9 topp__t15 cap_mim_2f0_m4m5_noshield c_length=4U c_width=4U
* device instance $1269 r0 *1 79.4,164.9 cap_mim_2f0_m4m5_noshield
X$1269 \$16__t2 topp__t14 cap_mim_2f0_m4m5_noshield c_length=4U c_width=4U
* device instance $1270 r0 *1 85.8,164.9 cap_mim_2f0_m4m5_noshield
X$1270 \$10__t8 topp__t13 cap_mim_2f0_m4m5_noshield c_length=4U c_width=4U
* device instance $1271 r0 *1 92.2,164.9 cap_mim_2f0_m4m5_noshield
X$1271 \$16__t1 topp__t12 cap_mim_2f0_m4m5_noshield c_length=4U c_width=4U
* device instance $1272 r0 *1 98.6,164.9 cap_mim_2f0_m4m5_noshield
X$1272 \$10__t7 topp__t11 cap_mim_2f0_m4m5_noshield c_length=4U c_width=4U
* device instance $1273 r0 *1 105,164.9 cap_mim_2f0_m4m5_noshield
X$1273 \$18__t0 topp__t10 cap_mim_2f0_m4m5_noshield c_length=4U c_width=4U
* device instance $1274 r0 *1 111.4,164.9 cap_mim_2f0_m4m5_noshield
X$1274 \$10__t6 topp__t9 cap_mim_2f0_m4m5_noshield c_length=4U c_width=4U
* device instance $1275 r0 *1 117.8,164.9 cap_mim_2f0_m4m5_noshield
X$1275 \$18__t8 topp__t268 cap_mim_2f0_m4m5_noshield c_length=4U c_width=4U
* device instance $1276 r0 *1 124.2,164.9 cap_mim_2f0_m4m5_noshield
X$1276 \$10__t37 topp__t72 cap_mim_2f0_m4m5_noshield c_length=4U c_width=4U
* device instance $1277 r0 *1 130.6,164.9 cap_mim_2f0_m4m5_noshield
X$1277 \$18__t2 topp__t71 cap_mim_2f0_m4m5_noshield c_length=4U c_width=4U
* device instance $1278 r0 *1 137,164.9 cap_mim_2f0_m4m5_noshield
X$1278 \$10__t36 topp__t70 cap_mim_2f0_m4m5_noshield c_length=4U c_width=4U
* device instance $1279 r0 *1 143.4,164.9 cap_mim_2f0_m4m5_noshield
X$1279 \$18__t1 topp__t69 cap_mim_2f0_m4m5_noshield c_length=4U c_width=4U
* device instance $1280 r0 *1 149.8,164.9 cap_mim_2f0_m4m5_noshield
X$1280 \$10__t35 topp__t68 cap_mim_2f0_m4m5_noshield c_length=4U c_width=4U
* device instance $1281 r0 *1 156.2,164.9 cap_mim_2f0_m4m5_noshield
X$1281 \$20__t1 topp__t67 cap_mim_2f0_m4m5_noshield c_length=4U c_width=4U
* device instance $1282 r0 *1 162.6,164.9 cap_mim_2f0_m4m5_noshield
X$1282 \$10__t34 topp__t66 cap_mim_2f0_m4m5_noshield c_length=4U c_width=4U
* device instance $1283 r0 *1 169,164.9 cap_mim_2f0_m4m5_noshield
X$1283 \$20__t0 topp__t65 cap_mim_2f0_m4m5_noshield c_length=4U c_width=4U
* device instance $1284 r0 *1 175.4,164.9 cap_mim_2f0_m4m5_noshield
X$1284 \$10__t33 topp__t64 cap_mim_2f0_m4m5_noshield c_length=4U c_width=4U
* device instance $1285 r0 *1 181.8,164.9 cap_mim_2f0_m4m5_noshield
X$1285 \$22__t0 topp__t107 cap_mim_2f0_m4m5_noshield c_length=4U c_width=4U
* device instance $1286 r0 *1 188.2,164.9 cap_mim_2f0_m4m5_noshield
X$1286 \$10__t60 topp__t118 cap_mim_2f0_m4m5_noshield c_length=4U c_width=4U
* device instance $1287 r0 *1 194.6,164.9 cap_mim_2f0_m4m5_noshield
X$1287 \$24__t0 topp__t117 cap_mim_2f0_m4m5_noshield c_length=4U c_width=4U
* device instance $1288 r0 *1 201,164.9 cap_mim_2f0_m4m5_noshield
X$1288 \$10__t59 topp__t116 cap_mim_2f0_m4m5_noshield c_length=4U c_width=4U
* device instance $1289 r0 *1 224,164.9 cap_mim_2f0_m4m5_noshield
X$1289 \$115__t0 topn__t8 cap_mim_2f0_m4m5_noshield c_length=4U c_width=4U
* device instance $1290 r0 *1 230.4,164.9 cap_mim_2f0_m4m5_noshield
X$1290 \$90__t3 topn__t7 cap_mim_2f0_m4m5_noshield c_length=4U c_width=4U
* device instance $1291 r0 *1 236.8,164.9 cap_mim_2f0_m4m5_noshield
X$1291 \$115__t25 topn__t462 cap_mim_2f0_m4m5_noshield c_length=4U c_width=4U
* device instance $1292 r0 *1 243.2,164.9 cap_mim_2f0_m4m5_noshield
X$1292 \$90__t232 topn__t463 cap_mim_2f0_m4m5_noshield c_length=4U c_width=4U
* device instance $1293 r0 *1 249.6,164.9 cap_mim_2f0_m4m5_noshield
X$1293 \$115__t26 topn__t464 cap_mim_2f0_m4m5_noshield c_length=4U c_width=4U
* device instance $1294 r0 *1 256,164.9 cap_mim_2f0_m4m5_noshield
X$1294 \$90__t248 topn__t495 cap_mim_2f0_m4m5_noshield c_length=4U c_width=4U
* device instance $1295 r0 *1 262.4,164.9 cap_mim_2f0_m4m5_noshield
X$1295 \$115__t29 topn__t496 cap_mim_2f0_m4m5_noshield c_length=4U c_width=4U
* device instance $1296 r0 *1 268.8,164.9 cap_mim_2f0_m4m5_noshield
X$1296 \$90__t249 topn__t497 cap_mim_2f0_m4m5_noshield c_length=4U c_width=4U
* device instance $1297 r0 *1 275.2,164.9 cap_mim_2f0_m4m5_noshield
X$1297 \$115__t30 topn__t498 cap_mim_2f0_m4m5_noshield c_length=4U c_width=4U
* device instance $1298 r0 *1 281.6,164.9 cap_mim_2f0_m4m5_noshield
X$1298 \$90__t250 topn__t499 cap_mim_2f0_m4m5_noshield c_length=4U c_width=4U
* device instance $1299 r0 *1 288,164.9 cap_mim_2f0_m4m5_noshield
X$1299 \$115__t31 topn__t500 cap_mim_2f0_m4m5_noshield c_length=4U c_width=4U
* device instance $1300 r0 *1 294.4,164.9 cap_mim_2f0_m4m5_noshield
X$1300 \$90__t129 topn__t261 cap_mim_2f0_m4m5_noshield c_length=4U c_width=4U
* device instance $1301 r0 *1 300.8,164.9 cap_mim_2f0_m4m5_noshield
X$1301 \$115__t27 topn__t475 cap_mim_2f0_m4m5_noshield c_length=4U c_width=4U
* device instance $1302 r0 *1 307.2,164.9 cap_mim_2f0_m4m5_noshield
X$1302 \$90__t237 topn__t476 cap_mim_2f0_m4m5_noshield c_length=4U c_width=4U
* device instance $1303 r0 *1 313.6,164.9 cap_mim_2f0_m4m5_noshield
X$1303 \$115__t28 topn__t477 cap_mim_2f0_m4m5_noshield c_length=4U c_width=4U
* device instance $1304 r0 *1 320,164.9 cap_mim_2f0_m4m5_noshield
X$1304 \$90__t238 topn__t478 cap_mim_2f0_m4m5_noshield c_length=4U c_width=4U
* device instance $1305 r0 *1 326.4,164.9 cap_mim_2f0_m4m5_noshield
X$1305 \$123__t14 topn__t479 cap_mim_2f0_m4m5_noshield c_length=4U c_width=4U
* device instance $1306 r0 *1 332.8,164.9 cap_mim_2f0_m4m5_noshield
X$1306 \$90__t239 topn__t480 cap_mim_2f0_m4m5_noshield c_length=4U c_width=4U
* device instance $1307 r0 *1 339.2,164.9 cap_mim_2f0_m4m5_noshield
X$1307 \$123__t15 topn__t481 cap_mim_2f0_m4m5_noshield c_length=4U c_width=4U
* device instance $1308 r0 *1 345.6,164.9 cap_mim_2f0_m4m5_noshield
X$1308 \$90__t240 topn__t482 cap_mim_2f0_m4m5_noshield c_length=4U c_width=4U
* device instance $1309 r0 *1 352,164.9 cap_mim_2f0_m4m5_noshield
X$1309 \$123__t6 topn__t182 cap_mim_2f0_m4m5_noshield c_length=4U c_width=4U
* device instance $1310 r0 *1 358.4,164.9 cap_mim_2f0_m4m5_noshield
X$1310 \$90__t152 topn__t304 cap_mim_2f0_m4m5_noshield c_length=4U c_width=4U
* device instance $1311 r0 *1 364.8,164.9 cap_mim_2f0_m4m5_noshield
X$1311 \$123__t8 topn__t289 cap_mim_2f0_m4m5_noshield c_length=4U c_width=4U
* device instance $1312 r0 *1 371.2,164.9 cap_mim_2f0_m4m5_noshield
X$1312 \$90__t119 topn__t242 cap_mim_2f0_m4m5_noshield c_length=4U c_width=4U
* device instance $1313 r0 *1 377.6,164.9 cap_mim_2f0_m4m5_noshield
X$1313 \$131__t4 topn__t243 cap_mim_2f0_m4m5_noshield c_length=4U c_width=4U
* device instance $1314 r0 *1 384,164.9 cap_mim_2f0_m4m5_noshield
X$1314 \$90__t120 topn__t244 cap_mim_2f0_m4m5_noshield c_length=4U c_width=4U
* device instance $1315 r0 *1 390.4,164.9 cap_mim_2f0_m4m5_noshield
X$1315 \$131__t5 topn__t245 cap_mim_2f0_m4m5_noshield c_length=4U c_width=4U
* device instance $1316 r0 *1 396.8,164.9 cap_mim_2f0_m4m5_noshield
X$1316 \$90__t121 topn__t246 cap_mim_2f0_m4m5_noshield c_length=4U c_width=4U
* device instance $1317 r0 *1 403.2,164.9 cap_mim_2f0_m4m5_noshield
X$1317 \$139__t2 topn__t247 cap_mim_2f0_m4m5_noshield c_length=4U c_width=4U
* device instance $1318 r0 *1 409.6,164.9 cap_mim_2f0_m4m5_noshield
X$1318 \$90__t122 topn__t248 cap_mim_2f0_m4m5_noshield c_length=4U c_width=4U
* device instance $1319 r0 *1 416,164.9 cap_mim_2f0_m4m5_noshield
X$1319 \$147__t0 topn__t249 cap_mim_2f0_m4m5_noshield c_length=4U c_width=4U
* device instance $1320 r0 *1 422.4,164.9 cap_mim_2f0_m4m5_noshield
X$1320 \$90__t123 topn__t250 cap_mim_2f0_m4m5_noshield c_length=4U c_width=4U
* device instance _10_t0 r0 *1 0,0
R_10_t0 \$10__t0 \$10 19.5106825
* device instance _10_t1 r0 *1 0,0
R_10_t1 \$10__t1 \$10 16.9862165008
* device instance _10_t2 r0 *1 0,0
R_10_t2 \$10__t2 \$10 14.2083765858
* device instance _10_t3 r0 *1 0,0
R_10_t3 \$10__t3 \$10 12.1977668443
* device instance _10_t4 r0 *1 0,0
R_10_t4 \$10__t4 \$10 5.41310121116
* device instance _10_t5 r0 *1 0,0
R_10_t5 \$10__t5 \$10 5.74849640488
* device instance _10_t6 r0 *1 0,0
R_10_t6 \$10__t6 \$10 7.39750497131
* device instance _10_t7 r0 *1 0,0
R_10_t7 \$10__t7 \$10 7.21099538127
* device instance _10_t8 r0 *1 0,0
R_10_t8 \$10__t8 \$10 7.46605656176
* device instance _10_t9 r0 *1 0,0
R_10_t9 \$10__t9 \$10 8.12118946858
* device instance _10_t10 r0 *1 0,0
R_10_t10 \$10__t10 \$10 6.52427494182
* device instance _10_t11 r0 *1 0,0
R_10_t11 \$10__t11 \$10 6.31201537583
* device instance _10_t12 r0 *1 0,0
R_10_t12 \$10__t12 \$10 6.60190005221
* device instance _10_t13 r0 *1 0,0
R_10_t13 \$10__t13 \$10 7.33463033155
* device instance _10_t14 r0 *1 0,0
R_10_t14 \$10__t14 \$10 6.57699997857
* device instance _10_t15 r0 *1 0,0
R_10_t15 \$10__t15 \$10 5.65917751392
* device instance _10_t16 r0 *1 0,0
R_10_t16 \$10__t16 \$10 4.80660583502
* device instance _10_t17 r0 *1 0,0
R_10_t17 \$10__t17 \$10 12.3703138357
* device instance _10_t18 r0 *1 0,0
R_10_t18 \$10__t18 \$10 14.1000470223
* device instance _10_t19 r0 *1 0,0
R_10_t19 \$10__t19 \$10 13.8968550886
* device instance _10_t20 r0 *1 0,0
R_10_t20 \$10__t20 \$10 6.98462342896
* device instance _10_t21 r0 *1 0,0
R_10_t21 \$10__t21 \$10 8.66989684263
* device instance _10_t22 r0 *1 0,0
R_10_t22 \$10__t22 \$10 10.3931433977
* device instance _10_t23 r0 *1 0,0
R_10_t23 \$10__t23 \$10 13.8325012858
* device instance _10_t24 r0 *1 0,0
R_10_t24 \$10__t24 \$10 9.11509073679
* device instance _10_t25 r0 *1 0,0
R_10_t25 \$10__t25 \$10 14.6299310144
* device instance _10_t26 r0 *1 0,0
R_10_t26 \$10__t26 \$10 10.6160779839
* device instance _10_t27 r0 *1 0,0
R_10_t27 \$10__t27 \$10 9.67598845195
* device instance _10_t28 r0 *1 0,0
R_10_t28 \$10__t28 \$10 11.1013956394
* device instance _10_t29 r0 *1 0,0
R_10_t29 \$10__t29 \$10 12.6224161463
* device instance _10_t30 r0 *1 0,0
R_10_t30 \$10__t30 \$10 10.2850215754
* device instance _10_t31 r0 *1 0,0
R_10_t31 \$10__t31 \$10 11.6360603912
* device instance _10_t32 r0 *1 0,0
R_10_t32 \$10__t32 \$10 13.095125263
* device instance _10_t33 r0 *1 0,0
R_10_t33 \$10__t33 \$10 12.859579346
* device instance _10_t34 r0 *1 0,0
R_10_t34 \$10__t34 \$10 11.4150469781
* device instance _10_t35 r0 *1 0,0
R_10_t35 \$10__t35 \$10 10.0849385558
* device instance _10_t36 r0 *1 0,0
R_10_t36 \$10__t36 \$10 8.92058548771
* device instance _10_t37 r0 *1 0,0
R_10_t37 \$10__t37 \$10 7.99474057233
* device instance _10_t38 r0 *1 0,0
R_10_t38 \$10__t38 \$10 11.8622482956
* device instance _10_t39 r0 *1 0,0
R_10_t39 \$10__t39 \$10 15.5803512919
* device instance _10_t40 r0 *1 0,0
R_10_t40 \$10__t40 \$10 12.3778780359
* device instance _10_t41 r0 *1 0,0
R_10_t41 \$10__t41 \$10 10.8695161451
* device instance _10_t42 r0 *1 0,0
R_10_t42 \$10__t42 \$10 9.46303700673
* device instance _10_t43 r0 *1 0,0
R_10_t43 \$10__t43 \$10 8.21096396043
* device instance _10_t44 r0 *1 0,0
R_10_t44 \$10__t44 \$10 7.19437005823
* device instance _10_t45 r0 *1 0,0
R_10_t45 \$10__t45 \$10 10.1199488823
* device instance _10_t46 r0 *1 0,0
R_10_t46 \$10__t46 \$10 15.2383553246
* device instance _10_t47 r0 *1 0,0
R_10_t47 \$10__t47 \$10 13.9551252135
* device instance _10_t48 r0 *1 0,0
R_10_t48 \$10__t48 \$10 9.09030295382
* device instance _10_t49 r0 *1 0,0
R_10_t49 \$10__t49 \$10 4.51429221933
* device instance _10_t50 r0 *1 0,0
R_10_t50 \$10__t50 \$10 4.91145400428
* device instance _10_t51 r0 *1 0,0
R_10_t51 \$10__t51 \$10 5.85953054752
* device instance _10_t52 r0 *1 0,0
R_10_t52 \$10__t52 \$10 7.14240769243
* device instance _10_t53 r0 *1 0,0
R_10_t53 \$10__t53 \$10 8.61173900319
* device instance _10_t54 r0 *1 0,0
R_10_t54 \$10__t54 \$10 10.1871625726
* device instance _10_t55 r0 *1 0,0
R_10_t55 \$10__t55 \$10 11.8263555463
* device instance _10_t56 r0 *1 0,0
R_10_t56 \$10__t56 \$10 8.39503969664
* device instance _10_t57 r0 *1 0,0
R_10_t57 \$10__t57 \$10 7.74188724574
* device instance _10_t58 r0 *1 0,0
R_10_t58 \$10__t58 \$10 13.619129028
* device instance _10_t59 r0 *1 0,0
R_10_t59 \$10__t59 \$10 15.965721489
* device instance _10_t60 r0 *1 0,0
R_10_t60 \$10__t60 \$10 14.3841035872
* device instance _10_t61 r0 *1 0,0
R_10_t61 \$10__t61 \$10 13.5061194034
* device instance _10_t62 r0 *1 0,0
R_10_t62 \$10__t62 \$10 7.54847246393
* device instance _10_t63 r0 *1 0,0
R_10_t63 \$10__t63 \$10 9.30567940342
* device instance _10_t64 r0 *1 0,0
R_10_t64 \$10__t64 \$10 11.0761037096
* device instance _10_t65 r0 *1 0,0
R_10_t65 \$10__t65 \$10 10.652390257
* device instance _10_t66 r0 *1 0,0
R_10_t66 \$10__t66 \$10 14.0917908676
* device instance _10_t67 r0 *1 0,0
R_10_t67 \$10__t67 \$10 12.3609024031
* device instance _10_t68 r0 *1 0,0
R_10_t68 \$10__t68 \$10 7.36484575173
* device instance _10_t69 r0 *1 0,0
R_10_t69 \$10__t69 \$10 12.8542852473
* device instance _10_t70 r0 *1 0,0
R_10_t70 \$10__t70 \$10 10.6633097284
* device instance _10_t71 r0 *1 0,0
R_10_t71 \$10__t71 \$10 10.0742775937
* device instance _10_t72 r0 *1 0,0
R_10_t72 \$10__t72 \$10 7.3880286077
* device instance _10_t73 r0 *1 0,0
R_10_t73 \$10__t73 \$10 9.17601216917
* device instance _10_t74 r0 *1 0,0
R_10_t74 \$10__t74 \$10 10.967388183
* device instance _10_t75 r0 *1 0,0
R_10_t75 \$10__t75 \$10 12.7607280117
* device instance _10_t76 r0 *1 0,0
R_10_t76 \$10__t76 \$10 10.9317965873
* device instance _10_t77 r0 *1 0,0
R_10_t77 \$10__t77 \$10 12.7301513133
* device instance _10_t78 r0 *1 0,0
R_10_t78 \$10__t78 \$10 2.63434400105
* device instance _10_t79 r0 *1 0,0
R_10_t79 \$10__t79 \$10 3.30957414904
* device instance _10_t80 r0 *1 0,0
R_10_t80 \$10__t80 \$10 4.60054332108
* device instance _10_t81 r0 *1 0,0
R_10_t81 \$10__t81 \$10 4.56959233756
* device instance _10_t82 r0 *1 0,0
R_10_t82 \$10__t82 \$10 2.68509494307
* device instance _10_t83 r0 *1 0,0
R_10_t83 \$10__t83 \$10 3.65979258185
* device instance _10_t84 r0 *1 0,0
R_10_t84 \$10__t84 \$10 3.72874538332
* device instance _10_t85 r0 *1 0,0
R_10_t85 \$10__t85 \$10 3.15188201954
* device instance _10_t86 r0 *1 0,0
R_10_t86 \$10__t86 \$10 4.14143527258
* device instance _10_t87 r0 *1 0,0
R_10_t87 \$10__t87 \$10 5.85892291602
* device instance _10_t88 r0 *1 0,0
R_10_t88 \$10__t88 \$10 7.80979828618
* device instance _10_t89 r0 *1 0,0
R_10_t89 \$10__t89 \$10 9.51888553831
* device instance _10_t90 r0 *1 0,0
R_10_t90 \$10__t90 \$10 11.2558245419
* device instance _10_t91 r0 *1 0,0
R_10_t91 \$10__t91 \$10 13.0094643223
* device instance _10_t92 r0 *1 0,0
R_10_t92 \$10__t92 \$10 8.97903668353
* device instance _10_t93 r0 *1 0,0
R_10_t93 \$10__t93 \$10 1.87733260304
* device instance _10_t94 r0 *1 0,0
R_10_t94 \$10__t94 \$10 6.1518199142
* device instance _10_t95 r0 *1 0,0
R_10_t95 \$10__t95 \$10 5.81647449273
* device instance _10_t96 r0 *1 0,0
R_10_t96 \$10__t96 \$10 5.60668401946
* device instance _10_t97 r0 *1 0,0
R_10_t97 \$10__t97 \$10 5.536739001
* device instance _10_t98 r0 *1 0,0
R_10_t98 \$10__t98 \$10 3.69145471561
* device instance _10_t99 r0 *1 0,0
R_10_t99 \$10__t99 \$10 3.75982689878
* device instance _10_t100 r0 *1 0,0
R_10_t100 \$10__t100 \$10 4.59498969604
* device instance _10_t101 r0 *1 0,0
R_10_t101 \$10__t101 \$10 2.81746219847
* device instance _10_t102 r0 *1 0,0
R_10_t102 \$10__t102 \$10 3.92749100943
* device instance _10_t103 r0 *1 0,0
R_10_t103 \$10__t103 \$10 2.90646755207
* device instance _10_t104 r0 *1 0,0
R_10_t104 \$10__t104 \$10 5.37317310661
* device instance _10_t105 r0 *1 0,0
R_10_t105 \$10__t105 \$10 12.1382008434
* device instance _10_t106 r0 *1 0,0
R_10_t106 \$10__t106 \$10 7.38063067238
* device instance _10_t107 r0 *1 0,0
R_10_t107 \$10__t107 \$10 8.99198843078
* device instance _10_t108 r0 *1 0,0
R_10_t108 \$10__t108 \$10 5.87875275132
* device instance _10_t109 r0 *1 0,0
R_10_t109 \$10__t109 \$10 11.8663203676
* device instance _10_t110 r0 *1 0,0
R_10_t110 \$10__t110 \$10 7.33508962313
* device instance _10_t111 r0 *1 0,0
R_10_t111 \$10__t111 \$10 9.13344252732
* device instance _10_t112 r0 *1 0,0
R_10_t112 \$10__t112 \$10 13.6600227197
* device instance _10_t113 r0 *1 0,0
R_10_t113 \$10__t113 \$10 6.50066179663
* device instance _10_t114 r0 *1 0,0
R_10_t114 \$10__t114 \$10 8.28497137059
* device instance _10_t115 r0 *1 0,0
R_10_t115 \$10__t115 \$10 0.894288706535
* device instance _10_t116 r0 *1 0,0
R_10_t116 \$10__t116 \$10 2.13150146266
* device instance _10_t117 r0 *1 0,0
R_10_t117 \$10__t117 \$10 1.9400699875
* device instance _10_t118 r0 *1 0,0
R_10_t118 \$10__t118 \$10 3.84122588329
* device instance _10_t119 r0 *1 0,0
R_10_t119 \$10__t119 \$10 3.7383939543
* device instance _10_t120 r0 *1 0,0
R_10_t120 \$10__t120 \$10 1.18816353653
* device instance _10_t121 r0 *1 0,0
R_10_t121 \$10__t121 \$10 1.38607105914
* device instance _10_t122 r0 *1 0,0
R_10_t122 \$10__t122 \$10 2.98308983755
* device instance _10_t123 r0 *1 0,0
R_10_t123 \$10__t123 \$10 4.72701053344
* device instance _10_t124 r0 *1 0,0
R_10_t124 \$10__t124 \$10 1.65678929666
* device instance _10_t125 r0 *1 0,0
R_10_t125 \$10__t125 \$10 0.142567042932
* device instance _10_t126 r0 *1 0,0
R_10_t126 \$10__t126 \$10 13.8264030087
* device instance _10_t127 r0 *1 0,0
R_10_t127 \$10__t127 \$10 12.0996561647
* device instance _10_t128 r0 *1 0,0
R_10_t128 \$10__t128 \$10 10.3972164572
* device instance _10_t129 r0 *1 0,0
R_10_t129 \$10__t129 \$10 8.73331050727
* device instance _10_t130 r0 *1 0,0
R_10_t130 \$10__t130 \$10 7.13494823961
* device instance _10_t131 r0 *1 0,0
R_10_t131 \$10__t131 \$10 5.65795298265
* device instance _10_t132 r0 *1 0,0
R_10_t132 \$10__t132 \$10 5.13066148526
* device instance _10_t133 r0 *1 0,0
R_10_t133 \$10__t133 \$10 11.9693031518
* device instance _10_t134 r0 *1 0,0
R_10_t134 \$10__t134 \$10 13.7495774327
* device instance _10_t135 r0 *1 0,0
R_10_t135 \$10__t135 \$10 2.71485612962
* device instance _10_t136 r0 *1 0,0
R_10_t136 \$10__t136 \$10 4.39918094163
* device instance _10_t137 r0 *1 0,0
R_10_t137 \$10__t137 \$10 4.42555636417
* device instance _10_t138 r0 *1 0,0
R_10_t138 \$10__t138 \$10 3.72784179584
* device instance _10_t139 r0 *1 0,0
R_10_t139 \$10__t139 \$10 10.1953777718
* device instance _10_t140 r0 *1 0,0
R_10_t140 \$10__t140 \$10 13.5722380741
* device instance _10_t141 r0 *1 0,0
R_10_t141 \$10__t141 \$10 11.9445381363
* device instance _10_t142 r0 *1 0,0
R_10_t142 \$10__t142 \$10 10.3733556695
* device instance _10_t143 r0 *1 0,0
R_10_t143 \$10__t143 \$10 8.88871171814
* device instance _10_t144 r0 *1 0,0
R_10_t144 \$10__t144 \$10 7.54188675181
* device instance _10_t145 r0 *1 0,0
R_10_t145 \$10__t145 \$10 6.42020927637
* device instance _10_t146 r0 *1 0,0
R_10_t146 \$10__t146 \$10 8.40130750174
* device instance _10_t147 r0 *1 0,0
R_10_t147 \$10__t147 \$10 6.72448821133
* device instance _10_t148 r0 *1 0,0
R_10_t148 \$10__t148 \$10 14.9427120201
* device instance _10_t149 r0 *1 0,0
R_10_t149 \$10__t149 \$10 13.2394416748
* device instance _10_t150 r0 *1 0,0
R_10_t150 \$10__t150 \$10 11.5649972248
* device instance _10_t151 r0 *1 0,0
R_10_t151 \$10__t151 \$10 9.93396584276
* device instance _10_t152 r0 *1 0,0
R_10_t152 \$10__t152 \$10 8.37176000178
* device instance _10_t153 r0 *1 0,0
R_10_t153 \$10__t153 \$10 6.92511554389
* device instance _10_t154 r0 *1 0,0
R_10_t154 \$10__t154 \$10 5.68297955931
* device instance _10_t155 r0 *1 0,0
R_10_t155 \$10__t155 \$10 13.468814859
* device instance _10_t156 r0 *1 0,0
R_10_t156 \$10__t156 \$10 11.689364091
* device instance _10_t157 r0 *1 0,0
R_10_t157 \$10__t157 \$10 9.91673654
* device instance _10_t158 r0 *1 0,0
R_10_t158 \$10__t158 \$10 8.15538263742
* device instance _10_t159 r0 *1 0,0
R_10_t159 \$10__t159 \$10 6.41459585074
* device instance _10_t160 r0 *1 0,0
R_10_t160 \$10__t160 \$10 4.71720102395
* device instance _10_t161 r0 *1 0,0
R_10_t161 \$10__t161 \$10 8.43180938386
* device instance _10_t162 r0 *1 0,0
R_10_t162 \$10__t162 \$10 6.68679763927
* device instance _10_t163 r0 *1 0,0
R_10_t163 \$10__t163 \$10 3.13450198259
* device instance _10_t164 r0 *1 0,0
R_10_t164 \$10__t164 \$10 4.97988829771
* device instance _10_t165 r0 *1 0,0
R_10_t165 \$10__t165 \$10 3.36949311518
* device instance _10_t166 r0 *1 0,0
R_10_t166 \$10__t166 \$10 2.09185368879
* device instance _10_t167 r0 *1 0,0
R_10_t167 \$10__t167 \$10 1.96631418239
* device instance _10_t168 r0 *1 0,0
R_10_t168 \$10__t168 \$10 14.3466431053
* device instance _10_t169 r0 *1 0,0
R_10_t169 \$10__t169 \$10 12.6506721858
* device instance _10_t170 r0 *1 0,0
R_10_t170 \$10__t170 \$10 10.987311624
* device instance _10_t171 r0 *1 0,0
R_10_t171 \$10__t171 \$10 9.3739371824
* device instance _10_t172 r0 *1 0,0
R_10_t172 \$10__t172 \$10 7.84146360587
* device instance _10_t173 r0 *1 0,0
R_10_t173 \$10__t173 \$10 6.44783500652
* device instance _10_t174 r0 *1 0,0
R_10_t174 \$10__t174 \$10 5.30365653742
* device instance _10_t175 r0 *1 0,0
R_10_t175 \$10__t175 \$10 4.59903692842
* device instance _10_t176 r0 *1 0,0
R_10_t176 \$10__t176 \$10 4.54331159811
* device instance _10_t177 r0 *1 0,0
R_10_t177 \$10__t177 \$10 5.15755673673
* device instance _10_t178 r0 *1 0,0
R_10_t178 \$10__t178 \$10 6.24718130952
* device instance _10_t179 r0 *1 0,0
R_10_t179 \$10__t179 \$10 7.61067202959
* device instance _10_t180 r0 *1 0,0
R_10_t180 \$10__t180 \$10 9.12609197721
* device instance _10_t181 r0 *1 0,0
R_10_t181 \$10__t181 \$10 10.7292568437
* device instance _10_t182 r0 *1 0,0
R_10_t182 \$10__t182 \$10 12.3861423238
* device instance _10_t183 r0 *1 0,0
R_10_t183 \$10__t183 \$10 14.0777932404
* device instance _10_t184 r0 *1 0,0
R_10_t184 \$10__t184 \$10 12.4468593219
* device instance _10_t185 r0 *1 0,0
R_10_t185 \$10__t185 \$10 10.6485046805
* device instance _10_t186 r0 *1 0,0
R_10_t186 \$10__t186 \$10 8.8501507606
* device instance _10_t187 r0 *1 0,0
R_10_t187 \$10__t187 \$10 7.0517981145
* device instance _10_t188 r0 *1 0,0
R_10_t188 \$10__t188 \$10 5.25344805024
* device instance _10_t189 r0 *1 0,0
R_10_t189 \$10__t189 \$10 3.45510459925
* device instance _10_t190 r0 *1 0,0
R_10_t190 \$10__t190 \$10 9.24740925757
* device instance _10_t191 r0 *1 0,0
R_10_t191 \$10__t191 \$10 7.54435326183
* device instance _10_t192 r0 *1 0,0
R_10_t192 \$10__t192 \$10 13.8179833544
* device instance _10_t193 r0 *1 0,0
R_10_t193 \$10__t193 \$10 12.0900340417
* device instance _10_t194 r0 *1 0,0
R_10_t194 \$10__t194 \$10 10.386017229
* device instance _10_t195 r0 *1 0,0
R_10_t195 \$10__t195 \$10 14.3562540517
* device instance _10_t196 r0 *1 0,0
R_10_t196 \$10__t196 \$10 12.573790349
* device instance _10_t197 r0 *1 0,0
R_10_t197 \$10__t197 \$10 5.9552525496
* device instance _10_t198 r0 *1 0,0
R_10_t198 \$10__t198 \$10 6.77840078987
* device instance _10_t199 r0 *1 0,0
R_10_t199 \$10__t199 \$10 5.6373465193
* device instance _10_t200 r0 *1 0,0
R_10_t200 \$10__t200 \$10 10.7965989408
* device instance _10_t201 r0 *1 0,0
R_10_t201 \$10__t201 \$10 9.0277940409
* device instance _10_t202 r0 *1 0,0
R_10_t202 \$10__t202 \$10 7.27349664241
* device instance _10_t203 r0 *1 0,0
R_10_t203 \$10__t203 \$10 13.3773807164
* device instance _10_t204 r0 *1 0,0
R_10_t204 \$10__t204 \$10 11.583892868
* device instance _10_t205 r0 *1 0,0
R_10_t205 \$10__t205 \$10 8.00347468844
* device instance _10_t206 r0 *1 0,0
R_10_t206 \$10__t206 \$10 6.22032001219
* device instance _10_t207 r0 *1 0,0
R_10_t207 \$10__t207 \$10 4.44941868406
* device instance _10_t208 r0 *1 0,0
R_10_t208 \$10__t208 \$10 4.37346056154
* device instance _10_t209 r0 *1 0,0
R_10_t209 \$10__t209 \$10 14.2452144118
* device instance _10_t210 r0 *1 0,0
R_10_t210 \$10__t210 \$10 2.43327917283
* device instance _10_t211 r0 *1 0,0
R_10_t211 \$10__t211 \$10 9.7921910076
* device instance _10_t212 r0 *1 0,0
R_10_t212 \$10__t212 \$10 14.4953628147
* device instance _10_t213 r0 *1 0,0
R_10_t213 \$10__t213 \$10 12.7323884826
* device instance _10_t214 r0 *1 0,0
R_10_t214 \$10__t214 \$10 10.9808952923
* device instance _10_t215 r0 *1 0,0
R_10_t215 \$10__t215 \$10 14.2725456933
* device instance _10_t216 r0 *1 0,0
R_10_t216 \$10__t216 \$10 12.4781302249
* device instance _10_t217 r0 *1 0,0
R_10_t217 \$10__t217 \$10 10.6850399559
* device instance _10_t218 r0 *1 0,0
R_10_t218 \$10__t218 \$10 7.11861856027
* device instance _10_t219 r0 *1 0,0
R_10_t219 \$10__t219 \$10 7.10684765396
* device instance _10_t220 r0 *1 0,0
R_10_t220 \$10__t220 \$10 5.32711397902
* device instance _10_t221 r0 *1 0,0
R_10_t221 \$10__t221 \$10 3.56611479354
* device instance _10_t222 r0 *1 0,0
R_10_t222 \$10__t222 \$10 5.89814597209
* device instance _10_t223 r0 *1 0,0
R_10_t223 \$10__t223 \$10 8.71997455507
* device instance _10_t224 r0 *1 0,0
R_10_t224 \$10__t224 \$10 5.54748710462
* device instance _10_t225 r0 *1 0,0
R_10_t225 \$10__t225 \$10 3.88762711062
* device instance _10_t226 r0 *1 0,0
R_10_t226 \$10__t226 \$10 8.89407642278
* device instance _10_t227 r0 *1 0,0
R_10_t227 \$10__t227 \$10 11.3835696581
* device instance _10_t228 r0 *1 0,0
R_10_t228 \$10__t228 \$10 12.9963128691
* device instance _10_t229 r0 *1 0,0
R_10_t229 \$10__t229 \$10 14.6523312079
* device instance _10_t230 r0 *1 0,0
R_10_t230 \$10__t230 \$10 1.78779812092
* device instance _10_t231 r0 *1 0,0
R_10_t231 \$10__t231 \$10 10.1307393882
* device instance _10_t232 r0 *1 0,0
R_10_t232 \$10__t232 \$10 8.79025907
* device instance _10_t233 r0 *1 0,0
R_10_t233 \$10__t233 \$10 7.64026178149
* device instance _10_t234 r0 *1 0,0
R_10_t234 \$10__t234 \$10 14.3891939995
* device instance _10_t235 r0 *1 0,0
R_10_t235 \$10__t235 \$10 12.7389624029
* device instance _10_t236 r0 *1 0,0
R_10_t236 \$10__t236 \$10 11.1347022347
* device instance _10_t237 r0 *1 0,0
R_10_t237 \$10__t237 \$10 9.59948937254
* device instance _10_t238 r0 *1 0,0
R_10_t238 \$10__t238 \$10 8.1723295442
* device instance _10_t239 r0 *1 0,0
R_10_t239 \$10__t239 \$10 6.92039852545
* device instance _10_t240 r0 *1 0,0
R_10_t240 \$10__t240 \$10 14.7489182076
* device instance _10_t241 r0 *1 0,0
R_10_t241 \$10__t241 \$10 13.1439281587
* device instance _10_t242 r0 *1 0,0
R_10_t242 \$10__t242 \$10 6.89021759036
* device instance _10_t243 r0 *1 0,0
R_10_t243 \$10__t243 \$10 7.80518430576
* device instance _10_t244 r0 *1 0,0
R_10_t244 \$10__t244 \$10 8.99082183439
* device instance _10_t245 r0 *1 0,0
R_10_t245 \$10__t245 \$10 10.3545653735
* device instance _10_t246 r0 *1 0,0
R_10_t246 \$10__t246 \$10 11.835004964
* device instance _10_t247 r0 *1 0,0
R_10_t247 \$10__t247 \$10 13.3934996371
* device instance _10_t248 r0 *1 0,0
R_10_t248 \$10__t248 \$10 15.0057487039
* device instance _10_t249 r0 *1 0,0
R_10_t249 \$10__t249 \$10 6.36376197265
* device instance _10_t250 r0 *1 0,0
R_10_t250 \$10__t250 \$10 9.83541253515
* device instance _10_t251 r0 *1 0,0
R_10_t251 \$10__t251 \$10 8.38768102154
* device instance _10_t252 r0 *1 0,0
R_10_t252 \$10__t252 \$10 7.10205728703
* device instance _10_t253 r0 *1 0,0
R_10_t253 \$10__t253 \$10 6.08222114888
* device instance _10_t254 r0 *1 0,0
R_10_t254 \$10__t254 \$10 5.4786660882
* device instance _10_t255 r0 *1 0,0
R_10_t255 \$10__t255 \$10 5.43197217542
* device instance _10_t256 r0 *1 0,0
R_10_t256 \$10__t256 \$10 11.5958302071
* device instance _10_t257 r0 *1 0,0
R_10_t257 \$10__t257 \$10 6.32360704449
* device instance _10_t258 r0 *1 0,0
R_10_t258 \$10__t258 \$10 16.5833858186
* device instance _10_t259 r0 *1 0,0
R_10_t259 \$10__t259 \$10 16.3932433974
* device instance _10_t260 r0 *1 0,0
R_10_t260 \$10__t260 \$10 16.7811320392
* device instance _10_t261 r0 *1 0,0
R_10_t261 \$10__t261 \$10 19.0167378578
* device instance _10_t262 r0 *1 0,0
R_10_t262 \$10__t262 \$10 19.2610435748
* device instance _10_t263 r0 *1 0,0
R_10_t263 \$10__t263 \$10 18.7779735089
* device instance _10 r0 *1 0,0
C_10 \$10 vsubs 5.63910403e-13
* device instance _100_t0 r0 *1 0,0
R_100_t0 \$100__t0 \$100 81.7777390336
* device instance _100_t1 r0 *1 0,0
R_100_t1 \$100__t1 \$100 21.4987692264
* device instance _100_t2 r0 *1 0,0
R_100_t2 \$100__t2 \$100 100.29899174
* device instance _100 r0 *1 0,0
C_100 \$100 vsubs 5.956568e-15
* device instance _102_t0 r0 *1 0,0
R_102_t0 \$102__t0 \$102 108.687402234
* device instance _102_t1 r0 *1 0,0
R_102_t1 \$102__t1 \$102 28.7964709909
* device instance _102_t2 r0 *1 0,0
R_102_t2 \$102__t2 \$102 133.512826775
* device instance _102 r0 *1 0,0
C_102 \$102 vsubs 6.487011e-15
* device instance _104_t0 r0 *1 0,0
R_104_t0 \$104__t0 \$104 135.591504929
* device instance _104_t1 r0 *1 0,0
R_104_t1 \$104__t1 \$104 36.2048686624
* device instance _104_t2 r0 *1 0,0
R_104_t2 \$104__t2 \$104 166.824926409
* device instance _104 r0 *1 0,0
C_104 \$104 vsubs 7.017453e-15
* device instance _106_t0 r0 *1 0,0
R_106_t0 \$106__t0 \$106 162.444438203
* device instance _106_t1 r0 *1 0,0
R_106_t1 \$106__t1 \$106 43.7126105743
* device instance _106_t2 r0 *1 0,0
R_106_t2 \$106__t2 \$106 200.179851222
* device instance _106 r0 *1 0,0
C_106 \$106 vsubs 7.547896e-15
* device instance _107_t0 r0 *1 0,0
R_107_t0 \$107__t0 \$107 0.332828513775
* device instance _107_t1 r0 *1 0,0
R_107_t1 \$107__t1 \$107 24.6244453911
* device instance _107_t2 r0 *1 0,0
R_107_t2 \$107__t2 \$107 10.4096455566
* device instance _107_t3 r0 *1 0,0
R_107_t3 \$107__t3 \$107 13.8299676671
* device instance _107_t4 r0 *1 0,0
R_107_t4 \$107__t4 \$107 17.2507181193
* device instance _107_t5 r0 *1 0,0
R_107_t5 \$107__t5 \$107 10.1276203079
* device instance _107_t6 r0 *1 0,0
R_107_t6 \$107__t6 \$107 6.70850719432
* device instance _107_t7 r0 *1 0,0
R_107_t7 \$107__t7 \$107 3.29415077816
* device instance _107_t8 r0 *1 0,0
R_107_t8 \$107__t8 \$107 6.9903805656
* device instance _107_t9 r0 *1 0,0
R_107_t9 \$107__t9 \$107 3.57520701319
* device instance _107_t10 r0 *1 0,0
R_107_t10 \$107__t10 \$107 30.65302794
* device instance _107_t11 r0 *1 0,0
R_107_t11 \$107__t11 \$107 27.231812062
* device instance _107_t12 r0 *1 0,0
R_107_t12 \$107__t12 \$107 23.8106497049
* device instance _107_t13 r0 *1 0,0
R_107_t13 \$107__t13 \$107 20.3895678095
* device instance _107_t14 r0 *1 0,0
R_107_t14 \$107__t14 \$107 16.9686150419
* device instance _107_t15 r0 *1 0,0
R_107_t15 \$107__t15 \$107 19.5645272339
* device instance _107_t16 r0 *1 0,0
R_107_t16 \$107__t16 \$107 19.0417983041
* device instance _107_t17 r0 *1 0,0
R_107_t17 \$107__t17 \$107 17.638948122
* device instance _107_t18 r0 *1 0,0
R_107_t18 \$107__t18 \$107 25.9726228288
* device instance _107_t19 r0 *1 0,0
R_107_t19 \$107__t19 \$107 29.3412282951
* device instance _107_t20 r0 *1 0,0
R_107_t20 \$107__t20 \$107 32.7207916167
* device instance _107_t21 r0 *1 0,0
R_107_t21 \$107__t21 \$107 33.551829647
* device instance _107_t22 r0 *1 0,0
R_107_t22 \$107__t22 \$107 30.2652068637
* device instance _107_t23 r0 *1 0,0
R_107_t23 \$107__t23 \$107 27.0120751747
* device instance _107_t24 r0 *1 0,0
R_107_t24 \$107__t24 \$107 23.8061682948
* device instance _107_t25 r0 *1 0,0
R_107_t25 \$107__t25 \$107 20.6694721127
* device instance _107_t26 r0 *1 0,0
R_107_t26 \$107__t26 \$107 21.6096894187
* device instance _107_t27 r0 *1 0,0
R_107_t27 \$107__t27 \$107 24.3880966004
* device instance _107_t28 r0 *1 0,0
R_107_t28 \$107__t28 \$107 27.3128508161
* device instance _107_t29 r0 *1 0,0
R_107_t29 \$107__t29 \$107 30.341660609
* device instance _107_t30 r0 *1 0,0
R_107_t30 \$107__t30 \$107 33.4462688834
* device instance _107_t31 r0 *1 0,0
R_107_t31 \$107__t31 \$107 17.8835268368
* device instance _107_t32 r0 *1 0,0
R_107_t32 \$107__t32 \$107 12.2138966922
* device instance _107_t33 r0 *1 0,0
R_107_t33 \$107__t33 \$107 10.1646761154
* device instance _107_t34 r0 *1 0,0
R_107_t34 \$107__t34 \$107 8.99299691725
* device instance _107_t35 r0 *1 0,0
R_107_t35 \$107__t35 \$107 9.04650935293
* device instance _107_t36 r0 *1 0,0
R_107_t36 \$107__t36 \$107 10.3061464325
* device instance _107_t37 r0 *1 0,0
R_107_t37 \$107__t37 \$107 12.4099138596
* device instance _107_t38 r0 *1 0,0
R_107_t38 \$107__t38 \$107 15.0069068969
* device instance _107_t39 r0 *1 0,0
R_107_t39 \$107__t39 \$107 14.7800503781
* device instance _107_t40 r0 *1 0,0
R_107_t40 \$107__t40 \$107 13.5478892202
* device instance _107_t41 r0 *1 0,0
R_107_t41 \$107__t41 \$107 16.2710006909
* device instance _107_t42 r0 *1 0,0
R_107_t42 \$107__t42 \$107 13.0434729261
* device instance _107_t43 r0 *1 0,0
R_107_t43 \$107__t43 \$107 9.94640102568
* device instance _107_t44 r0 *1 0,0
R_107_t44 \$107__t44 \$107 7.15133453632
* device instance _107_t45 r0 *1 0,0
R_107_t45 \$107__t45 \$107 5.07926421002
* device instance _107_t46 r0 *1 0,0
R_107_t46 \$107__t46 \$107 6.94590324533
* device instance _107_t47 r0 *1 0,0
R_107_t47 \$107__t47 \$107 9.70073212541
* device instance _107_t48 r0 *1 0,0
R_107_t48 \$107__t48 \$107 12.7818160111
* device instance _107_t49 r0 *1 0,0
R_107_t49 \$107__t49 \$107 16.0017943435
* device instance _107_t50 r0 *1 0,0
R_107_t50 \$107__t50 \$107 19.2912417635
* device instance _107_t51 r0 *1 0,0
R_107_t51 \$107__t51 \$107 22.6198713578
* device instance _107_t52 r0 *1 0,0
R_107_t52 \$107__t52 \$107 5.17341887286
* device instance _107_t53 r0 *1 0,0
R_107_t53 \$107__t53 \$107 20.6716842682
* device instance _107_t54 r0 *1 0,0
R_107_t54 \$107__t54 \$107 19.2435128292
* device instance _107_t55 r0 *1 0,0
R_107_t55 \$107__t55 \$107 16.9530381038
* device instance _107_t56 r0 *1 0,0
R_107_t56 \$107__t56 \$107 15.0966950286
* device instance _107_t57 r0 *1 0,0
R_107_t57 \$107__t57 \$107 13.8501583212
* device instance _107_t58 r0 *1 0,0
R_107_t58 \$107__t58 \$107 16.7813430164
* device instance _107_t59 r0 *1 0,0
R_107_t59 \$107__t59 \$107 13.3849002669
* device instance _107_t60 r0 *1 0,0
R_107_t60 \$107__t60 \$107 13.7802833673
* device instance _107_t61 r0 *1 0,0
R_107_t61 \$107__t61 \$107 14.9682613924
* device instance _107_t62 r0 *1 0,0
R_107_t62 \$107__t62 \$107 21.8319045428
* device instance _107_t63 r0 *1 0,0
R_107_t63 \$107__t63 \$107 20.9247651009
* device instance _107_t64 r0 *1 0,0
R_107_t64 \$107__t64 \$107 45.8307930391
* device instance _107_t65 r0 *1 0,0
R_107_t65 \$107__t65 \$107 46.5435577518
* device instance _107_t66 r0 *1 0,0
R_107_t66 \$107__t66 \$107 47.2581122934
* device instance _107_t67 r0 *1 0,0
R_107_t67 \$107__t67 \$107 47.9743766881
* device instance _107_t68 r0 *1 0,0
R_107_t68 \$107__t68 \$107 53.0596834863
* device instance _107_t69 r0 *1 0,0
R_107_t69 \$107__t69 \$107 52.3404371819
* device instance _107_t70 r0 *1 0,0
R_107_t70 \$107__t70 \$107 53.7803299606
* device instance _107_t71 r0 *1 0,0
R_107_t71 \$107__t71 \$107 54.5023210644
* device instance _107 r0 *1 0,0
C_107 \$107 vsubs 1.77118656e-13
* device instance _108_t0 r0 *1 0,0
R_108_t0 \$108__t0 \$108 81.7777390336
* device instance _108_t1 r0 *1 0,0
R_108_t1 \$108__t1 \$108 21.4987692264
* device instance _108_t2 r0 *1 0,0
R_108_t2 \$108__t2 \$108 100.29899174
* device instance _108 r0 *1 0,0
C_108 \$108 vsubs 5.956568e-15
* device instance _11_t0 r0 *1 0,0
R_11_t0 \$11__t0 \$11 162.444438203
* device instance _11_t1 r0 *1 0,0
R_11_t1 \$11__t1 \$11 43.7126105743
* device instance _11_t2 r0 *1 0,0
R_11_t2 \$11__t2 \$11 200.179851222
* device instance _11 r0 *1 0,0
C_11 \$11 vsubs 7.553404e-15
* device instance _110_t0 r0 *1 0,0
R_110_t0 \$110__t0 \$110 108.687402234
* device instance _110_t1 r0 *1 0,0
R_110_t1 \$110__t1 \$110 28.7964709909
* device instance _110_t2 r0 *1 0,0
R_110_t2 \$110__t2 \$110 133.512826775
* device instance _110 r0 *1 0,0
C_110 \$110 vsubs 6.487011e-15
* device instance _112_t0 r0 *1 0,0
R_112_t0 \$112__t0 \$112 135.591504929
* device instance _112_t1 r0 *1 0,0
R_112_t1 \$112__t1 \$112 36.2048686624
* device instance _112_t2 r0 *1 0,0
R_112_t2 \$112__t2 \$112 166.824926409
* device instance _112 r0 *1 0,0
C_112 \$112 vsubs 7.017453e-15
* device instance _114_t0 r0 *1 0,0
R_114_t0 \$114__t0 \$114 162.444438203
* device instance _114_t1 r0 *1 0,0
R_114_t1 \$114__t1 \$114 43.7126105743
* device instance _114_t2 r0 *1 0,0
R_114_t2 \$114__t2 \$114 200.179851222
* device instance _114 r0 *1 0,0
C_114 \$114 vsubs 7.547896e-15
* device instance _115_t0 r0 *1 0,0
R_115_t0 \$115__t0 \$115 40.6612251806
* device instance _115_t1 r0 *1 0,0
R_115_t1 \$115__t1 \$115 5.7338153314
* device instance _115_t2 r0 *1 0,0
R_115_t2 \$115__t2 \$115 9.48590969302
* device instance _115_t3 r0 *1 0,0
R_115_t3 \$115__t3 \$115 14.4367700653
* device instance _115_t4 r0 *1 0,0
R_115_t4 \$115__t4 \$115 10.1321743792
* device instance _115_t5 r0 *1 0,0
R_115_t5 \$115__t5 \$115 6.09120649544
* device instance _115_t6 r0 *1 0,0
R_115_t6 \$115__t6 \$115 23.9043832416
* device instance _115_t7 r0 *1 0,0
R_115_t7 \$115__t7 \$115 19.7025424729
* device instance _115_t8 r0 *1 0,0
R_115_t8 \$115__t8 \$115 25.0856937844
* device instance _115_t9 r0 *1 0,0
R_115_t9 \$115__t9 \$115 56.3269083493
* device instance _115_t10 r0 *1 0,0
R_115_t10 \$115__t10 \$115 50.8511594716
* device instance _115_t11 r0 *1 0,0
R_115_t11 \$115__t11 \$115 45.3904421413
* device instance _115_t12 r0 *1 0,0
R_115_t12 \$115__t12 \$115 39.9509206243
* device instance _115_t13 r0 *1 0,0
R_115_t13 \$115__t13 \$115 29.1828667015
* device instance _115_t14 r0 *1 0,0
R_115_t14 \$115__t14 \$115 34.5426096646
* device instance _115_t15 r0 *1 0,0
R_115_t15 \$115__t15 \$115 31.44325687
* device instance _115_t16 r0 *1 0,0
R_115_t16 \$115__t16 \$115 57.5305075405
* device instance _115_t17 r0 *1 0,0
R_115_t17 \$115__t17 \$115 52.1812141798
* device instance _115_t18 r0 *1 0,0
R_115_t18 \$115__t18 \$115 41.6306948345
* device instance _115_t19 r0 *1 0,0
R_115_t19 \$115__t19 \$115 36.4723261682
* device instance _115_t20 r0 *1 0,0
R_115_t20 \$115__t20 \$115 46.8756965971
* device instance _115_t21 r0 *1 0,0
R_115_t21 \$115__t21 \$115 26.616878702
* device instance _115_t22 r0 *1 0,0
R_115_t22 \$115__t22 \$115 22.1262302222
* device instance _115_t23 r0 *1 0,0
R_115_t23 \$115__t23 \$115 18.7758187615
* device instance _115_t24 r0 *1 0,0
R_115_t24 \$115__t24 \$115 30.5241852988
* device instance _115_t25 r0 *1 0,0
R_115_t25 \$115__t25 \$115 36.7546102914
* device instance _115_t26 r0 *1 0,0
R_115_t26 \$115__t26 \$115 33.3136537313
* device instance _115_t27 r0 *1 0,0
R_115_t27 \$115__t27 \$115 27.5447298335
* device instance _115_t28 r0 *1 0,0
R_115_t28 \$115__t28 \$115 28.7101080228
* device instance _115_t29 r0 *1 0,0
R_115_t29 \$115__t29 \$115 30.4963879001
* device instance _115_t30 r0 *1 0,0
R_115_t30 \$115__t30 \$115 28.4884507781
* device instance _115_t31 r0 *1 0,0
R_115_t31 \$115__t31 \$115 27.4679082438
* device instance _115_t32 r0 *1 0,0
R_115_t32 \$115__t32 \$115 50.9829391626
* device instance _115_t33 r0 *1 0,0
R_115_t33 \$115__t33 \$115 52.0682263054
* device instance _115_t34 r0 *1 0,0
R_115_t34 \$115__t34 \$115 53.1605608338
* device instance _115_t35 r0 *1 0,0
R_115_t35 \$115__t35 \$115 54.2595171226
* device instance _115_t36 r0 *1 0,0
R_115_t36 \$115__t36 \$115 61.2431072535
* device instance _115_t37 r0 *1 0,0
R_115_t37 \$115__t37 \$115 63.4801273676
* device instance _115_t38 r0 *1 0,0
R_115_t38 \$115__t38 \$115 62.3592007006
* device instance _115_t39 r0 *1 0,0
R_115_t39 \$115__t39 \$115 64.6056356818
* device instance _115 r0 *1 0,0
C_115 \$115 vsubs 1.4428614e-13
* device instance _116_t0 r0 *1 0,0
R_116_t0 \$116__t0 \$116 81.7777390336
* device instance _116_t1 r0 *1 0,0
R_116_t1 \$116__t1 \$116 21.4987692264
* device instance _116_t2 r0 *1 0,0
R_116_t2 \$116__t2 \$116 100.29899174
* device instance _116 r0 *1 0,0
C_116 \$116 vsubs 5.95106e-15
* device instance _118_t0 r0 *1 0,0
R_118_t0 \$118__t0 \$118 108.687402234
* device instance _118_t1 r0 *1 0,0
R_118_t1 \$118__t1 \$118 28.7964709909
* device instance _118_t2 r0 *1 0,0
R_118_t2 \$118__t2 \$118 133.512826775
* device instance _118 r0 *1 0,0
C_118 \$118 vsubs 6.467838e-15
* device instance _12_t0 r0 *1 0,0
R_12_t0 \$12__t0 \$12 20.5672656067
* device instance _12_t1 r0 *1 0,0
R_12_t1 \$12__t1 \$12 17.2983282239
* device instance _12_t2 r0 *1 0,0
R_12_t2 \$12__t2 \$12 8.80774734827
* device instance _12_t3 r0 *1 0,0
R_12_t3 \$12__t3 \$12 9.67848452201
* device instance _12_t4 r0 *1 0,0
R_12_t4 \$12__t4 \$12 11.1304520073
* device instance _12_t5 r0 *1 0,0
R_12_t5 \$12__t5 \$12 8.69465433542
* device instance _12_t6 r0 *1 0,0
R_12_t6 \$12__t6 \$12 10.2677415545
* device instance _12_t7 r0 *1 0,0
R_12_t7 \$12__t7 \$12 17.3766391749
* device instance _12_t8 r0 *1 0,0
R_12_t8 \$12__t8 \$12 19.8919358799
* device instance _12_t9 r0 *1 0,0
R_12_t9 \$12__t9 \$12 11.9448557016
* device instance _12_t10 r0 *1 0,0
R_12_t10 \$12__t10 \$12 14.4286729071
* device instance _12_t11 r0 *1 0,0
R_12_t11 \$12__t11 \$12 22.061622955
* device instance _12_t12 r0 *1 0,0
R_12_t12 \$12__t12 \$12 19.6447208786
* device instance _12_t13 r0 *1 0,0
R_12_t13 \$12__t13 \$12 12.9698924855
* device instance _12_t14 r0 *1 0,0
R_12_t14 \$12__t14 \$12 15.0554478591
* device instance _12_t15 r0 *1 0,0
R_12_t15 \$12__t15 \$12 16.2498641188
* device instance _12_t16 r0 *1 0,0
R_12_t16 \$12__t16 \$12 7.37574917973
* device instance _12_t17 r0 *1 0,0
R_12_t17 \$12__t17 \$12 13.7256186919
* device instance _12_t18 r0 *1 0,0
R_12_t18 \$12__t18 \$12 7.50873326872
* device instance _12_t19 r0 *1 0,0
R_12_t19 \$12__t19 \$12 8.51338502551
* device instance _12_t20 r0 *1 0,0
R_12_t20 \$12__t20 \$12 10.1336875735
* device instance _12_t21 r0 *1 0,0
R_12_t21 \$12__t21 \$12 12.1252947608
* device instance _12_t22 r0 *1 0,0
R_12_t22 \$12__t22 \$12 14.3342656661
* device instance _12_t23 r0 *1 0,0
R_12_t23 \$12__t23 \$12 16.6744361611
* device instance _12_t24 r0 *1 0,0
R_12_t24 \$12__t24 \$12 19.0976365121
* device instance _12_t25 r0 *1 0,0
R_12_t25 \$12__t25 \$12 21.5759094678
* device instance _12_t26 r0 *1 0,0
R_12_t26 \$12__t26 \$12 9.55456977352
* device instance _12_t27 r0 *1 0,0
R_12_t27 \$12__t27 \$12 6.78967465946
* device instance _12_t28 r0 *1 0,0
R_12_t28 \$12__t28 \$12 21.3948775305
* device instance _12_t29 r0 *1 0,0
R_12_t29 \$12__t29 \$12 18.8106567997
* device instance _12_t30 r0 *1 0,0
R_12_t30 \$12__t30 \$12 12.4869754348
* device instance _12_t31 r0 *1 0,0
R_12_t31 \$12__t31 \$12 15.1158924518
* device instance _12_t32 r0 *1 0,0
R_12_t32 \$12__t32 \$12 17.753115323
* device instance _12_t33 r0 *1 0,0
R_12_t33 \$12__t33 \$12 14.4239509157
* device instance _12_t34 r0 *1 0,0
R_12_t34 \$12__t34 \$12 19.5298786001
* device instance _12_t35 r0 *1 0,0
R_12_t35 \$12__t35 \$12 16.9609738547
* device instance _12_t36 r0 *1 0,0
R_12_t36 \$12__t36 \$12 11.939151389
* device instance _12_t37 r0 *1 0,0
R_12_t37 \$12__t37 \$12 4.78864364033
* device instance _12_t38 r0 *1 0,0
R_12_t38 \$12__t38 \$12 5.47451091608
* device instance _12_t39 r0 *1 0,0
R_12_t39 \$12__t39 \$12 7.75784564266
* device instance _12_t40 r0 *1 0,0
R_12_t40 \$12__t40 \$12 5.17367998118
* device instance _12_t41 r0 *1 0,0
R_12_t41 \$12__t41 \$12 4.65700965316
* device instance _12_t42 r0 *1 0,0
R_12_t42 \$12__t42 \$12 7.3403703921
* device instance _12_t43 r0 *1 0,0
R_12_t43 \$12__t43 \$12 3.724730927
* device instance _12_t44 r0 *1 0,0
R_12_t44 \$12__t44 \$12 9.87300138545
* device instance _12_t45 r0 *1 0,0
R_12_t45 \$12__t45 \$12 7.29006221914
* device instance _12_t46 r0 *1 0,0
R_12_t46 \$12__t46 \$12 5.54308246599
* device instance _12_t47 r0 *1 0,0
R_12_t47 \$12__t47 \$12 20.3954223463
* device instance _12_t48 r0 *1 0,0
R_12_t48 \$12__t48 \$12 10.223273361
* device instance _12_t49 r0 *1 0,0
R_12_t49 \$12__t49 \$12 12.7657243181
* device instance _12_t50 r0 *1 0,0
R_12_t50 \$12__t50 \$12 15.3469660347
* device instance _12_t51 r0 *1 0,0
R_12_t51 \$12__t51 \$12 17.9502720182
* device instance _12_t52 r0 *1 0,0
R_12_t52 \$12__t52 \$12 3.4487999565
* device instance _12_t53 r0 *1 0,0
R_12_t53 \$12__t53 \$12 9.54743744231
* device instance _12_t54 r0 *1 0,0
R_12_t54 \$12__t54 \$12 5.18683009073
* device instance _12_t55 r0 *1 0,0
R_12_t55 \$12__t55 \$12 5.99672359089
* device instance _12_t56 r0 *1 0,0
R_12_t56 \$12__t56 \$12 6.70810838767
* device instance _12_t57 r0 *1 0,0
R_12_t57 \$12__t57 \$12 8.25554313229
* device instance _12_t58 r0 *1 0,0
R_12_t58 \$12__t58 \$12 4.67161436251
* device instance _12_t59 r0 *1 0,0
R_12_t59 \$12__t59 \$12 6.40624066545
* device instance _12_t60 r0 *1 0,0
R_12_t60 \$12__t60 \$12 5.55535823032
* device instance _12_t61 r0 *1 0,0
R_12_t61 \$12__t61 \$12 7.34964484418
* device instance _12_t62 r0 *1 0,0
R_12_t62 \$12__t62 \$12 16.9649897124
* device instance _12_t63 r0 *1 0,0
R_12_t63 \$12__t63 \$12 19.5333663247
* device instance _12_t64 r0 *1 0,0
R_12_t64 \$12__t64 \$12 12.5226311455
* device instance _12_t65 r0 *1 0,0
R_12_t65 \$12__t65 \$12 14.9105102171
* device instance _12_t66 r0 *1 0,0
R_12_t66 \$12__t66 \$12 21.3781247384
* device instance _12_t67 r0 *1 0,0
R_12_t67 \$12__t67 \$12 21.7227414849
* device instance _12_t68 r0 *1 0,0
R_12_t68 \$12__t68 \$12 19.182740219
* device instance _12_t69 r0 *1 0,0
R_12_t69 \$12__t69 \$12 16.67917255
* device instance _12_t70 r0 *1 0,0
R_12_t70 \$12__t70 \$12 14.2312796876
* device instance _12_t71 r0 *1 0,0
R_12_t71 \$12__t71 \$12 11.8735460624
* device instance _12_t72 r0 *1 0,0
R_12_t72 \$12__t72 \$12 9.67213113017
* device instance _12_t73 r0 *1 0,0
R_12_t73 \$12__t73 \$12 7.76121092709
* device instance _12_t74 r0 *1 0,0
R_12_t74 \$12__t74 \$12 4.12224573483
* device instance _12_t75 r0 *1 0,0
R_12_t75 \$12__t75 \$12 9.36668909632
* device instance _12_t76 r0 *1 0,0
R_12_t76 \$12__t76 \$12 8.15717638506
* device instance _12_t77 r0 *1 0,0
R_12_t77 \$12__t77 \$12 18.9784843177
* device instance _12_t78 r0 *1 0,0
R_12_t78 \$12__t78 \$12 16.6570935825
* device instance _12_t79 r0 *1 0,0
R_12_t79 \$12__t79 \$12 14.4517098016
* device instance _12_t80 r0 *1 0,0
R_12_t80 \$12__t80 \$12 12.424263186
* device instance _12_t81 r0 *1 0,0
R_12_t81 \$12__t81 \$12 10.6766083189
* device instance _12_t82 r0 *1 0,0
R_12_t82 \$12__t82 \$12 11.2625211664
* device instance _12_t83 r0 *1 0,0
R_12_t83 \$12__t83 \$12 20.8765150176
* device instance _12_t84 r0 *1 0,0
R_12_t84 \$12__t84 \$12 18.4116139691
* device instance _12_t85 r0 *1 0,0
R_12_t85 \$12__t85 \$12 16.0082300261
* device instance _12_t86 r0 *1 0,0
R_12_t86 \$12__t86 \$12 13.6987801698
* device instance _12_t87 r0 *1 0,0
R_12_t87 \$12__t87 \$12 11.5397997238
* device instance _12_t88 r0 *1 0,0
R_12_t88 \$12__t88 \$12 9.63299678941
* device instance _12_t89 r0 *1 0,0
R_12_t89 \$12__t89 \$12 8.91142006224
* device instance _12_t90 r0 *1 0,0
R_12_t90 \$12__t90 \$12 4.90225170249
* device instance _12_t91 r0 *1 0,0
R_12_t91 \$12__t91 \$12 19.8875324001
* device instance _12_t92 r0 *1 0,0
R_12_t92 \$12__t92 \$12 17.371598111
* device instance _12_t93 r0 *1 0,0
R_12_t93 \$12__t93 \$12 14.9046350794
* device instance _12_t94 r0 *1 0,0
R_12_t94 \$12__t94 \$12 12.5156351306
* device instance _12_t95 r0 *1 0,0
R_12_t95 \$12__t95 \$12 10.2592079883
* device instance _12_t96 r0 *1 0,0
R_12_t96 \$12__t96 \$12 8.24492718743
* device instance _12_t97 r0 *1 0,0
R_12_t97 \$12__t97 \$12 6.69503921256
* device instance _12_t98 r0 *1 0,0
R_12_t98 \$12__t98 \$12 21.7187092051
* device instance _12_t99 r0 *1 0,0
R_12_t99 \$12__t99 \$12 6.39255437056
* device instance _12_t100 r0 *1 0,0
R_12_t100 \$12__t100 \$12 7.74991786871
* device instance _12_t101 r0 *1 0,0
R_12_t101 \$12__t101 \$12 9.66307158807
* device instance _12_t102 r0 *1 0,0
R_12_t102 \$12__t102 \$12 11.8661673684
* device instance _12_t103 r0 *1 0,0
R_12_t103 \$12__t103 \$12 14.2251240228
* device instance _12_t104 r0 *1 0,0
R_12_t104 \$12__t104 \$12 16.6739206208
* device instance _12_t105 r0 *1 0,0
R_12_t105 \$12__t105 \$12 19.1781739023
* device instance _12_t106 r0 *1 0,0
R_12_t106 \$12__t106 \$12 5.98210044571
* device instance _12_t107 r0 *1 0,0
R_12_t107 \$12__t107 \$12 21.3916933108
* device instance _12_t108 r0 *1 0,0
R_12_t108 \$12__t108 \$12 18.8070350506
* device instance _12_t109 r0 *1 0,0
R_12_t109 \$12__t109 \$12 16.2456714862
* device instance _12_t110 r0 *1 0,0
R_12_t110 \$12__t110 \$12 19.6540647858
* device instance _12_t111 r0 *1 0,0
R_12_t111 \$12__t111 \$12 12.0477849963
* device instance _12_t112 r0 *1 0,0
R_12_t112 \$12__t112 \$12 8.90377255344
* device instance _12_t113 r0 *1 0,0
R_12_t113 \$12__t113 \$12 14.3776497345
* device instance _12_t114 r0 *1 0,0
R_12_t114 \$12__t114 \$12 11.7520194631
* device instance _12_t115 r0 *1 0,0
R_12_t115 \$12__t115 \$12 9.14441692987
* device instance _12_t116 r0 *1 0,0
R_12_t116 \$12__t116 \$12 17.0129630655
* device instance _12_t117 r0 *1 0,0
R_12_t117 \$12__t117 \$12 6.77963421867
* device instance _12_t118 r0 *1 0,0
R_12_t118 \$12__t118 \$12 2.20341990635
* device instance _12_t119 r0 *1 0,0
R_12_t119 \$12__t119 \$12 2.6142797521
* device instance _12_t120 r0 *1 0,0
R_12_t120 \$12__t120 \$12 19.8323328043
* device instance _12_t121 r0 *1 0,0
R_12_t121 \$12__t121 \$12 17.2185967525
* device instance _12_t122 r0 *1 0,0
R_12_t122 \$12__t122 \$12 14.6203958136
* device instance _12_t123 r0 *1 0,0
R_12_t123 \$12__t123 \$12 9.52152943825
* device instance _12_t124 r0 *1 0,0
R_12_t124 \$12__t124 \$12 7.09134488813
* device instance _12_t125 r0 *1 0,0
R_12_t125 \$12__t125 \$12 13.720654745
* device instance _12_t126 r0 *1 0,0
R_12_t126 \$12__t126 \$12 11.2564710803
* device instance _12_t127 r0 *1 0,0
R_12_t127 \$12__t127 \$12 6.57632195579
* device instance _12_t128 r0 *1 0,0
R_12_t128 \$12__t128 \$12 20.8905981792
* device instance _12_t129 r0 *1 0,0
R_12_t129 \$12__t129 \$12 20.9350648293
* device instance _12_t130 r0 *1 0,0
R_12_t130 \$12__t130 \$12 20.9964633286
* device instance _12_t131 r0 *1 0,0
R_12_t131 \$12__t131 \$12 21.0746456907
* device instance _12_t132 r0 *1 0,0
R_12_t132 \$12__t132 \$12 23.3332267383
* device instance _12_t133 r0 *1 0,0
R_12_t133 \$12__t133 \$12 23.1330919348
* device instance _12_t134 r0 *1 0,0
R_12_t134 \$12__t134 \$12 22.9467884613
* device instance _12_t135 r0 *1 0,0
R_12_t135 \$12__t135 \$12 22.7746557534
* device instance _12 r0 *1 0,0
C_12 \$12 vsubs 3.07340524e-13
* device instance _120_t0 r0 *1 0,0
R_120_t0 \$120__t0 \$120 135.591504929
* device instance _120_t1 r0 *1 0,0
R_120_t1 \$120__t1 \$120 36.2048686624
* device instance _120_t2 r0 *1 0,0
R_120_t2 \$120__t2 \$120 166.824926409
* device instance _120 r0 *1 0,0
C_120 \$120 vsubs 7.006437e-15
* device instance _122_t0 r0 *1 0,0
R_122_t0 \$122__t0 \$122 162.444438203
* device instance _122_t1 r0 *1 0,0
R_122_t1 \$122__t1 \$122 43.7126105743
* device instance _122_t2 r0 *1 0,0
R_122_t2 \$122__t2 \$122 200.179851222
* device instance _122 r0 *1 0,0
C_122 \$122 vsubs 7.53688e-15
* device instance _123_t0 r0 *1 0,0
R_123_t0 \$123__t0 \$123 72.9480028932
* device instance _123_t1 r0 *1 0,0
R_123_t1 \$123__t1 \$123 31.2258059116
* device instance _123_t2 r0 *1 0,0
R_123_t2 \$123__t2 \$123 38.7844952627
* device instance _123_t3 r0 *1 0,0
R_123_t3 \$123__t3 \$123 50.4964807255
* device instance _123_t4 r0 *1 0,0
R_123_t4 \$123__t4 \$123 39.9051671664
* device instance _123_t5 r0 *1 0,0
R_123_t5 \$123__t5 \$123 27.8073889674
* device instance _123_t6 r0 *1 0,0
R_123_t6 \$123__t6 \$123 89.7741247868
* device instance _123_t7 r0 *1 0,0
R_123_t7 \$123__t7 \$123 26.5684973168
* device instance _123_t8 r0 *1 0,0
R_123_t8 \$123__t8 \$123 97.9178930967
* device instance _123_t9 r0 *1 0,0
R_123_t9 \$123__t9 \$123 22.4518368075
* device instance _123_t10 r0 *1 0,0
R_123_t10 \$123__t10 \$123 35.143579323
* device instance _123_t11 r0 *1 0,0
R_123_t11 \$123__t11 \$123 61.5864499613
* device instance _123_t12 r0 *1 0,0
R_123_t12 \$123__t12 \$123 21.4993717538
* device instance _123_t13 r0 *1 0,0
R_123_t13 \$123__t13 \$123 27.0442025389
* device instance _123_t14 r0 *1 0,0
R_123_t14 \$123__t14 \$123 76.5436152071
* device instance _123_t15 r0 *1 0,0
R_123_t15 \$123__t15 \$123 82.5614754474
* device instance _123_t16 r0 *1 0,0
R_123_t16 \$123__t16 \$123 67.0233578417
* device instance _123_t17 r0 *1 0,0
R_123_t17 \$123__t17 \$123 65.0604860723
* device instance _123_t18 r0 *1 0,0
R_123_t18 \$123__t18 \$123 71.0916433831
* device instance _123_t19 r0 *1 0,0
R_123_t19 \$123__t19 \$123 69.0351272905
* device instance _123_t20 r0 *1 0,0
R_123_t20 \$123__t20 \$123 89.9032885135
* device instance _123_t21 r0 *1 0,0
R_123_t21 \$123__t21 \$123 87.6773821833
* device instance _123_t22 r0 *1 0,0
R_123_t22 \$123__t22 \$123 92.1538598204
* device instance _123_t23 r0 *1 0,0
R_123_t23 \$123__t23 \$123 85.4780677293
* device instance _123 r0 *1 0,0
C_123 \$123 vsubs 1.27427881e-13
* device instance _124_t0 r0 *1 0,0
R_124_t0 \$124__t0 \$124 81.7777390336
* device instance _124_t1 r0 *1 0,0
R_124_t1 \$124__t1 \$124 21.4987692264
* device instance _124_t2 r0 *1 0,0
R_124_t2 \$124__t2 \$124 100.29899174
* device instance _124 r0 *1 0,0
C_124 \$124 vsubs 5.956568e-15
* device instance _126_t0 r0 *1 0,0
R_126_t0 \$126__t0 \$126 108.687402234
* device instance _126_t1 r0 *1 0,0
R_126_t1 \$126__t1 \$126 28.7964709909
* device instance _126_t2 r0 *1 0,0
R_126_t2 \$126__t2 \$126 133.512826775
* device instance _126 r0 *1 0,0
C_126 \$126 vsubs 6.487011e-15
* device instance _128_t0 r0 *1 0,0
R_128_t0 \$128__t0 \$128 135.591504929
* device instance _128_t1 r0 *1 0,0
R_128_t1 \$128__t1 \$128 36.2048686624
* device instance _128_t2 r0 *1 0,0
R_128_t2 \$128__t2 \$128 166.824926409
* device instance _128 r0 *1 0,0
C_128 \$128 vsubs 7.017453e-15
* device instance _13_t0 r0 *1 0,0
R_13_t0 \$13__t0 \$13 162.444438203
* device instance _13_t1 r0 *1 0,0
R_13_t1 \$13__t1 \$13 43.7126105743
* device instance _13_t2 r0 *1 0,0
R_13_t2 \$13__t2 \$13 200.179851222
* device instance _13 r0 *1 0,0
C_13 \$13 vsubs 7.553404e-15
* device instance _130_t0 r0 *1 0,0
R_130_t0 \$130__t0 \$130 162.444438203
* device instance _130_t1 r0 *1 0,0
R_130_t1 \$130__t1 \$130 43.7126105743
* device instance _130_t2 r0 *1 0,0
R_130_t2 \$130__t2 \$130 200.179851222
* device instance _130 r0 *1 0,0
C_130 \$130 vsubs 7.547896e-15
* device instance _131_t0 r0 *1 0,0
R_131_t0 \$131__t0 \$131 142.289684825
* device instance _131_t1 r0 *1 0,0
R_131_t1 \$131__t1 \$131 125.287522923
* device instance _131_t2 r0 *1 0,0
R_131_t2 \$131__t2 \$131 72.0360459861
* device instance _131_t3 r0 *1 0,0
R_131_t3 \$131__t3 \$131 83.8477379867
* device instance _131_t4 r0 *1 0,0
R_131_t4 \$131__t4 \$131 168.583622625
* device instance _131_t5 r0 *1 0,0
R_131_t5 \$131__t5 \$131 181.57595883
* device instance _131_t6 r0 *1 0,0
R_131_t6 \$131__t6 \$131 43.3993788607
* device instance _131_t7 r0 *1 0,0
R_131_t7 \$131__t7 \$131 61.0307900134
* device instance _131_t8 r0 *1 0,0
R_131_t8 \$131__t8 \$131 52.7667830685
* device instance _131_t9 r0 *1 0,0
R_131_t9 \$131__t9 \$131 53.9605922079
* device instance _131_t10 r0 *1 0,0
R_131_t10 \$131__t10 \$131 55.4365675675
* device instance _131_t11 r0 *1 0,0
R_131_t11 \$131__t11 \$131 57.1728601009
* device instance _131_t12 r0 *1 0,0
R_131_t12 \$131__t12 \$131 75.4954747436
* device instance _131_t13 r0 *1 0,0
R_131_t13 \$131__t13 \$131 78.1880761055
* device instance _131_t14 r0 *1 0,0
R_131_t14 \$131__t14 \$131 81.0014764039
* device instance _131_t15 r0 *1 0,0
R_131_t15 \$131__t15 \$131 83.9235277521
* device instance _131 r0 *1 0,0
C_131 \$131 vsubs 1.17707478e-13
* device instance _132_t0 r0 *1 0,0
R_132_t0 \$132__t0 \$132 81.7777390336
* device instance _132_t1 r0 *1 0,0
R_132_t1 \$132__t1 \$132 21.4987692264
* device instance _132_t2 r0 *1 0,0
R_132_t2 \$132__t2 \$132 100.29899174
* device instance _132 r0 *1 0,0
C_132 \$132 vsubs 5.956568e-15
* device instance _134_t0 r0 *1 0,0
R_134_t0 \$134__t0 \$134 108.687402234
* device instance _134_t1 r0 *1 0,0
R_134_t1 \$134__t1 \$134 28.7964709909
* device instance _134_t2 r0 *1 0,0
R_134_t2 \$134__t2 \$134 133.512826775
* device instance _134 r0 *1 0,0
C_134 \$134 vsubs 6.487011e-15
* device instance _136_t0 r0 *1 0,0
R_136_t0 \$136__t0 \$136 135.591504929
* device instance _136_t1 r0 *1 0,0
R_136_t1 \$136__t1 \$136 36.2048686624
* device instance _136_t2 r0 *1 0,0
R_136_t2 \$136__t2 \$136 166.824926409
* device instance _136 r0 *1 0,0
C_136 \$136 vsubs 7.017453e-15
* device instance _138_t0 r0 *1 0,0
R_138_t0 \$138__t0 \$138 162.444438203
* device instance _138_t1 r0 *1 0,0
R_138_t1 \$138__t1 \$138 43.7126105743
* device instance _138_t2 r0 *1 0,0
R_138_t2 \$138__t2 \$138 200.179851222
* device instance _138 r0 *1 0,0
C_138 \$138 vsubs 7.547896e-15
* device instance _139_t0 r0 *1 0,0
R_139_t0 \$139__t0 \$139 214.30791866
* device instance _139_t1 r0 *1 0,0
R_139_t1 \$139__t1 \$139 214.206328104
* device instance _139_t2 r0 *1 0,0
R_139_t2 \$139__t2 \$139 290.145972004
* device instance _139_t3 r0 *1 0,0
R_139_t3 \$139__t3 \$139 176.155871715
* device instance _139_t4 r0 *1 0,0
R_139_t4 \$139__t4 \$139 53.9658495186
* device instance _139_t5 r0 *1 0,0
R_139_t5 \$139__t5 \$139 56.1539675667
* device instance _139_t6 r0 *1 0,0
R_139_t6 \$139__t6 \$139 58.9817885977
* device instance _139_t7 r0 *1 0,0
R_139_t7 \$139__t7 \$139 62.3623512414
* device instance _139_t8 r0 *1 0,0
R_139_t8 \$139__t8 \$139 66.1262619636
* device instance _139_t9 r0 *1 0,0
R_139_t9 \$139__t9 \$139 68.3679041514
* device instance _139_t10 r0 *1 0,0
R_139_t10 \$139__t10 \$139 71.1356891322
* device instance _139_t11 r0 *1 0,0
R_139_t11 \$139__t11 \$139 74.3708973461
* device instance _139 r0 *1 0,0
C_139 \$139 vsubs 1.11650116e-13
* device instance _14_t0 r0 *1 0,0
R_14_t0 \$14__t0 \$14 35.8333033275
* device instance _14_t1 r0 *1 0,0
R_14_t1 \$14__t1 \$14 16.7165014163
* device instance _14_t2 r0 *1 0,0
R_14_t2 \$14__t2 \$14 17.1497875854
* device instance _14_t3 r0 *1 0,0
R_14_t3 \$14__t3 \$14 18.4519512117
* device instance _14_t4 r0 *1 0,0
R_14_t4 \$14__t4 \$14 20.457743949
* device instance _14_t5 r0 *1 0,0
R_14_t5 \$14__t5 \$14 22.9836804302
* device instance _14_t6 r0 *1 0,0
R_14_t6 \$14__t6 \$14 25.8778928706
* device instance _14_t7 r0 *1 0,0
R_14_t7 \$14__t7 \$14 29.0304427696
* device instance _14_t8 r0 *1 0,0
R_14_t8 \$14__t8 \$14 32.3659291546
* device instance _14_t9 r0 *1 0,0
R_14_t9 \$14__t9 \$14 32.6177667537
* device instance _14_t10 r0 *1 0,0
R_14_t10 \$14__t10 \$14 29.2710443943
* device instance _14_t11 r0 *1 0,0
R_14_t11 \$14__t11 \$14 26.1027750735
* device instance _14_t12 r0 *1 0,0
R_14_t12 \$14__t12 \$14 23.1862284084
* device instance _14_t13 r0 *1 0,0
R_14_t13 \$14__t13 \$14 20.6284513173
* device instance _14_t14 r0 *1 0,0
R_14_t14 \$14__t14 \$14 18.578221507
* device instance _14_t15 r0 *1 0,0
R_14_t15 \$14__t15 \$14 15.7943414124
* device instance _14_t16 r0 *1 0,0
R_14_t16 \$14__t16 \$14 19.7706093471
* device instance _14_t17 r0 *1 0,0
R_14_t17 \$14__t17 \$14 23.7482265007
* device instance _14_t18 r0 *1 0,0
R_14_t18 \$14__t18 \$14 27.7266122088
* device instance _14_t19 r0 *1 0,0
R_14_t19 \$14__t19 \$14 31.7054771592
* device instance _14_t20 r0 *1 0,0
R_14_t20 \$14__t20 \$14 0.808130023361
* device instance _14_t21 r0 *1 0,0
R_14_t21 \$14__t21 \$14 3.91495450273
* device instance _14_t22 r0 *1 0,0
R_14_t22 \$14__t22 \$14 11.8207843232
* device instance _14_t23 r0 *1 0,0
R_14_t23 \$14__t23 \$14 7.85405360641
* device instance _14_t24 r0 *1 0,0
R_14_t24 \$14__t24 \$14 22.7728405815
* device instance _14_t25 r0 *1 0,0
R_14_t25 \$14__t25 \$14 26.5997421691
* device instance _14_t26 r0 *1 0,0
R_14_t26 \$14__t26 \$14 30.4659776381
* device instance _14_t27 r0 *1 0,0
R_14_t27 \$14__t27 \$14 17.2178140206
* device instance _14_t28 r0 *1 0,0
R_14_t28 \$14__t28 \$14 4.20294827248
* device instance _14_t29 r0 *1 0,0
R_14_t29 \$14__t29 \$14 30.752399648
* device instance _14_t30 r0 *1 0,0
R_14_t30 \$14__t30 \$14 26.8838737668
* device instance _14_t31 r0 *1 0,0
R_14_t31 \$14__t31 \$14 23.0534324554
* device instance _14_t32 r0 *1 0,0
R_14_t32 \$14__t32 \$14 19.2837839107
* device instance _14_t33 r0 *1 0,0
R_14_t33 \$14__t33 \$14 15.6190073475
* device instance _14_t34 r0 *1 0,0
R_14_t34 \$14__t34 \$14 12.1543388879
* device instance _14_t35 r0 *1 0,0
R_14_t35 \$14__t35 \$14 9.12074622764
* device instance _14_t36 r0 *1 0,0
R_14_t36 \$14__t36 \$14 19.0090438348
* device instance _14_t37 r0 *1 0,0
R_14_t37 \$14__t37 \$14 11.911473051
* device instance _14_t38 r0 *1 0,0
R_14_t38 \$14__t38 \$14 8.92643005993
* device instance _14_t39 r0 *1 0,0
R_14_t39 \$14__t39 \$14 7.01174811698
* device instance _14_t40 r0 *1 0,0
R_14_t40 \$14__t40 \$14 7.09461516697
* device instance _14_t41 r0 *1 0,0
R_14_t41 \$14__t41 \$14 15.3548273042
* device instance _14_t42 r0 *1 0,0
R_14_t42 \$14__t42 \$14 28.0201777749
* device instance _14_t43 r0 *1 0,0
R_14_t43 \$14__t43 \$14 24.0417489893
* device instance _14_t44 r0 *1 0,0
R_14_t44 \$14__t44 \$14 20.0640604333
* device instance _14_t45 r0 *1 0,0
R_14_t45 \$14__t45 \$14 16.0876611831
* device instance _14_t46 r0 *1 0,0
R_14_t46 \$14__t46 \$14 12.1138209614
* device instance _14_t47 r0 *1 0,0
R_14_t47 \$14__t47 \$14 8.14628558902
* device instance _14_t48 r0 *1 0,0
R_14_t48 \$14__t48 \$14 23.5938311723
* device instance _14_t49 r0 *1 0,0
R_14_t49 \$14__t49 \$14 27.3059129988
* device instance _14_t50 r0 *1 0,0
R_14_t50 \$14__t50 \$14 31.0844397517
* device instance _14_t51 r0 *1 0,0
R_14_t51 \$14__t51 \$14 31.3652145752
* device instance _14_t52 r0 *1 0,0
R_14_t52 \$14__t52 \$14 27.5827712521
* device instance _14_t53 r0 *1 0,0
R_14_t53 \$14__t53 \$14 23.8647721383
* device instance _14_t54 r0 *1 0,0
R_14_t54 \$14__t54 \$14 20.2467509283
* device instance _14_t55 r0 *1 0,0
R_14_t55 \$14__t55 \$14 13.6306476382
* device instance _14_t56 r0 *1 0,0
R_14_t56 \$14__t56 \$14 11.0115672356
* device instance _14_t57 r0 *1 0,0
R_14_t57 \$14__t57 \$14 16.7934508591
* device instance _14_t58 r0 *1 0,0
R_14_t58 \$14__t58 \$14 19.9852532821
* device instance _14_t59 r0 *1 0,0
R_14_t59 \$14__t59 \$14 16.5480307825
* device instance _14_t60 r0 *1 0,0
R_14_t60 \$14__t60 \$14 13.4145365734
* device instance _14_t61 r0 *1 0,0
R_14_t61 \$14__t61 \$14 10.8511637556
* device instance _14_t62 r0 *1 0,0
R_14_t62 \$14__t62 \$14 9.33976514115
* device instance _14_t63 r0 *1 0,0
R_14_t63 \$14__t63 \$14 9.40213622551
* device instance _14_t64 r0 *1 0,0
R_14_t64 \$14__t64 \$14 31.7724106245
* device instance _14_t65 r0 *1 0,0
R_14_t65 \$14__t65 \$14 31.4480955718
* device instance _14_t66 r0 *1 0,0
R_14_t66 \$14__t66 \$14 31.1461623875
* device instance _14_t67 r0 *1 0,0
R_14_t67 \$14__t67 \$14 30.867267874
* device instance _14_t68 r0 *1 0,0
R_14_t68 \$14__t68 \$14 31.0618763574
* device instance _14_t69 r0 *1 0,0
R_14_t69 \$14__t69 \$14 31.1230704862
* device instance _14_t70 r0 *1 0,0
R_14_t70 \$14__t70 \$14 31.3220123601
* device instance _14_t71 r0 *1 0,0
R_14_t71 \$14__t71 \$14 31.2098533848
* device instance _14 r0 *1 0,0
C_14 \$14 vsubs 1.7471714e-13
* device instance _140_t0 r0 *1 0,0
R_140_t0 \$140__t0 \$140 81.7777390336
* device instance _140_t1 r0 *1 0,0
R_140_t1 \$140__t1 \$140 21.4987692264
* device instance _140_t2 r0 *1 0,0
R_140_t2 \$140__t2 \$140 100.29899174
* device instance _140 r0 *1 0,0
C_140 \$140 vsubs 5.956568e-15
* device instance _142_t0 r0 *1 0,0
R_142_t0 \$142__t0 \$142 108.687402234
* device instance _142_t1 r0 *1 0,0
R_142_t1 \$142__t1 \$142 28.7964709909
* device instance _142_t2 r0 *1 0,0
R_142_t2 \$142__t2 \$142 133.512826775
* device instance _142 r0 *1 0,0
C_142 \$142 vsubs 6.487011e-15
* device instance _144_t0 r0 *1 0,0
R_144_t0 \$144__t0 \$144 135.591504929
* device instance _144_t1 r0 *1 0,0
R_144_t1 \$144__t1 \$144 36.2048686624
* device instance _144_t2 r0 *1 0,0
R_144_t2 \$144__t2 \$144 166.824926409
* device instance _144 r0 *1 0,0
C_144 \$144 vsubs 7.017453e-15
* device instance _146_t0 r0 *1 0,0
R_146_t0 \$146__t0 \$146 162.444438203
* device instance _146_t1 r0 *1 0,0
R_146_t1 \$146__t1 \$146 43.7126105743
* device instance _146_t2 r0 *1 0,0
R_146_t2 \$146__t2 \$146 200.179851222
* device instance _146 r0 *1 0,0
C_146 \$146 vsubs 7.547896e-15
* device instance _147_t0 r0 *1 0,0
R_147_t0 \$147__t0 \$147 373.606370631
* device instance _147_t1 r0 *1 0,0
R_147_t1 \$147__t1 \$147 394.75592639
* device instance _147_t2 r0 *1 0,0
R_147_t2 \$147__t2 \$147 64.3199330144
* device instance _147_t3 r0 *1 0,0
R_147_t3 \$147__t3 \$147 71.5053107126
* device instance _147_t4 r0 *1 0,0
R_147_t4 \$147__t4 \$147 79.0098611682
* device instance _147_t5 r0 *1 0,0
R_147_t5 \$147__t5 \$147 86.7507918587
* device instance _147_t6 r0 *1 0,0
R_147_t6 \$147__t6 \$147 58.4693123166
* device instance _147_t7 r0 *1 0,0
R_147_t7 \$147__t7 \$147 54.1505546746
* device instance _147_t8 r0 *1 0,0
R_147_t8 \$147__t8 \$147 54.2292865283
* device instance _147_t9 r0 *1 0,0
R_147_t9 \$147__t9 \$147 55.7040527052
* device instance _147 r0 *1 0,0
C_147 \$147 vsubs 7.2132214e-14
* device instance _148_t0 r0 *1 0,0
R_148_t0 \$148__t0 \$148 81.7777390336
* device instance _148_t1 r0 *1 0,0
R_148_t1 \$148__t1 \$148 21.4987692264
* device instance _148_t2 r0 *1 0,0
R_148_t2 \$148__t2 \$148 100.29899174
* device instance _148 r0 *1 0,0
C_148 \$148 vsubs 5.956568e-15
* device instance _15_t0 r0 *1 0,0
R_15_t0 \$15__t0 \$15 162.444438203
* device instance _15_t1 r0 *1 0,0
R_15_t1 \$15__t1 \$15 43.7126105743
* device instance _15_t2 r0 *1 0,0
R_15_t2 \$15__t2 \$15 200.179851222
* device instance _15 r0 *1 0,0
C_15 \$15 vsubs 7.553404e-15
* device instance _150_t0 r0 *1 0,0
R_150_t0 \$150__t0 \$150 108.687402234
* device instance _150_t1 r0 *1 0,0
R_150_t1 \$150__t1 \$150 28.7964709909
* device instance _150_t2 r0 *1 0,0
R_150_t2 \$150__t2 \$150 133.512826775
* device instance _150 r0 *1 0,0
C_150 \$150 vsubs 6.487011e-15
* device instance _152_t0 r0 *1 0,0
R_152_t0 \$152__t0 \$152 135.591504929
* device instance _152_t1 r0 *1 0,0
R_152_t1 \$152__t1 \$152 36.2048686624
* device instance _152_t2 r0 *1 0,0
R_152_t2 \$152__t2 \$152 166.824926409
* device instance _152 r0 *1 0,0
C_152 \$152 vsubs 7.017453e-15
* device instance _154_t0 r0 *1 0,0
R_154_t0 \$154__t0 \$154 162.444438203
* device instance _154_t1 r0 *1 0,0
R_154_t1 \$154__t1 \$154 43.7126105743
* device instance _154_t2 r0 *1 0,0
R_154_t2 \$154__t2 \$154 200.179851222
* device instance _154 r0 *1 0,0
C_154 \$154 vsubs 7.547896e-15
* device instance _155_t0 r0 *1 0,0
R_155_t0 \$155__t0 \$155 435.943993442
* device instance _155_t1 r0 *1 0,0
R_155_t1 \$155__t1 \$155 81.600857154
* device instance _155_t2 r0 *1 0,0
R_155_t2 \$155__t2 \$155 99.150134717
* device instance _155_t3 r0 *1 0,0
R_155_t3 \$155__t3 \$155 117.262034068
* device instance _155_t4 r0 *1 0,0
R_155_t4 \$155__t4 \$155 65.0710124048
* device instance _155_t5 r0 *1 0,0
R_155_t5 \$155__t5 \$155 87.9636464217
* device instance _155_t6 r0 *1 0,0
R_155_t6 \$155__t6 \$155 100.523425398
* device instance _155_t7 r0 *1 0,0
R_155_t7 \$155__t7 \$155 114.977828771
* device instance _155_t8 r0 *1 0,0
R_155_t8 \$155__t8 \$155 130.699767625
* device instance _155 r0 *1 0,0
C_155 \$155 vsubs 5.1000661e-14
* device instance _16_t0 r0 *1 0,0
R_16_t0 \$16__t0 \$16 63.7248763132
* device instance _16_t1 r0 *1 0,0
R_16_t1 \$16__t1 \$16 35.2889476836
* device instance _16_t2 r0 *1 0,0
R_16_t2 \$16__t2 \$16 37.7316816728
* device instance _16_t3 r0 *1 0,0
R_16_t3 \$16__t3 \$16 40.9471235671
* device instance _16_t4 r0 *1 0,0
R_16_t4 \$16__t4 \$16 44.7690876422
* device instance _16_t5 r0 *1 0,0
R_16_t5 \$16__t5 \$16 49.056015345
* device instance _16_t6 r0 *1 0,0
R_16_t6 \$16__t6 \$16 53.6966593754
* device instance _16_t7 r0 *1 0,0
R_16_t7 \$16__t7 \$16 58.6070556157
* device instance _16_t8 r0 *1 0,0
R_16_t8 \$16__t8 \$16 43.0211153845
* device instance _16_t9 r0 *1 0,0
R_16_t9 \$16__t9 \$16 49.0129789831
* device instance _16_t10 r0 *1 0,0
R_16_t10 \$16__t10 \$16 55.0304007072
* device instance _16_t11 r0 *1 0,0
R_16_t11 \$16__t11 \$16 31.1730067392
* device instance _16_t12 r0 *1 0,0
R_16_t12 \$16__t12 \$16 37.0672062932
* device instance _16_t13 r0 *1 0,0
R_16_t13 \$16__t13 \$16 25.3801510884
* device instance _16_t14 r0 *1 0,0
R_16_t14 \$16__t14 \$16 12.2033405396
* device instance _16_t15 r0 *1 0,0
R_16_t15 \$16__t15 \$16 14.5874935978
* device instance _16_t16 r0 *1 0,0
R_16_t16 \$16__t16 \$16 19.7778902491
* device instance _16_t17 r0 *1 0,0
R_16_t17 \$16__t17 \$16 42.1081002979
* device instance _16_t18 r0 *1 0,0
R_16_t18 \$16__t18 \$16 36.2934743538
* device instance _16_t19 r0 *1 0,0
R_16_t19 \$16__t19 \$16 30.5934241948
* device instance _16_t20 r0 *1 0,0
R_16_t20 \$16__t20 \$16 25.0861730956
* device instance _16_t21 r0 *1 0,0
R_16_t21 \$16__t21 \$16 19.9321777669
* device instance _16_t22 r0 *1 0,0
R_16_t22 \$16__t22 \$16 15.4882049897
* device instance _16_t23 r0 *1 0,0
R_16_t23 \$16__t23 \$16 12.5337317029
* device instance _16_t24 r0 *1 0,0
R_16_t24 \$16__t24 \$16 20.2340554004
* device instance _16_t25 r0 *1 0,0
R_16_t25 \$16__t25 \$16 15.8748159428
* device instance _16_t26 r0 *1 0,0
R_16_t26 \$16__t26 \$16 25.3266927963
* device instance _16_t27 r0 *1 0,0
R_16_t27 \$16__t27 \$16 13.0084479403
* device instance _16_t28 r0 *1 0,0
R_16_t28 \$16__t28 \$16 42.251833074
* device instance _16_t29 r0 *1 0,0
R_16_t29 \$16__t29 \$16 36.4601366986
* device instance _16_t30 r0 *1 0,0
R_16_t30 \$16__t30 \$16 12.6904218898
* device instance _16_t31 r0 *1 0,0
R_16_t31 \$16__t31 \$16 30.7909547007
* device instance _16_t32 r0 *1 0,0
R_16_t32 \$16__t32 \$16 51.4140279233
* device instance _16_t33 r0 *1 0,0
R_16_t33 \$16__t33 \$16 52.2694680227
* device instance _16_t34 r0 *1 0,0
R_16_t34 \$16__t34 \$16 53.1466819363
* device instance _16_t35 r0 *1 0,0
R_16_t35 \$16__t35 \$16 54.044609423
* device instance _16_t36 r0 *1 0,0
R_16_t36 \$16__t36 \$16 49.2785311254
* device instance _16_t37 r0 *1 0,0
R_16_t37 \$16__t37 \$16 47.3947159474
* device instance _16_t38 r0 *1 0,0
R_16_t38 \$16__t38 \$16 47.9915247698
* device instance _16_t39 r0 *1 0,0
R_16_t39 \$16__t39 \$16 48.6198652107
* device instance _16 r0 *1 0,0
C_16 \$16 vsubs 1.45685352e-13
* device instance _166_t0 r0 *1 0,0
R_166_t0 \$166__t0 \$166 84.9620979822
* device instance _166_t1 r0 *1 0,0
R_166_t1 \$166__t1 \$166 24.9695335856
* device instance _166_t2 r0 *1 0,0
R_166_t2 \$166__t2 \$166 86.6725684323
* device instance _166 r0 *1 0,0
C_166 \$166 vsubs 3.621691e-15
* device instance _167_t0 r0 *1 0,0
R_167_t0 \$167__t0 \$167 84.9620979822
* device instance _167_t1 r0 *1 0,0
R_167_t1 \$167__t1 \$167 24.9695335856
* device instance _167_t2 r0 *1 0,0
R_167_t2 \$167__t2 \$167 86.6725684323
* device instance _167 r0 *1 0,0
C_167 \$167 vsubs 3.621691e-15
* device instance _17_t0 r0 *1 0,0
R_17_t0 \$17__t0 \$17 162.444438203
* device instance _17_t1 r0 *1 0,0
R_17_t1 \$17__t1 \$17 43.7126105743
* device instance _17_t2 r0 *1 0,0
R_17_t2 \$17__t2 \$17 200.179851222
* device instance _17 r0 *1 0,0
C_17 \$17 vsubs 7.547896e-15
* device instance _18_t0 r0 *1 0,0
R_18_t0 \$18__t0 \$18 68.6486411899
* device instance _18_t1 r0 *1 0,0
R_18_t1 \$18__t1 \$18 62.8101329229
* device instance _18_t2 r0 *1 0,0
R_18_t2 \$18__t2 \$18 63.4018457146
* device instance _18_t3 r0 *1 0,0
R_18_t3 \$18__t3 \$18 67.7808614177
* device instance _18_t4 r0 *1 0,0
R_18_t4 \$18__t4 \$18 43.8696260575
* device instance _18_t5 r0 *1 0,0
R_18_t5 \$18__t5 \$18 51.3155400199
* device instance _18_t6 r0 *1 0,0
R_18_t6 \$18__t6 \$18 59.3564234848
* device instance _18_t7 r0 *1 0,0
R_18_t7 \$18__t7 \$18 37.149029213
* device instance _18_t8 r0 *1 0,0
R_18_t8 \$18__t8 \$18 65.3883406005
* device instance _18_t9 r0 *1 0,0
R_18_t9 \$18__t9 \$18 30.7091113635
* device instance _18_t10 r0 *1 0,0
R_18_t10 \$18__t10 \$18 24.7492875056
* device instance _18_t11 r0 *1 0,0
R_18_t11 \$18__t11 \$18 26.214661437
* device instance _18_t12 r0 *1 0,0
R_18_t12 \$18__t12 \$18 33.5886258162
* device instance _18_t13 r0 *1 0,0
R_18_t13 \$18__t13 \$18 42.8594953463
* device instance _18_t14 r0 *1 0,0
R_18_t14 \$18__t14 \$18 52.2191220024
* device instance _18_t15 r0 *1 0,0
R_18_t15 \$18__t15 \$18 61.6270790182
* device instance _18_t16 r0 *1 0,0
R_18_t16 \$18__t16 \$18 85.9288725016
* device instance _18_t17 r0 *1 0,0
R_18_t17 \$18__t17 \$18 87.6363316886
* device instance _18_t18 r0 *1 0,0
R_18_t18 \$18__t18 \$18 89.3624828961
* device instance _18_t19 r0 *1 0,0
R_18_t19 \$18__t19 \$18 84.2412419308
* device instance _18_t20 r0 *1 0,0
R_18_t20 \$18__t20 \$18 75.2169757658
* device instance _18_t21 r0 *1 0,0
R_18_t21 \$18__t21 \$18 76.6604303043
* device instance _18_t22 r0 *1 0,0
R_18_t22 \$18__t22 \$18 78.1359131297
* device instance _18_t23 r0 *1 0,0
R_18_t23 \$18__t23 \$18 73.8074286732
* device instance _18 r0 *1 0,0
C_18 \$18 vsubs 1.32652353e-13
* device instance _19_t0 r0 *1 0,0
R_19_t0 \$19__t0 \$19 162.444438203
* device instance _19_t1 r0 *1 0,0
R_19_t1 \$19__t1 \$19 43.7126105743
* device instance _19_t2 r0 *1 0,0
R_19_t2 \$19__t2 \$19 200.179851222
* device instance _19 r0 *1 0,0
C_19 \$19 vsubs 7.553404e-15
* device instance _20_t0 r0 *1 0,0
R_20_t0 \$20__t0 \$20 86.0548120154
* device instance _20_t1 r0 *1 0,0
R_20_t1 \$20__t1 \$20 88.4685022133
* device instance _20_t2 r0 *1 0,0
R_20_t2 \$20__t2 \$20 134.408286648
* device instance _20_t3 r0 *1 0,0
R_20_t3 \$20__t3 \$20 124.587204655
* device instance _20_t4 r0 *1 0,0
R_20_t4 \$20__t4 \$20 44.974520605
* device instance _20_t5 r0 *1 0,0
R_20_t5 \$20__t5 \$20 49.4363501535
* device instance _20_t6 r0 *1 0,0
R_20_t6 \$20__t6 \$20 115.182258396
* device instance _20_t7 r0 *1 0,0
R_20_t7 \$20__t7 \$20 125.740083526
* device instance _20_t8 r0 *1 0,0
R_20_t8 \$20__t8 \$20 87.8618035579
* device instance _20_t9 r0 *1 0,0
R_20_t9 \$20__t9 \$20 89.9415943346
* device instance _20_t10 r0 *1 0,0
R_20_t10 \$20__t10 \$20 92.0358313944
* device instance _20_t11 r0 *1 0,0
R_20_t11 \$20__t11 \$20 94.143550663
* device instance _20_t12 r0 *1 0,0
R_20_t12 \$20__t12 \$20 73.6903486945
* device instance _20_t13 r0 *1 0,0
R_20_t13 \$20__t13 \$20 75.5311020885
* device instance _20_t14 r0 *1 0,0
R_20_t14 \$20__t14 \$20 77.4011451896
* device instance _20_t15 r0 *1 0,0
R_20_t15 \$20__t15 \$20 79.2984058643
* device instance _20 r0 *1 0,0
C_20 \$20 vsubs 1.26779805e-13
* device instance _21_t0 r0 *1 0,0
R_21_t0 \$21__t0 \$21 162.444438203
* device instance _21_t1 r0 *1 0,0
R_21_t1 \$21__t1 \$21 43.7126105743
* device instance _21_t2 r0 *1 0,0
R_21_t2 \$21__t2 \$21 200.179851222
* device instance _21 r0 *1 0,0
C_21 \$21 vsubs 7.553404e-15
* device instance _22_t0 r0 *1 0,0
R_22_t0 \$22__t0 \$22 146.337585121
* device instance _22_t1 r0 *1 0,0
R_22_t1 \$22__t1 \$22 253.248555575
* device instance _22_t2 r0 *1 0,0
R_22_t2 \$22__t2 \$22 101.811518158
* device instance _22_t3 r0 *1 0,0
R_22_t3 \$22__t3 \$22 241.408436749
* device instance _22_t4 r0 *1 0,0
R_22_t4 \$22__t4 \$22 93.0125381929
* device instance _22_t5 r0 *1 0,0
R_22_t5 \$22__t5 \$22 95.8432030558
* device instance _22_t6 r0 *1 0,0
R_22_t6 \$22__t6 \$22 98.6878038683
* device instance _22_t7 r0 *1 0,0
R_22_t7 \$22__t7 \$22 101.545169467
* device instance _22_t8 r0 *1 0,0
R_22_t8 \$22__t8 \$22 80.6078654279
* device instance _22_t9 r0 *1 0,0
R_22_t9 \$22__t9 \$22 77.9960768018
* device instance _22_t10 r0 *1 0,0
R_22_t10 \$22__t10 \$22 75.4183251839
* device instance _22_t11 r0 *1 0,0
R_22_t11 \$22__t11 \$22 72.8782223993
* device instance _22 r0 *1 0,0
C_22 \$22 vsubs 1.24592591e-13
* device instance _23_t0 r0 *1 0,0
R_23_t0 \$23__t0 \$23 162.444438203
* device instance _23_t1 r0 *1 0,0
R_23_t1 \$23__t1 \$23 43.7126105743
* device instance _23_t2 r0 *1 0,0
R_23_t2 \$23__t2 \$23 200.179851222
* device instance _23 r0 *1 0,0
C_23 \$23 vsubs 7.553404e-15
* device instance _24_t0 r0 *1 0,0
R_24_t0 \$24__t0 \$24 253.193602426
* device instance _24_t1 r0 *1 0,0
R_24_t1 \$24__t1 \$24 430.904688046
* device instance _24_t2 r0 *1 0,0
R_24_t2 \$24__t2 \$24 89.5166971687
* device instance _24_t3 r0 *1 0,0
R_24_t3 \$24__t3 \$24 93.3562941867
* device instance _24_t4 r0 *1 0,0
R_24_t4 \$24__t4 \$24 97.21044369
* device instance _24_t5 r0 *1 0,0
R_24_t5 \$24__t5 \$24 101.077481006
* device instance _24_t6 r0 *1 0,0
R_24_t6 \$24__t6 \$24 61.7498962671
* device instance _24_t7 r0 *1 0,0
R_24_t7 \$24__t7 \$24 65.141811665
* device instance _24_t8 r0 *1 0,0
R_24_t8 \$24__t8 \$24 68.601571927
* device instance _24_t9 r0 *1 0,0
R_24_t9 \$24__t9 \$24 72.119413618
* device instance _24 r0 *1 0,0
C_24 \$24 vsubs 8.8106853e-14
* device instance _25_t0 r0 *1 0,0
R_25_t0 \$25__t0 \$25 162.444438203
* device instance _25_t1 r0 *1 0,0
R_25_t1 \$25__t1 \$25 43.7126105743
* device instance _25_t2 r0 *1 0,0
R_25_t2 \$25__t2 \$25 200.179851222
* device instance _25 r0 *1 0,0
C_25 \$25 vsubs 7.553404e-15
* device instance _26_t0 r0 *1 0,0
R_26_t0 \$26__t0 \$26 622.968079763
* device instance _26_t1 r0 *1 0,0
R_26_t1 \$26__t1 \$26 96.1324088282
* device instance _26_t2 r0 *1 0,0
R_26_t2 \$26__t2 \$26 104.03086383
* device instance _26_t3 r0 *1 0,0
R_26_t3 \$26__t3 \$26 111.971229932
* device instance _26_t4 r0 *1 0,0
R_26_t4 \$26__t4 \$26 119.945183884
* device instance _26_t5 r0 *1 0,0
R_26_t5 \$26__t5 \$26 62.9996222332
* device instance _26_t6 r0 *1 0,0
R_26_t6 \$26__t6 \$26 56.9900757386
* device instance _26_t7 r0 *1 0,0
R_26_t7 \$26__t7 \$26 51.5843015367
* device instance _26_t8 r0 *1 0,0
R_26_t8 \$26__t8 \$26 46.9911342547
* device instance _26 r0 *1 0,0
C_26 \$26 vsubs 6.6967978e-14
* device instance _27_t0 r0 *1 0,0
R_27_t0 \$27__t0 \$27 108.687402234
* device instance _27_t1 r0 *1 0,0
R_27_t1 \$27__t1 \$27 28.7964709909
* device instance _27_t2 r0 *1 0,0
R_27_t2 \$27__t2 \$27 133.512826775
* device instance _27 r0 *1 0,0
C_27 \$27 vsubs 6.492519e-15
* device instance _29_t0 r0 *1 0,0
R_29_t0 \$29__t0 \$29 135.591504929
* device instance _29_t1 r0 *1 0,0
R_29_t1 \$29__t1 \$29 36.2048686624
* device instance _29_t2 r0 *1 0,0
R_29_t2 \$29__t2 \$29 166.824926409
* device instance _29 r0 *1 0,0
C_29 \$29 vsubs 7.022961e-15
* device instance _31_t0 r0 *1 0,0
R_31_t0 \$31__t0 \$31 108.687402234
* device instance _31_t1 r0 *1 0,0
R_31_t1 \$31__t1 \$31 28.7964709909
* device instance _31_t2 r0 *1 0,0
R_31_t2 \$31__t2 \$31 133.512826775
* device instance _31 r0 *1 0,0
C_31 \$31 vsubs 6.492519e-15
* device instance _33_t0 r0 *1 0,0
R_33_t0 \$33__t0 \$33 135.591504929
* device instance _33_t1 r0 *1 0,0
R_33_t1 \$33__t1 \$33 36.2048686624
* device instance _33_t2 r0 *1 0,0
R_33_t2 \$33__t2 \$33 166.824926409
* device instance _33 r0 *1 0,0
C_33 \$33 vsubs 7.022961e-15
* device instance _35_t0 r0 *1 0,0
R_35_t0 \$35__t0 \$35 108.687402234
* device instance _35_t1 r0 *1 0,0
R_35_t1 \$35__t1 \$35 28.7964709909
* device instance _35_t2 r0 *1 0,0
R_35_t2 \$35__t2 \$35 133.512826775
* device instance _35 r0 *1 0,0
C_35 \$35 vsubs 6.492519e-15
* device instance _37_t0 r0 *1 0,0
R_37_t0 \$37__t0 \$37 135.591504929
* device instance _37_t1 r0 *1 0,0
R_37_t1 \$37__t1 \$37 36.2048686624
* device instance _37_t2 r0 *1 0,0
R_37_t2 \$37__t2 \$37 166.824926409
* device instance _37 r0 *1 0,0
C_37 \$37 vsubs 7.022961e-15
* device instance _39_t0 r0 *1 0,0
R_39_t0 \$39__t0 \$39 108.687402234
* device instance _39_t1 r0 *1 0,0
R_39_t1 \$39__t1 \$39 28.7964709909
* device instance _39_t2 r0 *1 0,0
R_39_t2 \$39__t2 \$39 133.512826775
* device instance _39 r0 *1 0,0
C_39 \$39 vsubs 6.492519e-15
* device instance _41_t0 r0 *1 0,0
R_41_t0 \$41__t0 \$41 135.591504929
* device instance _41_t1 r0 *1 0,0
R_41_t1 \$41__t1 \$41 36.2048686624
* device instance _41_t2 r0 *1 0,0
R_41_t2 \$41__t2 \$41 166.824926409
* device instance _41 r0 *1 0,0
C_41 \$41 vsubs 7.022961e-15
* device instance _43_t0 r0 *1 0,0
R_43_t0 \$43__t0 \$43 108.687402234
* device instance _43_t1 r0 *1 0,0
R_43_t1 \$43__t1 \$43 28.7964709909
* device instance _43_t2 r0 *1 0,0
R_43_t2 \$43__t2 \$43 133.512826775
* device instance _43 r0 *1 0,0
C_43 \$43 vsubs 6.473346e-15
* device instance _45_t0 r0 *1 0,0
R_45_t0 \$45__t0 \$45 135.591504929
* device instance _45_t1 r0 *1 0,0
R_45_t1 \$45__t1 \$45 36.2048686624
* device instance _45_t2 r0 *1 0,0
R_45_t2 \$45__t2 \$45 166.824926409
* device instance _45 r0 *1 0,0
C_45 \$45 vsubs 7.017453e-15
* device instance _47_t0 r0 *1 0,0
R_47_t0 \$47__t0 \$47 108.687402234
* device instance _47_t1 r0 *1 0,0
R_47_t1 \$47__t1 \$47 28.7964709909
* device instance _47_t2 r0 *1 0,0
R_47_t2 \$47__t2 \$47 133.512826775
* device instance _47 r0 *1 0,0
C_47 \$47 vsubs 6.492519e-15
* device instance _49_t0 r0 *1 0,0
R_49_t0 \$49__t0 \$49 135.591504929
* device instance _49_t1 r0 *1 0,0
R_49_t1 \$49__t1 \$49 36.2048686624
* device instance _49_t2 r0 *1 0,0
R_49_t2 \$49__t2 \$49 166.824926409
* device instance _49 r0 *1 0,0
C_49 \$49 vsubs 7.022961e-15
* device instance _51_t0 r0 *1 0,0
R_51_t0 \$51__t0 \$51 108.687402234
* device instance _51_t1 r0 *1 0,0
R_51_t1 \$51__t1 \$51 28.7964709909
* device instance _51_t2 r0 *1 0,0
R_51_t2 \$51__t2 \$51 133.512826775
* device instance _51 r0 *1 0,0
C_51 \$51 vsubs 6.492519e-15
* device instance _53_t0 r0 *1 0,0
R_53_t0 \$53__t0 \$53 135.591504929
* device instance _53_t1 r0 *1 0,0
R_53_t1 \$53__t1 \$53 36.2048686624
* device instance _53_t2 r0 *1 0,0
R_53_t2 \$53__t2 \$53 166.824926409
* device instance _53 r0 *1 0,0
C_53 \$53 vsubs 7.022961e-15
* device instance _55_t0 r0 *1 0,0
R_55_t0 \$55__t0 \$55 108.687402234
* device instance _55_t1 r0 *1 0,0
R_55_t1 \$55__t1 \$55 28.7964709909
* device instance _55_t2 r0 *1 0,0
R_55_t2 \$55__t2 \$55 133.512826775
* device instance _55 r0 *1 0,0
C_55 \$55 vsubs 6.492519e-15
* device instance _57_t0 r0 *1 0,0
R_57_t0 \$57__t0 \$57 135.591504929
* device instance _57_t1 r0 *1 0,0
R_57_t1 \$57__t1 \$57 36.2048686624
* device instance _57_t2 r0 *1 0,0
R_57_t2 \$57__t2 \$57 166.824926409
* device instance _57 r0 *1 0,0
C_57 \$57 vsubs 7.022961e-15
* device instance _59_t0 r0 *1 0,0
R_59_t0 \$59__t0 \$59 108.687402234
* device instance _59_t1 r0 *1 0,0
R_59_t1 \$59__t1 \$59 28.7964709909
* device instance _59_t2 r0 *1 0,0
R_59_t2 \$59__t2 \$59 133.512826775
* device instance _59 r0 *1 0,0
C_59 \$59 vsubs 6.492519e-15
* device instance _61_t0 r0 *1 0,0
R_61_t0 \$61__t0 \$61 135.591504929
* device instance _61_t1 r0 *1 0,0
R_61_t1 \$61__t1 \$61 36.2048686624
* device instance _61_t2 r0 *1 0,0
R_61_t2 \$61__t2 \$61 166.824926409
* device instance _61 r0 *1 0,0
C_61 \$61 vsubs 7.022961e-15
* device instance _65_t0 r0 *1 0,0
R_65_t0 \$65__t0 \$65 100.29899174
* device instance _65_t1 r0 *1 0,0
R_65_t1 \$65__t1 \$65 21.4987692264
* device instance _65_t2 r0 *1 0,0
R_65_t2 \$65__t2 \$65 81.7777390336
* device instance _65 r0 *1 0,0
C_65 \$65 vsubs 5.962076e-15
* device instance _67_t0 r0 *1 0,0
R_67_t0 \$67__t0 \$67 81.7777390336
* device instance _67_t1 r0 *1 0,0
R_67_t1 \$67__t1 \$67 21.4987692264
* device instance _67_t2 r0 *1 0,0
R_67_t2 \$67__t2 \$67 100.29899174
* device instance _67 r0 *1 0,0
C_67 \$67 vsubs 5.962076e-15
* device instance _69_t0 r0 *1 0,0
R_69_t0 \$69__t0 \$69 81.7777390336
* device instance _69_t1 r0 *1 0,0
R_69_t1 \$69__t1 \$69 21.4987692264
* device instance _69_t2 r0 *1 0,0
R_69_t2 \$69__t2 \$69 100.29899174
* device instance _69 r0 *1 0,0
C_69 \$69 vsubs 5.962076e-15
* device instance _71_t0 r0 *1 0,0
R_71_t0 \$71__t0 \$71 81.7777390336
* device instance _71_t1 r0 *1 0,0
R_71_t1 \$71__t1 \$71 21.4987692264
* device instance _71_t2 r0 *1 0,0
R_71_t2 \$71__t2 \$71 100.29899174
* device instance _71 r0 *1 0,0
C_71 \$71 vsubs 5.962076e-15
* device instance _73_t0 r0 *1 0,0
R_73_t0 \$73__t0 \$73 81.7777390336
* device instance _73_t1 r0 *1 0,0
R_73_t1 \$73__t1 \$73 21.4987692264
* device instance _73_t2 r0 *1 0,0
R_73_t2 \$73__t2 \$73 100.29899174
* device instance _73 r0 *1 0,0
C_73 \$73 vsubs 5.956568e-15
* device instance _75_t0 r0 *1 0,0
R_75_t0 \$75__t0 \$75 81.7777390336
* device instance _75_t1 r0 *1 0,0
R_75_t1 \$75__t1 \$75 21.4987692264
* device instance _75_t2 r0 *1 0,0
R_75_t2 \$75__t2 \$75 100.29899174
* device instance _75 r0 *1 0,0
C_75 \$75 vsubs 5.962076e-15
* device instance _77_t0 r0 *1 0,0
R_77_t0 \$77__t0 \$77 81.7777390336
* device instance _77_t1 r0 *1 0,0
R_77_t1 \$77__t1 \$77 21.4987692264
* device instance _77_t2 r0 *1 0,0
R_77_t2 \$77__t2 \$77 100.29899174
* device instance _77 r0 *1 0,0
C_77 \$77 vsubs 5.962076e-15
* device instance _79_t0 r0 *1 0,0
R_79_t0 \$79__t0 \$79 81.7777390336
* device instance _79_t1 r0 *1 0,0
R_79_t1 \$79__t1 \$79 21.4987692264
* device instance _79_t2 r0 *1 0,0
R_79_t2 \$79__t2 \$79 100.29899174
* device instance _79 r0 *1 0,0
C_79 \$79 vsubs 5.962076e-15
* device instance _81_t0 r0 *1 0,0
R_81_t0 \$81__t0 \$81 81.7777390336
* device instance _81_t1 r0 *1 0,0
R_81_t1 \$81__t1 \$81 21.4987692264
* device instance _81_t2 r0 *1 0,0
R_81_t2 \$81__t2 \$81 100.29899174
* device instance _81 r0 *1 0,0
C_81 \$81 vsubs 5.962076e-15
* device instance _83_t0 r0 *1 0,0
R_83_t0 \$83__t0 \$83 81.7777390336
* device instance _83_t1 r0 *1 0,0
R_83_t1 \$83__t1 \$83 21.4987692264
* device instance _83_t2 r0 *1 0,0
R_83_t2 \$83__t2 \$83 100.29899174
* device instance _83 r0 *1 0,0
C_83 \$83 vsubs 5.956568e-15
* device instance _85_t0 r0 *1 0,0
R_85_t0 \$85__t0 \$85 108.687402234
* device instance _85_t1 r0 *1 0,0
R_85_t1 \$85__t1 \$85 28.7964709909
* device instance _85_t2 r0 *1 0,0
R_85_t2 \$85__t2 \$85 133.512826775
* device instance _85 r0 *1 0,0
C_85 \$85 vsubs 6.487011e-15
* device instance _87_t0 r0 *1 0,0
R_87_t0 \$87__t0 \$87 135.591504929
* device instance _87_t1 r0 *1 0,0
R_87_t1 \$87__t1 \$87 36.2048686624
* device instance _87_t2 r0 *1 0,0
R_87_t2 \$87__t2 \$87 166.824926409
* device instance _87 r0 *1 0,0
C_87 \$87 vsubs 7.017453e-15
* device instance _89_t0 r0 *1 0,0
R_89_t0 \$89__t0 \$89 162.444438203
* device instance _89_t1 r0 *1 0,0
R_89_t1 \$89__t1 \$89 43.7126105743
* device instance _89_t2 r0 *1 0,0
R_89_t2 \$89__t2 \$89 200.179851222
* device instance _89 r0 *1 0,0
C_89 \$89 vsubs 7.547896e-15
* device instance _9_t0 r0 *1 0,0
R_9_t0 \$9__t0 \$9 162.444438203
* device instance _9_t1 r0 *1 0,0
R_9_t1 \$9__t1 \$9 43.7126105743
* device instance _9_t2 r0 *1 0,0
R_9_t2 \$9__t2 \$9 200.179851222
* device instance _9 r0 *1 0,0
C_9 \$9 vsubs 7.553404e-15
* device instance _90_t0 r0 *1 0,0
R_90_t0 \$90__t0 \$90 12.3349378255
* device instance _90_t1 r0 *1 0,0
R_90_t1 \$90__t1 \$90 11.9711742807
* device instance _90_t2 r0 *1 0,0
R_90_t2 \$90__t2 \$90 12.0016803073
* device instance _90_t3 r0 *1 0,0
R_90_t3 \$90__t3 \$90 12.7429330978
* device instance _90_t4 r0 *1 0,0
R_90_t4 \$90__t4 \$90 2.72015529584
* device instance _90_t5 r0 *1 0,0
R_90_t5 \$90__t5 \$90 4.45011502559
* device instance _90_t6 r0 *1 0,0
R_90_t6 \$90__t6 \$90 2.99789655049
* device instance _90_t7 r0 *1 0,0
R_90_t7 \$90__t7 \$90 1.93161715335
* device instance _90_t8 r0 *1 0,0
R_90_t8 \$90__t8 \$90 2.00868291173
* device instance _90_t9 r0 *1 0,0
R_90_t9 \$90__t9 \$90 2.77541114905
* device instance _90_t10 r0 *1 0,0
R_90_t10 \$90__t10 \$90 3.45168996079
* device instance _90_t11 r0 *1 0,0
R_90_t11 \$90__t11 \$90 3.87269626421
* device instance _90_t12 r0 *1 0,0
R_90_t12 \$90__t12 \$90 4.73567750023
* device instance _90_t13 r0 *1 0,0
R_90_t13 \$90__t13 \$90 3.7934749148
* device instance _90_t14 r0 *1 0,0
R_90_t14 \$90__t14 \$90 4.84475218637
* device instance _90_t15 r0 *1 0,0
R_90_t15 \$90__t15 \$90 4.61755723353
* device instance _90_t16 r0 *1 0,0
R_90_t16 \$90__t16 \$90 6.18911951388
* device instance _90_t17 r0 *1 0,0
R_90_t17 \$90__t17 \$90 7.80054273897
* device instance _90_t18 r0 *1 0,0
R_90_t18 \$90__t18 \$90 9.43141743329
* device instance _90_t19 r0 *1 0,0
R_90_t19 \$90__t19 \$90 8.93837884831
* device instance _90_t20 r0 *1 0,0
R_90_t20 \$90__t20 \$90 7.42823825947
* device instance _90_t21 r0 *1 0,0
R_90_t21 \$90__t21 \$90 14.0816196874
* device instance _90_t22 r0 *1 0,0
R_90_t22 \$90__t22 \$90 12.4143653212
* device instance _90_t23 r0 *1 0,0
R_90_t23 \$90__t23 \$90 10.7471308147
* device instance _90_t24 r0 *1 0,0
R_90_t24 \$90__t24 \$90 9.07992710777
* device instance _90_t25 r0 *1 0,0
R_90_t25 \$90__t25 \$90 7.41277498171
* device instance _90_t26 r0 *1 0,0
R_90_t26 \$90__t26 \$90 13.6894741135
* device instance _90_t27 r0 *1 0,0
R_90_t27 \$90__t27 \$90 14.3222340158
* device instance _90_t28 r0 *1 0,0
R_90_t28 \$90__t28 \$90 12.6866402374
* device instance _90_t29 r0 *1 0,0
R_90_t29 \$90__t29 \$90 14.1936002197
* device instance _90_t30 r0 *1 0,0
R_90_t30 \$90__t30 \$90 12.5412415855
* device instance _90_t31 r0 *1 0,0
R_90_t31 \$90__t31 \$90 10.893442749
* device instance _90_t32 r0 *1 0,0
R_90_t32 \$90__t32 \$90 9.25264018864
* device instance _90_t33 r0 *1 0,0
R_90_t33 \$90__t33 \$90 3.55745467067
* device instance _90_t34 r0 *1 0,0
R_90_t34 \$90__t34 \$90 5.74571933614
* device instance _90_t35 r0 *1 0,0
R_90_t35 \$90__t35 \$90 6.00225587833
* device instance _90_t36 r0 *1 0,0
R_90_t36 \$90__t36 \$90 7.65312630853
* device instance _90_t37 r0 *1 0,0
R_90_t37 \$90__t37 \$90 9.30986090513
* device instance _90_t38 r0 *1 0,0
R_90_t38 \$90__t38 \$90 4.26093424344
* device instance _90_t39 r0 *1 0,0
R_90_t39 \$90__t39 \$90 5.92780955996
* device instance _90_t40 r0 *1 0,0
R_90_t40 \$90__t40 \$90 0.723560602061
* device instance _90_t41 r0 *1 0,0
R_90_t41 \$90__t41 \$90 1.89925056646
* device instance _90_t42 r0 *1 0,0
R_90_t42 \$90__t42 \$90 2.41269756694
* device instance _90_t43 r0 *1 0,0
R_90_t43 \$90__t43 \$90 0.75157877109
* device instance _90_t44 r0 *1 0,0
R_90_t44 \$90__t44 \$90 0.931951104907
* device instance _90_t45 r0 *1 0,0
R_90_t45 \$90__t45 \$90 4.18633479464
* device instance _90_t46 r0 *1 0,0
R_90_t46 \$90__t46 \$90 2.59022373538
* device instance _90_t47 r0 *1 0,0
R_90_t47 \$90__t47 \$90 1.20541283343
* device instance _90_t48 r0 *1 0,0
R_90_t48 \$90__t48 \$90 1.32539892552
* device instance _90_t49 r0 *1 0,0
R_90_t49 \$90__t49 \$90 4.07887846877
* device instance _90_t50 r0 *1 0,0
R_90_t50 \$90__t50 \$90 6.1518050386
* device instance _90_t51 r0 *1 0,0
R_90_t51 \$90__t51 \$90 7.5899948183
* device instance _90_t52 r0 *1 0,0
R_90_t52 \$90__t52 \$90 4.9989933798
* device instance _90_t53 r0 *1 0,0
R_90_t53 \$90__t53 \$90 6.47868044925
* device instance _90_t54 r0 *1 0,0
R_90_t54 \$90__t54 \$90 8.03222055405
* device instance _90_t55 r0 *1 0,0
R_90_t55 \$90__t55 \$90 9.623914734
* device instance _90_t56 r0 *1 0,0
R_90_t56 \$90__t56 \$90 10.6683811752
* device instance _90_t57 r0 *1 0,0
R_90_t57 \$90__t57 \$90 4.86223099382
* device instance _90_t58 r0 *1 0,0
R_90_t58 \$90__t58 \$90 9.10665902314
* device instance _90_t59 r0 *1 0,0
R_90_t59 \$90__t59 \$90 7.59487938315
* device instance _90_t60 r0 *1 0,0
R_90_t60 \$90__t60 \$90 9.26203868611
* device instance _90_t61 r0 *1 0,0
R_90_t61 \$90__t61 \$90 3.50009522681
* device instance _90_t62 r0 *1 0,0
R_90_t62 \$90__t62 \$90 5.14335314677
* device instance _90_t63 r0 *1 0,0
R_90_t63 \$90__t63 \$90 6.79833786312
* device instance _90_t64 r0 *1 0,0
R_90_t64 \$90__t64 \$90 8.45816853244
* device instance _90_t65 r0 *1 0,0
R_90_t65 \$90__t65 \$90 10.1204611189
* device instance _90_t66 r0 *1 0,0
R_90_t66 \$90__t66 \$90 4.36390995287
* device instance _90_t67 r0 *1 0,0
R_90_t67 \$90__t67 \$90 11.6557844627
* device instance _90_t68 r0 *1 0,0
R_90_t68 \$90__t68 \$90 12.1947563264
* device instance _90_t69 r0 *1 0,0
R_90_t69 \$90__t69 \$90 14.1131202245
* device instance _90_t70 r0 *1 0,0
R_90_t70 \$90__t70 \$90 12.4500849707
* device instance _90_t71 r0 *1 0,0
R_90_t71 \$90__t71 \$90 10.7883719902
* device instance _90_t72 r0 *1 0,0
R_90_t72 \$90__t72 \$90 13.2669166675
* device instance _90_t73 r0 *1 0,0
R_90_t73 \$90__t73 \$90 11.6023912073
* device instance _90_t74 r0 *1 0,0
R_90_t74 \$90__t74 \$90 9.93880207594
* device instance _90_t75 r0 *1 0,0
R_90_t75 \$90__t75 \$90 8.27671388869
* device instance _90_t76 r0 *1 0,0
R_90_t76 \$90__t76 \$90 6.6172577401
* device instance _90_t77 r0 *1 0,0
R_90_t77 \$90__t77 \$90 9.1287033982
* device instance _90_t78 r0 *1 0,0
R_90_t78 \$90__t78 \$90 7.47244152733
* device instance _90_t79 r0 *1 0,0
R_90_t79 \$90__t79 \$90 5.82249432284
* device instance _90_t80 r0 *1 0,0
R_90_t80 \$90__t80 \$90 9.44878036927
* device instance _90_t81 r0 *1 0,0
R_90_t81 \$90__t81 \$90 7.86025490133
* device instance _90_t82 r0 *1 0,0
R_90_t82 \$90__t82 \$90 6.31250068309
* device instance _90_t83 r0 *1 0,0
R_90_t83 \$90__t83 \$90 12.0832986129
* device instance _90_t84 r0 *1 0,0
R_90_t84 \$90__t84 \$90 10.4962093322
* device instance _90_t85 r0 *1 0,0
R_90_t85 \$90__t85 \$90 11.8641710125
* device instance _90_t86 r0 *1 0,0
R_90_t86 \$90__t86 \$90 11.0605241708
* device instance _90_t87 r0 *1 0,0
R_90_t87 \$90__t87 \$90 6.0149451259
* device instance _90_t88 r0 *1 0,0
R_90_t88 \$90__t88 \$90 7.62335274715
* device instance _90_t89 r0 *1 0,0
R_90_t89 \$90__t89 \$90 10.1957522624
* device instance _90_t90 r0 *1 0,0
R_90_t90 \$90__t90 \$90 11.8232423311
* device instance _90_t91 r0 *1 0,0
R_90_t91 \$90__t91 \$90 13.4604849599
* device instance _90_t92 r0 *1 0,0
R_90_t92 \$90__t92 \$90 7.32348476847
* device instance _90_t93 r0 *1 0,0
R_90_t93 \$90__t93 \$90 4.15661097375
* device instance _90_t94 r0 *1 0,0
R_90_t94 \$90__t94 \$90 10.4223373511
* device instance _90_t95 r0 *1 0,0
R_90_t95 \$90__t95 \$90 12.0191851172
* device instance _90_t96 r0 *1 0,0
R_90_t96 \$90__t96 \$90 13.6329163064
* device instance _90_t97 r0 *1 0,0
R_90_t97 \$90__t97 \$90 6.99726214248
* device instance _90_t98 r0 *1 0,0
R_90_t98 \$90__t98 \$90 7.03009051256
* device instance _90_t99 r0 *1 0,0
R_90_t99 \$90__t99 \$90 8.44737325176
* device instance _90_t100 r0 *1 0,0
R_90_t100 \$90__t100 \$90 9.94253278634
* device instance _90_t101 r0 *1 0,0
R_90_t101 \$90__t101 \$90 11.4851949341
* device instance _90_t102 r0 *1 0,0
R_90_t102 \$90__t102 \$90 8.85151523471
* device instance _90_t103 r0 *1 0,0
R_90_t103 \$90__t103 \$90 11.3181461955
* device instance _90_t104 r0 *1 0,0
R_90_t104 \$90__t104 \$90 8.3345545798
* device instance _90_t105 r0 *1 0,0
R_90_t105 \$90__t105 \$90 14.5229397516
* device instance _90_t106 r0 *1 0,0
R_90_t106 \$90__t106 \$90 10.0335232003
* device instance _90_t107 r0 *1 0,0
R_90_t107 \$90__t107 \$90 11.6836331179
* device instance _90_t108 r0 *1 0,0
R_90_t108 \$90__t108 \$90 13.338023803
* device instance _90_t109 r0 *1 0,0
R_90_t109 \$90__t109 \$90 13.0199916625
* device instance _90_t110 r0 *1 0,0
R_90_t110 \$90__t110 \$90 5.87174909807
* device instance _90_t111 r0 *1 0,0
R_90_t111 \$90__t111 \$90 11.5622008229
* device instance _90_t112 r0 *1 0,0
R_90_t112 \$90__t112 \$90 10.1690065375
* device instance _90_t113 r0 *1 0,0
R_90_t113 \$90__t113 \$90 8.87089629988
* device instance _90_t114 r0 *1 0,0
R_90_t114 \$90__t114 \$90 14.2016822211
* device instance _90_t115 r0 *1 0,0
R_90_t115 \$90__t115 \$90 12.6606548714
* device instance _90_t116 r0 *1 0,0
R_90_t116 \$90__t116 \$90 11.1560067564
* device instance _90_t117 r0 *1 0,0
R_90_t117 \$90__t117 \$90 9.70467376268
* device instance _90_t118 r0 *1 0,0
R_90_t118 \$90__t118 \$90 5.45945838041
* device instance _90_t119 r0 *1 0,0
R_90_t119 \$90__t119 \$90 9.8935912261
* device instance _90_t120 r0 *1 0,0
R_90_t120 \$90__t120 \$90 11.1972760394
* device instance _90_t121 r0 *1 0,0
R_90_t121 \$90__t121 \$90 12.5870860475
* device instance _90_t122 r0 *1 0,0
R_90_t122 \$90__t122 \$90 14.0374634727
* device instance _90_t123 r0 *1 0,0
R_90_t123 \$90__t123 \$90 15.5314496245
* device instance _90_t124 r0 *1 0,0
R_90_t124 \$90__t124 \$90 4.11992142817
* device instance _90_t125 r0 *1 0,0
R_90_t125 \$90__t125 \$90 4.71486918956
* device instance _90_t126 r0 *1 0,0
R_90_t126 \$90__t126 \$90 5.74857647493
* device instance _90_t127 r0 *1 0,0
R_90_t127 \$90__t127 \$90 5.531065027
* device instance _90_t128 r0 *1 0,0
R_90_t128 \$90__t128 \$90 6.27967816302
* device instance _90_t129 r0 *1 0,0
R_90_t129 \$90__t129 \$90 7.04741162467
* device instance _90_t130 r0 *1 0,0
R_90_t130 \$90__t130 \$90 10.1091168036
* device instance _90_t131 r0 *1 0,0
R_90_t131 \$90__t131 \$90 8.60761725274
* device instance _90_t132 r0 *1 0,0
R_90_t132 \$90__t132 \$90 7.17968022298
* device instance _90_t133 r0 *1 0,0
R_90_t133 \$90__t133 \$90 5.87915321726
* device instance _90_t134 r0 *1 0,0
R_90_t134 \$90__t134 \$90 4.81050705363
* device instance _90_t135 r0 *1 0,0
R_90_t135 \$90__t135 \$90 13.0585354559
* device instance _90_t136 r0 *1 0,0
R_90_t136 \$90__t136 \$90 7.09287024839
* device instance _90_t137 r0 *1 0,0
R_90_t137 \$90__t137 \$90 7.71600994556
* device instance _90_t138 r0 *1 0,0
R_90_t138 \$90__t138 \$90 14.6526753511
* device instance _90_t139 r0 *1 0,0
R_90_t139 \$90__t139 \$90 7.5414769664
* device instance _90_t140 r0 *1 0,0
R_90_t140 \$90__t140 \$90 8.87748934522
* device instance _90_t141 r0 *1 0,0
R_90_t141 \$90__t141 \$90 10.3104636378
* device instance _90_t142 r0 *1 0,0
R_90_t142 \$90__t142 \$90 11.8051431543
* device instance _90_t143 r0 *1 0,0
R_90_t143 \$90__t143 \$90 13.3408039665
* device instance _90_t144 r0 *1 0,0
R_90_t144 \$90__t144 \$90 14.9047843716
* device instance _90_t145 r0 *1 0,0
R_90_t145 \$90__t145 \$90 8.58356396184
* device instance _90_t146 r0 *1 0,0
R_90_t146 \$90__t146 \$90 8.10651295767
* device instance _90_t147 r0 *1 0,0
R_90_t147 \$90__t147 \$90 9.36223769046
* device instance _90_t148 r0 *1 0,0
R_90_t148 \$90__t148 \$90 10.730672762
* device instance _90_t149 r0 *1 0,0
R_90_t149 \$90__t149 \$90 12.1738688342
* device instance _90_t150 r0 *1 0,0
R_90_t150 \$90__t150 \$90 13.6681647624
* device instance _90_t151 r0 *1 0,0
R_90_t151 \$90__t151 \$90 15.1984958027
* device instance _90_t152 r0 *1 0,0
R_90_t152 \$90__t152 \$90 8.71476936639
* device instance _90_t153 r0 *1 0,0
R_90_t153 \$90__t153 \$90 12.5182038212
* device instance _90_t154 r0 *1 0,0
R_90_t154 \$90__t154 \$90 10.9664218167
* device instance _90_t155 r0 *1 0,0
R_90_t155 \$90__t155 \$90 9.45406204373
* device instance _90_t156 r0 *1 0,0
R_90_t156 \$90__t156 \$90 8.00350372679
* device instance _90_t157 r0 *1 0,0
R_90_t157 \$90__t157 \$90 6.65528029432
* device instance _90_t158 r0 *1 0,0
R_90_t158 \$90__t158 \$90 5.48537517407
* device instance _90_t159 r0 *1 0,0
R_90_t159 \$90__t159 \$90 4.63096392966
* device instance _90_t160 r0 *1 0,0
R_90_t160 \$90__t160 \$90 4.28511541833
* device instance _90_t161 r0 *1 0,0
R_90_t161 \$90__t161 \$90 4.56492086374
* device instance _90_t162 r0 *1 0,0
R_90_t162 \$90__t162 \$90 5.37351765133
* device instance _90_t163 r0 *1 0,0
R_90_t163 \$90__t163 \$90 6.51696114145
* device instance _90_t164 r0 *1 0,0
R_90_t164 \$90__t164 \$90 7.85027223747
* device instance _90_t165 r0 *1 0,0
R_90_t165 \$90__t165 \$90 9.29207549468
* device instance _90_t166 r0 *1 0,0
R_90_t166 \$90__t166 \$90 10.7990027738
* device instance _90_t167 r0 *1 0,0
R_90_t167 \$90__t167 \$90 12.3472327236
* device instance _90_t168 r0 *1 0,0
R_90_t168 \$90__t168 \$90 13.922993646
* device instance _90_t169 r0 *1 0,0
R_90_t169 \$90__t169 \$90 6.86697660991
* device instance _90_t170 r0 *1 0,0
R_90_t170 \$90__t170 \$90 7.83318471356
* device instance _90_t171 r0 *1 0,0
R_90_t171 \$90__t171 \$90 9.00678071597
* device instance _90_t172 r0 *1 0,0
R_90_t172 \$90__t172 \$90 10.3172339359
* device instance _90_t173 r0 *1 0,0
R_90_t173 \$90__t173 \$90 11.7187215353
* device instance _90_t174 r0 *1 0,0
R_90_t174 \$90__t174 \$90 6.77795831427
* device instance _90_t175 r0 *1 0,0
R_90_t175 \$90__t175 \$90 6.15666544917
* device instance _90_t176 r0 *1 0,0
R_90_t176 \$90__t176 \$90 5.95216272537
* device instance _90_t177 r0 *1 0,0
R_90_t177 \$90__t177 \$90 6.0591020614
* device instance _90_t178 r0 *1 0,0
R_90_t178 \$90__t178 \$90 5.35504699638
* device instance _90_t179 r0 *1 0,0
R_90_t179 \$90__t179 \$90 5.11861699971
* device instance _90_t180 r0 *1 0,0
R_90_t180 \$90__t180 \$90 5.41145569686
* device instance _90_t181 r0 *1 0,0
R_90_t181 \$90__t181 \$90 6.15851984178
* device instance _90_t182 r0 *1 0,0
R_90_t182 \$90__t182 \$90 7.22016493144
* device instance _90_t183 r0 *1 0,0
R_90_t183 \$90__t183 \$90 8.47903872771
* device instance _90_t184 r0 *1 0,0
R_90_t184 \$90__t184 \$90 9.85988412548
* device instance _90_t185 r0 *1 0,0
R_90_t185 \$90__t185 \$90 6.00189403074
* device instance _90_t186 r0 *1 0,0
R_90_t186 \$90__t186 \$90 4.96307448218
* device instance _90_t187 r0 *1 0,0
R_90_t187 \$90__t187 \$90 10.2134976558
* device instance _90_t188 r0 *1 0,0
R_90_t188 \$90__t188 \$90 8.56927161606
* device instance _90_t189 r0 *1 0,0
R_90_t189 \$90__t189 \$90 6.93607949838
* device instance _90_t190 r0 *1 0,0
R_90_t190 \$90__t190 \$90 5.32408515138
* device instance _90_t191 r0 *1 0,0
R_90_t191 \$90__t191 \$90 3.76064724528
* device instance _90_t192 r0 *1 0,0
R_90_t192 \$90__t192 \$90 2.34498482318
* device instance _90_t193 r0 *1 0,0
R_90_t193 \$90__t193 \$90 1.55413675447
* device instance _90_t194 r0 *1 0,0
R_90_t194 \$90__t194 \$90 2.2117028271
* device instance _90_t195 r0 *1 0,0
R_90_t195 \$90__t195 \$90 3.59552761807
* device instance _90_t196 r0 *1 0,0
R_90_t196 \$90__t196 \$90 5.15013683531
* device instance _90_t197 r0 *1 0,0
R_90_t197 \$90__t197 \$90 6.7586907834
* device instance _90_t198 r0 *1 0,0
R_90_t198 \$90__t198 \$90 8.3902201343
* device instance _90_t199 r0 *1 0,0
R_90_t199 \$90__t199 \$90 6.20579196224
* device instance _90_t200 r0 *1 0,0
R_90_t200 \$90__t200 \$90 3.32205023225
* device instance _90_t201 r0 *1 0,0
R_90_t201 \$90__t201 \$90 4.70063780266
* device instance _90_t202 r0 *1 0,0
R_90_t202 \$90__t202 \$90 12.2579515559
* device instance _90_t203 r0 *1 0,0
R_90_t203 \$90__t203 \$90 11.2375621778
* device instance _90_t204 r0 *1 0,0
R_90_t204 \$90__t204 \$90 11.0731523828
* device instance _90_t205 r0 *1 0,0
R_90_t205 \$90__t205 \$90 4.17423574903
* device instance _90_t206 r0 *1 0,0
R_90_t206 \$90__t206 \$90 5.62384735605
* device instance _90_t207 r0 *1 0,0
R_90_t207 \$90__t207 \$90 10.5957096229
* device instance _90_t208 r0 *1 0,0
R_90_t208 \$90__t208 \$90 9.02141585773
* device instance _90_t209 r0 *1 0,0
R_90_t209 \$90__t209 \$90 3.66776251539
* device instance _90_t210 r0 *1 0,0
R_90_t210 \$90__t210 \$90 3.22007284078
* device instance _90_t211 r0 *1 0,0
R_90_t211 \$90__t211 \$90 3.58401415228
* device instance _90_t212 r0 *1 0,0
R_90_t212 \$90__t212 \$90 1.73200123806
* device instance _90_t213 r0 *1 0,0
R_90_t213 \$90__t213 \$90 2.85891688938
* device instance _90_t214 r0 *1 0,0
R_90_t214 \$90__t214 \$90 4.02611416099
* device instance _90_t215 r0 *1 0,0
R_90_t215 \$90__t215 \$90 4.56961124174
* device instance _90_t216 r0 *1 0,0
R_90_t216 \$90__t216 \$90 2.96322969173
* device instance _90_t217 r0 *1 0,0
R_90_t217 \$90__t217 \$90 3.68326897908
* device instance _90_t218 r0 *1 0,0
R_90_t218 \$90__t218 \$90 3.14616756798
* device instance _90_t219 r0 *1 0,0
R_90_t219 \$90__t219 \$90 2.76047924058
* device instance _90_t220 r0 *1 0,0
R_90_t220 \$90__t220 \$90 2.59462833328
* device instance _90_t221 r0 *1 0,0
R_90_t221 \$90__t221 \$90 2.38686351445
* device instance _90_t222 r0 *1 0,0
R_90_t222 \$90__t222 \$90 11.7841738237
* device instance _90_t223 r0 *1 0,0
R_90_t223 \$90__t223 \$90 10.9292465209
* device instance _90_t224 r0 *1 0,0
R_90_t224 \$90__t224 \$90 10.9698030504
* device instance _90_t225 r0 *1 0,0
R_90_t225 \$90__t225 \$90 9.50707391828
* device instance _90_t226 r0 *1 0,0
R_90_t226 \$90__t226 \$90 8.23657621966
* device instance _90_t227 r0 *1 0,0
R_90_t227 \$90__t227 \$90 7.13146704894
* device instance _90_t228 r0 *1 0,0
R_90_t228 \$90__t228 \$90 10.4711959569
* device instance _90_t229 r0 *1 0,0
R_90_t229 \$90__t229 \$90 9.03010393016
* device instance _90_t230 r0 *1 0,0
R_90_t230 \$90__t230 \$90 7.68111387262
* device instance _90_t231 r0 *1 0,0
R_90_t231 \$90__t231 \$90 6.48198617493
* device instance _90_t232 r0 *1 0,0
R_90_t232 \$90__t232 \$90 11.3454517337
* device instance _90_t233 r0 *1 0,0
R_90_t233 \$90__t233 \$90 10.3729123562
* device instance _90_t234 r0 *1 0,0
R_90_t234 \$90__t234 \$90 8.75866384872
* device instance _90_t235 r0 *1 0,0
R_90_t235 \$90__t235 \$90 7.16874990448
* device instance _90_t236 r0 *1 0,0
R_90_t236 \$90__t236 \$90 7.02420893811
* device instance _90_t237 r0 *1 0,0
R_90_t237 \$90__t237 \$90 6.618341732
* device instance _90_t238 r0 *1 0,0
R_90_t238 \$90__t238 \$90 6.5953608748
* device instance _90_t239 r0 *1 0,0
R_90_t239 \$90__t239 \$90 6.98247978652
* device instance _90_t240 r0 *1 0,0
R_90_t240 \$90__t240 \$90 7.71823580766
* device instance _90_t241 r0 *1 0,0
R_90_t241 \$90__t241 \$90 4.94221152867
* device instance _90_t242 r0 *1 0,0
R_90_t242 \$90__t242 \$90 5.44809083024
* device instance _90_t243 r0 *1 0,0
R_90_t243 \$90__t243 \$90 10.8852019855
* device instance _90_t244 r0 *1 0,0
R_90_t244 \$90__t244 \$90 6.36379082843
* device instance _90_t245 r0 *1 0,0
R_90_t245 \$90__t245 \$90 4.97283792285
* device instance _90_t246 r0 *1 0,0
R_90_t246 \$90__t246 \$90 5.79403093754
* device instance _90_t247 r0 *1 0,0
R_90_t247 \$90__t247 \$90 5.76776666417
* device instance _90_t248 r0 *1 0,0
R_90_t248 \$90__t248 \$90 10.0307580603
* device instance _90_t249 r0 *1 0,0
R_90_t249 \$90__t249 \$90 8.83588369088
* device instance _90_t250 r0 *1 0,0
R_90_t250 \$90__t250 \$90 7.81597562986
* device instance _90_t251 r0 *1 0,0
R_90_t251 \$90__t251 \$90 12.8274491911
* device instance _90_t252 r0 *1 0,0
R_90_t252 \$90__t252 \$90 13.182240093
* device instance _90_t253 r0 *1 0,0
R_90_t253 \$90__t253 \$90 7.48750471494
* device instance _90_t254 r0 *1 0,0
R_90_t254 \$90__t254 \$90 6.02489923131
* device instance _90_t255 r0 *1 0,0
R_90_t255 \$90__t255 \$90 6.20671984165
* device instance _90_t256 r0 *1 0,0
R_90_t256 \$90__t256 \$90 37.2674064091
* device instance _90_t257 r0 *1 0,0
R_90_t257 \$90__t257 \$90 36.9042620116
* device instance _90_t258 r0 *1 0,0
R_90_t258 \$90__t258 \$90 36.5413601111
* device instance _90_t259 r0 *1 0,0
R_90_t259 \$90__t259 \$90 36.1787080051
* device instance _90_t260 r0 *1 0,0
R_90_t260 \$90__t260 \$90 39.7584628044
* device instance _90_t261 r0 *1 0,0
R_90_t261 \$90__t261 \$90 40.4852826985
* device instance _90_t262 r0 *1 0,0
R_90_t262 \$90__t262 \$90 39.3953829052
* device instance _90_t263 r0 *1 0,0
R_90_t263 \$90__t263 \$90 40.1217647278
* device instance _90 r0 *1 0,0
C_90 \$90 vsubs 5.73919448e-13
* device instance _92_t0 r0 *1 0,0
R_92_t0 \$92__t0 \$92 81.7777390336
* device instance _92_t1 r0 *1 0,0
R_92_t1 \$92__t1 \$92 21.4987692264
* device instance _92_t2 r0 *1 0,0
R_92_t2 \$92__t2 \$92 100.29899174
* device instance _92 r0 *1 0,0
C_92 \$92 vsubs 5.956568e-15
* device instance _94_t0 r0 *1 0,0
R_94_t0 \$94__t0 \$94 108.687402234
* device instance _94_t1 r0 *1 0,0
R_94_t1 \$94__t1 \$94 28.7964709909
* device instance _94_t2 r0 *1 0,0
R_94_t2 \$94__t2 \$94 133.512826775
* device instance _94 r0 *1 0,0
C_94 \$94 vsubs 6.487011e-15
* device instance _96_t0 r0 *1 0,0
R_96_t0 \$96__t0 \$96 135.591504929
* device instance _96_t1 r0 *1 0,0
R_96_t1 \$96__t1 \$96 36.2048686624
* device instance _96_t2 r0 *1 0,0
R_96_t2 \$96__t2 \$96 166.824926409
* device instance _96 r0 *1 0,0
C_96 \$96 vsubs 7.017453e-15
* device instance _98_t0 r0 *1 0,0
R_98_t0 \$98__t0 \$98 162.444438203
* device instance _98_t1 r0 *1 0,0
R_98_t1 \$98__t1 \$98 43.7126105743
* device instance _98_t2 r0 *1 0,0
R_98_t2 \$98__t2 \$98 200.179851222
* device instance _98 r0 *1 0,0
C_98 \$98 vsubs 7.547896e-15
* device instance _99_t0 r0 *1 0,0
R_99_t0 \$99__t0 \$99 17.1597305229
* device instance _99_t1 r0 *1 0,0
R_99_t1 \$99__t1 \$99 14.8504486127
* device instance _99_t2 r0 *1 0,0
R_99_t2 \$99__t2 \$99 5.96454825955
* device instance _99_t3 r0 *1 0,0
R_99_t3 \$99__t3 \$99 3.86021875103
* device instance _99_t4 r0 *1 0,0
R_99_t4 \$99__t4 \$99 2.28909156088
* device instance _99_t5 r0 *1 0,0
R_99_t5 \$99__t5 \$99 2.56744815829
* device instance _99_t6 r0 *1 0,0
R_99_t6 \$99__t6 \$99 3.4015072788
* device instance _99_t7 r0 *1 0,0
R_99_t7 \$99__t7 \$99 3.59473248506
* device instance _99_t8 r0 *1 0,0
R_99_t8 \$99__t8 \$99 4.46689356376
* device instance _99_t9 r0 *1 0,0
R_99_t9 \$99__t9 \$99 6.26704359114
* device instance _99_t10 r0 *1 0,0
R_99_t10 \$99__t10 \$99 4.90997835943
* device instance _99_t11 r0 *1 0,0
R_99_t11 \$99__t11 \$99 4.35394515583
* device instance _99_t12 r0 *1 0,0
R_99_t12 \$99__t12 \$99 6.50654173102
* device instance _99_t13 r0 *1 0,0
R_99_t13 \$99__t13 \$99 8.7593681666
* device instance _99_t14 r0 *1 0,0
R_99_t14 \$99__t14 \$99 10.6520479543
* device instance _99_t15 r0 *1 0,0
R_99_t15 \$99__t15 \$99 11.0512974153
* device instance _99_t16 r0 *1 0,0
R_99_t16 \$99__t16 \$99 13.3622235032
* device instance _99_t17 r0 *1 0,0
R_99_t17 \$99__t17 \$99 8.09054891583
* device instance _99_t18 r0 *1 0,0
R_99_t18 \$99__t18 \$99 12.2824618885
* device instance _99_t19 r0 *1 0,0
R_99_t19 \$99__t19 \$99 10.1316990998
* device instance _99_t20 r0 *1 0,0
R_99_t20 \$99__t20 \$99 21.3030755677
* device instance _99_t21 r0 *1 0,0
R_99_t21 \$99__t21 \$99 4.60777607956
* device instance _99_t22 r0 *1 0,0
R_99_t22 \$99__t22 \$99 19.0147493078
* device instance _99_t23 r0 *1 0,0
R_99_t23 \$99__t23 \$99 19.9306447188
* device instance _99_t24 r0 *1 0,0
R_99_t24 \$99__t24 \$99 19.7711984289
* device instance _99_t25 r0 *1 0,0
R_99_t25 \$99__t25 \$99 17.4397978532
* device instance _99_t26 r0 *1 0,0
R_99_t26 \$99__t26 \$99 15.113107209
* device instance _99_t27 r0 *1 0,0
R_99_t27 \$99__t27 \$99 12.7936964308
* device instance _99_t28 r0 *1 0,0
R_99_t28 \$99__t28 \$99 6.47349577385
* device instance _99_t29 r0 *1 0,0
R_99_t29 \$99__t29 \$99 12.8209737834
* device instance _99_t30 r0 *1 0,0
R_99_t30 \$99__t30 \$99 5.0286330164
* device instance _99_t31 r0 *1 0,0
R_99_t31 \$99__t31 \$99 6.97605883656
* device instance _99_t32 r0 *1 0,0
R_99_t32 \$99__t32 \$99 9.11355267016
* device instance _99_t33 r0 *1 0,0
R_99_t33 \$99__t33 \$99 11.3340851486
* device instance _99_t34 r0 *1 0,0
R_99_t34 \$99__t34 \$99 13.5970338141
* device instance _99_t35 r0 *1 0,0
R_99_t35 \$99__t35 \$99 8.57718374456
* device instance _99_t36 r0 *1 0,0
R_99_t36 \$99__t36 \$99 6.68455195648
* device instance _99_t37 r0 *1 0,0
R_99_t37 \$99__t37 \$99 14.4941233587
* device instance _99_t38 r0 *1 0,0
R_99_t38 \$99__t38 \$99 15.1896448332
* device instance _99_t39 r0 *1 0,0
R_99_t39 \$99__t39 \$99 16.6961153028
* device instance _99_t40 r0 *1 0,0
R_99_t40 \$99__t40 \$99 15.3211070456
* device instance _99_t41 r0 *1 0,0
R_99_t41 \$99__t41 \$99 13.0387491715
* device instance _99_t42 r0 *1 0,0
R_99_t42 \$99__t42 \$99 10.7840084066
* device instance _99_t43 r0 *1 0,0
R_99_t43 \$99__t43 \$99 16.7425670772
* device instance _99_t44 r0 *1 0,0
R_99_t44 \$99__t44 \$99 17.6203535933
* device instance _99_t45 r0 *1 0,0
R_99_t45 \$99__t45 \$99 10.4863971753
* device instance _99_t46 r0 *1 0,0
R_99_t46 \$99__t46 \$99 10.0021892576
* device instance _99_t47 r0 *1 0,0
R_99_t47 \$99__t47 \$99 10.7582468533
* device instance _99_t48 r0 *1 0,0
R_99_t48 \$99__t48 \$99 16.5694769362
* device instance _99_t49 r0 *1 0,0
R_99_t49 \$99__t49 \$99 18.8625211688
* device instance _99_t50 r0 *1 0,0
R_99_t50 \$99__t50 \$99 21.1673106994
* device instance _99_t51 r0 *1 0,0
R_99_t51 \$99__t51 \$99 9.84303511394
* device instance _99_t52 r0 *1 0,0
R_99_t52 \$99__t52 \$99 10.347696672
* device instance _99_t53 r0 *1 0,0
R_99_t53 \$99__t53 \$99 12.4612346823
* device instance _99_t54 r0 *1 0,0
R_99_t54 \$99__t54 \$99 14.6459247473
* device instance _99_t55 r0 *1 0,0
R_99_t55 \$99__t55 \$99 16.8741533744
* device instance _99_t56 r0 *1 0,0
R_99_t56 \$99__t56 \$99 19.1307132905
* device instance _99_t57 r0 *1 0,0
R_99_t57 \$99__t57 \$99 21.4066468277
* device instance _99_t58 r0 *1 0,0
R_99_t58 \$99__t58 \$99 11.9475827716
* device instance _99_t59 r0 *1 0,0
R_99_t59 \$99__t59 \$99 14.0163788736
* device instance _99_t60 r0 *1 0,0
R_99_t60 \$99__t60 \$99 16.1612566924
* device instance _99_t61 r0 *1 0,0
R_99_t61 \$99__t61 \$99 6.16604804881
* device instance _99_t62 r0 *1 0,0
R_99_t62 \$99__t62 \$99 6.90517901085
* device instance _99_t63 r0 *1 0,0
R_99_t63 \$99__t63 \$99 8.26777142322
* device instance _99_t64 r0 *1 0,0
R_99_t64 \$99__t64 \$99 18.3555647564
* device instance _99_t65 r0 *1 0,0
R_99_t65 \$99__t65 \$99 5.58883592524
* device instance _99_t66 r0 *1 0,0
R_99_t66 \$99__t66 \$99 14.5371670319
* device instance _99_t67 r0 *1 0,0
R_99_t67 \$99__t67 \$99 12.4463401419
* device instance _99_t68 r0 *1 0,0
R_99_t68 \$99__t68 \$99 10.4645467673
* device instance _99_t69 r0 *1 0,0
R_99_t69 \$99__t69 \$99 8.66690796442
* device instance _99_t70 r0 *1 0,0
R_99_t70 \$99__t70 \$99 7.19284691802
* device instance _99_t71 r0 *1 0,0
R_99_t71 \$99__t71 \$99 6.27471102216
* device instance _99_t72 r0 *1 0,0
R_99_t72 \$99__t72 \$99 4.58754845623
* device instance _99_t73 r0 *1 0,0
R_99_t73 \$99__t73 \$99 20.5835005691
* device instance _99_t74 r0 *1 0,0
R_99_t74 \$99__t74 \$99 12.0454507449
* device instance _99_t75 r0 *1 0,0
R_99_t75 \$99__t75 \$99 12.5873277346
* device instance _99_t76 r0 *1 0,0
R_99_t76 \$99__t76 \$99 14.5655402283
* device instance _99_t77 r0 *1 0,0
R_99_t77 \$99__t77 \$99 16.6397807464
* device instance _99_t78 r0 *1 0,0
R_99_t78 \$99__t78 \$99 18.7782545232
* device instance _99_t79 r0 *1 0,0
R_99_t79 \$99__t79 \$99 14.2938317306
* device instance _99_t80 r0 *1 0,0
R_99_t80 \$99__t80 \$99 20.9613115308
* device instance _99_t81 r0 *1 0,0
R_99_t81 \$99__t81 \$99 15.4317439468
* device instance _99_t82 r0 *1 0,0
R_99_t82 \$99__t82 \$99 13.2745726711
* device instance _99_t83 r0 *1 0,0
R_99_t83 \$99__t83 \$99 11.1938838865
* device instance _99_t84 r0 *1 0,0
R_99_t84 \$99__t84 \$99 9.24148212318
* device instance _99_t85 r0 *1 0,0
R_99_t85 \$99__t85 \$99 7.51798814205
* device instance _99_t86 r0 *1 0,0
R_99_t86 \$99__t86 \$99 6.21679162253
* device instance _99_t87 r0 *1 0,0
R_99_t87 \$99__t87 \$99 5.63826648493
* device instance _99_t88 r0 *1 0,0
R_99_t88 \$99__t88 \$99 7.14931788483
* device instance _99_t89 r0 *1 0,0
R_99_t89 \$99__t89 \$99 8.79169452408
* device instance _99_t90 r0 *1 0,0
R_99_t90 \$99__t90 \$99 10.6999176396
* device instance _99_t91 r0 *1 0,0
R_99_t91 \$99__t91 \$99 12.7552256306
* device instance _99_t92 r0 *1 0,0
R_99_t92 \$99__t92 \$99 14.8968628503
* device instance _99_t93 r0 *1 0,0
R_99_t93 \$99__t93 \$99 17.0924095194
* device instance _99_t94 r0 *1 0,0
R_99_t94 \$99__t94 \$99 19.3234987019
* device instance _99_t95 r0 *1 0,0
R_99_t95 \$99__t95 \$99 5.99539809647
* device instance _99_t96 r0 *1 0,0
R_99_t96 \$99__t96 \$99 21.5791088668
* device instance _99_t97 r0 *1 0,0
R_99_t97 \$99__t97 \$99 8.57868831302
* device instance _99_t98 r0 *1 0,0
R_99_t98 \$99__t98 \$99 8.20143777507
* device instance _99_t99 r0 *1 0,0
R_99_t99 \$99__t99 \$99 15.0433310937
* device instance _99_t100 r0 *1 0,0
R_99_t100 \$99__t100 \$99 15.6837513956
* device instance _99_t101 r0 *1 0,0
R_99_t101 \$99__t101 \$99 6.23836905483
* device instance _99_t102 r0 *1 0,0
R_99_t102 \$99__t102 \$99 12.9923388395
* device instance _99_t103 r0 *1 0,0
R_99_t103 \$99__t103 \$99 10.8576988992
* device instance _99_t104 r0 *1 0,0
R_99_t104 \$99__t104 \$99 4.93727028593
* device instance _99_t105 r0 *1 0,0
R_99_t105 \$99__t105 \$99 5.34147800299
* device instance _99_t106 r0 *1 0,0
R_99_t106 \$99__t106 \$99 6.61054726476
* device instance _99_t107 r0 *1 0,0
R_99_t107 \$99__t107 \$99 4.28274457509
* device instance _99_t108 r0 *1 0,0
R_99_t108 \$99__t108 \$99 5.78876921104
* device instance _99_t109 r0 *1 0,0
R_99_t109 \$99__t109 \$99 7.72599478158
* device instance _99_t110 r0 *1 0,0
R_99_t110 \$99__t110 \$99 8.35945461893
* device instance _99_t111 r0 *1 0,0
R_99_t111 \$99__t111 \$99 3.76658356012
* device instance _99_t112 r0 *1 0,0
R_99_t112 \$99__t112 \$99 5.17799065593
* device instance _99_t113 r0 *1 0,0
R_99_t113 \$99__t113 \$99 15.8842805765
* device instance _99_t114 r0 *1 0,0
R_99_t114 \$99__t114 \$99 13.0616793844
* device instance _99_t115 r0 *1 0,0
R_99_t115 \$99__t115 \$99 11.1894067965
* device instance _99_t116 r0 *1 0,0
R_99_t116 \$99__t116 \$99 9.5295004631
* device instance _99_t117 r0 *1 0,0
R_99_t117 \$99__t117 \$99 8.21176790945
* device instance _99_t118 r0 *1 0,0
R_99_t118 \$99__t118 \$99 12.5941010938
* device instance _99_t119 r0 *1 0,0
R_99_t119 \$99__t119 \$99 10.3778677591
* device instance _99_t120 r0 *1 0,0
R_99_t120 \$99__t120 \$99 8.23420272967
* device instance _99_t121 r0 *1 0,0
R_99_t121 \$99__t121 \$99 15.0673591159
* device instance _99_t122 r0 *1 0,0
R_99_t122 \$99__t122 \$99 7.32913596222
* device instance _99_t123 r0 *1 0,0
R_99_t123 \$99__t123 \$99 7.96100386788
* device instance _99_t124 r0 *1 0,0
R_99_t124 \$99__t124 \$99 7.42078727792
* device instance _99_t125 r0 *1 0,0
R_99_t125 \$99__t125 \$99 9.16799485816
* device instance _99_t126 r0 *1 0,0
R_99_t126 \$99__t126 \$99 8.83128420754
* device instance _99_t127 r0 *1 0,0
R_99_t127 \$99__t127 \$99 7.00761975461
* device instance _99_t128 r0 *1 0,0
R_99_t128 \$99__t128 \$99 42.8215493659
* device instance _99_t129 r0 *1 0,0
R_99_t129 \$99__t129 \$99 42.3175992325
* device instance _99_t130 r0 *1 0,0
R_99_t130 \$99__t130 \$99 41.8142423426
* device instance _99_t131 r0 *1 0,0
R_99_t131 \$99__t131 \$99 41.3115003812
* device instance _99_t132 r0 *1 0,0
R_99_t132 \$99__t132 \$99 45.8211763921
* device instance _99_t133 r0 *1 0,0
R_99_t133 \$99__t133 \$99 46.3255845955
* device instance _99_t134 r0 *1 0,0
R_99_t134 \$99__t134 \$99 46.8305126328
* device instance _99_t135 r0 *1 0,0
R_99_t135 \$99__t135 \$99 47.335943869
* device instance _99 r0 *1 0,0
C_99 \$99 vsubs 3.13544276e-13
* device instance hi_128_n_t0 r0 *1 0,0
Rhi_128_n_t0 hi_128_n__t0 hi_128_n 159.628415411
* device instance hi_128_n_t1 r0 *1 0,0
Rhi_128_n_t1 hi_128_n__t1 hi_128_n 17.8399437493
* device instance hi_128_n_t2 r0 *1 0,0
Rhi_128_n_t2 hi_128_n__t2 hi_128_n 156.869440839
* device instance hi_128_n r0 *1 0,0
Chi_128_n hi_128_n vsubs 4.857429e-15
* device instance hi_128_p_t0 r0 *1 0,0
Rhi_128_p_t0 hi_128_p__t0 hi_128_p 159.628415411
* device instance hi_128_p_t1 r0 *1 0,0
Rhi_128_p_t1 hi_128_p__t1 hi_128_p 17.8399437493
* device instance hi_128_p_t2 r0 *1 0,0
Rhi_128_p_t2 hi_128_p__t2 hi_128_p 156.869440839
* device instance hi_128_p r0 *1 0,0
Chi_128_p hi_128_p vsubs 4.857429e-15
* device instance hi_16_n_t0 r0 *1 0,0
Rhi_16_n_t0 hi_16_n__t0 hi_16_n 159.628415411
* device instance hi_16_n_t1 r0 *1 0,0
Rhi_16_n_t1 hi_16_n__t1 hi_16_n 17.8399437493
* device instance hi_16_n_t2 r0 *1 0,0
Rhi_16_n_t2 hi_16_n__t2 hi_16_n 156.869440839
* device instance hi_16_n r0 *1 0,0
Chi_16_n hi_16_n vsubs 4.851921e-15
* device instance hi_16_p_t0 r0 *1 0,0
Rhi_16_p_t0 hi_16_p__t0 hi_16_p 159.628415411
* device instance hi_16_p_t1 r0 *1 0,0
Rhi_16_p_t1 hi_16_p__t1 hi_16_p 17.8399437493
* device instance hi_16_p_t2 r0 *1 0,0
Rhi_16_p_t2 hi_16_p__t2 hi_16_p 156.869440839
* device instance hi_16_p r0 *1 0,0
Chi_16_p hi_16_p vsubs 4.851921e-15
* device instance hi_1_n_t0 r0 *1 0,0
Rhi_1_n_t0 hi_1_n__t0 hi_1_n 159.628415411
* device instance hi_1_n_t1 r0 *1 0,0
Rhi_1_n_t1 hi_1_n__t1 hi_1_n 17.8399437493
* device instance hi_1_n_t2 r0 *1 0,0
Rhi_1_n_t2 hi_1_n__t2 hi_1_n 156.869440839
* device instance hi_1_n r0 *1 0,0
Chi_1_n hi_1_n vsubs 4.857429e-15
* device instance hi_1_p_t0 r0 *1 0,0
Rhi_1_p_t0 hi_1_p__t0 hi_1_p 159.628415411
* device instance hi_1_p_t1 r0 *1 0,0
Rhi_1_p_t1 hi_1_p__t1 hi_1_p 17.8399437493
* device instance hi_1_p_t2 r0 *1 0,0
Rhi_1_p_t2 hi_1_p__t2 hi_1_p 156.869440839
* device instance hi_1_p r0 *1 0,0
Chi_1_p hi_1_p vsubs 4.857429e-15
* device instance hi_256_n_t0 r0 *1 0,0
Rhi_256_n_t0 hi_256_n__t0 hi_256_n 159.628415411
* device instance hi_256_n_t1 r0 *1 0,0
Rhi_256_n_t1 hi_256_n__t1 hi_256_n 17.8399437493
* device instance hi_256_n_t2 r0 *1 0,0
Rhi_256_n_t2 hi_256_n__t2 hi_256_n 156.869440839
* device instance hi_256_n r0 *1 0,0
Chi_256_n hi_256_n vsubs 4.857429e-15
* device instance hi_256_p_t0 r0 *1 0,0
Rhi_256_p_t0 hi_256_p__t0 hi_256_p 159.628415411
* device instance hi_256_p_t1 r0 *1 0,0
Rhi_256_p_t1 hi_256_p__t1 hi_256_p 17.8399437493
* device instance hi_256_p_t2 r0 *1 0,0
Rhi_256_p_t2 hi_256_p__t2 hi_256_p 156.869440839
* device instance hi_256_p r0 *1 0,0
Chi_256_p hi_256_p vsubs 4.857429e-15
* device instance hi_2_n_t0 r0 *1 0,0
Rhi_2_n_t0 hi_2_n__t0 hi_2_n 159.628415411
* device instance hi_2_n_t1 r0 *1 0,0
Rhi_2_n_t1 hi_2_n__t1 hi_2_n 17.8399437493
* device instance hi_2_n_t2 r0 *1 0,0
Rhi_2_n_t2 hi_2_n__t2 hi_2_n 156.869440839
* device instance hi_2_n r0 *1 0,0
Chi_2_n hi_2_n vsubs 4.857429e-15
* device instance hi_2_p_t0 r0 *1 0,0
Rhi_2_p_t0 hi_2_p__t0 hi_2_p 159.628415411
* device instance hi_2_p_t1 r0 *1 0,0
Rhi_2_p_t1 hi_2_p__t1 hi_2_p 17.8399437493
* device instance hi_2_p_t2 r0 *1 0,0
Rhi_2_p_t2 hi_2_p__t2 hi_2_p 156.869440839
* device instance hi_2_p r0 *1 0,0
Chi_2_p hi_2_p vsubs 4.857429e-15
* device instance hi_32_n_t0 r0 *1 0,0
Rhi_32_n_t0 hi_32_n__t0 hi_32_n 159.628415411
* device instance hi_32_n_t1 r0 *1 0,0
Rhi_32_n_t1 hi_32_n__t1 hi_32_n 17.8399437493
* device instance hi_32_n_t2 r0 *1 0,0
Rhi_32_n_t2 hi_32_n__t2 hi_32_n 156.869440839
* device instance hi_32_n r0 *1 0,0
Chi_32_n hi_32_n vsubs 4.857429e-15
* device instance hi_32_p_t0 r0 *1 0,0
Rhi_32_p_t0 hi_32_p__t0 hi_32_p 159.628415411
* device instance hi_32_p_t1 r0 *1 0,0
Rhi_32_p_t1 hi_32_p__t1 hi_32_p 17.8399437493
* device instance hi_32_p_t2 r0 *1 0,0
Rhi_32_p_t2 hi_32_p__t2 hi_32_p 156.869440839
* device instance hi_32_p r0 *1 0,0
Chi_32_p hi_32_p vsubs 4.857429e-15
* device instance hi_4_n_t0 r0 *1 0,0
Rhi_4_n_t0 hi_4_n__t0 hi_4_n 159.628415411
* device instance hi_4_n_t1 r0 *1 0,0
Rhi_4_n_t1 hi_4_n__t1 hi_4_n 17.8399437493
* device instance hi_4_n_t2 r0 *1 0,0
Rhi_4_n_t2 hi_4_n__t2 hi_4_n 156.869440839
* device instance hi_4_n r0 *1 0,0
Chi_4_n hi_4_n vsubs 4.857429e-15
* device instance hi_4_p_t0 r0 *1 0,0
Rhi_4_p_t0 hi_4_p__t0 hi_4_p 159.628415411
* device instance hi_4_p_t1 r0 *1 0,0
Rhi_4_p_t1 hi_4_p__t1 hi_4_p 17.8399437493
* device instance hi_4_p_t2 r0 *1 0,0
Rhi_4_p_t2 hi_4_p__t2 hi_4_p 156.869440839
* device instance hi_4_p r0 *1 0,0
Chi_4_p hi_4_p vsubs 4.857429e-15
* device instance hi_64_n_t0 r0 *1 0,0
Rhi_64_n_t0 hi_64_n__t0 hi_64_n 159.628415411
* device instance hi_64_n_t1 r0 *1 0,0
Rhi_64_n_t1 hi_64_n__t1 hi_64_n 17.8399437493
* device instance hi_64_n_t2 r0 *1 0,0
Rhi_64_n_t2 hi_64_n__t2 hi_64_n 156.869440839
* device instance hi_64_n r0 *1 0,0
Chi_64_n hi_64_n vsubs 4.857429e-15
* device instance hi_64_p_t0 r0 *1 0,0
Rhi_64_p_t0 hi_64_p__t0 hi_64_p 159.628415411
* device instance hi_64_p_t1 r0 *1 0,0
Rhi_64_p_t1 hi_64_p__t1 hi_64_p 17.8399437493
* device instance hi_64_p_t2 r0 *1 0,0
Rhi_64_p_t2 hi_64_p__t2 hi_64_p 156.869440839
* device instance hi_64_p r0 *1 0,0
Chi_64_p hi_64_p vsubs 4.857429e-15
* device instance hi_8_n_t0 r0 *1 0,0
Rhi_8_n_t0 hi_8_n__t0 hi_8_n 159.628415411
* device instance hi_8_n_t1 r0 *1 0,0
Rhi_8_n_t1 hi_8_n__t1 hi_8_n 17.8399437493
* device instance hi_8_n_t2 r0 *1 0,0
Rhi_8_n_t2 hi_8_n__t2 hi_8_n 156.869440839
* device instance hi_8_n r0 *1 0,0
Chi_8_n hi_8_n vsubs 4.857429e-15
* device instance hi_8_p_t0 r0 *1 0,0
Rhi_8_p_t0 hi_8_p__t0 hi_8_p 159.628415411
* device instance hi_8_p_t1 r0 *1 0,0
Rhi_8_p_t1 hi_8_p__t1 hi_8_p 17.8399437493
* device instance hi_8_p_t2 r0 *1 0,0
Rhi_8_p_t2 hi_8_p__t2 hi_8_p 156.869440839
* device instance hi_8_p r0 *1 0,0
Chi_8_p hi_8_p vsubs 4.857429e-15
* device instance lo_128_n_t0 r0 *1 0,0
Rlo_128_n_t0 lo_128_n__t0 lo_128_n 192.317036104
* device instance lo_128_n_t1 r0 *1 0,0
Rlo_128_n_t1 lo_128_n__t1 lo_128_n 21.6360274196
* device instance lo_128_n_t2 r0 *1 0,0
Rlo_128_n_t2 lo_128_n__t2 lo_128_n 188.273336477
* device instance lo_128_n r0 *1 0,0
Clo_128_n lo_128_n vsubs 5.390587e-15
* device instance lo_128_p_t0 r0 *1 0,0
Rlo_128_p_t0 lo_128_p__t0 lo_128_p 192.317036104
* device instance lo_128_p_t1 r0 *1 0,0
Rlo_128_p_t1 lo_128_p__t1 lo_128_p 21.6360274196
* device instance lo_128_p_t2 r0 *1 0,0
Rlo_128_p_t2 lo_128_p__t2 lo_128_p 188.273336477
* device instance lo_128_p r0 *1 0,0
Clo_128_p lo_128_p vsubs 5.394106e-15
* device instance lo_16_n_t0 r0 *1 0,0
Rlo_16_n_t0 lo_16_n__t0 lo_16_n 192.317036104
* device instance lo_16_n_t1 r0 *1 0,0
Rlo_16_n_t1 lo_16_n__t1 lo_16_n 21.6360274196
* device instance lo_16_n_t2 r0 *1 0,0
Rlo_16_n_t2 lo_16_n__t2 lo_16_n 188.273336477
* device instance lo_16_n r0 *1 0,0
Clo_16_n lo_16_n vsubs 5.385079e-15
* device instance lo_16_p_t0 r0 *1 0,0
Rlo_16_p_t0 lo_16_p__t0 lo_16_p 192.317036104
* device instance lo_16_p_t1 r0 *1 0,0
Rlo_16_p_t1 lo_16_p__t1 lo_16_p 21.6360274196
* device instance lo_16_p_t2 r0 *1 0,0
Rlo_16_p_t2 lo_16_p__t2 lo_16_p 188.273336477
* device instance lo_16_p r0 *1 0,0
Clo_16_p lo_16_p vsubs 5.388598e-15
* device instance lo_1_n_t0 r0 *1 0,0
Rlo_1_n_t0 lo_1_n__t0 lo_1_n 192.317036104
* device instance lo_1_n_t1 r0 *1 0,0
Rlo_1_n_t1 lo_1_n__t1 lo_1_n 21.6360274196
* device instance lo_1_n_t2 r0 *1 0,0
Rlo_1_n_t2 lo_1_n__t2 lo_1_n 188.273336477
* device instance lo_1_n r0 *1 0,0
Clo_1_n lo_1_n vsubs 5.390587e-15
* device instance lo_1_p_t0 r0 *1 0,0
Rlo_1_p_t0 lo_1_p__t0 lo_1_p 192.317036104
* device instance lo_1_p_t1 r0 *1 0,0
Rlo_1_p_t1 lo_1_p__t1 lo_1_p 21.6360274196
* device instance lo_1_p_t2 r0 *1 0,0
Rlo_1_p_t2 lo_1_p__t2 lo_1_p 188.273336477
* device instance lo_1_p r0 *1 0,0
Clo_1_p lo_1_p vsubs 5.394106e-15
* device instance lo_256_n_t0 r0 *1 0,0
Rlo_256_n_t0 lo_256_n__t0 lo_256_n 192.317036104
* device instance lo_256_n_t1 r0 *1 0,0
Rlo_256_n_t1 lo_256_n__t1 lo_256_n 21.6360274196
* device instance lo_256_n_t2 r0 *1 0,0
Rlo_256_n_t2 lo_256_n__t2 lo_256_n 188.273336477
* device instance lo_256_n r0 *1 0,0
Clo_256_n lo_256_n vsubs 5.390587e-15
* device instance lo_256_p_t0 r0 *1 0,0
Rlo_256_p_t0 lo_256_p__t0 lo_256_p 192.317036104
* device instance lo_256_p_t1 r0 *1 0,0
Rlo_256_p_t1 lo_256_p__t1 lo_256_p 21.6360274196
* device instance lo_256_p_t2 r0 *1 0,0
Rlo_256_p_t2 lo_256_p__t2 lo_256_p 188.273336477
* device instance lo_256_p r0 *1 0,0
Clo_256_p lo_256_p vsubs 5.394106e-15
* device instance lo_2_n_t0 r0 *1 0,0
Rlo_2_n_t0 lo_2_n__t0 lo_2_n 192.317036104
* device instance lo_2_n_t1 r0 *1 0,0
Rlo_2_n_t1 lo_2_n__t1 lo_2_n 21.6360274196
* device instance lo_2_n_t2 r0 *1 0,0
Rlo_2_n_t2 lo_2_n__t2 lo_2_n 188.273336477
* device instance lo_2_n r0 *1 0,0
Clo_2_n lo_2_n vsubs 5.390587e-15
* device instance lo_2_p_t0 r0 *1 0,0
Rlo_2_p_t0 lo_2_p__t0 lo_2_p 192.317036104
* device instance lo_2_p_t1 r0 *1 0,0
Rlo_2_p_t1 lo_2_p__t1 lo_2_p 21.6360274196
* device instance lo_2_p_t2 r0 *1 0,0
Rlo_2_p_t2 lo_2_p__t2 lo_2_p 188.273336477
* device instance lo_2_p r0 *1 0,0
Clo_2_p lo_2_p vsubs 5.394106e-15
* device instance lo_32_n_t0 r0 *1 0,0
Rlo_32_n_t0 lo_32_n__t0 lo_32_n 192.317036104
* device instance lo_32_n_t1 r0 *1 0,0
Rlo_32_n_t1 lo_32_n__t1 lo_32_n 21.6360274196
* device instance lo_32_n_t2 r0 *1 0,0
Rlo_32_n_t2 lo_32_n__t2 lo_32_n 188.273336477
* device instance lo_32_n r0 *1 0,0
Clo_32_n lo_32_n vsubs 5.390587e-15
* device instance lo_32_p_t0 r0 *1 0,0
Rlo_32_p_t0 lo_32_p__t0 lo_32_p 192.317036104
* device instance lo_32_p_t1 r0 *1 0,0
Rlo_32_p_t1 lo_32_p__t1 lo_32_p 21.6360274196
* device instance lo_32_p_t2 r0 *1 0,0
Rlo_32_p_t2 lo_32_p__t2 lo_32_p 188.273336477
* device instance lo_32_p r0 *1 0,0
Clo_32_p lo_32_p vsubs 5.394106e-15
* device instance lo_4_n_t0 r0 *1 0,0
Rlo_4_n_t0 lo_4_n__t0 lo_4_n 192.317036104
* device instance lo_4_n_t1 r0 *1 0,0
Rlo_4_n_t1 lo_4_n__t1 lo_4_n 21.6360274196
* device instance lo_4_n_t2 r0 *1 0,0
Rlo_4_n_t2 lo_4_n__t2 lo_4_n 188.273336477
* device instance lo_4_n r0 *1 0,0
Clo_4_n lo_4_n vsubs 5.390587e-15
* device instance lo_4_p_t0 r0 *1 0,0
Rlo_4_p_t0 lo_4_p__t0 lo_4_p 192.317036104
* device instance lo_4_p_t1 r0 *1 0,0
Rlo_4_p_t1 lo_4_p__t1 lo_4_p 21.6360274196
* device instance lo_4_p_t2 r0 *1 0,0
Rlo_4_p_t2 lo_4_p__t2 lo_4_p 188.273336477
* device instance lo_4_p r0 *1 0,0
Clo_4_p lo_4_p vsubs 5.394106e-15
* device instance lo_64_n_t0 r0 *1 0,0
Rlo_64_n_t0 lo_64_n__t0 lo_64_n 192.317036104
* device instance lo_64_n_t1 r0 *1 0,0
Rlo_64_n_t1 lo_64_n__t1 lo_64_n 21.6360274196
* device instance lo_64_n_t2 r0 *1 0,0
Rlo_64_n_t2 lo_64_n__t2 lo_64_n 188.273336477
* device instance lo_64_n r0 *1 0,0
Clo_64_n lo_64_n vsubs 5.390587e-15
* device instance lo_64_p_t0 r0 *1 0,0
Rlo_64_p_t0 lo_64_p__t0 lo_64_p 192.317036104
* device instance lo_64_p_t1 r0 *1 0,0
Rlo_64_p_t1 lo_64_p__t1 lo_64_p 21.6360274196
* device instance lo_64_p_t2 r0 *1 0,0
Rlo_64_p_t2 lo_64_p__t2 lo_64_p 188.273336477
* device instance lo_64_p r0 *1 0,0
Clo_64_p lo_64_p vsubs 5.394106e-15
* device instance lo_8_n_t0 r0 *1 0,0
Rlo_8_n_t0 lo_8_n__t0 lo_8_n 192.317036104
* device instance lo_8_n_t1 r0 *1 0,0
Rlo_8_n_t1 lo_8_n__t1 lo_8_n 21.6360274196
* device instance lo_8_n_t2 r0 *1 0,0
Rlo_8_n_t2 lo_8_n__t2 lo_8_n 188.273336477
* device instance lo_8_n r0 *1 0,0
Clo_8_n lo_8_n vsubs 5.390587e-15
* device instance lo_8_p_t0 r0 *1 0,0
Rlo_8_p_t0 lo_8_p__t0 lo_8_p 192.317036104
* device instance lo_8_p_t1 r0 *1 0,0
Rlo_8_p_t1 lo_8_p__t1 lo_8_p 21.6360274196
* device instance lo_8_p_t2 r0 *1 0,0
Rlo_8_p_t2 lo_8_p__t2 lo_8_p 188.273336477
* device instance lo_8_p r0 *1 0,0
Clo_8_p lo_8_p vsubs 5.394106e-15
* device instance pinn_t0 r0 *1 0,0
Rpinn_t0 vinn__t0 vinn 161.958109832
* device instance pinn_t1 r0 *1 0,0
Rpinn_t1 vinn__t1 vinn 233.907460461
* device instance pinn_t2 r0 *1 0,0
Rpinn_t2 vinn__t2 vinn 90.0297060612
* device instance pinn_t3 r0 *1 0,0
Rpinn_t3 vinn__t3 vinn 305.862976071
* device instance pinn_t4 r0 *1 0,0
Rpinn_t4 vinn__t4 vinn 18.3699743913
* device instance pinn_t5 r0 *1 0,0
Rpinn_t5 vinn__t5 vinn 54.0994759425
* device instance pinn_t6 r0 *1 0,0
Rpinn_t6 vinn__t6 vinn 125.989047095
* device instance pinn_t7 r0 *1 0,0
Rpinn_t7 vinn__t7 vinn 269.884755824
* device instance pinn_t8 r0 *1 0,0
Rpinn_t8 vinn__t8 vinn 197.931594322
* device instance pinn_t9 r0 *1 0,0
Rpinn_t9 vinn__t9 vinn 18.3699743913
* device instance pinn_t10 r0 *1 0,0
Rpinn_t10 vinn__t10 vinn 125.989047095
* device instance pinn_t11 r0 *1 0,0
Rpinn_t11 vinn__t11 vinn 197.931594322
* device instance pinn_t12 r0 *1 0,0
Rpinn_t12 vinn__t12 vinn 90.0297060612
* device instance pinn_t13 r0 *1 0,0
Rpinn_t13 vinn__t13 vinn 305.862976071
* device instance pinn_t14 r0 *1 0,0
Rpinn_t14 vinn__t14 vinn 161.958109832
* device instance pinn_t15 r0 *1 0,0
Rpinn_t15 vinn__t15 vinn 269.884755824
* device instance pinn_t16 r0 *1 0,0
Rpinn_t16 vinn__t16 vinn 54.0994759425
* device instance pinn_t17 r0 *1 0,0
Rpinn_t17 vinn__t17 vinn 233.907460461
* device instance pinn r0 *1 0,0
Cpinn vinn vsubs 8.37261e-14
* device instance pinp_t0 r0 *1 0,0
Rpinp_t0 vinp__t0 vinp 305.862976071
* device instance pinp_t1 r0 *1 0,0
Rpinp_t1 vinp__t1 vinp 269.884755824
* device instance pinp_t2 r0 *1 0,0
Rpinp_t2 vinp__t2 vinp 161.958109832
* device instance pinp_t3 r0 *1 0,0
Rpinp_t3 vinp__t3 vinp 54.0994759425
* device instance pinp_t4 r0 *1 0,0
Rpinp_t4 vinp__t4 vinp 90.0297060612
* device instance pinp_t5 r0 *1 0,0
Rpinp_t5 vinp__t5 vinp 305.862976071
* device instance pinp_t6 r0 *1 0,0
Rpinp_t6 vinp__t6 vinp 197.931594322
* device instance pinp_t7 r0 *1 0,0
Rpinp_t7 vinp__t7 vinp 18.3699743913
* device instance pinp_t8 r0 *1 0,0
Rpinp_t8 vinp__t8 vinp 233.907460461
* device instance pinp_t9 r0 *1 0,0
Rpinp_t9 vinp__t9 vinp 125.989047095
* device instance pinp_t10 r0 *1 0,0
Rpinp_t10 vinp__t10 vinp 197.931594322
* device instance pinp_t11 r0 *1 0,0
Rpinp_t11 vinp__t11 vinp 54.0994759425
* device instance pinp_t12 r0 *1 0,0
Rpinp_t12 vinp__t12 vinp 233.907460461
* device instance pinp_t13 r0 *1 0,0
Rpinp_t13 vinp__t13 vinp 161.958109832
* device instance pinp_t14 r0 *1 0,0
Rpinp_t14 vinp__t14 vinp 125.989047095
* device instance pinp_t15 r0 *1 0,0
Rpinp_t15 vinp__t15 vinp 269.884755824
* device instance pinp_t16 r0 *1 0,0
Rpinp_t16 vinp__t16 vinp 90.0297060612
* device instance pinp_t17 r0 *1 0,0
Rpinp_t17 vinp__t17 vinp 18.3699743913
* device instance pinp r0 *1 0,0
Cpinp vinp vsubs 8.378118e-14
* device instance rel_128_n_t0 r0 *1 0,0
Rrel_128_n_t0 rel_128_n__t0 rel_128_n 127.025622285
* device instance rel_128_n_t1 r0 *1 0,0
Rrel_128_n_t1 rel_128_n__t1 rel_128_n 14.1171220219
* device instance rel_128_n_t2 r0 *1 0,0
Rrel_128_n_t2 rel_128_n__t2 rel_128_n 125.307355693
* device instance rel_128_n r0 *1 0,0
Crel_128_n rel_128_n vsubs 4.320752e-15
* device instance rel_128_p_t0 r0 *1 0,0
Rrel_128_p_t0 rel_128_p__t0 rel_128_p 127.025622285
* device instance rel_128_p_t1 r0 *1 0,0
Rrel_128_p_t1 rel_128_p__t1 rel_128_p 14.1171220219
* device instance rel_128_p_t2 r0 *1 0,0
Rrel_128_p_t2 rel_128_p__t2 rel_128_p 125.307355693
* device instance rel_128_p r0 *1 0,0
Crel_128_p rel_128_p vsubs 4.320752e-15
* device instance rel_16_n_t0 r0 *1 0,0
Rrel_16_n_t0 rel_16_n__t0 rel_16_n 127.025622285
* device instance rel_16_n_t1 r0 *1 0,0
Rrel_16_n_t1 rel_16_n__t1 rel_16_n 14.1171220219
* device instance rel_16_n_t2 r0 *1 0,0
Rrel_16_n_t2 rel_16_n__t2 rel_16_n 125.307355693
* device instance rel_16_n r0 *1 0,0
Crel_16_n rel_16_n vsubs 4.320701e-15
* device instance rel_16_p_t0 r0 *1 0,0
Rrel_16_p_t0 rel_16_p__t0 rel_16_p 127.025622285
* device instance rel_16_p_t1 r0 *1 0,0
Rrel_16_p_t1 rel_16_p__t1 rel_16_p 14.1171220219
* device instance rel_16_p_t2 r0 *1 0,0
Rrel_16_p_t2 rel_16_p__t2 rel_16_p 125.307355693
* device instance rel_16_p r0 *1 0,0
Crel_16_p rel_16_p vsubs 4.320701e-15
* device instance rel_1_n_t0 r0 *1 0,0
Rrel_1_n_t0 rel_1_n__t0 rel_1_n 127.025622285
* device instance rel_1_n_t1 r0 *1 0,0
Rrel_1_n_t1 rel_1_n__t1 rel_1_n 14.1171220219
* device instance rel_1_n_t2 r0 *1 0,0
Rrel_1_n_t2 rel_1_n__t2 rel_1_n 125.307355693
* device instance rel_1_n r0 *1 0,0
Crel_1_n rel_1_n vsubs 4.320752e-15
* device instance rel_1_p_t0 r0 *1 0,0
Rrel_1_p_t0 rel_1_p__t0 rel_1_p 127.025622285
* device instance rel_1_p_t1 r0 *1 0,0
Rrel_1_p_t1 rel_1_p__t1 rel_1_p 14.1171220219
* device instance rel_1_p_t2 r0 *1 0,0
Rrel_1_p_t2 rel_1_p__t2 rel_1_p 125.307355693
* device instance rel_1_p r0 *1 0,0
Crel_1_p rel_1_p vsubs 4.320752e-15
* device instance rel_256_n_t0 r0 *1 0,0
Rrel_256_n_t0 rel_256_n__t0 rel_256_n 127.025622285
* device instance rel_256_n_t1 r0 *1 0,0
Rrel_256_n_t1 rel_256_n__t1 rel_256_n 14.1171220219
* device instance rel_256_n_t2 r0 *1 0,0
Rrel_256_n_t2 rel_256_n__t2 rel_256_n 125.307355693
* device instance rel_256_n r0 *1 0,0
Crel_256_n rel_256_n vsubs 4.320752e-15
* device instance rel_256_p_t0 r0 *1 0,0
Rrel_256_p_t0 rel_256_p__t0 rel_256_p 127.025622285
* device instance rel_256_p_t1 r0 *1 0,0
Rrel_256_p_t1 rel_256_p__t1 rel_256_p 14.1171220219
* device instance rel_256_p_t2 r0 *1 0,0
Rrel_256_p_t2 rel_256_p__t2 rel_256_p 125.307355693
* device instance rel_256_p r0 *1 0,0
Crel_256_p rel_256_p vsubs 4.320752e-15
* device instance rel_2_n_t0 r0 *1 0,0
Rrel_2_n_t0 rel_2_n__t0 rel_2_n 127.025622285
* device instance rel_2_n_t1 r0 *1 0,0
Rrel_2_n_t1 rel_2_n__t1 rel_2_n 14.1171220219
* device instance rel_2_n_t2 r0 *1 0,0
Rrel_2_n_t2 rel_2_n__t2 rel_2_n 125.307355693
* device instance rel_2_n r0 *1 0,0
Crel_2_n rel_2_n vsubs 4.320752e-15
* device instance rel_2_p_t0 r0 *1 0,0
Rrel_2_p_t0 rel_2_p__t0 rel_2_p 127.025622285
* device instance rel_2_p_t1 r0 *1 0,0
Rrel_2_p_t1 rel_2_p__t1 rel_2_p 14.1171220219
* device instance rel_2_p_t2 r0 *1 0,0
Rrel_2_p_t2 rel_2_p__t2 rel_2_p 125.307355693
* device instance rel_2_p r0 *1 0,0
Crel_2_p rel_2_p vsubs 4.320752e-15
* device instance rel_32_n_t0 r0 *1 0,0
Rrel_32_n_t0 rel_32_n__t0 rel_32_n 127.025622285
* device instance rel_32_n_t1 r0 *1 0,0
Rrel_32_n_t1 rel_32_n__t1 rel_32_n 14.1171220219
* device instance rel_32_n_t2 r0 *1 0,0
Rrel_32_n_t2 rel_32_n__t2 rel_32_n 125.307355693
* device instance rel_32_n r0 *1 0,0
Crel_32_n rel_32_n vsubs 4.320752e-15
* device instance rel_32_p_t0 r0 *1 0,0
Rrel_32_p_t0 rel_32_p__t0 rel_32_p 127.025622285
* device instance rel_32_p_t1 r0 *1 0,0
Rrel_32_p_t1 rel_32_p__t1 rel_32_p 14.1171220219
* device instance rel_32_p_t2 r0 *1 0,0
Rrel_32_p_t2 rel_32_p__t2 rel_32_p 125.307355693
* device instance rel_32_p r0 *1 0,0
Crel_32_p rel_32_p vsubs 4.320752e-15
* device instance rel_4_n_t0 r0 *1 0,0
Rrel_4_n_t0 rel_4_n__t0 rel_4_n 127.025622285
* device instance rel_4_n_t1 r0 *1 0,0
Rrel_4_n_t1 rel_4_n__t1 rel_4_n 14.1171220219
* device instance rel_4_n_t2 r0 *1 0,0
Rrel_4_n_t2 rel_4_n__t2 rel_4_n 125.307355693
* device instance rel_4_n r0 *1 0,0
Crel_4_n rel_4_n vsubs 4.320752e-15
* device instance rel_4_p_t0 r0 *1 0,0
Rrel_4_p_t0 rel_4_p__t0 rel_4_p 127.025622285
* device instance rel_4_p_t1 r0 *1 0,0
Rrel_4_p_t1 rel_4_p__t1 rel_4_p 14.1171220219
* device instance rel_4_p_t2 r0 *1 0,0
Rrel_4_p_t2 rel_4_p__t2 rel_4_p 125.307355693
* device instance rel_4_p r0 *1 0,0
Crel_4_p rel_4_p vsubs 4.320752e-15
* device instance rel_64_n_t0 r0 *1 0,0
Rrel_64_n_t0 rel_64_n__t0 rel_64_n 127.025622285
* device instance rel_64_n_t1 r0 *1 0,0
Rrel_64_n_t1 rel_64_n__t1 rel_64_n 14.1171220219
* device instance rel_64_n_t2 r0 *1 0,0
Rrel_64_n_t2 rel_64_n__t2 rel_64_n 125.307355693
* device instance rel_64_n r0 *1 0,0
Crel_64_n rel_64_n vsubs 4.320752e-15
* device instance rel_64_p_t0 r0 *1 0,0
Rrel_64_p_t0 rel_64_p__t0 rel_64_p 127.025622285
* device instance rel_64_p_t1 r0 *1 0,0
Rrel_64_p_t1 rel_64_p__t1 rel_64_p 14.1171220219
* device instance rel_64_p_t2 r0 *1 0,0
Rrel_64_p_t2 rel_64_p__t2 rel_64_p 125.307355693
* device instance rel_64_p r0 *1 0,0
Crel_64_p rel_64_p vsubs 4.320752e-15
* device instance rel_8_n_t0 r0 *1 0,0
Rrel_8_n_t0 rel_8_n__t0 rel_8_n 127.025622285
* device instance rel_8_n_t1 r0 *1 0,0
Rrel_8_n_t1 rel_8_n__t1 rel_8_n 14.1171220219
* device instance rel_8_n_t2 r0 *1 0,0
Rrel_8_n_t2 rel_8_n__t2 rel_8_n 125.307355693
* device instance rel_8_n r0 *1 0,0
Crel_8_n rel_8_n vsubs 4.320752e-15
* device instance rel_8_p_t0 r0 *1 0,0
Rrel_8_p_t0 rel_8_p__t0 rel_8_p 127.025622285
* device instance rel_8_p_t1 r0 *1 0,0
Rrel_8_p_t1 rel_8_p__t1 rel_8_p 14.1171220219
* device instance rel_8_p_t2 r0 *1 0,0
Rrel_8_p_t2 rel_8_p__t2 rel_8_p 125.307355693
* device instance rel_8_p r0 *1 0,0
Crel_8_p rel_8_p vsubs 4.320752e-15
* device instance sel_in_t0 r0 *1 0,0
Rsel_in_t0 sel_in__t0 sel_in 157.389236749
* device instance sel_in_t1 r0 *1 0,0
Rsel_in_t1 sel_in__t1 sel_in 148.265534629
* device instance sel_in_t2 r0 *1 0,0
Rsel_in_t2 sel_in__t2 sel_in 138.872461874
* device instance sel_in_t3 r0 *1 0,0
Rsel_in_t3 sel_in__t3 sel_in 30.4532597228
* device instance sel_in_t4 r0 *1 0,0
Rsel_in_t4 sel_in__t4 sel_in 30.2418682563
* device instance sel_in_t5 r0 *1 0,0
Rsel_in_t5 sel_in__t5 sel_in 15.8979076174
* device instance sel_in_t6 r0 *1 0,0
Rsel_in_t6 sel_in__t6 sel_in 120.730228904
* device instance sel_in_t7 r0 *1 0,0
Rsel_in_t7 sel_in__t7 sel_in 65.7766028834
* device instance sel_in_t8 r0 *1 0,0
Rsel_in_t8 sel_in__t8 sel_in 157.477433945
* device instance sel_in_t9 r0 *1 0,0
Rsel_in_t9 sel_in__t9 sel_in 157.436691308
* device instance sel_in_t10 r0 *1 0,0
Rsel_in_t10 sel_in__t10 sel_in 120.677080422
* device instance sel_in_t11 r0 *1 0,0
Rsel_in_t11 sel_in__t11 sel_in 84.0482397568
* device instance sel_in_t12 r0 *1 0,0
Rsel_in_t12 sel_in__t12 sel_in 47.9852977845
* device instance sel_in_t13 r0 *1 0,0
Rsel_in_t13 sel_in__t13 sel_in 84.1245329159
* device instance sel_in_t14 r0 *1 0,0
Rsel_in_t14 sel_in__t14 sel_in 47.8514197423
* device instance sel_in_t15 r0 *1 0,0
Rsel_in_t15 sel_in__t15 sel_in 102.226341243
* device instance sel_in_t16 r0 *1 0,0
Rsel_in_t16 sel_in__t16 sel_in 65.6790001048
* device instance sel_in_t17 r0 *1 0,0
Rsel_in_t17 sel_in__t17 sel_in 138.918649213
* device instance sel_in_t18 r0 *1 0,0
Rsel_in_t18 sel_in__t18 sel_in 15.4891263308
* device instance sel_in_t19 r0 *1 0,0
Rsel_in_t19 sel_in__t19 sel_in 102.16356695
* device instance sel_in_t20 r0 *1 0,0
Rsel_in_t20 sel_in__t20 sel_in 13.6463180541
* device instance sel_in_t21 r0 *1 0,0
Rsel_in_t21 sel_in__t21 sel_in 74.8956283035
* device instance sel_in_t22 r0 *1 0,0
Rsel_in_t22 sel_in__t22 sel_in 111.389748439
* device instance sel_in_t23 r0 *1 0,0
Rsel_in_t23 sel_in__t23 sel_in 111.159139655
* device instance sel_in_t24 r0 *1 0,0
Rsel_in_t24 sel_in__t24 sel_in 38.5255160931
* device instance sel_in_t25 r0 *1 0,0
Rsel_in_t25 sel_in__t25 sel_in 111.507723002
* device instance sel_in_t26 r0 *1 0,0
Rsel_in_t26 sel_in__t26 sel_in 74.8984560415
* device instance sel_in_t27 r0 *1 0,0
Rsel_in_t27 sel_in__t27 sel_in 39.5146779331
* device instance sel_in_t28 r0 *1 0,0
Rsel_in_t28 sel_in__t28 sel_in 74.5522193533
* device instance sel_in_t29 r0 *1 0,0
Rsel_in_t29 sel_in__t29 sel_in 148.438507428
* device instance sel_in_t30 r0 *1 0,0
Rsel_in_t30 sel_in__t30 sel_in 147.916118611
* device instance sel_in_t31 r0 *1 0,0
Rsel_in_t31 sel_in__t31 sel_in 38.8598513081
* device instance sel_in_t32 r0 *1 0,0
Rsel_in_t32 sel_in__t32 sel_in 11.6146574622
* device instance sel_in_t33 r0 *1 0,0
Rsel_in_t33 sel_in__t33 sel_in 75.2402847275
* device instance sel_in_t34 r0 *1 0,0
Rsel_in_t34 sel_in__t34 sel_in 148.089499538
* device instance sel_in_t35 r0 *1 0,0
Rsel_in_t35 sel_in__t35 sel_in 39.1859301116
* device instance sel_in_t36 r0 *1 0,0
Rsel_in_t36 sel_in__t36 sel_in 111.737612368
* device instance sel_in_t37 r0 *1 0,0
Rsel_in_t37 sel_in__t37 sel_in 102.219648859
* device instance sel_in_t38 r0 *1 0,0
Rsel_in_t38 sel_in__t38 sel_in 31.0533782993
* device instance sel_in_t39 r0 *1 0,0
Rsel_in_t39 sel_in__t39 sel_in 139.190916928
* device instance sel_in_t40 r0 *1 0,0
Rsel_in_t40 sel_in__t40 sel_in 138.960279198
* device instance sel_in_t41 r0 *1 0,0
Rsel_in_t41 sel_in__t41 sel_in 65.6677769463
* device instance sel_in_t42 r0 *1 0,0
Rsel_in_t42 sel_in__t42 sel_in 83.7310406815
* device instance sel_in_t43 r0 *1 0,0
Rsel_in_t43 sel_in__t43 sel_in 120.402665999
* device instance sel_in_t44 r0 *1 0,0
Rsel_in_t44 sel_in__t44 sel_in 14.5796520997
* device instance sel_in_t45 r0 *1 0,0
Rsel_in_t45 sel_in__t45 sel_in 16.6348554528
* device instance sel_in_t46 r0 *1 0,0
Rsel_in_t46 sel_in__t46 sel_in 48.1001811438
* device instance sel_in_t47 r0 *1 0,0
Rsel_in_t47 sel_in__t47 sel_in 47.4286333925
* device instance sel_in_t48 r0 *1 0,0
Rsel_in_t48 sel_in__t48 sel_in 30.0026689348
* device instance sel_in_t49 r0 *1 0,0
Rsel_in_t49 sel_in__t49 sel_in 102.532964326
* device instance sel_in_t50 r0 *1 0,0
Rsel_in_t50 sel_in__t50 sel_in 120.668778648
* device instance sel_in_t51 r0 *1 0,0
Rsel_in_t51 sel_in__t51 sel_in 66.1544336357
* device instance sel_in_t52 r0 *1 0,0
Rsel_in_t52 sel_in__t52 sel_in 84.1132530235
* device instance sel_in_t53 r0 *1 0,0
Rsel_in_t53 sel_in__t53 sel_in 157.185303651
* device instance sel_in r0 *1 0,0
Csel_in sel_in vsubs 1.1115819e-13
* device instance topn_t0 r0 *1 0,0
Rtopn_t0 topn__t0 topn 0.382165226954
* device instance topn_t1 r0 *1 0,0
Rtopn_t1 topn__t1 topn 1.57526024694
* device instance topn_t2 r0 *1 0,0
Rtopn_t2 topn__t2 topn 1.66573298021
* device instance topn_t3 r0 *1 0,0
Rtopn_t3 topn__t3 topn 1.53763181266
* device instance topn_t4 r0 *1 0,0
Rtopn_t4 topn__t4 topn 1.63019419306
* device instance topn_t5 r0 *1 0,0
Rtopn_t5 topn__t5 topn 1.45929289424
* device instance topn_t6 r0 *1 0,0
Rtopn_t6 topn__t6 topn 1.55652088549
* device instance topn_t7 r0 *1 0,0
Rtopn_t7 topn__t7 topn 1.61802825078
* device instance topn_t8 r0 *1 0,0
Rtopn_t8 topn__t8 topn 1.7062347248
* device instance topn_t9 r0 *1 0,0
Rtopn_t9 topn__t9 topn 0.347288281445
* device instance topn_t10 r0 *1 0,0
Rtopn_t10 topn__t10 topn 0.415672476475
* device instance topn_t11 r0 *1 0,0
Rtopn_t11 topn__t11 topn 0.340783443309
* device instance topn_t12 r0 *1 0,0
Rtopn_t12 topn__t12 topn 0.280927790058
* device instance topn_t13 r0 *1 0,0
Rtopn_t13 topn__t13 topn 0.247274769597
* device instance topn_t14 r0 *1 0,0
Rtopn_t14 topn__t14 topn 0.250612291378
* device instance topn_t15 r0 *1 0,0
Rtopn_t15 topn__t15 topn 0.289664547294
* device instance topn_t16 r0 *1 0,0
Rtopn_t16 topn__t16 topn 0.352763234744
* device instance topn_t17 r0 *1 0,0
Rtopn_t17 topn__t17 topn 0.429436339955
* device instance topn_t18 r0 *1 0,0
Rtopn_t18 topn__t18 topn 0.376441469286
* device instance topn_t19 r0 *1 0,0
Rtopn_t19 topn__t19 topn 0.426901077096
* device instance topn_t20 r0 *1 0,0
Rtopn_t20 topn__t20 topn 0.49215668228
* device instance topn_t21 r0 *1 0,0
Rtopn_t21 topn__t21 topn 0.467918935389
* device instance topn_t22 r0 *1 0,0
Rtopn_t22 topn__t22 topn 0.509396191509
* device instance topn_t23 r0 *1 0,0
Rtopn_t23 topn__t23 topn 0.56520628996
* device instance topn_t24 r0 *1 0,0
Rtopn_t24 topn__t24 topn 0.501174555789
* device instance topn_t25 r0 *1 0,0
Rtopn_t25 topn__t25 topn 0.462561350919
* device instance topn_t26 r0 *1 0,0
Rtopn_t26 topn__t26 topn 0.442930459345
* device instance topn_t27 r0 *1 0,0
Rtopn_t27 topn__t27 topn 0.444802316458
* device instance topn_t28 r0 *1 0,0
Rtopn_t28 topn__t28 topn 0.480193958248
* device instance topn_t29 r0 *1 0,0
Rtopn_t29 topn__t29 topn 0.60222493474
* device instance topn_t30 r0 *1 0,0
Rtopn_t30 topn__t30 topn 0.693513160426
* device instance topn_t31 r0 *1 0,0
Rtopn_t31 topn__t31 topn 0.786564336724
* device instance topn_t32 r0 *1 0,0
Rtopn_t32 topn__t32 topn 0.88081991825
* device instance topn_t33 r0 *1 0,0
Rtopn_t33 topn__t33 topn 0.975931002389
* device instance topn_t34 r0 *1 0,0
Rtopn_t34 topn__t34 topn 1.13292489383
* device instance topn_t35 r0 *1 0,0
Rtopn_t35 topn__t35 topn 1.07166983485
* device instance topn_t36 r0 *1 0,0
Rtopn_t36 topn__t36 topn 1.16788204408
* device instance topn_t37 r0 *1 0,0
Rtopn_t37 topn__t37 topn 1.26445957756
* device instance topn_t38 r0 *1 0,0
Rtopn_t38 topn__t38 topn 1.36132468506
* device instance topn_t39 r0 *1 0,0
Rtopn_t39 topn__t39 topn 0.554820861031
* device instance topn_t40 r0 *1 0,0
Rtopn_t40 topn__t40 topn 0.939487763114
* device instance topn_t41 r0 *1 0,0
Rtopn_t41 topn__t41 topn 0.853698074428
* device instance topn_t42 r0 *1 0,0
Rtopn_t42 topn__t42 topn 0.770973973609
* device instance topn_t43 r0 *1 0,0
Rtopn_t43 topn__t43 topn 0.692415088037
* device instance topn_t44 r0 *1 0,0
Rtopn_t44 topn__t44 topn 1.5823211473
* device instance topn_t45 r0 *1 0,0
Rtopn_t45 topn__t45 topn 1.52033033738
* device instance topn_t46 r0 *1 0,0
Rtopn_t46 topn__t46 topn 1.42179683386
* device instance topn_t47 r0 *1 0,0
Rtopn_t47 topn__t47 topn 1.323270743
* device instance topn_t48 r0 *1 0,0
Rtopn_t48 topn__t48 topn 1.22475385373
* device instance topn_t49 r0 *1 0,0
Rtopn_t49 topn__t49 topn 1.12624858074
* device instance topn_t50 r0 *1 0,0
Rtopn_t50 topn__t50 topn 1.02775826413
* device instance topn_t51 r0 *1 0,0
Rtopn_t51 topn__t51 topn 0.929287659349
* device instance topn_t52 r0 *1 0,0
Rtopn_t52 topn__t52 topn 0.830843775087
* device instance topn_t53 r0 *1 0,0
Rtopn_t53 topn__t53 topn 0.732437385613
* device instance topn_t54 r0 *1 0,0
Rtopn_t54 topn__t54 topn 0.634085948073
* device instance topn_t55 r0 *1 0,0
Rtopn_t55 topn__t55 topn 0.344887578086
* device instance topn_t56 r0 *1 0,0
Rtopn_t56 topn__t56 topn 1.48789855676
* device instance topn_t57 r0 *1 0,0
Rtopn_t57 topn__t57 topn 1.39405212876
* device instance topn_t58 r0 *1 0,0
Rtopn_t58 topn__t58 topn 1.55772278114
* device instance topn_t59 r0 *1 0,0
Rtopn_t59 topn__t59 topn 1.46171206635
* device instance topn_t60 r0 *1 0,0
Rtopn_t60 topn__t60 topn 1.36606785608
* device instance topn_t61 r0 *1 0,0
Rtopn_t61 topn__t61 topn 1.53905738459
* device instance topn_t62 r0 *1 0,0
Rtopn_t62 topn__t62 topn 1.44180426379
* device instance topn_t63 r0 *1 0,0
Rtopn_t63 topn__t63 topn 1.34474486709
* device instance topn_t64 r0 *1 0,0
Rtopn_t64 topn__t64 topn 1.24792439696
* device instance topn_t65 r0 *1 0,0
Rtopn_t65 topn__t65 topn 1.15140312833
* device instance topn_t66 r0 *1 0,0
Rtopn_t66 topn__t66 topn 1.05526316518
* device instance topn_t67 r0 *1 0,0
Rtopn_t67 topn__t67 topn 0.959619118255
* device instance topn_t68 r0 *1 0,0
Rtopn_t68 topn__t68 topn 0.864635574623
* device instance topn_t69 r0 *1 0,0
Rtopn_t69 topn__t69 topn 0.417056333212
* device instance topn_t70 r0 *1 0,0
Rtopn_t70 topn__t70 topn 0.369760805205
* device instance topn_t71 r0 *1 0,0
Rtopn_t71 topn__t71 topn 0.535819723137
* device instance topn_t72 r0 *1 0,0
Rtopn_t72 topn__t72 topn 0.858765636833
* device instance topn_t73 r0 *1 0,0
Rtopn_t73 topn__t73 topn 0.956073225252
* device instance topn_t74 r0 *1 0,0
Rtopn_t74 topn__t74 topn 1.0536180169
* device instance topn_t75 r0 *1 0,0
Rtopn_t75 topn__t75 topn 1.15133972375
* device instance topn_t76 r0 *1 0,0
Rtopn_t76 topn__t76 topn 1.24919682753
* device instance topn_t77 r0 *1 0,0
Rtopn_t77 topn__t77 topn 1.34715982303
* device instance topn_t78 r0 *1 0,0
Rtopn_t78 topn__t78 topn 0.552613403493
* device instance topn_t79 r0 *1 0,0
Rtopn_t79 topn__t79 topn 0.650897231045
* device instance topn_t80 r0 *1 0,0
Rtopn_t80 topn__t80 topn 0.749259739679
* device instance topn_t81 r0 *1 0,0
Rtopn_t81 topn__t81 topn 0.847673539804
* device instance topn_t82 r0 *1 0,0
Rtopn_t82 topn__t82 topn 0.946122625837
* device instance topn_t83 r0 *1 0,0
Rtopn_t83 topn__t83 topn 0.164686317567
* device instance topn_t84 r0 *1 0,0
Rtopn_t84 topn__t84 topn 0.260111385798
* device instance topn_t85 r0 *1 0,0
Rtopn_t85 topn__t85 topn 0.35725565539
* device instance topn_t86 r0 *1 0,0
Rtopn_t86 topn__t86 topn 0.0776051146797
* device instance topn_t87 r0 *1 0,0
Rtopn_t87 topn__t87 topn 1.31677659587
* device instance topn_t88 r0 *1 0,0
Rtopn_t88 topn__t88 topn 0.242569694998
* device instance topn_t89 r0 *1 0,0
Rtopn_t89 topn__t89 topn 0.147061636482
* device instance topn_t90 r0 *1 0,0
Rtopn_t90 topn__t90 topn 0.0620605621708
* device instance topn_t91 r0 *1 0,0
Rtopn_t91 topn__t91 topn 0.0742510760032
* device instance topn_t92 r0 *1 0,0
Rtopn_t92 topn__t92 topn 0.163132619843
* device instance topn_t93 r0 *1 0,0
Rtopn_t93 topn__t93 topn 0.259130471934
* device instance topn_t94 r0 *1 0,0
Rtopn_t94 topn__t94 topn 0.356542103785
* device instance topn_t95 r0 *1 0,0
Rtopn_t95 topn__t95 topn 0.34058720019
* device instance topn_t96 r0 *1 0,0
Rtopn_t96 topn__t96 topn 0.366631011125
* device instance topn_t97 r0 *1 0,0
Rtopn_t97 topn__t97 topn 0.278869227154
* device instance topn_t98 r0 *1 0,0
Rtopn_t98 topn__t98 topn 0.201383002874
* device instance topn_t99 r0 *1 0,0
Rtopn_t99 topn__t99 topn 0.150928798772
* device instance topn_t100 r0 *1 0,0
Rtopn_t100 topn__t100 topn 0.156336851732
* device instance topn_t101 r0 *1 0,0
Rtopn_t101 topn__t101 topn 0.213401594602
* device instance topn_t102 r0 *1 0,0
Rtopn_t102 topn__t102 topn 0.29338812247
* device instance topn_t103 r0 *1 0,0
Rtopn_t103 topn__t103 topn 0.339838652005
* device instance topn_t104 r0 *1 0,0
Rtopn_t104 topn__t104 topn 0.868173966404
* device instance topn_t105 r0 *1 0,0
Rtopn_t105 topn__t105 topn 0.648442365875
* device instance topn_t106 r0 *1 0,0
Rtopn_t106 topn__t106 topn 1.04282496209
* device instance topn_t107 r0 *1 0,0
Rtopn_t107 topn__t107 topn 0.734004859333
* device instance topn_t108 r0 *1 0,0
Rtopn_t108 topn__t108 topn 0.822487741942
* device instance topn_t109 r0 *1 0,0
Rtopn_t109 topn__t109 topn 0.913042363872
* device instance topn_t110 r0 *1 0,0
Rtopn_t110 topn__t110 topn 1.00510892507
* device instance topn_t111 r0 *1 0,0
Rtopn_t111 topn__t111 topn 1.09830727247
* device instance topn_t112 r0 *1 0,0
Rtopn_t112 topn__t112 topn 1.1923720471
* device instance topn_t113 r0 *1 0,0
Rtopn_t113 topn__t113 topn 1.28711330237
* device instance topn_t114 r0 *1 0,0
Rtopn_t114 topn__t114 topn 1.38239195889
* device instance topn_t115 r0 *1 0,0
Rtopn_t115 topn__t115 topn 1.4100522963
* device instance topn_t116 r0 *1 0,0
Rtopn_t116 topn__t116 topn 0.95440364025
* device instance topn_t117 r0 *1 0,0
Rtopn_t117 topn__t117 topn 0.705490929891
* device instance topn_t118 r0 *1 0,0
Rtopn_t118 topn__t118 topn 1.22433289959
* device instance topn_t119 r0 *1 0,0
Rtopn_t119 topn__t119 topn 0.761786155312
* device instance topn_t120 r0 *1 0,0
Rtopn_t120 topn__t120 topn 1.04459702116
* device instance topn_t121 r0 *1 0,0
Rtopn_t121 topn__t121 topn 1.14309018479
* device instance topn_t122 r0 *1 0,0
Rtopn_t122 topn__t122 topn 1.2415976502
* device instance topn_t123 r0 *1 0,0
Rtopn_t123 topn__t123 topn 1.34011626356
* device instance topn_t124 r0 *1 0,0
Rtopn_t124 topn__t124 topn 0.553074050428
* device instance topn_t125 r0 *1 0,0
Rtopn_t125 topn__t125 topn 0.651288366946
* device instance topn_t126 r0 *1 0,0
Rtopn_t126 topn__t126 topn 0.749599552455
* device instance topn_t127 r0 *1 0,0
Rtopn_t127 topn__t127 topn 0.847973915648
* device instance topn_t128 r0 *1 0,0
Rtopn_t128 topn__t128 topn 0.946391755384
* device instance topn_t129 r0 *1 0,0
Rtopn_t129 topn__t129 topn 1.04484078603
* device instance topn_t130 r0 *1 0,0
Rtopn_t130 topn__t130 topn 1.14331295021
* device instance topn_t131 r0 *1 0,0
Rtopn_t131 topn__t131 topn 1.24180274461
* device instance topn_t132 r0 *1 0,0
Rtopn_t132 topn__t132 topn 1.34030628268
* device instance topn_t133 r0 *1 0,0
Rtopn_t133 topn__t133 topn 0.569481836973
* device instance topn_t134 r0 *1 0,0
Rtopn_t134 topn__t134 topn 0.665278283355
* device instance topn_t135 r0 *1 0,0
Rtopn_t135 topn__t135 topn 0.784858639388
* device instance topn_t136 r0 *1 0,0
Rtopn_t136 topn__t136 topn 1.02757551171
* device instance topn_t137 r0 *1 0,0
Rtopn_t137 topn__t137 topn 1.50552836488
* device instance topn_t138 r0 *1 0,0
Rtopn_t138 topn__t138 topn 1.57530268834
* device instance topn_t139 r0 *1 0,0
Rtopn_t139 topn__t139 topn 1.47930965119
* device instance topn_t140 r0 *1 0,0
Rtopn_t140 topn__t140 topn 1.59994911583
* device instance topn_t141 r0 *1 0,0
Rtopn_t141 topn__t141 topn 1.08230447548
* device instance topn_t142 r0 *1 0,0
Rtopn_t142 topn__t142 topn 1.5265426046
* device instance topn_t143 r0 *1 0,0
Rtopn_t143 topn__t143 topn 1.42843768702
* device instance topn_t144 r0 *1 0,0
Rtopn_t144 topn__t144 topn 1.33040349075
* device instance topn_t145 r0 *1 0,0
Rtopn_t145 topn__t145 topn 1.2324568922
* device instance topn_t146 r0 *1 0,0
Rtopn_t146 topn__t146 topn 1.13462057735
* device instance topn_t147 r0 *1 0,0
Rtopn_t147 topn__t147 topn 1.03692576321
* device instance topn_t148 r0 *1 0,0
Rtopn_t148 topn__t148 topn 1.52049783502
* device instance topn_t149 r0 *1 0,0
Rtopn_t149 topn__t149 topn 1.42197593802
* device instance topn_t150 r0 *1 0,0
Rtopn_t150 topn__t150 topn 1.32346318075
* device instance topn_t151 r0 *1 0,0
Rtopn_t151 topn__t151 topn 1.22496176828
* device instance topn_t152 r0 *1 0,0
Rtopn_t152 topn__t152 topn 1.12647467666
* device instance topn_t153 r0 *1 0,0
Rtopn_t153 topn__t153 topn 1.02800602188
* device instance topn_t154 r0 *1 0,0
Rtopn_t154 topn__t154 topn 0.929561663019
* device instance topn_t155 r0 *1 0,0
Rtopn_t155 topn__t155 topn 0.831150233194
* device instance topn_t156 r0 *1 0,0
Rtopn_t156 topn__t156 topn 0.634487447536
* device instance topn_t157 r0 *1 0,0
Rtopn_t157 topn__t157 topn 0.536294795089
* device instance topn_t158 r0 *1 0,0
Rtopn_t158 topn__t158 topn 0.939416597011
* device instance topn_t159 r0 *1 0,0
Rtopn_t159 topn__t159 topn 0.842157566922
* device instance topn_t160 r0 *1 0,0
Rtopn_t160 topn__t160 topn 0.745246612045
* device instance topn_t161 r0 *1 0,0
Rtopn_t161 topn__t161 topn 0.648839717084
* device instance topn_t162 r0 *1 0,0
Rtopn_t162 topn__t162 topn 0.553200474172
* device instance topn_t163 r0 *1 0,0
Rtopn_t163 topn__t163 topn 0.989278263159
* device instance topn_t164 r0 *1 0,0
Rtopn_t164 topn__t164 topn 0.897439305325
* device instance topn_t165 r0 *1 0,0
Rtopn_t165 topn__t165 topn 0.807192945946
* device instance topn_t166 r0 *1 0,0
Rtopn_t166 topn__t166 topn 0.719139011377
* device instance topn_t167 r0 *1 0,0
Rtopn_t167 topn__t167 topn 0.634191377932
* device instance topn_t168 r0 *1 0,0
Rtopn_t168 topn__t168 topn 1.30090656108
* device instance topn_t169 r0 *1 0,0
Rtopn_t169 topn__t169 topn 1.20862390514
* device instance topn_t170 r0 *1 0,0
Rtopn_t170 topn__t170 topn 1.11741797369
* device instance topn_t171 r0 *1 0,0
Rtopn_t171 topn__t171 topn 0.732784999424
* device instance topn_t172 r0 *1 0,0
Rtopn_t172 topn__t172 topn 1.4457357223
* device instance topn_t173 r0 *1 0,0
Rtopn_t173 topn__t173 topn 1.54381776597
* device instance topn_t174 r0 *1 0,0
Rtopn_t174 topn__t174 topn 1.17623628314
* device instance topn_t175 r0 *1 0,0
Rtopn_t175 topn__t175 topn 1.27087290095
* device instance topn_t176 r0 *1 0,0
Rtopn_t176 topn__t176 topn 0.586852685096
* device instance topn_t177 r0 *1 0,0
Rtopn_t177 topn__t177 topn 0.677759756732
* device instance topn_t178 r0 *1 0,0
Rtopn_t178 topn__t178 topn 0.770556826033
* device instance topn_t179 r0 *1 0,0
Rtopn_t179 topn__t179 topn 0.623295872432
* device instance topn_t180 r0 *1 0,0
Rtopn_t180 topn__t180 topn 0.69727589835
* device instance topn_t181 r0 *1 0,0
Rtopn_t181 topn__t181 topn 0.776741226348
* device instance topn_t182 r0 *1 0,0
Rtopn_t182 topn__t182 topn 0.86017295206
* device instance topn_t183 r0 *1 0,0
Rtopn_t183 topn__t183 topn 1.05646912188
* device instance topn_t184 r0 *1 0,0
Rtopn_t184 topn__t184 topn 1.15250849091
* device instance topn_t185 r0 *1 0,0
Rtopn_t185 topn__t185 topn 1.24894433751
* device instance topn_t186 r0 *1 0,0
Rtopn_t186 topn__t186 topn 1.34569142646
* device instance topn_t187 r0 *1 0,0
Rtopn_t187 topn__t187 topn 1.44268714307
* device instance topn_t188 r0 *1 0,0
Rtopn_t188 topn__t188 topn 1.53988450565
* device instance topn_t189 r0 *1 0,0
Rtopn_t189 topn__t189 topn 0.589018447664
* device instance topn_t190 r0 *1 0,0
Rtopn_t190 topn__t190 topn 0.636996094652
* device instance topn_t191 r0 *1 0,0
Rtopn_t191 topn__t191 topn 0.721613635156
* device instance topn_t192 r0 *1 0,0
Rtopn_t192 topn__t192 topn 0.809398401742
* device instance topn_t193 r0 *1 0,0
Rtopn_t193 topn__t193 topn 0.513875922529
* device instance topn_t194 r0 *1 0,0
Rtopn_t194 topn__t194 topn 0.991078605721
* device instance topn_t195 r0 *1 0,0
Rtopn_t195 topn__t195 topn 1.083950321
* device instance topn_t196 r0 *1 0,0
Rtopn_t196 topn__t196 topn 1.17775087116
* device instance topn_t197 r0 *1 0,0
Rtopn_t197 topn__t197 topn 1.27227483317
* device instance topn_t198 r0 *1 0,0
Rtopn_t198 topn__t198 topn 1.3673721908
* device instance topn_t199 r0 *1 0,0
Rtopn_t199 topn__t199 topn 1.46293112814
* device instance topn_t200 r0 *1 0,0
Rtopn_t200 topn__t200 topn 1.55886676264
* device instance topn_t201 r0 *1 0,0
Rtopn_t201 topn__t201 topn 0.679635891879
* device instance topn_t202 r0 *1 0,0
Rtopn_t202 topn__t202 topn 0.695717354946
* device instance topn_t203 r0 *1 0,0
Rtopn_t203 topn__t203 topn 0.773941116503
* device instance topn_t204 r0 *1 0,0
Rtopn_t204 topn__t204 topn 0.856378646461
* device instance topn_t205 r0 *1 0,0
Rtopn_t205 topn__t205 topn 0.941924222468
* device instance topn_t206 r0 *1 0,0
Rtopn_t206 topn__t206 topn 1.02980358131
* device instance topn_t207 r0 *1 0,0
Rtopn_t207 topn__t207 topn 1.11946724461
* device instance topn_t208 r0 *1 0,0
Rtopn_t208 topn__t208 topn 1.21051878461
* device instance topn_t209 r0 *1 0,0
Rtopn_t209 topn__t209 topn 0.899423497303
* device instance topn_t210 r0 *1 0,0
Rtopn_t210 topn__t210 topn 1.48359001758
* device instance topn_t211 r0 *1 0,0
Rtopn_t211 topn__t211 topn 0.779633409731
* device instance topn_t212 r0 *1 0,0
Rtopn_t212 topn__t212 topn 0.898439051886
* device instance topn_t213 r0 *1 0,0
Rtopn_t213 topn__t213 topn 0.832003915924
* device instance topn_t214 r0 *1 0,0
Rtopn_t214 topn__t214 topn 0.90982549304
* device instance topn_t215 r0 *1 0,0
Rtopn_t215 topn__t215 topn 1.68881141245
* device instance topn_t216 r0 *1 0,0
Rtopn_t216 topn__t216 topn 1.60068294452
* device instance topn_t217 r0 *1 0,0
Rtopn_t217 topn__t217 topn 1.03766229238
* device instance topn_t218 r0 *1 0,0
Rtopn_t218 topn__t218 topn 1.51384448057
* device instance topn_t219 r0 *1 0,0
Rtopn_t219 topn__t219 topn 1.13529372814
* device instance topn_t220 r0 *1 0,0
Rtopn_t220 topn__t220 topn 1.23307663418
* device instance topn_t221 r0 *1 0,0
Rtopn_t221 topn__t221 topn 1.33097762671
* device instance topn_t222 r0 *1 0,0
Rtopn_t222 topn__t222 topn 1.42897243511
* device instance topn_t223 r0 *1 0,0
Rtopn_t223 topn__t223 topn 1.52704299818
* device instance topn_t224 r0 *1 0,0
Rtopn_t224 topn__t224 topn 1.42853129273
* device instance topn_t225 r0 *1 0,0
Rtopn_t225 topn__t225 topn 0.55699114106
* device instance topn_t226 r0 *1 0,0
Rtopn_t226 topn__t226 topn 1.26371147877
* device instance topn_t227 r0 *1 0,0
Rtopn_t227 topn__t227 topn 1.18501274504
* device instance topn_t228 r0 *1 0,0
Rtopn_t228 topn__t228 topn 1.10949584528
* device instance topn_t229 r0 *1 0,0
Rtopn_t229 topn__t229 topn 1.03785556602
* device instance topn_t230 r0 *1 0,0
Rtopn_t230 topn__t230 topn 0.97095038062
* device instance topn_t231 r0 *1 0,0
Rtopn_t231 topn__t231 topn 1.64819054577
* device instance topn_t232 r0 *1 0,0
Rtopn_t232 topn__t232 topn 1.55776570035
* device instance topn_t233 r0 *1 0,0
Rtopn_t233 topn__t233 topn 1.46839136462
* device instance topn_t234 r0 *1 0,0
Rtopn_t234 topn__t234 topn 1.38027161915
* device instance topn_t235 r0 *1 0,0
Rtopn_t235 topn__t235 topn 1.29366286413
* device instance topn_t236 r0 *1 0,0
Rtopn_t236 topn__t236 topn 1.20888989983
* device instance topn_t237 r0 *1 0,0
Rtopn_t237 topn__t237 topn 1.12636729988
* device instance topn_t238 r0 *1 0,0
Rtopn_t238 topn__t238 topn 1.04662749773
* device instance topn_t239 r0 *1 0,0
Rtopn_t239 topn__t239 topn 0.970356771633
* device instance topn_t240 r0 *1 0,0
Rtopn_t240 topn__t240 topn 0.501415833722
* device instance topn_t241 r0 *1 0,0
Rtopn_t241 topn__t241 topn 1.34503364929
* device instance topn_t242 r0 *1 0,0
Rtopn_t242 topn__t242 topn 1.04152971584
* device instance topn_t243 r0 *1 0,0
Rtopn_t243 topn__t243 topn 1.11293351272
* device instance topn_t244 r0 *1 0,0
Rtopn_t244 topn__t244 topn 1.18823195503
* device instance topn_t245 r0 *1 0,0
Rtopn_t245 topn__t245 topn 1.26673070328
* device instance topn_t246 r0 *1 0,0
Rtopn_t246 topn__t246 topn 1.3478707248
* device instance topn_t247 r0 *1 0,0
Rtopn_t247 topn__t247 topn 1.43120286031
* device instance topn_t248 r0 *1 0,0
Rtopn_t248 topn__t248 topn 1.51636574889
* device instance topn_t249 r0 *1 0,0
Rtopn_t249 topn__t249 topn 1.60306764109
* device instance topn_t250 r0 *1 0,0
Rtopn_t250 topn__t250 topn 1.69107183759
* device instance topn_t251 r0 *1 0,0
Rtopn_t251 topn__t251 topn 0.472791829379
* device instance topn_t252 r0 *1 0,0
Rtopn_t252 topn__t252 topn 0.449925643365
* device instance topn_t253 r0 *1 0,0
Rtopn_t253 topn__t253 topn 0.448075189725
* device instance topn_t254 r0 *1 0,0
Rtopn_t254 topn__t254 topn 0.467490093152
* device instance topn_t255 r0 *1 0,0
Rtopn_t255 topn__t255 topn 0.505727119306
* device instance topn_t256 r0 *1 0,0
Rtopn_t256 topn__t256 topn 0.558936643697
* device instance topn_t257 r0 *1 0,0
Rtopn_t257 topn__t257 topn 1.30266721172
* device instance topn_t258 r0 *1 0,0
Rtopn_t258 topn__t258 topn 0.707918822053
* device instance topn_t259 r0 *1 0,0
Rtopn_t259 topn__t259 topn 0.570258284828
* device instance topn_t260 r0 *1 0,0
Rtopn_t260 topn__t260 topn 0.786309298498
* device instance topn_t261 r0 *1 0,0
Rtopn_t261 topn__t261 topn 0.868822702081
* device instance topn_t262 r0 *1 0,0
Rtopn_t262 topn__t262 topn 1.41167682638
* device instance topn_t263 r0 *1 0,0
Rtopn_t263 topn__t263 topn 1.31851605499
* device instance topn_t264 r0 *1 0,0
Rtopn_t264 topn__t264 topn 1.22620350385
* device instance topn_t265 r0 *1 0,0
Rtopn_t265 topn__t265 topn 1.13494616563
* device instance topn_t266 r0 *1 0,0
Rtopn_t266 topn__t266 topn 1.04502051912
* device instance topn_t267 r0 *1 0,0
Rtopn_t267 topn__t267 topn 0.956802117657
* device instance topn_t268 r0 *1 0,0
Rtopn_t268 topn__t268 topn 0.870809979142
* device instance topn_t269 r0 *1 0,0
Rtopn_t269 topn__t269 topn 0.787773487528
* device instance topn_t270 r0 *1 0,0
Rtopn_t270 topn__t270 topn 0.708732273846
* device instance topn_t271 r0 *1 0,0
Rtopn_t271 topn__t271 topn 0.635179600418
* device instance topn_t272 r0 *1 0,0
Rtopn_t272 topn__t272 topn 0.56924698861
* device instance topn_t273 r0 *1 0,0
Rtopn_t273 topn__t273 topn 0.516113571322
* device instance topn_t274 r0 *1 0,0
Rtopn_t274 topn__t274 topn 1.39569528248
* device instance topn_t275 r0 *1 0,0
Rtopn_t275 topn__t275 topn 1.48943818235
* device instance topn_t276 r0 *1 0,0
Rtopn_t276 topn__t276 topn 0.772467230846
* device instance topn_t277 r0 *1 0,0
Rtopn_t277 topn__t277 topn 0.855720476793
* device instance topn_t278 r0 *1 0,0
Rtopn_t278 topn__t278 topn 1.58376898474
* device instance topn_t279 r0 *1 0,0
Rtopn_t279 topn__t279 topn 0.77220753676
* device instance topn_t280 r0 *1 0,0
Rtopn_t280 topn__t280 topn 0.762704773686
* device instance topn_t281 r0 *1 0,0
Rtopn_t281 topn__t281 topn 0.834674059525
* device instance topn_t282 r0 *1 0,0
Rtopn_t282 topn__t282 topn 0.911636067707
* device instance topn_t283 r0 *1 0,0
Rtopn_t283 topn__t283 topn 0.992429934404
* device instance topn_t284 r0 *1 0,0
Rtopn_t284 topn__t284 topn 1.07619298916
* device instance topn_t285 r0 *1 0,0
Rtopn_t285 topn__t285 topn 1.16228346181
* device instance topn_t286 r0 *1 0,0
Rtopn_t286 topn__t286 topn 1.25022064522
* device instance topn_t287 r0 *1 0,0
Rtopn_t287 topn__t287 topn 1.33964092141
* device instance topn_t288 r0 *1 0,0
Rtopn_t288 topn__t288 topn 1.43026614844
* device instance topn_t289 r0 *1 0,0
Rtopn_t289 topn__t289 topn 0.974876717682
* device instance topn_t290 r0 *1 0,0
Rtopn_t290 topn__t290 topn 1.61431723365
* device instance topn_t291 r0 *1 0,0
Rtopn_t291 topn__t291 topn 0.866106999503
* device instance topn_t292 r0 *1 0,0
Rtopn_t292 topn__t292 topn 0.835973579781
* device instance topn_t293 r0 *1 0,0
Rtopn_t293 topn__t293 topn 0.902116422604
* device instance topn_t294 r0 *1 0,0
Rtopn_t294 topn__t294 topn 0.973762586174
* device instance topn_t295 r0 *1 0,0
Rtopn_t295 topn__t295 topn 1.04978589674
* device instance topn_t296 r0 *1 0,0
Rtopn_t296 topn__t296 topn 1.12930270707
* device instance topn_t297 r0 *1 0,0
Rtopn_t297 topn__t297 topn 1.21162539586
* device instance topn_t298 r0 *1 0,0
Rtopn_t298 topn__t298 topn 1.29621947062
* device instance topn_t299 r0 *1 0,0
Rtopn_t299 topn__t299 topn 1.38266809199
* device instance topn_t300 r0 *1 0,0
Rtopn_t300 topn__t300 topn 1.47064424986
* device instance topn_t301 r0 *1 0,0
Rtopn_t301 topn__t301 topn 1.55988951121
* device instance topn_t302 r0 *1 0,0
Rtopn_t302 topn__t302 topn 1.65019798362
* device instance topn_t303 r0 *1 0,0
Rtopn_t303 topn__t303 topn 0.960945112795
* device instance topn_t304 r0 *1 0,0
Rtopn_t304 topn__t304 topn 0.914014442358
* device instance topn_t305 r0 *1 0,0
Rtopn_t305 topn__t305 topn 1.52188108369
* device instance topn_t306 r0 *1 0,0
Rtopn_t306 topn__t306 topn 1.62847488779
* device instance topn_t307 r0 *1 0,0
Rtopn_t307 topn__t307 topn 1.53580888928
* device instance topn_t308 r0 *1 0,0
Rtopn_t308 topn__t308 topn 1.44392685031
* device instance topn_t309 r0 *1 0,0
Rtopn_t309 topn__t309 topn 1.35298849743
* device instance topn_t310 r0 *1 0,0
Rtopn_t310 topn__t310 topn 1.26319765665
* device instance topn_t311 r0 *1 0,0
Rtopn_t311 topn__t311 topn 1.17481746915
* device instance topn_t312 r0 *1 0,0
Rtopn_t312 topn__t312 topn 1.08819169833
* device instance topn_t313 r0 *1 0,0
Rtopn_t313 topn__t313 topn 1.00377466559
* device instance topn_t314 r0 *1 0,0
Rtopn_t314 topn__t314 topn 0.922173143557
* device instance topn_t315 r0 *1 0,0
Rtopn_t315 topn__t315 topn 0.844203976879
* device instance topn_t316 r0 *1 0,0
Rtopn_t316 topn__t316 topn 0.770969988336
* device instance topn_t317 r0 *1 0,0
Rtopn_t317 topn__t317 topn 0.703950574765
* device instance topn_t318 r0 *1 0,0
Rtopn_t318 topn__t318 topn 0.645085591969
* device instance topn_t319 r0 *1 0,0
Rtopn_t319 topn__t319 topn 0.596792887592
* device instance topn_t320 r0 *1 0,0
Rtopn_t320 topn__t320 topn 0.56180548311
* device instance topn_t321 r0 *1 0,0
Rtopn_t321 topn__t321 topn 1.3952392144
* device instance topn_t322 r0 *1 0,0
Rtopn_t322 topn__t322 topn 0.541169716976
* device instance topn_t323 r0 *1 0,0
Rtopn_t323 topn__t323 topn 0.55735112283
* device instance topn_t324 r0 *1 0,0
Rtopn_t324 topn__t324 topn 0.589790815566
* device instance topn_t325 r0 *1 0,0
Rtopn_t325 topn__t325 topn 0.636005863646
* device instance topn_t326 r0 *1 0,0
Rtopn_t326 topn__t326 topn 0.693246732063
* device instance topn_t327 r0 *1 0,0
Rtopn_t327 topn__t327 topn 0.75902300683
* device instance topn_t328 r0 *1 0,0
Rtopn_t328 topn__t328 topn 0.831311096244
* device instance topn_t329 r0 *1 0,0
Rtopn_t329 topn__t329 topn 0.908558018532
* device instance topn_t330 r0 *1 0,0
Rtopn_t330 topn__t330 topn 0.989603217354
* device instance topn_t331 r0 *1 0,0
Rtopn_t331 topn__t331 topn 1.07358684
* device instance topn_t332 r0 *1 0,0
Rtopn_t332 topn__t332 topn 1.1598707681
* device instance topn_t333 r0 *1 0,0
Rtopn_t333 topn__t333 topn 1.24797797049
* device instance topn_t334 r0 *1 0,0
Rtopn_t334 topn__t334 topn 1.33754818658
* device instance topn_t335 r0 *1 0,0
Rtopn_t335 topn__t335 topn 1.42830620263
* device instance topn_t336 r0 *1 0,0
Rtopn_t336 topn__t336 topn 1.5200392712
* device instance topn_t337 r0 *1 0,0
Rtopn_t337 topn__t337 topn 0.542702839022
* device instance topn_t338 r0 *1 0,0
Rtopn_t338 topn__t338 topn 0.919815865162
* device instance topn_t339 r0 *1 0,0
Rtopn_t339 topn__t339 topn 0.982011638152
* device instance topn_t340 r0 *1 0,0
Rtopn_t340 topn__t340 topn 1.04979512744
* device instance topn_t341 r0 *1 0,0
Rtopn_t341 topn__t341 topn 1.12215421497
* device instance topn_t342 r0 *1 0,0
Rtopn_t342 topn__t342 topn 1.19826027023
* device instance topn_t343 r0 *1 0,0
Rtopn_t343 topn__t343 topn 1.27744377125
* device instance topn_t344 r0 *1 0,0
Rtopn_t344 topn__t344 topn 1.35916695908
* device instance topn_t345 r0 *1 0,0
Rtopn_t345 topn__t345 topn 1.44299839815
* device instance topn_t346 r0 *1 0,0
Rtopn_t346 topn__t346 topn 1.52859126386
* device instance topn_t347 r0 *1 0,0
Rtopn_t347 topn__t347 topn 0.810043184948
* device instance topn_t348 r0 *1 0,0
Rtopn_t348 topn__t348 topn 0.774286580676
* device instance topn_t349 r0 *1 0,0
Rtopn_t349 topn__t349 topn 0.749871173608
* device instance topn_t350 r0 *1 0,0
Rtopn_t350 topn__t350 topn 0.737923549875
* device instance topn_t351 r0 *1 0,0
Rtopn_t351 topn__t351 topn 0.73904862788
* device instance topn_t352 r0 *1 0,0
Rtopn_t352 topn__t352 topn 0.753187827663
* device instance topn_t353 r0 *1 0,0
Rtopn_t353 topn__t353 topn 1.61258100074
* device instance topn_t354 r0 *1 0,0
Rtopn_t354 topn__t354 topn 0.681151816662
* device instance topn_t355 r0 *1 0,0
Rtopn_t355 topn__t355 topn 0.653264774295
* device instance topn_t356 r0 *1 0,0
Rtopn_t356 topn__t356 topn 0.639514858144
* device instance topn_t357 r0 *1 0,0
Rtopn_t357 topn__t357 topn 0.640812736061
* device instance topn_t358 r0 *1 0,0
Rtopn_t358 topn__t358 topn 0.657069244499
* device instance topn_t359 r0 *1 0,0
Rtopn_t359 topn__t359 topn 0.687223647654
* device instance topn_t360 r0 *1 0,0
Rtopn_t360 topn__t360 topn 0.729554667027
* device instance topn_t361 r0 *1 0,0
Rtopn_t361 topn__t361 topn 0.782087592873
* device instance topn_t362 r0 *1 0,0
Rtopn_t362 topn__t362 topn 0.842917145472
* device instance topn_t363 r0 *1 0,0
Rtopn_t363 topn__t363 topn 0.910381758271
* device instance topn_t364 r0 *1 0,0
Rtopn_t364 topn__t364 topn 0.983116421343
* device instance topn_t365 r0 *1 0,0
Rtopn_t365 topn__t365 topn 1.06003687223
* device instance topn_t366 r0 *1 0,0
Rtopn_t366 topn__t366 topn 1.14029634899
* device instance topn_t367 r0 *1 0,0
Rtopn_t367 topn__t367 topn 1.22323778434
* device instance topn_t368 r0 *1 0,0
Rtopn_t368 topn__t368 topn 1.30835121851
* device instance topn_t369 r0 *1 0,0
Rtopn_t369 topn__t369 topn 0.721538668268
* device instance topn_t370 r0 *1 0,0
Rtopn_t370 topn__t370 topn 0.619607747498
* device instance topn_t371 r0 *1 0,0
Rtopn_t371 topn__t371 topn 0.553781374246
* device instance topn_t372 r0 *1 0,0
Rtopn_t372 topn__t372 topn 0.498869903504
* device instance topn_t373 r0 *1 0,0
Rtopn_t373 topn__t373 topn 0.458809188271
* device instance topn_t374 r0 *1 0,0
Rtopn_t374 topn__t374 topn 0.437696107271
* device instance topn_t375 r0 *1 0,0
Rtopn_t375 topn__t375 topn 0.438277553449
* device instance topn_t376 r0 *1 0,0
Rtopn_t376 topn__t376 topn 1.34772682076
* device instance topn_t377 r0 *1 0,0
Rtopn_t377 topn__t377 topn 1.2498082687
* device instance topn_t378 r0 *1 0,0
Rtopn_t378 topn__t378 topn 1.15200310508
* device instance topn_t379 r0 *1 0,0
Rtopn_t379 topn__t379 topn 1.05434288547
* device instance topn_t380 r0 *1 0,0
Rtopn_t380 topn__t380 topn 0.956871990735
* device instance topn_t381 r0 *1 0,0
Rtopn_t381 topn__t381 topn 0.859654822365
* device instance topn_t382 r0 *1 0,0
Rtopn_t382 topn__t382 topn 0.762788398598
* device instance topn_t383 r0 *1 0,0
Rtopn_t383 topn__t383 topn 0.666425681464
* device instance topn_t384 r0 *1 0,0
Rtopn_t384 topn__t384 topn 0.570821826188
* device instance topn_t385 r0 *1 0,0
Rtopn_t385 topn__t385 topn 0.864414781572
* device instance topn_t386 r0 *1 0,0
Rtopn_t386 topn__t386 topn 0.384159153612
* device instance topn_t387 r0 *1 0,0
Rtopn_t387 topn__t387 topn 0.295980717306
* device instance topn_t388 r0 *1 0,0
Rtopn_t388 topn__t388 topn 0.216952149538
* device instance topn_t389 r0 *1 0,0
Rtopn_t389 topn__t389 topn 0.161149637976
* device instance topn_t390 r0 *1 0,0
Rtopn_t390 topn__t390 topn 0.155908617174
* device instance topn_t391 r0 *1 0,0
Rtopn_t391 topn__t391 topn 0.205141678986
* device instance topn_t392 r0 *1 0,0
Rtopn_t392 topn__t392 topn 0.281595526356
* device instance topn_t393 r0 *1 0,0
Rtopn_t393 topn__t393 topn 0.368708954229
* device instance topn_t394 r0 *1 0,0
Rtopn_t394 topn__t394 topn 0.460471351826
* device instance topn_t395 r0 *1 0,0
Rtopn_t395 topn__t395 topn 0.554579804208
* device instance topn_t396 r0 *1 0,0
Rtopn_t396 topn__t396 topn 0.650016132935
* device instance topn_t397 r0 *1 0,0
Rtopn_t397 topn__t397 topn 0.746271068296
* device instance topn_t398 r0 *1 0,0
Rtopn_t398 topn__t398 topn 0.843064269278
* device instance topn_t399 r0 *1 0,0
Rtopn_t399 topn__t399 topn 0.940229513125
* device instance topn_t400 r0 *1 0,0
Rtopn_t400 topn__t400 topn 0.817191485427
* device instance topn_t401 r0 *1 0,0
Rtopn_t401 topn__t401 topn 0.476433884237
* device instance topn_t402 r0 *1 0,0
Rtopn_t402 topn__t402 topn 0.148783253297
* device instance topn_t403 r0 *1 0,0
Rtopn_t403 topn__t403 topn 0.243617299197
* device instance topn_t404 r0 *1 0,0
Rtopn_t404 topn__t404 topn 0.651185705171
* device instance topn_t405 r0 *1 0,0
Rtopn_t405 topn__t405 topn 1.50400521064
* device instance topn_t406 r0 *1 0,0
Rtopn_t406 topn__t406 topn 1.59851593343
* device instance topn_t407 r0 *1 0,0
Rtopn_t407 topn__t407 topn 1.4781040976
* device instance topn_t408 r0 *1 0,0
Rtopn_t408 topn__t408 topn 1.45842006757
* device instance topn_t409 r0 *1 0,0
Rtopn_t409 topn__t409 topn 1.55570260953
* device instance topn_t410 r0 *1 0,0
Rtopn_t410 topn__t410 topn 0.695346792161
* device instance topn_t411 r0 *1 0,0
Rtopn_t411 topn__t411 topn 0.604335610159
* device instance topn_t412 r0 *1 0,0
Rtopn_t412 topn__t412 topn 0.788181523185
* device instance topn_t413 r0 *1 0,0
Rtopn_t413 topn__t413 topn 1.38368090569
* device instance topn_t414 r0 *1 0,0
Rtopn_t414 topn__t414 topn 1.28849756456
* device instance topn_t415 r0 *1 0,0
Rtopn_t415 topn__t415 topn 1.19386616481
* device instance topn_t416 r0 *1 0,0
Rtopn_t416 topn__t416 topn 1.09992917295
* device instance topn_t417 r0 *1 0,0
Rtopn_t417 topn__t417 topn 0.495765590446
* device instance topn_t418 r0 *1 0,0
Rtopn_t418 topn__t418 topn 0.431056667254
* device instance topn_t419 r0 *1 0,0
Rtopn_t419 topn__t419 topn 0.381147609931
* device instance topn_t420 r0 *1 0,0
Rtopn_t420 topn__t420 topn 0.352383982591
* device instance topn_t421 r0 *1 0,0
Rtopn_t421 topn__t421 topn 0.350018231348
* device instance topn_t422 r0 *1 0,0
Rtopn_t422 topn__t422 topn 0.374550896173
* device instance topn_t423 r0 *1 0,0
Rtopn_t423 topn__t423 topn 0.066036693692
* device instance topn_t424 r0 *1 0,0
Rtopn_t424 topn__t424 topn 0.255642676942
* device instance topn_t425 r0 *1 0,0
Rtopn_t425 topn__t425 topn 0.25237168891
* device instance topn_t426 r0 *1 0,0
Rtopn_t426 topn__t426 topn 0.28542438738
* device instance topn_t427 r0 *1 0,0
Rtopn_t427 topn__t427 topn 0.344499655904
* device instance topn_t428 r0 *1 0,0
Rtopn_t428 topn__t428 topn 0.418724569834
* device instance topn_t429 r0 *1 0,0
Rtopn_t429 topn__t429 topn 0.421309038392
* device instance topn_t430 r0 *1 0,0
Rtopn_t430 topn__t430 topn 0.483892093649
* device instance topn_t431 r0 *1 0,0
Rtopn_t431 topn__t431 topn 0.432391290104
* device instance topn_t432 r0 *1 0,0
Rtopn_t432 topn__t432 topn 0.356354539007
* device instance topn_t433 r0 *1 0,0
Rtopn_t433 topn__t433 topn 0.631560876682
* device instance topn_t434 r0 *1 0,0
Rtopn_t434 topn__t434 topn 0.567123611444
* device instance topn_t435 r0 *1 0,0
Rtopn_t435 topn__t435 topn 0.513640497643
* device instance topn_t436 r0 *1 0,0
Rtopn_t436 topn__t436 topn 0.474827601807
* device instance topn_t437 r0 *1 0,0
Rtopn_t437 topn__t437 topn 0.454459307877
* device instance topn_t438 r0 *1 0,0
Rtopn_t438 topn__t438 topn 0.455019333714
* device instance topn_t439 r0 *1 0,0
Rtopn_t439 topn__t439 topn 0.294027562727
* device instance topn_t440 r0 *1 0,0
Rtopn_t440 topn__t440 topn 1.43882074169
* device instance topn_t441 r0 *1 0,0
Rtopn_t441 topn__t441 topn 1.53734402218
* device instance topn_t442 r0 *1 0,0
Rtopn_t442 topn__t442 topn 1.43864373463
* device instance topn_t443 r0 *1 0,0
Rtopn_t443 topn__t443 topn 1.53717836017
* device instance topn_t444 r0 *1 0,0
Rtopn_t444 topn__t444 topn 1.57417065121
* device instance topn_t445 r0 *1 0,0
Rtopn_t445 topn__t445 topn 1.44520717688
* device instance topn_t446 r0 *1 0,0
Rtopn_t446 topn__t446 topn 1.54332281131
* device instance topn_t447 r0 *1 0,0
Rtopn_t447 topn__t447 topn 1.31087917863
* device instance topn_t448 r0 *1 0,0
Rtopn_t448 topn__t448 topn 1.22594126572
* device instance topn_t449 r0 *1 0,0
Rtopn_t449 topn__t449 topn 1.14319599086
* device instance topn_t450 r0 *1 0,0
Rtopn_t450 topn__t450 topn 1.06315543571
* device instance topn_t451 r0 *1 0,0
Rtopn_t451 topn__t451 topn 0.986478184195
* device instance topn_t452 r0 *1 0,0
Rtopn_t452 topn__t452 topn 0.91401108077
* device instance topn_t453 r0 *1 0,0
Rtopn_t453 topn__t453 topn 0.846835653541
* device instance topn_t454 r0 *1 0,0
Rtopn_t454 topn__t454 topn 1.35505738664
* device instance topn_t455 r0 *1 0,0
Rtopn_t455 topn__t455 topn 1.26541335803
* device instance topn_t456 r0 *1 0,0
Rtopn_t456 topn__t456 topn 1.1771995297
* device instance topn_t457 r0 *1 0,0
Rtopn_t457 topn__t457 topn 1.09076295281
* device instance topn_t458 r0 *1 0,0
Rtopn_t458 topn__t458 topn 1.00656158589
* device instance topn_t459 r0 *1 0,0
Rtopn_t459 topn__t459 topn 0.925205897951
* device instance topn_t460 r0 *1 0,0
Rtopn_t460 topn__t460 topn 0.847515782439
* device instance topn_t461 r0 *1 0,0
Rtopn_t461 topn__t461 topn 0.774594971466
* device instance topn_t462 r0 *1 0,0
Rtopn_t462 topn__t462 topn 1.5310882486
* device instance topn_t463 r0 *1 0,0
Rtopn_t463 topn__t463 topn 1.44564323058
* device instance topn_t464 r0 *1 0,0
Rtopn_t464 topn__t464 topn 1.36197459437
* device instance topn_t465 r0 *1 0,0
Rtopn_t465 topn__t465 topn 1.36225972408
* device instance topn_t466 r0 *1 0,0
Rtopn_t466 topn__t466 topn 1.26546619116
* device instance topn_t467 r0 *1 0,0
Rtopn_t467 topn__t467 topn 1.16897182454
* device instance topn_t468 r0 *1 0,0
Rtopn_t468 topn__t468 topn 1.07285734961
* device instance topn_t469 r0 *1 0,0
Rtopn_t469 topn__t469 topn 0.977234863842
* device instance topn_t470 r0 *1 0,0
Rtopn_t470 topn__t470 topn 0.88226435158
* device instance topn_t471 r0 *1 0,0
Rtopn_t471 topn__t471 topn 1.44586562168
* device instance topn_t472 r0 *1 0,0
Rtopn_t472 topn__t472 topn 0.685994976162
* device instance topn_t473 r0 *1 0,0
Rtopn_t473 topn__t473 topn 0.726112498023
* device instance topn_t474 r0 *1 0,0
Rtopn_t474 topn__t474 topn 0.566769836668
* device instance topn_t475 r0 *1 0,0
Rtopn_t475 topn__t475 topn 0.821852722151
* device instance topn_t476 r0 *1 0,0
Rtopn_t476 topn__t476 topn 0.784517830658
* device instance topn_t477 r0 *1 0,0
Rtopn_t477 topn__t477 topn 0.758242623962
* device instance topn_t478 r0 *1 0,0
Rtopn_t478 topn__t478 topn 0.744199467497
* device instance topn_t479 r0 *1 0,0
Rtopn_t479 topn__t479 topn 0.743082188262
* device instance topn_t480 r0 *1 0,0
Rtopn_t480 topn__t480 topn 0.75494817707
* device instance topn_t481 r0 *1 0,0
Rtopn_t481 topn__t481 topn 0.779204518767
* device instance topn_t482 r0 *1 0,0
Rtopn_t482 topn__t482 topn 0.814745318816
* device instance topn_t483 r0 *1 0,0
Rtopn_t483 topn__t483 topn 0.547840321981
* device instance topn_t484 r0 *1 0,0
Rtopn_t484 topn__t484 topn 0.546321617252
* device instance topn_t485 r0 *1 0,0
Rtopn_t485 topn__t485 topn 0.562354799948
* device instance topn_t486 r0 *1 0,0
Rtopn_t486 topn__t486 topn 1.39761002264
* device instance topn_t487 r0 *1 0,0
Rtopn_t487 topn__t487 topn 0.640395272856
* device instance topn_t488 r0 *1 0,0
Rtopn_t488 topn__t488 topn 0.649413633882
* device instance topn_t489 r0 *1 0,0
Rtopn_t489 topn__t489 topn 0.60146853416
* device instance topn_t490 r0 *1 0,0
Rtopn_t490 topn__t490 topn 0.734078553126
* device instance topn_t491 r0 *1 0,0
Rtopn_t491 topn__t491 topn 0.69202431451
* device instance topn_t492 r0 *1 0,0
Rtopn_t492 topn__t492 topn 0.662088590783
* device instance topn_t493 r0 *1 0,0
Rtopn_t493 topn__t493 topn 0.645958414046
* device instance topn_t494 r0 *1 0,0
Rtopn_t494 topn__t494 topn 0.644670895702
* device instance topn_t495 r0 *1 0,0
Rtopn_t495 topn__t495 topn 1.28043061575
* device instance topn_t496 r0 *1 0,0
Rtopn_t496 topn__t496 topn 1.20144398465
* device instance topn_t497 r0 *1 0,0
Rtopn_t497 topn__t497 topn 1.12555322185
* device instance topn_t498 r0 *1 0,0
Rtopn_t498 topn__t498 topn 1.05342763522
* device instance topn_t499 r0 *1 0,0
Rtopn_t499 topn__t499 topn 0.985893924577
* device instance topn_t500 r0 *1 0,0
Rtopn_t500 topn__t500 topn 0.923959522304
* device instance topn_t501 r0 *1 0,0
Rtopn_t501 topn__t501 topn 1.48581985794
* device instance topn_t502 r0 *1 0,0
Rtopn_t502 topn__t502 topn 0.594521532858
* device instance topn_t503 r0 *1 0,0
Rtopn_t503 topn__t503 topn 1.57315718719
* device instance topn_t504 r0 *1 0,0
Rtopn_t504 topn__t504 topn 1.66374428666
* device instance topn_t505 r0 *1 0,0
Rtopn_t505 topn__t505 topn 1.61566563598
* device instance topn_t506 r0 *1 0,0
Rtopn_t506 topn__t506 topn 1.70399441404
* device instance topn_t507 r0 *1 0,0
Rtopn_t507 topn__t507 topn 1.00688096219
* device instance topn_t508 r0 *1 0,0
Rtopn_t508 topn__t508 topn 0.914992720726
* device instance topn_t509 r0 *1 0,0
Rtopn_t509 topn__t509 topn 0.824652294244
* device instance topn_t510 r0 *1 0,0
Rtopn_t510 topn__t510 topn 0.65831312862
* device instance topn_t511 r0 *1 0,0
Rtopn_t511 topn__t511 topn 0.736429531104
* device instance topn_t512 r0 *1 0,0
Rtopn_t512 topn__t512 topn 2.29549083234
* device instance topn_t513 r0 *1 0,0
Rtopn_t513 topn__t513 topn 2.21896652295
* device instance topn r0 *1 0,0
Ctopn topn vsubs 2.23481553e-13
* device instance topp_t0 r0 *1 0,0
Rtopp_t0 topp__t0 topp 1.58745075242
* device instance topp_t1 r0 *1 0,0
Rtopp_t1 topp__t1 topp 1.58951057708
* device instance topp_t2 r0 *1 0,0
Rtopp_t2 topp__t2 topp 1.46843544617
* device instance topp_t3 r0 *1 0,0
Rtopp_t3 topp__t3 topp 1.55227735463
* device instance topp_t4 r0 *1 0,0
Rtopp_t4 topp__t4 topp 1.18155804581
* device instance topp_t5 r0 *1 0,0
Rtopp_t5 topp__t5 topp 1.26467185592
* device instance topp_t6 r0 *1 0,0
Rtopp_t6 topp__t6 topp 0.508369453957
* device instance topp_t7 r0 *1 0,0
Rtopp_t7 topp__t7 topp 0.527841435552
* device instance topp_t8 r0 *1 0,0
Rtopp_t8 topp__t8 topp 0.561642774949
* device instance topp_t9 r0 *1 0,0
Rtopp_t9 topp__t9 topp 0.696664204074
* device instance topp_t10 r0 *1 0,0
Rtopp_t10 topp__t10 topp 0.687182799707
* device instance topp_t11 r0 *1 0,0
Rtopp_t11 topp__t11 topp 0.689745122045
* device instance topp_t12 r0 *1 0,0
Rtopp_t12 topp__t12 topp 0.70421971909
* device instance topp_t13 r0 *1 0,0
Rtopp_t13 topp__t13 topp 0.729898238333
* device instance topp_t14 r0 *1 0,0
Rtopp_t14 topp__t14 topp 0.76565423664
* device instance topp_t15 r0 *1 0,0
Rtopp_t15 topp__t15 topp 0.810154508749
* device instance topp_t16 r0 *1 0,0
Rtopp_t16 topp__t16 topp 0.607385856286
* device instance topp_t17 r0 *1 0,0
Rtopp_t17 topp__t17 topp 0.606928434253
* device instance topp_t18 r0 *1 0,0
Rtopp_t18 topp__t18 topp 0.596021233917
* device instance topp_t19 r0 *1 0,0
Rtopp_t19 topp__t19 topp 0.598973659231
* device instance topp_t20 r0 *1 0,0
Rtopp_t20 topp__t20 topp 0.615586325239
* device instance topp_t21 r0 *1 0,0
Rtopp_t21 topp__t21 topp 0.644804272154
* device instance topp_t22 r0 *1 0,0
Rtopp_t22 topp__t22 topp 0.6850164386
* device instance topp_t23 r0 *1 0,0
Rtopp_t23 topp__t23 topp 0.734419116795
* device instance topp_t24 r0 *1 0,0
Rtopp_t24 topp__t24 topp 0.791292805017
* device instance topp_t25 r0 *1 0,0
Rtopp_t25 topp__t25 topp 0.662602064876
* device instance topp_t26 r0 *1 0,0
Rtopp_t26 topp__t26 topp 0.725130581713
* device instance topp_t27 r0 *1 0,0
Rtopp_t27 topp__t27 topp 0.51771824535
* device instance topp_t28 r0 *1 0,0
Rtopp_t28 topp__t28 topp 0.504887481073
* device instance topp_t29 r0 *1 0,0
Rtopp_t29 topp__t29 topp 0.691753658473
* device instance topp_t30 r0 *1 0,0
Rtopp_t30 topp__t30 topp 0.429361368814
* device instance topp_t31 r0 *1 0,0
Rtopp_t31 topp__t31 topp 0.86204593393
* device instance topp_t32 r0 *1 0,0
Rtopp_t32 topp__t32 topp 1.20361200405
* device instance topp_t33 r0 *1 0,0
Rtopp_t33 topp__t33 topp 1.29176092603
* device instance topp_t34 r0 *1 0,0
Rtopp_t34 topp__t34 topp 1.38031143948
* device instance topp_t35 r0 *1 0,0
Rtopp_t35 topp__t35 topp 1.46919093248
* device instance topp_t36 r0 *1 0,0
Rtopp_t36 topp__t36 topp 1.45194314349
* device instance topp_t37 r0 *1 0,0
Rtopp_t37 topp__t37 topp 0.740412571759
* device instance topp_t38 r0 *1 0,0
Rtopp_t38 topp__t38 topp 0.827605267727
* device instance topp_t39 r0 *1 0,0
Rtopp_t39 topp__t39 topp 0.915586767115
* device instance topp_t40 r0 *1 0,0
Rtopp_t40 topp__t40 topp 1.00414975141
* device instance topp_t41 r0 *1 0,0
Rtopp_t41 topp__t41 topp 1.09315290083
* device instance topp_t42 r0 *1 0,0
Rtopp_t42 topp__t42 topp 1.4338663525
* device instance topp_t43 r0 *1 0,0
Rtopp_t43 topp__t43 topp 1.51961674213
* device instance topp_t44 r0 *1 0,0
Rtopp_t44 topp__t44 topp 1.34883628988
* device instance topp_t45 r0 *1 0,0
Rtopp_t45 topp__t45 topp 0.865625165672
* device instance topp_t46 r0 *1 0,0
Rtopp_t46 topp__t46 topp 0.941289875752
* device instance topp_t47 r0 *1 0,0
Rtopp_t47 topp__t47 topp 1.50774054416
* device instance topp_t48 r0 *1 0,0
Rtopp_t48 topp__t48 topp 1.09973309229
* device instance topp_t49 r0 *1 0,0
Rtopp_t49 topp__t49 topp 0.921757489896
* device instance topp_t50 r0 *1 0,0
Rtopp_t50 topp__t50 topp 0.993154858484
* device instance topp_t51 r0 *1 0,0
Rtopp_t51 topp__t51 topp 1.0675791408
* device instance topp_t52 r0 *1 0,0
Rtopp_t52 topp__t52 topp 1.14443995781
* device instance topp_t53 r0 *1 0,0
Rtopp_t53 topp__t53 topp 1.22327811979
* device instance topp_t54 r0 *1 0,0
Rtopp_t54 topp__t54 topp 1.30373495999
* device instance topp_t55 r0 *1 0,0
Rtopp_t55 topp__t55 topp 1.38552851997
* device instance topp_t56 r0 *1 0,0
Rtopp_t56 topp__t56 topp 0.983166190994
* device instance topp_t57 r0 *1 0,0
Rtopp_t57 topp__t57 topp 1.05039776364
* device instance topp_t58 r0 *1 0,0
Rtopp_t58 topp__t58 topp 1.12102814898
* device instance topp_t59 r0 *1 0,0
Rtopp_t59 topp__t59 topp 1.19445456421
* device instance topp_t60 r0 *1 0,0
Rtopp_t60 topp__t60 topp 1.2701922088
* device instance topp_t61 r0 *1 0,0
Rtopp_t61 topp__t61 topp 1.34785152552
* device instance topp_t62 r0 *1 0,0
Rtopp_t62 topp__t62 topp 1.42711883478
* device instance topp_t63 r0 *1 0,0
Rtopp_t63 topp__t63 topp 1.01950737081
* device instance topp_t64 r0 *1 0,0
Rtopp_t64 topp__t64 topp 1.23783730124
* device instance topp_t65 r0 *1 0,0
Rtopp_t65 topp__t65 topp 1.16302661592
* device instance topp_t66 r0 *1 0,0
Rtopp_t66 topp__t66 topp 1.09071975344
* device instance topp_t67 r0 *1 0,0
Rtopp_t67 topp__t67 topp 1.02144857821
* device instance topp_t68 r0 *1 0,0
Rtopp_t68 topp__t68 topp 0.955873297843
* device instance topp_t69 r0 *1 0,0
Rtopp_t69 topp__t69 topp 0.894806834641
* device instance topp_t70 r0 *1 0,0
Rtopp_t70 topp__t70 topp 0.839234012246
* device instance topp_t71 r0 *1 0,0
Rtopp_t71 topp__t71 topp 0.79031457629
* device instance topp_t72 r0 *1 0,0
Rtopp_t72 topp__t72 topp 0.749352705927
* device instance topp_t73 r0 *1 0,0
Rtopp_t73 topp__t73 topp 1.14459399913
* device instance topp_t74 r0 *1 0,0
Rtopp_t74 topp__t74 topp 1.05538438573
* device instance topp_t75 r0 *1 0,0
Rtopp_t75 topp__t75 topp 1.51663867067
* device instance topp_t76 r0 *1 0,0
Rtopp_t76 topp__t76 topp 1.43317368019
* device instance topp_t77 r0 *1 0,0
Rtopp_t77 topp__t77 topp 0.413799917841
* device instance topp_t78 r0 *1 0,0
Rtopp_t78 topp__t78 topp 1.26945717399
* device instance topp_t79 r0 *1 0,0
Rtopp_t79 topp__t79 topp 1.18964797121
* device instance topp_t80 r0 *1 0,0
Rtopp_t80 topp__t80 topp 1.11159885768
* device instance topp_t81 r0 *1 0,0
Rtopp_t81 topp__t81 topp 1.03570782154
* device instance topp_t82 r0 *1 0,0
Rtopp_t82 topp__t82 topp 0.962485485086
* device instance topp_t83 r0 *1 0,0
Rtopp_t83 topp__t83 topp 0.892588859776
* device instance topp_t84 r0 *1 0,0
Rtopp_t84 topp__t84 topp 0.8268617674
* device instance topp_t85 r0 *1 0,0
Rtopp_t85 topp__t85 topp 0.766377738701
* device instance topp_t86 r0 *1 0,0
Rtopp_t86 topp__t86 topp 0.712473326211
* device instance topp_t87 r0 *1 0,0
Rtopp_t87 topp__t87 topp 0.66674627029
* device instance topp_t88 r0 *1 0,0
Rtopp_t88 topp__t88 topp 0.966553633609
* device instance topp_t89 r0 *1 0,0
Rtopp_t89 topp__t89 topp 0.878216714623
* device instance topp_t90 r0 *1 0,0
Rtopp_t90 topp__t90 topp 1.48319348523
* device instance topp_t91 r0 *1 0,0
Rtopp_t91 topp__t91 topp 1.35071450869
* device instance topp_t92 r0 *1 0,0
Rtopp_t92 topp__t92 topp 0.920078802365
* device instance topp_t93 r0 *1 0,0
Rtopp_t93 topp__t93 topp 0.418041272098
* device instance topp_t94 r0 *1 0,0
Rtopp_t94 topp__t94 topp 0.441515101154
* device instance topp_t95 r0 *1 0,0
Rtopp_t95 topp__t95 topp 0.481416254517
* device instance topp_t96 r0 *1 0,0
Rtopp_t96 topp__t96 topp 0.534075445866
* device instance topp_t97 r0 *1 0,0
Rtopp_t97 topp__t97 topp 0.596121212371
* device instance topp_t98 r0 *1 0,0
Rtopp_t98 topp__t98 topp 0.66493109718
* device instance topp_t99 r0 *1 0,0
Rtopp_t99 topp__t99 topp 0.73861706882
* device instance topp_t100 r0 *1 0,0
Rtopp_t100 topp__t100 topp 0.81585901411
* device instance topp_t101 r0 *1 0,0
Rtopp_t101 topp__t101 topp 0.895737480323
* device instance topp_t102 r0 *1 0,0
Rtopp_t102 topp__t102 topp 0.977606404747
* device instance topp_t103 r0 *1 0,0
Rtopp_t103 topp__t103 topp 1.06100512616
* device instance topp_t104 r0 *1 0,0
Rtopp_t104 topp__t104 topp 1.14559958934
* device instance topp_t105 r0 *1 0,0
Rtopp_t105 topp__t105 topp 1.2311433331
* device instance topp_t106 r0 *1 0,0
Rtopp_t106 topp__t106 topp 1.31745145655
* device instance topp_t107 r0 *1 0,0
Rtopp_t107 topp__t107 topp 1.31472445993
* device instance topp_t108 r0 *1 0,0
Rtopp_t108 topp__t108 topp 1.49182909424
* device instance topp_t109 r0 *1 0,0
Rtopp_t109 topp__t109 topp 0.854146423997
* device instance topp_t110 r0 *1 0,0
Rtopp_t110 topp__t110 topp 0.654324093907
* device instance topp_t111 r0 *1 0,0
Rtopp_t111 topp__t111 topp 0.793244080275
* device instance topp_t112 r0 *1 0,0
Rtopp_t112 topp__t112 topp 0.378317981578
* device instance topp_t113 r0 *1 0,0
Rtopp_t113 topp__t113 topp 1.41377748023
* device instance topp_t114 r0 *1 0,0
Rtopp_t114 topp__t114 topp 1.3238431568
* device instance topp_t115 r0 *1 0,0
Rtopp_t115 topp__t115 topp 1.23410031611
* device instance topp_t116 r0 *1 0,0
Rtopp_t116 topp__t116 topp 1.55472561769
* device instance topp_t117 r0 *1 0,0
Rtopp_t117 topp__t117 topp 1.47341972517
* device instance topp_t118 r0 *1 0,0
Rtopp_t118 topp__t118 topp 1.39334438418
* device instance topp_t119 r0 *1 0,0
Rtopp_t119 topp__t119 topp 1.40438303902
* device instance topp_t120 r0 *1 0,0
Rtopp_t120 topp__t120 topp 0.826286361624
* device instance topp_t121 r0 *1 0,0
Rtopp_t121 topp__t121 topp 0.914394772707
* device instance topp_t122 r0 *1 0,0
Rtopp_t122 topp__t122 topp 1.00306300674
* device instance topp_t123 r0 *1 0,0
Rtopp_t123 topp__t123 topp 1.09215472202
* device instance topp_t124 r0 *1 0,0
Rtopp_t124 topp__t124 topp 1.18157412987
* device instance topp_t125 r0 *1 0,0
Rtopp_t125 topp__t125 topp 1.27125208284
* device instance topp_t126 r0 *1 0,0
Rtopp_t126 topp__t126 topp 1.05915319372
* device instance topp_t127 r0 *1 0,0
Rtopp_t127 topp__t127 topp 1.14388462229
* device instance topp_t128 r0 *1 0,0
Rtopp_t128 topp__t128 topp 1.40298443695
* device instance topp_t129 r0 *1 0,0
Rtopp_t129 topp__t129 topp 1.49051254824
* device instance topp_t130 r0 *1 0,0
Rtopp_t130 topp__t130 topp 1.22954768783
* device instance topp_t131 r0 *1 0,0
Rtopp_t131 topp__t131 topp 1.31596046688
* device instance topp_t132 r0 *1 0,0
Rtopp_t132 topp__t132 topp 0.813449163089
* device instance topp_t133 r0 *1 0,0
Rtopp_t133 topp__t133 topp 0.893543084401
* device instance topp_t134 r0 *1 0,0
Rtopp_t134 topp__t134 topp 1.36113747948
* device instance topp_t135 r0 *1 0,0
Rtopp_t135 topp__t135 topp 1.11595984191
* device instance topp_t136 r0 *1 0,0
Rtopp_t136 topp__t136 topp 1.06965597035
* device instance topp_t137 r0 *1 0,0
Rtopp_t137 topp__t137 topp 1.16080979598
* device instance topp_t138 r0 *1 0,0
Rtopp_t138 topp__t138 topp 1.06945202293
* device instance topp_t139 r0 *1 0,0
Rtopp_t139 topp__t139 topp 0.716357328303
* device instance topp_t140 r0 *1 0,0
Rtopp_t140 topp__t140 topp 0.806156017508
* device instance topp_t141 r0 *1 0,0
Rtopp_t141 topp__t141 topp 0.89624559888
* device instance topp_t142 r0 *1 0,0
Rtopp_t142 topp__t142 topp 0.986546384442
* device instance topp_t143 r0 *1 0,0
Rtopp_t143 topp__t143 topp 1.07700525068
* device instance topp_t144 r0 *1 0,0
Rtopp_t144 topp__t144 topp 1.1675854562
* device instance topp_t145 r0 *1 0,0
Rtopp_t145 topp__t145 topp 1.25826079621
* device instance topp_t146 r0 *1 0,0
Rtopp_t146 topp__t146 topp 1.34901208712
* device instance topp_t147 r0 *1 0,0
Rtopp_t147 topp__t147 topp 1.4398249676
* device instance topp_t148 r0 *1 0,0
Rtopp_t148 topp__t148 topp 1.16062186645
* device instance topp_t149 r0 *1 0,0
Rtopp_t149 topp__t149 topp 1.25180172177
* device instance topp_t150 r0 *1 0,0
Rtopp_t150 topp__t150 topp 1.34298954968
* device instance topp_t151 r0 *1 0,0
Rtopp_t151 topp__t151 topp 0.978517937272
* device instance topp_t152 r0 *1 0,0
Rtopp_t152 topp__t152 topp 0.334910626681
* device instance topp_t153 r0 *1 0,0
Rtopp_t153 topp__t153 topp 0.406989065735
* device instance topp_t154 r0 *1 0,0
Rtopp_t154 topp__t154 topp 0.402089170338
* device instance topp_t155 r0 *1 0,0
Rtopp_t155 topp__t155 topp 0.463843370834
* device instance topp_t156 r0 *1 0,0
Rtopp_t156 topp__t156 topp 0.534111028371
* device instance topp_t157 r0 *1 0,0
Rtopp_t157 topp__t157 topp 0.609956928632
* device instance topp_t158 r0 *1 0,0
Rtopp_t158 topp__t158 topp 0.530386832324
* device instance topp_t159 r0 *1 0,0
Rtopp_t159 topp__t159 topp 0.323531445097
* device instance topp_t160 r0 *1 0,0
Rtopp_t160 topp__t160 topp 0.424764399468
* device instance topp_t161 r0 *1 0,0
Rtopp_t161 topp__t161 topp 0.409028094427
* device instance topp_t162 r0 *1 0,0
Rtopp_t162 topp__t162 topp 0.413318418659
* device instance topp_t163 r0 *1 0,0
Rtopp_t163 topp__t163 topp 0.437045986794
* device instance topp_t164 r0 *1 0,0
Rtopp_t164 topp__t164 topp 0.592818783326
* device instance topp_t165 r0 *1 0,0
Rtopp_t165 topp__t165 topp 0.353340735461
* device instance topp_t166 r0 *1 0,0
Rtopp_t166 topp__t166 topp 0.33803147164
* device instance topp_t167 r0 *1 0,0
Rtopp_t167 topp__t167 topp 0.738938054681
* device instance topp_t168 r0 *1 0,0
Rtopp_t168 topp__t168 topp 0.485555370261
* device instance topp_t169 r0 *1 0,0
Rtopp_t169 topp__t169 topp 0.56792330622
* device instance topp_t170 r0 *1 0,0
Rtopp_t170 topp__t170 topp 0.66197203417
* device instance topp_t171 r0 *1 0,0
Rtopp_t171 topp__t171 topp 0.477320877544
* device instance topp_t172 r0 *1 0,0
Rtopp_t172 topp__t172 topp 1.45119177374
* device instance topp_t173 r0 *1 0,0
Rtopp_t173 topp__t173 topp 0.771712395711
* device instance topp_t174 r0 *1 0,0
Rtopp_t174 topp__t174 topp 0.85572175644
* device instance topp_t175 r0 *1 0,0
Rtopp_t175 topp__t175 topp 0.941078303539
* device instance topp_t176 r0 *1 0,0
Rtopp_t176 topp__t176 topp 1.02744633365
* device instance topp_t177 r0 *1 0,0
Rtopp_t177 topp__t177 topp 1.11459073649
* device instance topp_t178 r0 *1 0,0
Rtopp_t178 topp__t178 topp 1.20234271213
* device instance topp_t179 r0 *1 0,0
Rtopp_t179 topp__t179 topp 1.29057833205
* device instance topp_t180 r0 *1 0,0
Rtopp_t180 topp__t180 topp 1.37920477489
* device instance topp_t181 r0 *1 0,0
Rtopp_t181 topp__t181 topp 1.4681512651
* device instance topp_t182 r0 *1 0,0
Rtopp_t182 topp__t182 topp 0.975596172926
* device instance topp_t183 r0 *1 0,0
Rtopp_t183 topp__t183 topp 0.318032172578
* device instance topp_t184 r0 *1 0,0
Rtopp_t184 topp__t184 topp 0.178586326293
* device instance topp_t185 r0 *1 0,0
Rtopp_t185 topp__t185 topp 0.137011907927
* device instance topp_t186 r0 *1 0,0
Rtopp_t186 topp__t186 topp 0.689542794279
* device instance topp_t187 r0 *1 0,0
Rtopp_t187 topp__t187 topp 0.652655109612
* device instance topp_t188 r0 *1 0,0
Rtopp_t188 topp__t188 topp 0.626974533184
* device instance topp_t189 r0 *1 0,0
Rtopp_t189 topp__t189 topp 0.613909101266
* device instance topp_t190 r0 *1 0,0
Rtopp_t190 topp__t190 topp 0.735954335797
* device instance topp_t191 r0 *1 0,0
Rtopp_t191 topp__t191 topp 0.61426431621
* device instance topp_t192 r0 *1 0,0
Rtopp_t192 topp__t192 topp 0.322797648169
* device instance topp_t193 r0 *1 0,0
Rtopp_t193 topp__t193 topp 0.258719984817
* device instance topp_t194 r0 *1 0,0
Rtopp_t194 topp__t194 topp 0.328217084923
* device instance topp_t195 r0 *1 0,0
Rtopp_t195 topp__t195 topp 0.357636035943
* device instance topp_t196 r0 *1 0,0
Rtopp_t196 topp__t196 topp 0.405868894807
* device instance topp_t197 r0 *1 0,0
Rtopp_t197 topp__t197 topp 0.467123679057
* device instance topp_t198 r0 *1 0,0
Rtopp_t198 topp__t198 topp 0.536962242152
* device instance topp_t199 r0 *1 0,0
Rtopp_t199 topp__t199 topp 1.43418382946
* device instance topp_t200 r0 *1 0,0
Rtopp_t200 topp__t200 topp 0.231981071467
* device instance topp_t201 r0 *1 0,0
Rtopp_t201 topp__t201 topp 0.239464717007
* device instance topp_t202 r0 *1 0,0
Rtopp_t202 topp__t202 topp 0.342518809248
* device instance topp_t203 r0 *1 0,0
Rtopp_t203 topp__t203 topp 0.338151527614
* device instance topp_t204 r0 *1 0,0
Rtopp_t204 topp__t204 topp 0.409660136444
* device instance topp_t205 r0 *1 0,0
Rtopp_t205 topp__t205 topp 0.487796417937
* device instance topp_t206 r0 *1 0,0
Rtopp_t206 topp__t206 topp 0.278424909196
* device instance topp_t207 r0 *1 0,0
Rtopp_t207 topp__t207 topp 0.569840512346
* device instance topp_t208 r0 *1 0,0
Rtopp_t208 topp__t208 topp 1.18249682965
* device instance topp_t209 r0 *1 0,0
Rtopp_t209 topp__t209 topp 1.27210973814
* device instance topp_t210 r0 *1 0,0
Rtopp_t210 topp__t210 topp 1.36193853232
* device instance topp_t211 r0 *1 0,0
Rtopp_t211 topp__t211 topp 0.77368849065
* device instance topp_t212 r0 *1 0,0
Rtopp_t212 topp__t212 topp 0.857504275974
* device instance topp_t213 r0 *1 0,0
Rtopp_t213 topp__t213 topp 0.942699438984
* device instance topp_t214 r0 *1 0,0
Rtopp_t214 topp__t214 topp 1.02893140073
* device instance topp_t215 r0 *1 0,0
Rtopp_t215 topp__t215 topp 0.612455152362
* device instance topp_t216 r0 *1 0,0
Rtopp_t216 topp__t216 topp 1.2519759647
* device instance topp_t217 r0 *1 0,0
Rtopp_t217 topp__t217 topp 0.704950452989
* device instance topp_t218 r0 *1 0,0
Rtopp_t218 topp__t218 topp 0.796036961403
* device instance topp_t219 r0 *1 0,0
Rtopp_t219 topp__t219 topp 0.887154717548
* device instance topp_t220 r0 *1 0,0
Rtopp_t220 topp__t220 topp 0.978294990282
* device instance topp_t221 r0 *1 0,0
Rtopp_t221 topp__t221 topp 1.34315196315
* device instance topp_t222 r0 *1 0,0
Rtopp_t222 topp__t222 topp 1.43433591681
* device instance topp_t223 r0 *1 0,0
Rtopp_t223 topp__t223 topp 0.705259815049
* device instance topp_t224 r0 *1 0,0
Rtopp_t224 topp__t224 topp 0.796310937682
* device instance topp_t225 r0 *1 0,0
Rtopp_t225 topp__t225 topp 0.887400562553
* device instance topp_t226 r0 *1 0,0
Rtopp_t226 topp__t226 topp 0.149333171419
* device instance topp_t227 r0 *1 0,0
Rtopp_t227 topp__t227 topp 0.206100643996
* device instance topp_t228 r0 *1 0,0
Rtopp_t228 topp__t228 topp 0.538214878005
* device instance topp_t229 r0 *1 0,0
Rtopp_t229 topp__t229 topp 0.281608772985
* device instance topp_t230 r0 *1 0,0
Rtopp_t230 topp__t230 topp 0.251178861327
* device instance topp_t231 r0 *1 0,0
Rtopp_t231 topp__t231 topp 0.450446878941
* device instance topp_t232 r0 *1 0,0
Rtopp_t232 topp__t232 topp 0.432076046666
* device instance topp_t233 r0 *1 0,0
Rtopp_t233 topp__t233 topp 0.522936491614
* device instance topp_t234 r0 *1 0,0
Rtopp_t234 topp__t234 topp 0.364387805485
* device instance topp_t235 r0 *1 0,0
Rtopp_t235 topp__t235 topp 0.126951411362
* device instance topp_t236 r0 *1 0,0
Rtopp_t236 topp__t236 topp 0.0547343385998
* device instance topp_t237 r0 *1 0,0
Rtopp_t237 topp__t237 topp 0.0807711643734
* device instance topp_t238 r0 *1 0,0
Rtopp_t238 topp__t238 topp 0.163404591012
* device instance topp_t239 r0 *1 0,0
Rtopp_t239 topp__t239 topp 0.252045801255
* device instance topp_t240 r0 *1 0,0
Rtopp_t240 topp__t240 topp 0.342055635379
* device instance topp_t241 r0 *1 0,0
Rtopp_t241 topp__t241 topp 0.432580600184
* device instance topp_t242 r0 *1 0,0
Rtopp_t242 topp__t242 topp 0.523353455911
* device instance topp_t243 r0 *1 0,0
Rtopp_t243 topp__t243 topp 0.125221385131
* device instance topp_t244 r0 *1 0,0
Rtopp_t244 topp__t244 topp 0.0505923143298
* device instance topp_t245 r0 *1 0,0
Rtopp_t245 topp__t245 topp 0.0780238132978
* device instance topp_t246 r0 *1 0,0
Rtopp_t246 topp__t246 topp 0.162064168807
* device instance topp_t247 r0 *1 0,0
Rtopp_t247 topp__t247 topp 0.341417328414
* device instance topp_t248 r0 *1 0,0
Rtopp_t248 topp__t248 topp 1.39773275516
* device instance topp_t249 r0 *1 0,0
Rtopp_t249 topp__t249 topp 1.43148519648
* device instance topp_t250 r0 *1 0,0
Rtopp_t250 topp__t250 topp 1.34273743076
* device instance topp_t251 r0 *1 0,0
Rtopp_t251 topp__t251 topp 1.25434711877
* device instance topp_t252 r0 *1 0,0
Rtopp_t252 topp__t252 topp 1.16639552767
* device instance topp_t253 r0 *1 0,0
Rtopp_t253 topp__t253 topp 1.07898994703
* device instance topp_t254 r0 *1 0,0
Rtopp_t254 topp__t254 topp 0.992274675071
* device instance topp_t255 r0 *1 0,0
Rtopp_t255 topp__t255 topp 0.906447848465
* device instance topp_t256 r0 *1 0,0
Rtopp_t256 topp__t256 topp 0.821787879799
* device instance topp_t257 r0 *1 0,0
Rtopp_t257 topp__t257 topp 0.738696069422
* device instance topp_t258 r0 *1 0,0
Rtopp_t258 topp__t258 topp 0.657766974522
* device instance topp_t259 r0 *1 0,0
Rtopp_t259 topp__t259 topp 0.579906758678
* device instance topp_t260 r0 *1 0,0
Rtopp_t260 topp__t260 topp 0.506532576392
* device instance topp_t261 r0 *1 0,0
Rtopp_t261 topp__t261 topp 0.439894986707
* device instance topp_t262 r0 *1 0,0
Rtopp_t262 topp__t262 topp 0.454083854373
* device instance topp_t263 r0 *1 0,0
Rtopp_t263 topp__t263 topp 0.987209484007
* device instance topp_t264 r0 *1 0,0
Rtopp_t264 topp__t264 topp 1.16814579321
* device instance topp_t265 r0 *1 0,0
Rtopp_t265 topp__t265 topp 1.2587807704
* device instance topp_t266 r0 *1 0,0
Rtopp_t266 topp__t266 topp 1.34949709443
* device instance topp_t267 r0 *1 0,0
Rtopp_t267 topp__t267 topp 1.44027939442
* device instance topp_t268 r0 *1 0,0
Rtopp_t268 topp__t268 topp 0.717712179401
* device instance topp_t269 r0 *1 0,0
Rtopp_t269 topp__t269 topp 0.214211157667
* device instance topp_t270 r0 *1 0,0
Rtopp_t270 topp__t270 topp 0.630976927888
* device instance topp_t271 r0 *1 0,0
Rtopp_t271 topp__t271 topp 0.307448307854
* device instance topp_t272 r0 *1 0,0
Rtopp_t272 topp__t272 topp 0.545712324206
* device instance topp_t273 r0 *1 0,0
Rtopp_t273 topp__t273 topp 0.458469796473
* device instance topp_t274 r0 *1 0,0
Rtopp_t274 topp__t274 topp 0.213190418444
* device instance topp_t275 r0 *1 0,0
Rtopp_t275 topp__t275 topp 0.462732043684
* device instance topp_t276 r0 *1 0,0
Rtopp_t276 topp__t276 topp 0.3835216994
* device instance topp_t277 r0 *1 0,0
Rtopp_t277 topp__t277 topp 0.248320025694
* device instance topp_t278 r0 *1 0,0
Rtopp_t278 topp__t278 topp 0.310975545286
* device instance topp_t279 r0 *1 0,0
Rtopp_t279 topp__t279 topp 1.07761268861
* device instance topp_t280 r0 *1 0,0
Rtopp_t280 topp__t280 topp 1.31304978628
* device instance topp_t281 r0 *1 0,0
Rtopp_t281 topp__t281 topp 1.22930532166
* device instance topp_t282 r0 *1 0,0
Rtopp_t282 topp__t282 topp 1.1467049981
* device instance topp_t283 r0 *1 0,0
Rtopp_t283 topp__t283 topp 1.06551493545
* device instance topp_t284 r0 *1 0,0
Rtopp_t284 topp__t284 topp 0.986083540512
* device instance topp_t285 r0 *1 0,0
Rtopp_t285 topp__t285 topp 0.908872029642
* device instance topp_t286 r0 *1 0,0
Rtopp_t286 topp__t286 topp 0.834496812373
* device instance topp_t287 r0 *1 0,0
Rtopp_t287 topp__t287 topp 0.763786907227
* device instance topp_t288 r0 *1 0,0
Rtopp_t288 topp__t288 topp 0.697857360526
* device instance topp_t289 r0 *1 0,0
Rtopp_t289 topp__t289 topp 0.638191427259
* device instance topp_t290 r0 *1 0,0
Rtopp_t290 topp__t290 topp 0.586703201125
* device instance topp_t291 r0 *1 0,0
Rtopp_t291 topp__t291 topp 0.790539192729
* device instance topp_t292 r0 *1 0,0
Rtopp_t292 topp__t292 topp 0.703767560232
* device instance topp_t293 r0 *1 0,0
Rtopp_t293 topp__t293 topp 0.618283340085
* device instance topp_t294 r0 *1 0,0
Rtopp_t294 topp__t294 topp 1.45471025228
* device instance topp_t295 r0 *1 0,0
Rtopp_t295 topp__t295 topp 1.36747060601
* device instance topp_t296 r0 *1 0,0
Rtopp_t296 topp__t296 topp 1.28078832939
* device instance topp_t297 r0 *1 0,0
Rtopp_t297 topp__t297 topp 1.194784741
* device instance topp_t298 r0 *1 0,0
Rtopp_t298 topp__t298 topp 1.10961766214
* device instance topp_t299 r0 *1 0,0
Rtopp_t299 topp__t299 topp 1.02549552955
* device instance topp_t300 r0 *1 0,0
Rtopp_t300 topp__t300 topp 0.942698123648
* device instance topp_t301 r0 *1 0,0
Rtopp_t301 topp__t301 topp 0.861607433653
* device instance topp_t302 r0 *1 0,0
Rtopp_t302 topp__t302 topp 0.782754069501
* device instance topp_t303 r0 *1 0,0
Rtopp_t303 topp__t303 topp 0.706887150196
* device instance topp_t304 r0 *1 0,0
Rtopp_t304 topp__t304 topp 0.635077868534
* device instance topp_t305 r0 *1 0,0
Rtopp_t305 topp__t305 topp 0.568864923587
* device instance topp_t306 r0 *1 0,0
Rtopp_t306 topp__t306 topp 0.5104308471
* device instance topp_t307 r0 *1 0,0
Rtopp_t307 topp__t307 topp 0.534704352531
* device instance topp_t308 r0 *1 0,0
Rtopp_t308 topp__t308 topp 0.379519479133
* device instance topp_t309 r0 *1 0,0
Rtopp_t309 topp__t309 topp 1.40179620689
* device instance topp_t310 r0 *1 0,0
Rtopp_t310 topp__t310 topp 1.31104025334
* device instance topp_t311 r0 *1 0,0
Rtopp_t311 topp__t311 topp 1.22035627268
* device instance topp_t312 r0 *1 0,0
Rtopp_t312 topp__t312 topp 1.12976159648
* device instance topp_t313 r0 *1 0,0
Rtopp_t313 topp__t313 topp 1.03927957918
* device instance topp_t314 r0 *1 0,0
Rtopp_t314 topp__t314 topp 0.948942447515
* device instance topp_t315 r0 *1 0,0
Rtopp_t315 topp__t315 topp 0.858795924476
* device instance topp_t316 r0 *1 0,0
Rtopp_t316 topp__t316 topp 0.768907053741
* device instance topp_t317 r0 *1 0,0
Rtopp_t317 topp__t317 topp 0.679378113342
* device instance topp_t318 r0 *1 0,0
Rtopp_t318 topp__t318 topp 0.590372874275
* device instance topp_t319 r0 *1 0,0
Rtopp_t319 topp__t319 topp 0.502169878297
* device instance topp_t320 r0 *1 0,0
Rtopp_t320 topp__t320 topp 0.415280614591
* device instance topp_t321 r0 *1 0,0
Rtopp_t321 topp__t321 topp 0.330742100795
* device instance topp_t322 r0 *1 0,0
Rtopp_t322 topp__t322 topp 0.896975456838
* device instance topp_t323 r0 *1 0,0
Rtopp_t323 topp__t323 topp 0.806967360692
* device instance topp_t324 r0 *1 0,0
Rtopp_t324 topp__t324 topp 0.717270254836
* device instance topp_t325 r0 *1 0,0
Rtopp_t325 topp__t325 topp 0.250941490828
* device instance topp_t326 r0 *1 0,0
Rtopp_t326 topp__t326 topp 0.539429375881
* device instance topp_t327 r0 *1 0,0
Rtopp_t327 topp__t327 topp 0.451897319538
* device instance topp_t328 r0 *1 0,0
Rtopp_t328 topp__t328 topp 0.36617928593
* device instance topp_t329 r0 *1 0,0
Rtopp_t329 topp__t329 topp 0.283923048871
* device instance topp_t330 r0 *1 0,0
Rtopp_t330 topp__t330 topp 0.209251695605
* device instance topp_t331 r0 *1 0,0
Rtopp_t331 topp__t331 topp 0.153652831878
* device instance topp_t332 r0 *1 0,0
Rtopp_t332 topp__t332 topp 0.141707655304
* device instance topp_t333 r0 *1 0,0
Rtopp_t333 topp__t333 topp 0.182213810116
* device instance topp_t334 r0 *1 0,0
Rtopp_t334 topp__t334 topp 0.628017405746
* device instance topp_t335 r0 *1 0,0
Rtopp_t335 topp__t335 topp 1.51803693034
* device instance topp_t336 r0 *1 0,0
Rtopp_t336 topp__t336 topp 1.43219195493
* device instance topp_t337 r0 *1 0,0
Rtopp_t337 topp__t337 topp 1.34705620366
* device instance topp_t338 r0 *1 0,0
Rtopp_t338 topp__t338 topp 1.26277313168
* device instance topp_t339 r0 *1 0,0
Rtopp_t339 topp__t339 topp 1.1795255379
* device instance topp_t340 r0 *1 0,0
Rtopp_t340 topp__t340 topp 1.09754906642
* device instance topp_t341 r0 *1 0,0
Rtopp_t341 topp__t341 topp 1.01715109893
* device instance topp_t342 r0 *1 0,0
Rtopp_t342 topp__t342 topp 0.938737295048
* device instance topp_t343 r0 *1 0,0
Rtopp_t343 topp__t343 topp 0.862848773751
* device instance topp_t344 r0 *1 0,0
Rtopp_t344 topp__t344 topp 0.79021342042
* device instance topp_t345 r0 *1 0,0
Rtopp_t345 topp__t345 topp 0.721813992283
* device instance topp_t346 r0 *1 0,0
Rtopp_t346 topp__t346 topp 0.65897084556
* device instance topp_t347 r0 *1 0,0
Rtopp_t347 topp__t347 topp 0.603422453457
* device instance topp_t348 r0 *1 0,0
Rtopp_t348 topp__t348 topp 0.557354183238
* device instance topp_t349 r0 *1 0,0
Rtopp_t349 topp__t349 topp 0.523275892819
* device instance topp_t350 r0 *1 0,0
Rtopp_t350 topp__t350 topp 1.48157483562
* device instance topp_t351 r0 *1 0,0
Rtopp_t351 topp__t351 topp 0.500112434822
* device instance topp_t352 r0 *1 0,0
Rtopp_t352 topp__t352 topp 0.513062628233
* device instance topp_t353 r0 *1 0,0
Rtopp_t353 topp__t353 topp 0.541297533443
* device instance topp_t354 r0 *1 0,0
Rtopp_t354 topp__t354 topp 0.582599111852
* device instance topp_t355 r0 *1 0,0
Rtopp_t355 topp__t355 topp 0.634420504671
* device instance topp_t356 r0 *1 0,0
Rtopp_t356 topp__t356 topp 0.694410523078
* device instance topp_t357 r0 *1 0,0
Rtopp_t357 topp__t357 topp 0.760638888417
* device instance topp_t358 r0 *1 0,0
Rtopp_t358 topp__t358 topp 0.831616503432
* device instance topp_t359 r0 *1 0,0
Rtopp_t359 topp__t359 topp 0.906228141908
* device instance topp_t360 r0 *1 0,0
Rtopp_t360 topp__t360 topp 0.983647206974
* device instance topp_t361 r0 *1 0,0
Rtopp_t361 topp__t361 topp 1.06326062496
* device instance topp_t362 r0 *1 0,0
Rtopp_t362 topp__t362 topp 1.1446106026
* device instance topp_t363 r0 *1 0,0
Rtopp_t363 topp__t363 topp 1.22735188629
* device instance topp_t364 r0 *1 0,0
Rtopp_t364 topp__t364 topp 1.31122111795
* device instance topp_t365 r0 *1 0,0
Rtopp_t365 topp__t365 topp 1.39601501917
* device instance topp_t366 r0 *1 0,0
Rtopp_t366 topp__t366 topp 0.503627422443
* device instance topp_t367 r0 *1 0,0
Rtopp_t367 topp__t367 topp 1.30434085597
* device instance topp_t368 r0 *1 0,0
Rtopp_t368 topp__t368 topp 1.21315619562
* device instance topp_t369 r0 *1 0,0
Rtopp_t369 topp__t369 topp 1.12198029732
* device instance topp_t370 r0 *1 0,0
Rtopp_t370 topp__t370 topp 1.0308154861
* device instance topp_t371 r0 *1 0,0
Rtopp_t371 topp__t371 topp 0.939664988915
* device instance topp_t372 r0 *1 0,0
Rtopp_t372 topp__t372 topp 0.848533418666
* device instance topp_t373 r0 *1 0,0
Rtopp_t373 topp__t373 topp 0.757427607096
* device instance topp_t374 r0 *1 0,0
Rtopp_t374 topp__t374 topp 0.666358119621
* device instance topp_t375 r0 *1 0,0
Rtopp_t375 topp__t375 topp 0.575342205454
* device instance topp_t376 r0 *1 0,0
Rtopp_t376 topp__t376 topp 0.484410063238
* device instance topp_t377 r0 *1 0,0
Rtopp_t377 topp__t377 topp 0.393619755033
* device instance topp_t378 r0 *1 0,0
Rtopp_t378 topp__t378 topp 0.303098762676
* device instance topp_t379 r0 *1 0,0
Rtopp_t379 topp__t379 topp 0.90476176042
* device instance topp_t380 r0 *1 0,0
Rtopp_t380 topp__t380 topp 0.736626108762
* device instance topp_t381 r0 *1 0,0
Rtopp_t381 topp__t381 topp 1.45336008206
* device instance topp_t382 r0 *1 0,0
Rtopp_t382 topp__t382 topp 1.36603421199
* device instance topp_t383 r0 *1 0,0
Rtopp_t383 topp__t383 topp 1.27925460904
* device instance topp_t384 r0 *1 0,0
Rtopp_t384 topp__t384 topp 1.1931404726
* device instance topp_t385 r0 *1 0,0
Rtopp_t385 topp__t385 topp 1.10784699582
* device instance topp_t386 r0 *1 0,0
Rtopp_t386 topp__t386 topp 1.02357935264
* device instance topp_t387 r0 *1 0,0
Rtopp_t387 topp__t387 topp 1.41300581592
* device instance topp_t388 r0 *1 0,0
Rtopp_t388 topp__t388 topp 1.32301903843
* device instance topp_t389 r0 *1 0,0
Rtopp_t389 topp__t389 topp 1.23321622697
* device instance topp_t390 r0 *1 0,0
Rtopp_t390 topp__t390 topp 0.819927716641
* device instance topp_t391 r0 *1 0,0
Rtopp_t391 topp__t391 topp 0.626466624284
* device instance topp_t392 r0 *1 0,0
Rtopp_t392 topp__t392 topp 0.713138688594
* device instance topp_t393 r0 *1 0,0
Rtopp_t393 topp__t393 topp 0.631979041684
* device instance topp_t394 r0 *1 0,0
Rtopp_t394 topp__t394 topp 0.565403317388
* device instance topp_t395 r0 *1 0,0
Rtopp_t395 topp__t395 topp 1.05435045117
* device instance topp_t396 r0 *1 0,0
Rtopp_t396 topp__t396 topp 0.965424569233
* device instance topp_t397 r0 *1 0,0
Rtopp_t397 topp__t397 topp 0.876973927822
* device instance topp_t398 r0 *1 0,0
Rtopp_t398 topp__t398 topp 0.789158341195
* device instance topp_t399 r0 *1 0,0
Rtopp_t399 topp__t399 topp 0.70221609998
* device instance topp_t400 r0 *1 0,0
Rtopp_t400 topp__t400 topp 0.616516796903
* device instance topp_t401 r0 *1 0,0
Rtopp_t401 topp__t401 topp 1.39568885999
* device instance topp_t402 r0 *1 0,0
Rtopp_t402 topp__t402 topp 1.30450808128
* device instance topp_t403 r0 *1 0,0
Rtopp_t403 topp__t403 topp 1.21333598831
* device instance topp_t404 r0 *1 0,0
Rtopp_t404 topp__t404 topp 1.12217469814
* device instance topp_t405 r0 *1 0,0
Rtopp_t405 topp__t405 topp 1.03102707624
* device instance topp_t406 r0 *1 0,0
Rtopp_t406 topp__t406 topp 1.1436407194
* device instance topp_t407 r0 *1 0,0
Rtopp_t407 topp__t407 topp 0.84879045008
* device instance topp_t408 r0 *1 0,0
Rtopp_t408 topp__t408 topp 0.75771554395
* device instance topp_t409 r0 *1 0,0
Rtopp_t409 topp__t409 topp 0.666685389924
* device instance topp_t410 r0 *1 0,0
Rtopp_t410 topp__t410 topp 0.575721216328
* device instance topp_t411 r0 *1 0,0
Rtopp_t411 topp__t411 topp 0.484860160169
* device instance topp_t412 r0 *1 0,0
Rtopp_t412 topp__t412 topp 0.394173536789
* device instance topp_t413 r0 *1 0,0
Rtopp_t413 topp__t413 topp 0.303817585877
* device instance topp_t414 r0 *1 0,0
Rtopp_t414 topp__t414 topp 0.506570093568
* device instance topp_t415 r0 *1 0,0
Rtopp_t415 topp__t415 topp 0.43641005999
* device instance topp_t416 r0 *1 0,0
Rtopp_t416 topp__t416 topp 1.39553256084
* device instance topp_t417 r0 *1 0,0
Rtopp_t417 topp__t417 topp 0.254469453531
* device instance topp_t418 r0 *1 0,0
Rtopp_t418 topp__t418 topp 0.227230917253
* device instance topp_t419 r0 *1 0,0
Rtopp_t419 topp__t419 topp 0.274479693779
* device instance topp_t420 r0 *1 0,0
Rtopp_t420 topp__t420 topp 0.939897099126
* device instance topp_t421 r0 *1 0,0
Rtopp_t421 topp__t421 topp 1.43041812379
* device instance topp_t422 r0 *1 0,0
Rtopp_t422 topp__t422 topp 1.34159977232
* device instance topp_t423 r0 *1 0,0
Rtopp_t423 topp__t423 topp 1.2531292174
* device instance topp_t424 r0 *1 0,0
Rtopp_t424 topp__t424 topp 1.16508569132
* device instance topp_t425 r0 *1 0,0
Rtopp_t425 topp__t425 topp 1.07757387075
* device instance topp_t426 r0 *1 0,0
Rtopp_t426 topp__t426 topp 0.990734662722
* device instance topp_t427 r0 *1 0,0
Rtopp_t427 topp__t427 topp 1.4013293007
* device instance topp_t428 r0 *1 0,0
Rtopp_t428 topp__t428 topp 1.31054101394
* device instance topp_t429 r0 *1 0,0
Rtopp_t429 topp__t429 topp 1.21981991934
* device instance topp_t430 r0 *1 0,0
Rtopp_t430 topp__t430 topp 1.12918221215
* device instance topp_t431 r0 *1 0,0
Rtopp_t431 topp__t431 topp 1.03864972297
* device instance topp_t432 r0 *1 0,0
Rtopp_t432 topp__t432 topp 0.948252588732
* device instance topp_t433 r0 *1 0,0
Rtopp_t433 topp__t433 topp 0.704104433403
* device instance topp_t434 r0 *1 0,0
Rtopp_t434 topp__t434 topp 0.76805550622
* device instance topp_t435 r0 *1 0,0
Rtopp_t435 topp__t435 topp 0.678414198134
* device instance topp_t436 r0 *1 0,0
Rtopp_t436 topp__t436 topp 0.589263382556
* device instance topp_t437 r0 *1 0,0
Rtopp_t437 topp__t437 topp 0.500865041713
* device instance topp_t438 r0 *1 0,0
Rtopp_t438 topp__t438 topp 0.413701815559
* device instance topp_t439 r0 *1 0,0
Rtopp_t439 topp__t439 topp 0.328757571137
* device instance topp_t440 r0 *1 0,0
Rtopp_t440 topp__t440 topp 0.655441480151
* device instance topp_t441 r0 *1 0,0
Rtopp_t441 topp__t441 topp 0.577267693441
* device instance topp_t442 r0 *1 0,0
Rtopp_t442 topp__t442 topp 0.503509078446
* device instance topp_t443 r0 *1 0,0
Rtopp_t443 topp__t443 topp 0.940613290548
* device instance topp_t444 r0 *1 0,0
Rtopp_t444 topp__t444 topp 0.859325886816
* device instance topp_t445 r0 *1 0,0
Rtopp_t445 topp__t445 topp 0.780241977432
* device instance topp_t446 r0 *1 0,0
Rtopp_t446 topp__t446 topp 0.532660695802
* device instance topp_t447 r0 *1 0,0
Rtopp_t447 topp__t447 topp 0.451675568344
* device instance topp_t448 r0 *1 0,0
Rtopp_t448 topp__t448 topp 0.375423983547
* device instance topp_t449 r0 *1 0,0
Rtopp_t449 topp__t449 topp 0.858033590973
* device instance topp_t450 r0 *1 0,0
Rtopp_t450 topp__t450 topp 0.684984926911
* device instance topp_t451 r0 *1 0,0
Rtopp_t451 topp__t451 topp 1.14195944098
* device instance topp_t452 r0 *1 0,0
Rtopp_t452 topp__t452 topp 1.22095778231
* device instance topp_t453 r0 *1 0,0
Rtopp_t453 topp__t453 topp 1.30155806391
* device instance topp_t454 r0 *1 0,0
Rtopp_t454 topp__t454 topp 1.38348033143
* device instance topp_t455 r0 *1 0,0
Rtopp_t455 topp__t455 topp 1.466503054
* device instance topp_t456 r0 *1 0,0
Rtopp_t456 topp__t456 topp 1.55044946177
* device instance topp_t457 r0 *1 0,0
Rtopp_t457 topp__t457 topp 0.234865968007
* device instance topp_t458 r0 *1 0,0
Rtopp_t458 topp__t458 topp 1.01824025389
* device instance topp_t459 r0 *1 0,0
Rtopp_t459 topp__t459 topp 0.952444107672
* device instance topp_t460 r0 *1 0,0
Rtopp_t460 topp__t460 topp 0.891142686684
* device instance topp_t461 r0 *1 0,0
Rtopp_t461 topp__t461 topp 0.835326130334
* device instance topp_t462 r0 *1 0,0
Rtopp_t462 topp__t462 topp 0.786163561993
* device instance topp_t463 r0 *1 0,0
Rtopp_t463 topp__t463 topp 1.51476777269
* device instance topp_t464 r0 *1 0,0
Rtopp_t464 topp__t464 topp 1.4311936785
* device instance topp_t465 r0 *1 0,0
Rtopp_t465 topp__t465 topp 1.34861344788
* device instance topp_t466 r0 *1 0,0
Rtopp_t466 topp__t466 topp 1.26722139518
* device instance topp_t467 r0 *1 0,0
Rtopp_t467 topp__t467 topp 1.18726191012
* device instance topp_t468 r0 *1 0,0
Rtopp_t468 topp__t468 topp 1.10904489008
* device instance topp_t469 r0 *1 0,0
Rtopp_t469 topp__t469 topp 1.03296623344
* device instance topp_t470 r0 *1 0,0
Rtopp_t470 topp__t470 topp 0.9595347085
* device instance topp_t471 r0 *1 0,0
Rtopp_t471 topp__t471 topp 1.08771577043
* device instance topp_t472 r0 *1 0,0
Rtopp_t472 topp__t472 topp 0.823425121187
* device instance topp_t473 r0 *1 0,0
Rtopp_t473 topp__t473 topp 0.762668595257
* device instance topp_t474 r0 *1 0,0
Rtopp_t474 topp__t474 topp 0.70848203109
* device instance topp_t475 r0 *1 0,0
Rtopp_t475 topp__t475 topp 0.662479536862
* device instance topp_t476 r0 *1 0,0
Rtopp_t476 topp__t476 topp 0.744973485829
* device instance topp_t477 r0 *1 0,0
Rtopp_t477 topp__t477 topp 1.55261964531
* device instance topp_t478 r0 *1 0,0
Rtopp_t478 topp__t478 topp 1.47119737059
* device instance topp_t479 r0 *1 0,0
Rtopp_t479 topp__t479 topp 1.39099410122
* device instance topp_t480 r0 *1 0,0
Rtopp_t480 topp__t480 topp 1.31223337187
* device instance topp_t481 r0 *1 0,0
Rtopp_t481 topp__t481 topp 0.889406217884
* device instance topp_t482 r0 *1 0,0
Rtopp_t482 topp__t482 topp 0.725401581905
* device instance topp_t483 r0 *1 0,0
Rtopp_t483 topp__t483 topp 0.761368785015
* device instance topp_t484 r0 *1 0,0
Rtopp_t484 topp__t484 topp 0.806105665999
* device instance topp_t485 r0 *1 0,0
Rtopp_t485 topp__t485 topp 0.858241929129
* device instance topp_t486 r0 *1 0,0
Rtopp_t486 topp__t486 topp 0.916515695048
* device instance topp_t487 r0 *1 0,0
Rtopp_t487 topp__t487 topp 0.979832524375
* device instance topp_t488 r0 *1 0,0
Rtopp_t488 topp__t488 topp 1.04727812857
* device instance topp_t489 r0 *1 0,0
Rtopp_t489 topp__t489 topp 1.11810559766
* device instance topp_t490 r0 *1 0,0
Rtopp_t490 topp__t490 topp 1.19171209722
* device instance topp_t491 r0 *1 0,0
Rtopp_t491 topp__t491 topp 1.2676136099
* device instance topp_t492 r0 *1 0,0
Rtopp_t492 topp__t492 topp 1.34542177459
* device instance topp_t493 r0 *1 0,0
Rtopp_t493 topp__t493 topp 1.4248242647
* device instance topp_t494 r0 *1 0,0
Rtopp_t494 topp__t494 topp 1.50556885104
* device instance topp_t495 r0 *1 0,0
Rtopp_t495 topp__t495 topp 0.691951609542
* device instance topp_t496 r0 *1 0,0
Rtopp_t496 topp__t496 topp 0.699558024373
* device instance topp_t497 r0 *1 0,0
Rtopp_t497 topp__t497 topp 1.23519115972
* device instance topp_t498 r0 *1 0,0
Rtopp_t498 topp__t498 topp 1.06491960715
* device instance topp_t499 r0 *1 0,0
Rtopp_t499 topp__t499 topp 0.990295471435
* device instance topp_t500 r0 *1 0,0
Rtopp_t500 topp__t500 topp 0.918675904764
* device instance topp_t501 r0 *1 0,0
Rtopp_t501 topp__t501 topp 0.85081999356
* device instance topp_t502 r0 *1 0,0
Rtopp_t502 topp__t502 topp 0.787700990914
* device instance topp_t503 r0 *1 0,0
Rtopp_t503 topp__t503 topp 0.730547730767
* device instance topp_t504 r0 *1 0,0
Rtopp_t504 topp__t504 topp 0.680864207436
* device instance topp_t505 r0 *1 0,0
Rtopp_t505 topp__t505 topp 0.64039136253
* device instance topp_t506 r0 *1 0,0
Rtopp_t506 topp__t506 topp 0.610962414258
* device instance topp_t507 r0 *1 0,0
Rtopp_t507 topp__t507 topp 0.594220491288
* device instance topp_t508 r0 *1 0,0
Rtopp_t508 topp__t508 topp 0.591244331131
* device instance topp_t509 r0 *1 0,0
Rtopp_t509 topp__t509 topp 0.6022380527
* device instance topp_t510 r0 *1 0,0
Rtopp_t510 topp__t510 topp 1.16020986293
* device instance topp_t511 r0 *1 0,0
Rtopp_t511 topp__t511 topp 0.682404731023
* device instance topp_t512 r0 *1 0,0
Rtopp_t512 topp__t512 topp 5.03077510656
* device instance topp_t513 r0 *1 0,0
Rtopp_t513 topp__t513 topp 4.94430761921
* device instance topp r0 *1 0,0
Ctopp topp vsubs 2.3701877e-13
* device instance tp_gn_t0 r0 *1 0,0
Rtp_gn_t0 tp_gn__t0 tp_gn 31.7522969677
* device instance tp_gn_t1 r0 *1 0,0
Rtp_gn_t1 tp_gn__t1 tp_gn 100.696431059
* device instance tp_gn_t2 r0 *1 0,0
Rtp_gn_t2 tp_gn__t2 tp_gn 64.5097300968
* device instance tp_gn_t3 r0 *1 0,0
Rtp_gn_t3 tp_gn__t3 tp_gn 70.2913261279
* device instance tp_gn_t4 r0 *1 0,0
Rtp_gn_t4 tp_gn__t4 tp_gn 99.0585228122
* device instance tp_gn_t5 r0 *1 0,0
Rtp_gn_t5 tp_gn__t5 tp_gn 38.2150929367
* device instance tp_gn r0 *1 0,0
Ctp_gn tp_gn vsubs 4.986478e-15
* device instance vcm_t0 r0 *1 0,0
Rvcm_t0 vcm__t0 vcm 410.277980669
* device instance vcm_t1 r0 *1 0,0
Rvcm_t1 vcm__t1 vcm 145.320841278
* device instance vcm_t2 r0 *1 0,0
Rvcm_t2 vcm__t2 vcm 386.488112829
* device instance vcm_t3 r0 *1 0,0
Rvcm_t3 vcm__t3 vcm 364.461961382
* device instance vcm_t4 r0 *1 0,0
Rvcm_t4 vcm__t4 vcm 40.0196394518
* device instance vcm_t5 r0 *1 0,0
Rvcm_t5 vcm__t5 vcm 157.337706822
* device instance vcm_t6 r0 *1 0,0
Rvcm_t6 vcm__t6 vcm 254.315172105
* device instance vcm_t7 r0 *1 0,0
Rvcm_t7 vcm__t7 vcm 316.34065158
* device instance vcm_t8 r0 *1 0,0
Rvcm_t8 vcm__t8 vcm 153.29974609
* device instance vcm_t9 r0 *1 0,0
Rvcm_t9 vcm__t9 vcm 233.749021714
* device instance vcm_t10 r0 *1 0,0
Rvcm_t10 vcm__t10 vcm 314.351818836
* device instance vcm_t11 r0 *1 0,0
Rvcm_t11 vcm__t11 vcm 73.5097748748
* device instance vcm_t12 r0 *1 0,0
Rvcm_t12 vcm__t12 vcm 81.5967452716
* device instance vcm_t13 r0 *1 0,0
Rvcm_t13 vcm__t13 vcm 97.9070073938
* device instance vcm_t14 r0 *1 0,0
Rvcm_t14 vcm__t14 vcm 236.416892351
* device instance vcm_t15 r0 *1 0,0
Rvcm_t15 vcm__t15 vcm 91.2767235391
* device instance vcm_t16 r0 *1 0,0
Rvcm_t16 vcm__t16 vcm 171.336857293
* device instance vcm_t17 r0 *1 0,0
Rvcm_t17 vcm__t17 vcm 18.6341005975
* device instance vcm_t18 r0 *1 0,0
Rvcm_t18 vcm__t18 vcm 174.959025214
* device instance vcm_t19 r0 *1 0,0
Rvcm_t19 vcm__t19 vcm 332.457634951
* device instance vcm_t20 r0 *1 0,0
Rvcm_t20 vcm__t20 vcm 251.836980855
* device instance vcm_t21 r0 *1 0,0
Rvcm_t21 vcm__t21 vcm 334.338781588
* device instance vcm_t22 r0 *1 0,0
Rvcm_t22 vcm__t22 vcm 373.970347457
* device instance vcm_t23 r0 *1 0,0
Rvcm_t23 vcm__t23 vcm 50.0731802297
* device instance vcm_t24 r0 *1 0,0
Rvcm_t24 vcm__t24 vcm 351.87600844
* device instance vcm_t25 r0 *1 0,0
Rvcm_t25 vcm__t25 vcm 112.339832528
* device instance vcm_t26 r0 *1 0,0
Rvcm_t26 vcm__t26 vcm 56.7359662087
* device instance vcm_t27 r0 *1 0,0
Rvcm_t27 vcm__t27 vcm 375.426466204
* device instance vcm_t28 r0 *1 0,0
Rvcm_t28 vcm__t28 vcm 121.637827524
* device instance vcm_t29 r0 *1 0,0
Rvcm_t29 vcm__t29 vcm 130.429551327
* device instance vcm_t30 r0 *1 0,0
Rvcm_t30 vcm__t30 vcm 295.497010965
* device instance vcm_t31 r0 *1 0,0
Rvcm_t31 vcm__t31 vcm 216.177249739
* device instance vcm_t32 r0 *1 0,0
Rvcm_t32 vcm__t32 vcm 198.527630721
* device instance vcm_t33 r0 *1 0,0
Rvcm_t33 vcm__t33 vcm 68.4313268217
* device instance vcm_t34 r0 *1 0,0
Rvcm_t34 vcm__t34 vcm 277.617267271
* device instance vcm_t35 r0 *1 0,0
Rvcm_t35 vcm__t35 vcm 138.518558221
* device instance vcm_t36 r0 *1 0,0
Rvcm_t36 vcm__t36 vcm 211.085480771
* device instance vcm_t37 r0 *1 0,0
Rvcm_t37 vcm__t37 vcm 273.67101413
* device instance vcm_t38 r0 *1 0,0
Rvcm_t38 vcm__t38 vcm 192.970715518
* device instance vcm_t39 r0 *1 0,0
Rvcm_t39 vcm__t39 vcm 32.3024263699
* device instance vcm_t40 r0 *1 0,0
Rvcm_t40 vcm__t40 vcm 291.792666764
* device instance vcm_t41 r0 *1 0,0
Rvcm_t41 vcm__t41 vcm 372.517796104
* device instance vcm r0 *1 0,0
Cvcm vcm vsubs 2.70851866e-13
* device instance vdd_t0 r0 *1 0,0
Rvdd_t0 vdd__t0 vdd 388.595289028
* device instance vdd_t1 r0 *1 0,0
Rvdd_t1 vdd__t1 vdd 115.683483157
* device instance vdd_t2 r0 *1 0,0
Rvdd_t2 vdd__t2 vdd 104.904600294
* device instance vdd_t3 r0 *1 0,0
Rvdd_t3 vdd__t3 vdd 190.025556209
* device instance vdd_t4 r0 *1 0,0
Rvdd_t4 vdd__t4 vdd 110.284357141
* device instance vdd_t5 r0 *1 0,0
Rvdd_t5 vdd__t5 vdd 200.228635697
* device instance vdd_t6 r0 *1 0,0
Rvdd_t6 vdd__t6 vdd 35.1372642803
* device instance vdd_t7 r0 *1 0,0
Rvdd_t7 vdd__t7 vdd 34.1082859091
* device instance vdd_t8 r0 *1 0,0
Rvdd_t8 vdd__t8 vdd 117.055254996
* device instance vdd_t9 r0 *1 0,0
Rvdd_t9 vdd__t9 vdd 29.0535836155
* device instance vdd_t10 r0 *1 0,0
Rvdd_t10 vdd__t10 vdd 111.722441241
* device instance vdd_t11 r0 *1 0,0
Rvdd_t11 vdd__t11 vdd 194.704377892
* device instance vdd_t12 r0 *1 0,0
Rvdd_t12 vdd__t12 vdd 106.415410583
* device instance vdd_t13 r0 *1 0,0
Rvdd_t13 vdd__t13 vdd 101.138221858
* device instance vdd_t14 r0 *1 0,0
Rvdd_t14 vdd__t14 vdd 189.183634508
* device instance vdd_t15 r0 *1 0,0
Rvdd_t15 vdd__t15 vdd 30.2549647884
* device instance vdd_t16 r0 *1 0,0
Rvdd_t16 vdd__t16 vdd 32.3879552619
* device instance vdd_t17 r0 *1 0,0
Rvdd_t17 vdd__t17 vdd 35.2840045346
* device instance vdd_t18 r0 *1 0,0
Rvdd_t18 vdd__t18 vdd 99.5473529225
* device instance vdd_t19 r0 *1 0,0
Rvdd_t19 vdd__t19 vdd 94.4087800667
* device instance vdd_t20 r0 *1 0,0
Rvdd_t20 vdd__t20 vdd 359.205027327
* device instance vdd_t21 r0 *1 0,0
Rvdd_t21 vdd__t21 vdd 364.764567284
* device instance vdd_t22 r0 *1 0,0
Rvdd_t22 vdd__t22 vdd 256.365136303
* device instance vdd_t23 r0 *1 0,0
Rvdd_t23 vdd__t23 vdd 261.914574486
* device instance vdd_t24 r0 *1 0,0
Rvdd_t24 vdd__t24 vdd 267.465455943
* device instance vdd_t25 r0 *1 0,0
Rvdd_t25 vdd__t25 vdd 273.017692643
* device instance vdd_t26 r0 *1 0,0
Rvdd_t26 vdd__t26 vdd 205.756124851
* device instance vdd_t27 r0 *1 0,0
Rvdd_t27 vdd__t27 vdd 347.629407801
* device instance vdd_t28 r0 *1 0,0
Rvdd_t28 vdd__t28 vdd 353.194583623
* device instance vdd_t29 r0 *1 0,0
Rvdd_t29 vdd__t29 vdd 358.760347879
* device instance vdd_t30 r0 *1 0,0
Rvdd_t30 vdd__t30 vdd 364.326673604
* device instance vdd_t31 r0 *1 0,0
Rvdd_t31 vdd__t31 vdd 262.523349009
* device instance vdd_t32 r0 *1 0,0
Rvdd_t32 vdd__t32 vdd 268.061624575
* device instance vdd_t33 r0 *1 0,0
Rvdd_t33 vdd__t33 vdd 273.601763413
* device instance vdd_t34 r0 *1 0,0
Rvdd_t34 vdd__t34 vdd 348.088307208
* device instance vdd_t35 r0 *1 0,0
Rvdd_t35 vdd__t35 vdd 256.987057181
* device instance vdd_t36 r0 *1 0,0
Rvdd_t36 vdd__t36 vdd 427.880874017
* device instance vdd_t37 r0 *1 0,0
Rvdd_t37 vdd__t37 vdd 452.801957733
* device instance vdd_t38 r0 *1 0,0
Rvdd_t38 vdd__t38 vdd 166.536581089
* device instance vdd_t39 r0 *1 0,0
Rvdd_t39 vdd__t39 vdd 172.007402579
* device instance vdd_t40 r0 *1 0,0
Rvdd_t40 vdd__t40 vdd 177.485280576
* device instance vdd_t41 r0 *1 0,0
Rvdd_t41 vdd__t41 vdd 182.969581293
* device instance vdd_t42 r0 *1 0,0
Rvdd_t42 vdd__t42 vdd 76.9575273484
* device instance vdd_t43 r0 *1 0,0
Rvdd_t43 vdd__t43 vdd 89.220078523
* device instance vdd_t44 r0 *1 0,0
Rvdd_t44 vdd__t44 vdd 87.4125732655
* device instance vdd_t45 r0 *1 0,0
Rvdd_t45 vdd__t45 vdd 92.702498925
* device instance vdd_t46 r0 *1 0,0
Rvdd_t46 vdd__t46 vdd 165.575265043
* device instance vdd_t47 r0 *1 0,0
Rvdd_t47 vdd__t47 vdd 171.076830971
* device instance vdd_t48 r0 *1 0,0
Rvdd_t48 vdd__t48 vdd 176.583579006
* device instance vdd_t49 r0 *1 0,0
Rvdd_t49 vdd__t49 vdd 182.09503901
* device instance vdd_t50 r0 *1 0,0
Rvdd_t50 vdd__t50 vdd 79.0045914003
* device instance vdd_t51 r0 *1 0,0
Rvdd_t51 vdd__t51 vdd 84.0820530664
* device instance vdd_t52 r0 *1 0,0
Rvdd_t52 vdd__t52 vdd 82.1615920069
* device instance vdd_t53 r0 *1 0,0
Rvdd_t53 vdd__t53 vdd 201.0243045
* device instance vdd_t54 r0 *1 0,0
Rvdd_t54 vdd__t54 vdd 353.646261605
* device instance vdd_t55 r0 *1 0,0
Rvdd_t55 vdd__t55 vdd 285.709330818
* device instance vdd_t56 r0 *1 0,0
Rvdd_t56 vdd__t56 vdd 291.265482017
* device instance vdd_t57 r0 *1 0,0
Rvdd_t57 vdd__t57 vdd 296.822682575
* device instance vdd_t58 r0 *1 0,0
Rvdd_t58 vdd__t58 vdd 286.267508047
* device instance vdd_t59 r0 *1 0,0
Rvdd_t59 vdd__t59 vdd 280.723514233
* device instance vdd_t60 r0 *1 0,0
Rvdd_t60 vdd__t60 vdd 377.470953119
* device instance vdd_t61 r0 *1 0,0
Rvdd_t61 vdd__t61 vdd 383.03280181
* device instance vdd_t62 r0 *1 0,0
Rvdd_t62 vdd__t62 vdd 206.530499831
* device instance vdd_t63 r0 *1 0,0
Rvdd_t63 vdd__t63 vdd 371.480300644
* device instance vdd_t64 r0 *1 0,0
Rvdd_t64 vdd__t64 vdd 377.047816599
* device instance vdd_t65 r0 *1 0,0
Rvdd_t65 vdd__t65 vdd 382.615816212
* device instance vdd_t66 r0 *1 0,0
Rvdd_t66 vdd__t66 vdd 388.184278671
* device instance vdd_t67 r0 *1 0,0
Rvdd_t67 vdd__t67 vdd 39.5502897935
* device instance vdd_t68 r0 *1 0,0
Rvdd_t68 vdd__t68 vdd 36.9897836274
* device instance vdd_t69 r0 *1 0,0
Rvdd_t69 vdd__t69 vdd 195.522528669
* device instance vdd_t70 r0 *1 0,0
Rvdd_t70 vdd__t70 vdd 371.909771603
* device instance vdd_t71 r0 *1 0,0
Rvdd_t71 vdd__t71 vdd 291.813031686
* device instance vdd_t72 r0 *1 0,0
Rvdd_t72 vdd__t72 vdd 297.359999559
* device instance vdd_t73 r0 *1 0,0
Rvdd_t73 vdd__t73 vdd 280.154291412
* device instance vdd r0 *1 0,0
Cvdd vdd vsubs 2.60092726e-13
* device instance vref_t0 r0 *1 0,0
Rvref_t0 vref__t0 vref 41.1303894494
* device instance vref_t1 r0 *1 0,0
Rvref_t1 vref__t1 vref 200.050600921
* device instance vref_t2 r0 *1 0,0
Rvref_t2 vref__t2 vref 33.8001529648
* device instance vref_t3 r0 *1 0,0
Rvref_t3 vref__t3 vref 331.662885454
* device instance vref_t4 r0 *1 0,0
Rvref_t4 vref__t4 vref 243.842447541
* device instance vref_t5 r0 *1 0,0
Rvref_t5 vref__t5 vref 201.418721882
* device instance vref_t6 r0 *1 0,0
Rvref_t6 vref__t6 vref 288.678148414
* device instance vref_t7 r0 *1 0,0
Rvref_t7 vref__t7 vref 376.366526479
* device instance vref_t8 r0 *1 0,0
Rvref_t8 vref__t8 vref 115.564037281
* device instance vref_t9 r0 *1 0,0
Rvref_t9 vref__t9 vref 113.162662203
* device instance vref_t10 r0 *1 0,0
Rvref_t10 vref__t10 vref 70.9241115508
* device instance vref_t11 r0 *1 0,0
Rvref_t11 vref__t11 vref 287.725241812
* device instance vref_t12 r0 *1 0,0
Rvref_t12 vref__t12 vref 375.636131993
* device instance vref_t13 r0 *1 0,0
Rvref_t13 vref__t13 vref 74.6959717461
* device instance vref_t14 r0 *1 0,0
Rvref_t14 vref__t14 vref 158.172009184
* device instance vref_t15 r0 *1 0,0
Rvref_t15 vref__t15 vref 156.426103619
* device instance vref_t16 r0 *1 0,0
Rvref_t16 vref__t16 vref 332.489891852
* device instance vref_t17 r0 *1 0,0
Rvref_t17 vref__t17 vref 244.966115654
* device instance vref_t18 r0 *1 0,0
Rvref_t18 vref__t18 vref 33.8001529648
* device instance vref_t19 r0 *1 0,0
Rvref_t19 vref__t19 vref 156.426103619
* device instance vref_t20 r0 *1 0,0
Rvref_t20 vref__t20 vref 74.6959717461
* device instance vref_t21 r0 *1 0,0
Rvref_t21 vref__t21 vref 376.366526479
* device instance vref_t22 r0 *1 0,0
Rvref_t22 vref__t22 vref 158.172009184
* device instance vref_t23 r0 *1 0,0
Rvref_t23 vref__t23 vref 288.678148414
* device instance vref_t24 r0 *1 0,0
Rvref_t24 vref__t24 vref 113.162662203
* device instance vref_t25 r0 *1 0,0
Rvref_t25 vref__t25 vref 200.050600921
* device instance vref_t26 r0 *1 0,0
Rvref_t26 vref__t26 vref 375.636131993
* device instance vref_t27 r0 *1 0,0
Rvref_t27 vref__t27 vref 244.966115654
* device instance vref_t28 r0 *1 0,0
Rvref_t28 vref__t28 vref 332.489891852
* device instance vref_t29 r0 *1 0,0
Rvref_t29 vref__t29 vref 41.1303894494
* device instance vref_t30 r0 *1 0,0
Rvref_t30 vref__t30 vref 115.564037281
* device instance vref_t31 r0 *1 0,0
Rvref_t31 vref__t31 vref 287.725241812
* device instance vref_t32 r0 *1 0,0
Rvref_t32 vref__t32 vref 201.418721882
* device instance vref_t33 r0 *1 0,0
Rvref_t33 vref__t33 vref 331.662885454
* device instance vref_t34 r0 *1 0,0
Rvref_t34 vref__t34 vref 243.842447541
* device instance vref_t35 r0 *1 0,0
Rvref_t35 vref__t35 vref 70.9241115508
* device instance vref r0 *1 0,0
Cvref vref vsubs 1.80497549e-13
* device instance vss_t0 r0 *1 0,0
Rvss_t0 vss__t0 vss 116.116056055
* device instance vss_t1 r0 *1 0,0
Rvss_t1 vss__t1 vss 67.5624915375
* device instance vss_t2 r0 *1 0,0
Rvss_t2 vss__t2 vss 65.1537336239
* device instance vss_t3 r0 *1 0,0
Rvss_t3 vss__t3 vss 42.5598864346
* device instance vss_t4 r0 *1 0,0
Rvss_t4 vss__t4 vss 38.9231897243
* device instance vss_t5 r0 *1 0,0
Rvss_t5 vss__t5 vss 91.4984622336
* device instance vss_t6 r0 *1 0,0
Rvss_t6 vss__t6 vss 15.6818979143
* device instance vss_t7 r0 *1 0,0
Rvss_t7 vss__t7 vss 68.3316233028
* device instance vss_t8 r0 *1 0,0
Rvss_t8 vss__t8 vss 94.4671521336
* device instance vss_t9 r0 *1 0,0
Rvss_t9 vss__t9 vss 18.7201069076
* device instance vss_t10 r0 *1 0,0
Rvss_t10 vss__t10 vss 120.730444381
* device instance vss_t11 r0 *1 0,0
Rvss_t11 vss__t11 vss 41.3137199111
* device instance vss_t12 r0 *1 0,0
Rvss_t12 vss__t12 vss 13.4902064724
* device instance vss_t13 r0 *1 0,0
Rvss_t13 vss__t13 vss 93.9123120352
* device instance vss_t14 r0 *1 0,0
Rvss_t14 vss__t14 vss 16.9264925813
* device instance vss_t15 r0 *1 0,0
Rvss_t15 vss__t15 vss 40.2434488923
* device instance vss_t16 r0 *1 0,0
Rvss_t16 vss__t16 vss 120.296798461
* device instance vss_t17 r0 *1 0,0
Rvss_t17 vss__t17 vss 92.0678503689
* device instance vss_t18 r0 *1 0,0
Rvss_t18 vss__t18 vss 65.9509627342
* device instance vss_t19 r0 *1 0,0
Rvss_t19 vss__t19 vss 54.84517903
* device instance vss_t20 r0 *1 0,0
Rvss_t20 vss__t20 vss 26.846545206
* device instance vss_t21 r0 *1 0,0
Rvss_t21 vss__t21 vss 107.293139369
* device instance vss_t22 r0 *1 0,0
Rvss_t22 vss__t22 vss 29.0304909938
* device instance vss_t23 r0 *1 0,0
Rvss_t23 vss__t23 vss 54.7919116077
* device instance vss_t24 r0 *1 0,0
Rvss_t24 vss__t24 vss 104.882447261
* device instance vss_t25 r0 *1 0,0
Rvss_t25 vss__t25 vss 78.5804397921
* device instance vss_t26 r0 *1 0,0
Rvss_t26 vss__t26 vss 52.4618781281
* device instance vss_t27 r0 *1 0,0
Rvss_t27 vss__t27 vss 9.28388934853
* device instance vss_t28 r0 *1 0,0
Rvss_t28 vss__t28 vss 26.7375560642
* device instance vss_t29 r0 *1 0,0
Rvss_t29 vss__t29 vss 52.4061882941
* device instance vss_t30 r0 *1 0,0
Rvss_t30 vss__t30 vss 80.9845851201
* device instance vss_t31 r0 *1 0,0
Rvss_t31 vss__t31 vss 104.910284666
* device instance vss_t32 r0 *1 0,0
Rvss_t32 vss__t32 vss 8.96384494664
* device instance vss_t33 r0 *1 0,0
Rvss_t33 vss__t33 vss 78.6175909268
* device instance vss_t34 r0 *1 0,0
Rvss_t34 vss__t34 vss 107.320351476
* device instance vss_t35 r0 *1 0,0
Rvss_t35 vss__t35 vss 81.0206338675
* device instance vss_t36 r0 *1 0,0
Rvss_t36 vss__t36 vss 29.1309027074
* device instance vss_t37 r0 *1 0,0
Rvss_t37 vss__t37 vss 69.7747439574
* device instance vss_t38 r0 *1 0,0
Rvss_t38 vss__t38 vss 23.7861810488
* device instance vss_t39 r0 *1 0,0
Rvss_t39 vss__t39 vss 74.5766493046
* device instance vss_t40 r0 *1 0,0
Rvss_t40 vss__t40 vss 72.9756234615
* device instance vss_t41 r0 *1 0,0
Rvss_t41 vss__t41 vss 19.5722376557
* device instance vss_t42 r0 *1 0,0
Rvss_t42 vss__t42 vss 101.168789033
* device instance vss_t43 r0 *1 0,0
Rvss_t43 vss__t43 vss 99.568135323
* device instance vss_t44 r0 *1 0,0
Rvss_t44 vss__t44 vss 111.308215703
* device instance vss_t45 r0 *1 0,0
Rvss_t45 vss__t45 vss 112.910632746
* device instance vss_t46 r0 *1 0,0
Rvss_t46 vss__t46 vss 114.513248946
* device instance vss_t47 r0 *1 0,0
Rvss_t47 vss__t47 vss 97.9677720568
* device instance vss_t48 r0 *1 0,0
Rvss_t48 vss__t48 vss 96.3677137048
* device instance vss_t49 r0 *1 0,0
Rvss_t49 vss__t49 vss 96.0904162379
* device instance vss_t50 r0 *1 0,0
Rvss_t50 vss__t50 vss 97.6950162999
* device instance vss_t51 r0 *1 0,0
Rvss_t51 vss__t51 vss 99.2997755273
* device instance vss_t52 r0 *1 0,0
Rvss_t52 vss__t52 vss 100.904686326
* device instance vss_t53 r0 *1 0,0
Rvss_t53 vss__t53 vss 71.3749795834
* device instance vss_t54 r0 *1 0,0
Rvss_t54 vss__t54 vss 43.5961807391
* device instance vss_t55 r0 *1 0,0
Rvss_t55 vss__t55 vss 111.068225569
* device instance vss_t56 r0 *1 0,0
Rvss_t56 vss__t56 vss 63.2354970694
* device instance vss_t57 r0 *1 0,0
Rvss_t57 vss__t57 vss 128.5388163
* device instance vss_t58 r0 *1 0,0
Rvss_t58 vss__t58 vss 135.742739629
* device instance vss_t59 r0 *1 0,0
Rvss_t59 vss__t59 vss 61.6378487744
* device instance vss_t60 r0 *1 0,0
Rvss_t60 vss__t60 vss 60.0408344905
* device instance vss_t61 r0 *1 0,0
Rvss_t61 vss__t61 vss 58.4445061912
* device instance vss_t62 r0 *1 0,0
Rvss_t62 vss__t62 vss 89.5302550325
* device instance vss_t63 r0 *1 0,0
Rvss_t63 vss__t63 vss 87.9266033533
* device instance vss_t64 r0 *1 0,0
Rvss_t64 vss__t64 vss 86.3231700134
* device instance vss_t65 r0 *1 0,0
Rvss_t65 vss__t65 vss 34.7627295038
* device instance vss_t66 r0 *1 0,0
Rvss_t66 vss__t66 vss 12.4798627389
* device instance vss_t67 r0 *1 0,0
Rvss_t67 vss__t67 vss 20.9474270818
* device instance vss_t68 r0 *1 0,0
Rvss_t68 vss__t68 vss 10.1104843658
* device instance vss_t69 r0 *1 0,0
Rvss_t69 vss__t69 vss 9.12310218325
* device instance vss_t70 r0 *1 0,0
Rvss_t70 vss__t70 vss 33.2322307562
* device instance vss_t71 r0 *1 0,0
Rvss_t71 vss__t71 vss 14.4608134595
* device instance vss_t72 r0 *1 0,0
Rvss_t72 vss__t72 vss 13.4075366697
* device instance vss_t73 r0 *1 0,0
Rvss_t73 vss__t73 vss 12.473573908
* device instance vss_t74 r0 *1 0,0
Rvss_t74 vss__t74 vss 11.6875637057
* device instance vss_t75 r0 *1 0,0
Rvss_t75 vss__t75 vss 36.3000641449
* device instance vss_t76 r0 *1 0,0
Rvss_t76 vss__t76 vss 37.8434015931
* device instance vss_t77 r0 *1 0,0
Rvss_t77 vss__t77 vss 37.1315888727
* device instance vss_t78 r0 *1 0,0
Rvss_t78 vss__t78 vss 35.557369208
* device instance vss_t79 r0 *1 0,0
Rvss_t79 vss__t79 vss 33.9864562822
* device instance vss_t80 r0 *1 0,0
Rvss_t80 vss__t80 vss 32.4193307936
* device instance vss_t81 r0 *1 0,0
Rvss_t81 vss__t81 vss 11.2425036189
* device instance vss_t82 r0 *1 0,0
Rvss_t82 vss__t82 vss 18.1577623875
* device instance vss_t83 r0 *1 0,0
Rvss_t83 vss__t83 vss 22.3539260242
* device instance vss_t84 r0 *1 0,0
Rvss_t84 vss__t84 vss 74.933602432
* device instance vss_t85 r0 *1 0,0
Rvss_t85 vss__t85 vss 73.3403693168
* device instance vss_t86 r0 *1 0,0
Rvss_t86 vss__t86 vss 48.3586889777
* device instance vss_t87 r0 *1 0,0
Rvss_t87 vss__t87 vss 46.7696814036
* device instance vss_t88 r0 *1 0,0
Rvss_t88 vss__t88 vss 45.1821257843
* device instance vss_t89 r0 *1 0,0
Rvss_t89 vss__t89 vss 22.6365690192
* device instance vss_t90 r0 *1 0,0
Rvss_t90 vss__t90 vss 21.1265202238
* device instance vss_t91 r0 *1 0,0
Rvss_t91 vss__t91 vss 19.6322833471
* device instance vss_t92 r0 *1 0,0
Rvss_t92 vss__t92 vss 71.7478631212
* device instance vss_t93 r0 *1 0,0
Rvss_t93 vss__t93 vss 70.1561333473
* device instance vss_t94 r0 *1 0,0
Rvss_t94 vss__t94 vss 89.8278059295
* device instance vss_t95 r0 *1 0,0
Rvss_t95 vss__t95 vss 112.674055732
* device instance vss_t96 r0 *1 0,0
Rvss_t96 vss__t96 vss 86.6317368699
* device instance vss_t97 r0 *1 0,0
Rvss_t97 vss__t97 vss 48.9073711374
* device instance vss_t98 r0 *1 0,0
Rvss_t98 vss__t98 vss 47.3367853843
* device instance vss_t99 r0 *1 0,0
Rvss_t99 vss__t99 vss 85.0343520576
* device instance vss_t100 r0 *1 0,0
Rvss_t100 vss__t100 vss 45.7689047533
* device instance vss_t101 r0 *1 0,0
Rvss_t101 vss__t101 vss 44.2040170908
* device instance vss_t102 r0 *1 0,0
Rvss_t102 vss__t102 vss 63.6560778052
* device instance vss_t103 r0 *1 0,0
Rvss_t103 vss__t103 vss 62.0692561053
* device instance vss_t104 r0 *1 0,0
Rvss_t104 vss__t104 vss 60.4836338049
* device instance vss_t105 r0 *1 0,0
Rvss_t105 vss__t105 vss 58.8993077706
* device instance vss_t106 r0 *1 0,0
Rvss_t106 vss__t106 vss 84.7199674099
* device instance vss_t107 r0 *1 0,0
Rvss_t107 vss__t107 vss 115.886022979
* device instance vss_t108 r0 *1 0,0
Rvss_t108 vss__t108 vss 114.27998964
* device instance vss_t109 r0 *1 0,0
Rvss_t109 vss__t109 vss 88.2295626714
* device instance vss r0 *1 0,0
Cvss vss vsubs 2.1268623e-13
* device instance cc__10__12 r0 *1 0,0
Ccc__10__12 \$10 \$12 1.614766e-15
* device instance cc__10__14 r0 *1 0,0
Ccc__10__14 \$10 \$14 8.88663e-16
* device instance cc__10__16 r0 *1 0,0
Ccc__10__16 \$10 \$16 5.52705e-16
* device instance cc__10__18 r0 *1 0,0
Ccc__10__18 \$10 \$18 3.79308e-16
* device instance cc__10__20 r0 *1 0,0
Ccc__10__20 \$10 \$20 2.92609e-16
* device instance cc__10__22 r0 *1 0,0
Ccc__10__22 \$10 \$22 2.49259e-16
* device instance cc__10__24 r0 *1 0,0
Ccc__10__24 \$10 \$24 2.0591e-16
* device instance cc__10__26 r0 *1 0,0
Ccc__10__26 \$10 \$26 9.7536e-17
* device instance cc__10__27 r0 *1 0,0
Ccc__10__27 \$10 \$27 1.0837e-17
* device instance cc__10__29 r0 *1 0,0
Ccc__10__29 \$10 \$29 1.0837e-17
* device instance cc__10__65 r0 *1 0,0
Ccc__10__65 \$10 \$65 1.0837e-17
* device instance cc__10__83 r0 *1 0,0
Ccc__10__83 \$10 \$83 1.0837e-17
* device instance cc__10__85 r0 *1 0,0
Ccc__10__85 \$10 \$85 1.0837e-17
* device instance cc__10__87 r0 *1 0,0
Ccc__10__87 \$10 \$87 1.0837e-17
* device instance cc__10__89 r0 *1 0,0
Ccc__10__89 \$10 \$89 1.0837e-17
* device instance cc__10__9 r0 *1 0,0
Ccc__10__9 \$10 \$9 1.0837e-17
* device instance cc__10__90 r0 *1 0,0
Ccc__10__90 \$10 \$90 1.0837e-17
* device instance cc__10_hi_256_n r0 *1 0,0
Ccc__10_hi_256_n \$10 hi_256_n 1.0837e-17
* device instance cc__10_hi_256_p r0 *1 0,0
Ccc__10_hi_256_p \$10 hi_256_p 1.0837e-17
* device instance cc__10_lo_256_n r0 *1 0,0
Ccc__10_lo_256_n \$10 lo_256_n 1.0837e-17
* device instance cc__10_lo_256_p r0 *1 0,0
Ccc__10_lo_256_p \$10 lo_256_p 1.0837e-17
* device instance cc__10_pinn r0 *1 0,0
Ccc__10_pinn \$10 vinn 1.0837e-17
* device instance cc__10_rel_256_n r0 *1 0,0
Ccc__10_rel_256_n \$10 rel_256_n 1.0837e-17
* device instance cc__10_rel_256_p r0 *1 0,0
Ccc__10_rel_256_p \$10 rel_256_p 1.0837e-17
* device instance cc__10_sel_in r0 *1 0,0
Ccc__10_sel_in \$10 sel_in 2.1675e-17
* device instance cc__10_topp r0 *1 0,0
Ccc__10_topp \$10 topp 4.2159087e-14
* device instance cc__10_vcm r0 *1 0,0
Ccc__10_vcm \$10 vcm 1.19211e-16
* device instance cc__10_vref r0 *1 0,0
Ccc__10_vref \$10 vref 1.0837e-17
* device instance cc__10_vss r0 *1 0,0
Ccc__10_vss \$10 vss 5.20075e-16
* device instance cc__100__107 r0 *1 0,0
Ccc__100__107 \$100 \$107 1.0837e-17
* device instance cc__100__14 r0 *1 0,0
Ccc__100__14 \$100 \$14 1.0837e-17
* device instance cc__102__107 r0 *1 0,0
Ccc__102__107 \$102 \$107 1.0837e-17
* device instance cc__102__14 r0 *1 0,0
Ccc__102__14 \$102 \$14 1.0837e-17
* device instance cc__104__107 r0 *1 0,0
Ccc__104__107 \$104 \$107 1.0837e-17
* device instance cc__104__14 r0 *1 0,0
Ccc__104__14 \$104 \$14 1.0837e-17
* device instance cc__106__107 r0 *1 0,0
Ccc__106__107 \$106 \$107 1.0837e-17
* device instance cc__106__14 r0 *1 0,0
Ccc__106__14 \$106 \$14 1.0837e-17
* device instance cc__107__115 r0 *1 0,0
Ccc__107__115 \$107 \$115 7.5862e-17
* device instance cc__107__123 r0 *1 0,0
Ccc__107__123 \$107 \$123 7.5862e-17
* device instance cc__107__131 r0 *1 0,0
Ccc__107__131 \$107 \$131 7.5862e-17
* device instance cc__107__139 r0 *1 0,0
Ccc__107__139 \$107 \$139 7.5862e-17
* device instance cc__107__14 r0 *1 0,0
Ccc__107__14 \$107 \$14 1.0837e-17
* device instance cc__107__147 r0 *1 0,0
Ccc__107__147 \$107 \$147 5.4187e-17
* device instance cc__107__155 r0 *1 0,0
Ccc__107__155 \$107 \$155 3.2512e-17
* device instance cc__107__16 r0 *1 0,0
Ccc__107__16 \$107 \$16 1.7212e-17
* device instance cc__107__18 r0 *1 0,0
Ccc__107__18 \$107 \$18 1.7212e-17
* device instance cc__107__20 r0 *1 0,0
Ccc__107__20 \$107 \$20 1.7212e-17
* device instance cc__107__22 r0 *1 0,0
Ccc__107__22 \$107 \$22 1.7212e-17
* device instance cc__107__24 r0 *1 0,0
Ccc__107__24 \$107 \$24 1.7212e-17
* device instance cc__107__26 r0 *1 0,0
Ccc__107__26 \$107 \$26 1.7212e-17
* device instance cc__107__90 r0 *1 0,0
Ccc__107__90 \$107 \$90 8.88663e-16
* device instance cc__107__99 r0 *1 0,0
Ccc__107__99 \$107 \$99 1.19211e-16
* device instance cc__107_lo_64_n r0 *1 0,0
Ccc__107_lo_64_n \$107 lo_64_n 6.924e-18
* device instance cc__107_sel_in r0 *1 0,0
Ccc__107_sel_in \$107 sel_in 1.0837e-17
* device instance cc__107_topn r0 *1 0,0
Ccc__107_topn \$107 topn 1.0539772e-14
* device instance cc__107_topp r0 *1 0,0
Ccc__107_topp \$107 topp 1.7212e-17
* device instance cc__107_vcm r0 *1 0,0
Ccc__107_vcm \$107 vcm 4.9724e-17
* device instance cc__107_vss r0 *1 0,0
Ccc__107_vss \$107 vss 1.0837e-17
* device instance cc__108__115 r0 *1 0,0
Ccc__108__115 \$108 \$115 1.0837e-17
* device instance cc__108__16 r0 *1 0,0
Ccc__108__16 \$108 \$16 1.0837e-17
* device instance cc__11__12 r0 *1 0,0
Ccc__11__12 \$11 \$12 1.0837e-17
* device instance cc__110__115 r0 *1 0,0
Ccc__110__115 \$110 \$115 1.0837e-17
* device instance cc__110__16 r0 *1 0,0
Ccc__110__16 \$110 \$16 1.0837e-17
* device instance cc__112__115 r0 *1 0,0
Ccc__112__115 \$112 \$115 1.0837e-17
* device instance cc__112__16 r0 *1 0,0
Ccc__112__16 \$112 \$16 1.0837e-17
* device instance cc__114__115 r0 *1 0,0
Ccc__114__115 \$114 \$115 1.0837e-17
* device instance cc__114__16 r0 *1 0,0
Ccc__114__16 \$114 \$16 1.0837e-17
* device instance cc__115__123 r0 *1 0,0
Ccc__115__123 \$115 \$123 2.49259e-16
* device instance cc__115__131 r0 *1 0,0
Ccc__115__131 \$115 \$131 1.6256e-16
* device instance cc__115__139 r0 *1 0,0
Ccc__115__139 \$115 \$139 1.19211e-16
* device instance cc__115__147 r0 *1 0,0
Ccc__115__147 \$115 \$147 7.5862e-17
* device instance cc__115__155 r0 *1 0,0
Ccc__115__155 \$115 \$155 3.2512e-17
* device instance cc__115__16 r0 *1 0,0
Ccc__115__16 \$115 \$16 1.0837e-17
* device instance cc__115__18 r0 *1 0,0
Ccc__115__18 \$115 \$18 1.7212e-17
* device instance cc__115__20 r0 *1 0,0
Ccc__115__20 \$115 \$20 1.7212e-17
* device instance cc__115__22 r0 *1 0,0
Ccc__115__22 \$115 \$22 1.7212e-17
* device instance cc__115__24 r0 *1 0,0
Ccc__115__24 \$115 \$24 1.7212e-17
* device instance cc__115__26 r0 *1 0,0
Ccc__115__26 \$115 \$26 1.7212e-17
* device instance cc__115__90 r0 *1 0,0
Ccc__115__90 \$115 \$90 5.52705e-16
* device instance cc__115__99 r0 *1 0,0
Ccc__115__99 \$115 \$99 1.19211e-16
* device instance cc__115_lo_32_n r0 *1 0,0
Ccc__115_lo_32_n \$115 lo_32_n 6.924e-18
* device instance cc__115_sel_in r0 *1 0,0
Ccc__115_sel_in \$115 sel_in 1.0837e-17
* device instance cc__115_topn r0 *1 0,0
Ccc__115_topn \$115 topn 5.162851e-15
* device instance cc__115_topp r0 *1 0,0
Ccc__115_topp \$115 topp 1.7212e-17
* device instance cc__115_vcm r0 *1 0,0
Ccc__115_vcm \$115 vcm 6.0562e-17
* device instance cc__115_vss r0 *1 0,0
Ccc__115_vss \$115 vss 1.0837e-17
* device instance cc__116__123 r0 *1 0,0
Ccc__116__123 \$116 \$123 1.0837e-17
* device instance cc__116__18 r0 *1 0,0
Ccc__116__18 \$116 \$18 1.0837e-17
* device instance cc__116_vcm r0 *1 0,0
Ccc__116_vcm \$116 vcm 1.0837e-17
* device instance cc__118__123 r0 *1 0,0
Ccc__118__123 \$118 \$123 1.0837e-17
* device instance cc__118__18 r0 *1 0,0
Ccc__118__18 \$118 \$18 1.0837e-17
* device instance cc__118_vcm r0 *1 0,0
Ccc__118_vcm \$118 vcm 3.7724e-17
* device instance cc__12__14 r0 *1 0,0
Ccc__12__14 \$12 \$14 1.53635e-16
* device instance cc__12__16 r0 *1 0,0
Ccc__12__16 \$12 \$16 1.53635e-16
* device instance cc__12__18 r0 *1 0,0
Ccc__12__18 \$12 \$18 1.19211e-16
* device instance cc__12__20 r0 *1 0,0
Ccc__12__20 \$12 \$20 1.19211e-16
* device instance cc__12__22 r0 *1 0,0
Ccc__12__22 \$12 \$22 1.19211e-16
* device instance cc__12__24 r0 *1 0,0
Ccc__12__24 \$12 \$24 9.7536e-17
* device instance cc__12__26 r0 *1 0,0
Ccc__12__26 \$12 \$26 5.4187e-17
* device instance cc__12__31 r0 *1 0,0
Ccc__12__31 \$12 \$31 1.0837e-17
* device instance cc__12__33 r0 *1 0,0
Ccc__12__33 \$12 \$33 1.0837e-17
* device instance cc__12__67 r0 *1 0,0
Ccc__12__67 \$12 \$67 1.0837e-17
* device instance cc__12__90 r0 *1 0,0
Ccc__12__90 \$12 \$90 1.7212e-17
* device instance cc__12__92 r0 *1 0,0
Ccc__12__92 \$12 \$92 1.0837e-17
* device instance cc__12__94 r0 *1 0,0
Ccc__12__94 \$12 \$94 1.0837e-17
* device instance cc__12__96 r0 *1 0,0
Ccc__12__96 \$12 \$96 1.0837e-17
* device instance cc__12__98 r0 *1 0,0
Ccc__12__98 \$12 \$98 1.0837e-17
* device instance cc__12__99 r0 *1 0,0
Ccc__12__99 \$12 \$99 1.0837e-17
* device instance cc__12_hi_128_n r0 *1 0,0
Ccc__12_hi_128_n \$12 hi_128_n 1.0837e-17
* device instance cc__12_hi_128_p r0 *1 0,0
Ccc__12_hi_128_p \$12 hi_128_p 1.0837e-17
* device instance cc__12_lo_128_n r0 *1 0,0
Ccc__12_lo_128_n \$12 lo_128_n 1.0837e-17
* device instance cc__12_lo_128_p r0 *1 0,0
Ccc__12_lo_128_p \$12 lo_128_p 1.0837e-17
* device instance cc__12_pinn r0 *1 0,0
Ccc__12_pinn \$12 vinn 1.0837e-17
* device instance cc__12_rel_128_n r0 *1 0,0
Ccc__12_rel_128_n \$12 rel_128_n 1.0837e-17
* device instance cc__12_rel_128_p r0 *1 0,0
Ccc__12_rel_128_p \$12 rel_128_p 1.0837e-17
* device instance cc__12_sel_in r0 *1 0,0
Ccc__12_sel_in \$12 sel_in 2.1675e-17
* device instance cc__12_topp r0 *1 0,0
Ccc__12_topp \$12 topp 2.1079544e-14
* device instance cc__12_vcm r0 *1 0,0
Ccc__12_vcm \$12 vcm 6.5024e-17
* device instance cc__12_vdd r0 *1 0,0
Ccc__12_vdd \$12 vdd 1.0837e-17
* device instance cc__12_vref r0 *1 0,0
Ccc__12_vref \$12 vref 1.0837e-17
* device instance cc__12_vss r0 *1 0,0
Ccc__12_vss \$12 vss 5.20075e-16
* device instance cc__120__123 r0 *1 0,0
Ccc__120__123 \$120 \$123 1.0837e-17
* device instance cc__120__18 r0 *1 0,0
Ccc__120__18 \$120 \$18 1.0837e-17
* device instance cc__120_vcm r0 *1 0,0
Ccc__120_vcm \$120 vcm 2.1675e-17
* device instance cc__122__123 r0 *1 0,0
Ccc__122__123 \$122 \$123 1.0837e-17
* device instance cc__122__18 r0 *1 0,0
Ccc__122__18 \$122 \$18 1.0837e-17
* device instance cc__122_vcm r0 *1 0,0
Ccc__122_vcm \$122 vcm 2.1675e-17
* device instance cc__123__131 r0 *1 0,0
Ccc__123__131 \$123 \$131 1.6256e-16
* device instance cc__123__139 r0 *1 0,0
Ccc__123__139 \$123 \$139 1.19211e-16
* device instance cc__123__147 r0 *1 0,0
Ccc__123__147 \$123 \$147 7.5862e-17
* device instance cc__123__155 r0 *1 0,0
Ccc__123__155 \$123 \$155 3.2512e-17
* device instance cc__123__18 r0 *1 0,0
Ccc__123__18 \$123 \$18 1.0837e-17
* device instance cc__123__20 r0 *1 0,0
Ccc__123__20 \$123 \$20 1.7212e-17
* device instance cc__123__22 r0 *1 0,0
Ccc__123__22 \$123 \$22 1.7212e-17
* device instance cc__123__24 r0 *1 0,0
Ccc__123__24 \$123 \$24 1.7212e-17
* device instance cc__123__26 r0 *1 0,0
Ccc__123__26 \$123 \$26 1.7212e-17
* device instance cc__123__90 r0 *1 0,0
Ccc__123__90 \$123 \$90 3.79308e-16
* device instance cc__123__99 r0 *1 0,0
Ccc__123__99 \$123 \$99 1.19211e-16
* device instance cc__123_lo_16_n r0 *1 0,0
Ccc__123_lo_16_n \$123 lo_16_n 6.924e-18
* device instance cc__123_sel_in r0 *1 0,0
Ccc__123_sel_in \$123 sel_in 1.0837e-17
* device instance cc__123_topn r0 *1 0,0
Ccc__123_topn \$123 topn 2.757718e-15
* device instance cc__123_topp r0 *1 0,0
Ccc__123_topp \$123 topp 1.7212e-17
* device instance cc__123_vcm r0 *1 0,0
Ccc__123_vcm \$123 vcm 6.5024e-17
* device instance cc__123_vss r0 *1 0,0
Ccc__123_vss \$123 vss 1.0837e-17
* device instance cc__124__131 r0 *1 0,0
Ccc__124__131 \$124 \$131 1.0837e-17
* device instance cc__124__20 r0 *1 0,0
Ccc__124__20 \$124 \$20 1.0837e-17
* device instance cc__126__131 r0 *1 0,0
Ccc__126__131 \$126 \$131 1.0837e-17
* device instance cc__126__20 r0 *1 0,0
Ccc__126__20 \$126 \$20 1.0837e-17
* device instance cc__128__131 r0 *1 0,0
Ccc__128__131 \$128 \$131 1.0837e-17
* device instance cc__128__20 r0 *1 0,0
Ccc__128__20 \$128 \$20 1.0837e-17
* device instance cc__13__14 r0 *1 0,0
Ccc__13__14 \$13 \$14 1.0837e-17
* device instance cc__130__131 r0 *1 0,0
Ccc__130__131 \$130 \$131 1.0837e-17
* device instance cc__130__20 r0 *1 0,0
Ccc__130__20 \$130 \$20 1.0837e-17
* device instance cc__131__139 r0 *1 0,0
Ccc__131__139 \$131 \$139 2.23925e-16
* device instance cc__131__147 r0 *1 0,0
Ccc__131__147 \$131 \$147 7.5862e-17
* device instance cc__131__155 r0 *1 0,0
Ccc__131__155 \$131 \$155 3.2512e-17
* device instance cc__131__20 r0 *1 0,0
Ccc__131__20 \$131 \$20 1.0837e-17
* device instance cc__131__22 r0 *1 0,0
Ccc__131__22 \$131 \$22 1.7212e-17
* device instance cc__131__24 r0 *1 0,0
Ccc__131__24 \$131 \$24 1.7212e-17
* device instance cc__131__26 r0 *1 0,0
Ccc__131__26 \$131 \$26 1.7212e-17
* device instance cc__131__90 r0 *1 0,0
Ccc__131__90 \$131 \$90 2.92609e-16
* device instance cc__131__99 r0 *1 0,0
Ccc__131__99 \$131 \$99 1.19211e-16
* device instance cc__131_lo_8_n r0 *1 0,0
Ccc__131_lo_8_n \$131 lo_8_n 6.924e-18
* device instance cc__131_sel_in r0 *1 0,0
Ccc__131_sel_in \$131 sel_in 1.0837e-17
* device instance cc__131_topn r0 *1 0,0
Ccc__131_topn \$131 topn 1.309601e-15
* device instance cc__131_topp r0 *1 0,0
Ccc__131_topp \$131 topp 1.7212e-17
* device instance cc__131_vcm r0 *1 0,0
Ccc__131_vcm \$131 vcm 6.0562e-17
* device instance cc__131_vss r0 *1 0,0
Ccc__131_vss \$131 vss 1.0837e-17
* device instance cc__132__139 r0 *1 0,0
Ccc__132__139 \$132 \$139 1.0837e-17
* device instance cc__132__22 r0 *1 0,0
Ccc__132__22 \$132 \$22 1.0837e-17
* device instance cc__134__139 r0 *1 0,0
Ccc__134__139 \$134 \$139 1.0837e-17
* device instance cc__134__22 r0 *1 0,0
Ccc__134__22 \$134 \$22 1.0837e-17
* device instance cc__136__139 r0 *1 0,0
Ccc__136__139 \$136 \$139 1.0837e-17
* device instance cc__136__22 r0 *1 0,0
Ccc__136__22 \$136 \$22 1.0837e-17
* device instance cc__138__139 r0 *1 0,0
Ccc__138__139 \$138 \$139 1.0837e-17
* device instance cc__138__22 r0 *1 0,0
Ccc__138__22 \$138 \$22 1.0837e-17
* device instance cc__139__147 r0 *1 0,0
Ccc__139__147 \$139 \$147 7.5862e-17
* device instance cc__139__155 r0 *1 0,0
Ccc__139__155 \$139 \$155 3.2512e-17
* device instance cc__139__22 r0 *1 0,0
Ccc__139__22 \$139 \$22 1.0837e-17
* device instance cc__139__24 r0 *1 0,0
Ccc__139__24 \$139 \$24 1.7212e-17
* device instance cc__139__26 r0 *1 0,0
Ccc__139__26 \$139 \$26 1.7212e-17
* device instance cc__139__90 r0 *1 0,0
Ccc__139__90 \$139 \$90 2.49259e-16
* device instance cc__139__99 r0 *1 0,0
Ccc__139__99 \$139 \$99 1.19211e-16
* device instance cc__139_lo_4_n r0 *1 0,0
Ccc__139_lo_4_n \$139 lo_4_n 6.924e-18
* device instance cc__139_sel_in r0 *1 0,0
Ccc__139_sel_in \$139 sel_in 1.0837e-17
* device instance cc__139_topn r0 *1 0,0
Ccc__139_topn \$139 topn 6.72013e-16
* device instance cc__139_topp r0 *1 0,0
Ccc__139_topp \$139 topp 1.7212e-17
* device instance cc__139_vcm r0 *1 0,0
Ccc__139_vcm \$139 vcm 6.0562e-17
* device instance cc__139_vss r0 *1 0,0
Ccc__139_vss \$139 vss 1.0837e-17
* device instance cc__14__16 r0 *1 0,0
Ccc__14__16 \$14 \$16 1.10286e-16
* device instance cc__14__18 r0 *1 0,0
Ccc__14__18 \$14 \$18 1.10286e-16
* device instance cc__14__20 r0 *1 0,0
Ccc__14__20 \$14 \$20 1.10286e-16
* device instance cc__14__22 r0 *1 0,0
Ccc__14__22 \$14 \$22 7.5862e-17
* device instance cc__14__24 r0 *1 0,0
Ccc__14__24 \$14 \$24 5.4187e-17
* device instance cc__14__26 r0 *1 0,0
Ccc__14__26 \$14 \$26 3.2512e-17
* device instance cc__14__35 r0 *1 0,0
Ccc__14__35 \$14 \$35 1.0837e-17
* device instance cc__14__37 r0 *1 0,0
Ccc__14__37 \$14 \$37 1.0837e-17
* device instance cc__14__69 r0 *1 0,0
Ccc__14__69 \$14 \$69 1.0837e-17
* device instance cc__14__90 r0 *1 0,0
Ccc__14__90 \$14 \$90 1.7212e-17
* device instance cc__14__99 r0 *1 0,0
Ccc__14__99 \$14 \$99 1.7212e-17
* device instance cc__14_hi_64_n r0 *1 0,0
Ccc__14_hi_64_n \$14 hi_64_n 1.0837e-17
* device instance cc__14_hi_64_p r0 *1 0,0
Ccc__14_hi_64_p \$14 hi_64_p 1.0837e-17
* device instance cc__14_lo_64_n r0 *1 0,0
Ccc__14_lo_64_n \$14 lo_64_n 1.0837e-17
* device instance cc__14_lo_64_p r0 *1 0,0
Ccc__14_lo_64_p \$14 lo_64_p 1.0837e-17
* device instance cc__14_pinn r0 *1 0,0
Ccc__14_pinn \$14 vinn 1.0837e-17
* device instance cc__14_rel_64_n r0 *1 0,0
Ccc__14_rel_64_n \$14 rel_64_n 1.0837e-17
* device instance cc__14_rel_64_p r0 *1 0,0
Ccc__14_rel_64_p \$14 rel_64_p 1.0837e-17
* device instance cc__14_sel_in r0 *1 0,0
Ccc__14_sel_in \$14 sel_in 2.1675e-17
* device instance cc__14_topp r0 *1 0,0
Ccc__14_topp \$14 topp 1.0556984e-14
* device instance cc__14_vcm r0 *1 0,0
Ccc__14_vcm \$14 vcm 4.3349e-17
* device instance cc__14_vdd r0 *1 0,0
Ccc__14_vdd \$14 vdd 1.0837e-17
* device instance cc__14_vref r0 *1 0,0
Ccc__14_vref \$14 vref 1.0837e-17
* device instance cc__14_vss r0 *1 0,0
Ccc__14_vss \$14 vss 5.20075e-16
* device instance cc__140__147 r0 *1 0,0
Ccc__140__147 \$140 \$147 1.0837e-17
* device instance cc__140__24 r0 *1 0,0
Ccc__140__24 \$140 \$24 1.0837e-17
* device instance cc__142__147 r0 *1 0,0
Ccc__142__147 \$142 \$147 1.0837e-17
* device instance cc__142__24 r0 *1 0,0
Ccc__142__24 \$142 \$24 1.0837e-17
* device instance cc__144__147 r0 *1 0,0
Ccc__144__147 \$144 \$147 1.0837e-17
* device instance cc__144__24 r0 *1 0,0
Ccc__144__24 \$144 \$24 1.0837e-17
* device instance cc__146__147 r0 *1 0,0
Ccc__146__147 \$146 \$147 1.0837e-17
* device instance cc__146__24 r0 *1 0,0
Ccc__146__24 \$146 \$24 1.0837e-17
* device instance cc__147__155 r0 *1 0,0
Ccc__147__155 \$147 \$155 2.1675e-17
* device instance cc__147__24 r0 *1 0,0
Ccc__147__24 \$147 \$24 1.0837e-17
* device instance cc__147__26 r0 *1 0,0
Ccc__147__26 \$147 \$26 1.7212e-17
* device instance cc__147__90 r0 *1 0,0
Ccc__147__90 \$147 \$90 2.0591e-16
* device instance cc__147__99 r0 *1 0,0
Ccc__147__99 \$147 \$99 9.7536e-17
* device instance cc__147_lo_2_n r0 *1 0,0
Ccc__147_lo_2_n \$147 lo_2_n 6.924e-18
* device instance cc__147_sel_in r0 *1 0,0
Ccc__147_sel_in \$147 sel_in 1.0837e-17
* device instance cc__147_topn r0 *1 0,0
Ccc__147_topn \$147 topn 3.44613e-16
* device instance cc__147_topp r0 *1 0,0
Ccc__147_topp \$147 topp 1.7212e-17
* device instance cc__147_vcm r0 *1 0,0
Ccc__147_vcm \$147 vcm 3.8887e-17
* device instance cc__147_vss r0 *1 0,0
Ccc__147_vss \$147 vss 1.0837e-17
* device instance cc__148__155 r0 *1 0,0
Ccc__148__155 \$148 \$155 1.0837e-17
* device instance cc__148__26 r0 *1 0,0
Ccc__148__26 \$148 \$26 1.0837e-17
* device instance cc__15__16 r0 *1 0,0
Ccc__15__16 \$15 \$16 1.0837e-17
* device instance cc__150__155 r0 *1 0,0
Ccc__150__155 \$150 \$155 1.0837e-17
* device instance cc__150__26 r0 *1 0,0
Ccc__150__26 \$150 \$26 1.0837e-17
* device instance cc__152__155 r0 *1 0,0
Ccc__152__155 \$152 \$155 1.0837e-17
* device instance cc__152__26 r0 *1 0,0
Ccc__152__26 \$152 \$26 1.0837e-17
* device instance cc__154__155 r0 *1 0,0
Ccc__154__155 \$154 \$155 1.0837e-17
* device instance cc__154__26 r0 *1 0,0
Ccc__154__26 \$154 \$26 1.0837e-17
* device instance cc__155__26 r0 *1 0,0
Ccc__155__26 \$155 \$26 4.5262e-17
* device instance cc__155__90 r0 *1 0,0
Ccc__155__90 \$155 \$90 9.7536e-17
* device instance cc__155__99 r0 *1 0,0
Ccc__155__99 \$155 \$99 5.4187e-17
* device instance cc__155_lo_1_n r0 *1 0,0
Ccc__155_lo_1_n \$155 lo_1_n 6.924e-18
* device instance cc__155_sel_in r0 *1 0,0
Ccc__155_sel_in \$155 sel_in 1.0837e-17
* device instance cc__155_topn r0 *1 0,0
Ccc__155_topn \$155 topn 1.80912e-16
* device instance cc__155_topp r0 *1 0,0
Ccc__155_topp \$155 topp 1.7212e-17
* device instance cc__155_vcm r0 *1 0,0
Ccc__155_vcm \$155 vcm 2.805e-17
* device instance cc__155_vss r0 *1 0,0
Ccc__155_vss \$155 vss 1.0837e-17
* device instance cc__16__18 r0 *1 0,0
Ccc__16__18 \$16 \$18 2.83684e-16
* device instance cc__16__20 r0 *1 0,0
Ccc__16__20 \$16 \$20 1.96985e-16
* device instance cc__16__22 r0 *1 0,0
Ccc__16__22 \$16 \$22 1.53635e-16
* device instance cc__16__24 r0 *1 0,0
Ccc__16__24 \$16 \$24 1.10286e-16
* device instance cc__16__26 r0 *1 0,0
Ccc__16__26 \$16 \$26 6.6937e-17
* device instance cc__16__39 r0 *1 0,0
Ccc__16__39 \$16 \$39 1.0837e-17
* device instance cc__16__41 r0 *1 0,0
Ccc__16__41 \$16 \$41 1.0837e-17
* device instance cc__16__71 r0 *1 0,0
Ccc__16__71 \$16 \$71 1.0837e-17
* device instance cc__16__90 r0 *1 0,0
Ccc__16__90 \$16 \$90 1.7212e-17
* device instance cc__16__99 r0 *1 0,0
Ccc__16__99 \$16 \$99 1.7212e-17
* device instance cc__16_hi_32_n r0 *1 0,0
Ccc__16_hi_32_n \$16 hi_32_n 1.0837e-17
* device instance cc__16_hi_32_p r0 *1 0,0
Ccc__16_hi_32_p \$16 hi_32_p 1.0837e-17
* device instance cc__16_lo_32_n r0 *1 0,0
Ccc__16_lo_32_n \$16 lo_32_n 1.0837e-17
* device instance cc__16_lo_32_p r0 *1 0,0
Ccc__16_lo_32_p \$16 lo_32_p 1.0837e-17
* device instance cc__16_pinn r0 *1 0,0
Ccc__16_pinn \$16 vinn 1.0837e-17
* device instance cc__16_rel_32_n r0 *1 0,0
Ccc__16_rel_32_n \$16 rel_32_n 1.0837e-17
* device instance cc__16_rel_32_p r0 *1 0,0
Ccc__16_rel_32_p \$16 rel_32_p 1.0837e-17
* device instance cc__16_sel_in r0 *1 0,0
Ccc__16_sel_in \$16 sel_in 2.1675e-17
* device instance cc__16_topp r0 *1 0,0
Ccc__16_topp \$16 topp 5.180063e-15
* device instance cc__16_vcm r0 *1 0,0
Ccc__16_vcm \$16 vcm 5.4187e-17
* device instance cc__16_vdd r0 *1 0,0
Ccc__16_vdd \$16 vdd 1.0837e-17
* device instance cc__16_vref r0 *1 0,0
Ccc__16_vref \$16 vref 1.0837e-17
* device instance cc__16_vss r0 *1 0,0
Ccc__16_vss \$16 vss 5.20075e-16
* device instance cc__17__18 r0 *1 0,0
Ccc__17__18 \$17 \$18 1.0837e-17
* device instance cc__17_vcm r0 *1 0,0
Ccc__17_vcm \$17 vcm 1.0837e-17
* device instance cc__18__20 r0 *1 0,0
Ccc__18__20 \$18 \$20 1.96985e-16
* device instance cc__18__22 r0 *1 0,0
Ccc__18__22 \$18 \$22 1.53635e-16
* device instance cc__18__24 r0 *1 0,0
Ccc__18__24 \$18 \$24 1.10286e-16
* device instance cc__18__26 r0 *1 0,0
Ccc__18__26 \$18 \$26 6.6937e-17
* device instance cc__18__43 r0 *1 0,0
Ccc__18__43 \$18 \$43 1.0837e-17
* device instance cc__18__45 r0 *1 0,0
Ccc__18__45 \$18 \$45 1.0837e-17
* device instance cc__18__73 r0 *1 0,0
Ccc__18__73 \$18 \$73 1.0837e-17
* device instance cc__18__90 r0 *1 0,0
Ccc__18__90 \$18 \$90 1.7212e-17
* device instance cc__18__99 r0 *1 0,0
Ccc__18__99 \$18 \$99 1.7212e-17
* device instance cc__18_hi_16_n r0 *1 0,0
Ccc__18_hi_16_n \$18 hi_16_n 1.0837e-17
* device instance cc__18_hi_16_p r0 *1 0,0
Ccc__18_hi_16_p \$18 hi_16_p 1.0837e-17
* device instance cc__18_lo_16_n r0 *1 0,0
Ccc__18_lo_16_n \$18 lo_16_n 1.0837e-17
* device instance cc__18_lo_16_p r0 *1 0,0
Ccc__18_lo_16_p \$18 lo_16_p 1.0837e-17
* device instance cc__18_pinn r0 *1 0,0
Ccc__18_pinn \$18 vinn 1.0837e-17
* device instance cc__18_rel_16_n r0 *1 0,0
Ccc__18_rel_16_n \$18 rel_16_n 1.0837e-17
* device instance cc__18_rel_16_p r0 *1 0,0
Ccc__18_rel_16_p \$18 rel_16_p 1.0837e-17
* device instance cc__18_sel_in r0 *1 0,0
Ccc__18_sel_in \$18 sel_in 2.1675e-17
* device instance cc__18_topp r0 *1 0,0
Ccc__18_topp \$18 topp 2.77493e-15
* device instance cc__18_vcm r0 *1 0,0
Ccc__18_vcm \$18 vcm 9.9449e-17
* device instance cc__18_vdd r0 *1 0,0
Ccc__18_vdd \$18 vdd 1.0837e-17
* device instance cc__18_vref r0 *1 0,0
Ccc__18_vref \$18 vref 1.0837e-17
* device instance cc__18_vss r0 *1 0,0
Ccc__18_vss \$18 vss 5.20075e-16
* device instance cc__19__20 r0 *1 0,0
Ccc__19__20 \$19 \$20 1.0837e-17
* device instance cc__20__22 r0 *1 0,0
Ccc__20__22 \$20 \$22 1.53635e-16
* device instance cc__20__24 r0 *1 0,0
Ccc__20__24 \$20 \$24 1.10286e-16
* device instance cc__20__26 r0 *1 0,0
Ccc__20__26 \$20 \$26 6.6937e-17
* device instance cc__20__47 r0 *1 0,0
Ccc__20__47 \$20 \$47 1.0837e-17
* device instance cc__20__49 r0 *1 0,0
Ccc__20__49 \$20 \$49 1.0837e-17
* device instance cc__20__75 r0 *1 0,0
Ccc__20__75 \$20 \$75 1.0837e-17
* device instance cc__20__90 r0 *1 0,0
Ccc__20__90 \$20 \$90 1.7212e-17
* device instance cc__20__99 r0 *1 0,0
Ccc__20__99 \$20 \$99 1.7212e-17
* device instance cc__20_hi_8_n r0 *1 0,0
Ccc__20_hi_8_n \$20 hi_8_n 1.0837e-17
* device instance cc__20_hi_8_p r0 *1 0,0
Ccc__20_hi_8_p \$20 hi_8_p 1.0837e-17
* device instance cc__20_lo_8_n r0 *1 0,0
Ccc__20_lo_8_n \$20 lo_8_n 1.0837e-17
* device instance cc__20_lo_8_p r0 *1 0,0
Ccc__20_lo_8_p \$20 lo_8_p 1.0837e-17
* device instance cc__20_pinn r0 *1 0,0
Ccc__20_pinn \$20 vinn 1.0837e-17
* device instance cc__20_rel_8_n r0 *1 0,0
Ccc__20_rel_8_n \$20 rel_8_n 1.0837e-17
* device instance cc__20_rel_8_p r0 *1 0,0
Ccc__20_rel_8_p \$20 rel_8_p 1.0837e-17
* device instance cc__20_sel_in r0 *1 0,0
Ccc__20_sel_in \$20 sel_in 2.1675e-17
* device instance cc__20_topp r0 *1 0,0
Ccc__20_topp \$20 topp 1.326814e-15
* device instance cc__20_vcm r0 *1 0,0
Ccc__20_vcm \$20 vcm 8.8611e-17
* device instance cc__20_vdd r0 *1 0,0
Ccc__20_vdd \$20 vdd 1.0837e-17
* device instance cc__20_vref r0 *1 0,0
Ccc__20_vref \$20 vref 1.0837e-17
* device instance cc__20_vss r0 *1 0,0
Ccc__20_vss \$20 vss 5.20075e-16
* device instance cc__21__22 r0 *1 0,0
Ccc__21__22 \$21 \$22 1.0837e-17
* device instance cc__22__24 r0 *1 0,0
Ccc__22__24 \$22 \$24 1.10286e-16
* device instance cc__22__26 r0 *1 0,0
Ccc__22__26 \$22 \$26 6.6937e-17
* device instance cc__22__51 r0 *1 0,0
Ccc__22__51 \$22 \$51 1.0837e-17
* device instance cc__22__53 r0 *1 0,0
Ccc__22__53 \$22 \$53 1.0837e-17
* device instance cc__22__77 r0 *1 0,0
Ccc__22__77 \$22 \$77 1.0837e-17
* device instance cc__22__90 r0 *1 0,0
Ccc__22__90 \$22 \$90 1.7212e-17
* device instance cc__22__99 r0 *1 0,0
Ccc__22__99 \$22 \$99 1.7212e-17
* device instance cc__22_hi_4_n r0 *1 0,0
Ccc__22_hi_4_n \$22 hi_4_n 1.0837e-17
* device instance cc__22_hi_4_p r0 *1 0,0
Ccc__22_hi_4_p \$22 hi_4_p 1.0837e-17
* device instance cc__22_lo_4_n r0 *1 0,0
Ccc__22_lo_4_n \$22 lo_4_n 1.0837e-17
* device instance cc__22_lo_4_p r0 *1 0,0
Ccc__22_lo_4_p \$22 lo_4_p 1.0837e-17
* device instance cc__22_pinn r0 *1 0,0
Ccc__22_pinn \$22 vinn 1.0837e-17
* device instance cc__22_rel_4_n r0 *1 0,0
Ccc__22_rel_4_n \$22 rel_4_n 1.0837e-17
* device instance cc__22_rel_4_p r0 *1 0,0
Ccc__22_rel_4_p \$22 rel_4_p 1.0837e-17
* device instance cc__22_sel_in r0 *1 0,0
Ccc__22_sel_in \$22 sel_in 2.1675e-17
* device instance cc__22_topp r0 *1 0,0
Ccc__22_topp \$22 topp 6.72013e-16
* device instance cc__22_vcm r0 *1 0,0
Ccc__22_vcm \$22 vcm 8.8611e-17
* device instance cc__22_vdd r0 *1 0,0
Ccc__22_vdd \$22 vdd 1.0837e-17
* device instance cc__22_vref r0 *1 0,0
Ccc__22_vref \$22 vref 1.0837e-17
* device instance cc__22_vss r0 *1 0,0
Ccc__22_vss \$22 vss 5.20075e-16
* device instance cc__23__24 r0 *1 0,0
Ccc__23__24 \$23 \$24 1.0837e-17
* device instance cc__24__26 r0 *1 0,0
Ccc__24__26 \$24 \$26 5.6099e-17
* device instance cc__24__55 r0 *1 0,0
Ccc__24__55 \$24 \$55 1.0837e-17
* device instance cc__24__57 r0 *1 0,0
Ccc__24__57 \$24 \$57 1.0837e-17
* device instance cc__24__79 r0 *1 0,0
Ccc__24__79 \$24 \$79 1.0837e-17
* device instance cc__24__90 r0 *1 0,0
Ccc__24__90 \$24 \$90 1.7212e-17
* device instance cc__24__99 r0 *1 0,0
Ccc__24__99 \$24 \$99 1.7212e-17
* device instance cc__24_hi_2_n r0 *1 0,0
Ccc__24_hi_2_n \$24 hi_2_n 1.0837e-17
* device instance cc__24_hi_2_p r0 *1 0,0
Ccc__24_hi_2_p \$24 hi_2_p 1.0837e-17
* device instance cc__24_lo_2_n r0 *1 0,0
Ccc__24_lo_2_n \$24 lo_2_n 1.0837e-17
* device instance cc__24_lo_2_p r0 *1 0,0
Ccc__24_lo_2_p \$24 lo_2_p 1.0837e-17
* device instance cc__24_pinn r0 *1 0,0
Ccc__24_pinn \$24 vinn 1.0837e-17
* device instance cc__24_rel_2_n r0 *1 0,0
Ccc__24_rel_2_n \$24 rel_2_n 1.0837e-17
* device instance cc__24_rel_2_p r0 *1 0,0
Ccc__24_rel_2_p \$24 rel_2_p 1.0837e-17
* device instance cc__24_sel_in r0 *1 0,0
Ccc__24_sel_in \$24 sel_in 2.1675e-17
* device instance cc__24_topn r0 *1 0,0
Ccc__24_topn \$24 topn 1.7212e-17
* device instance cc__24_topp r0 *1 0,0
Ccc__24_topp \$24 topp 3.44613e-16
* device instance cc__24_vcm r0 *1 0,0
Ccc__24_vcm \$24 vcm 6.6937e-17
* device instance cc__24_vdd r0 *1 0,0
Ccc__24_vdd \$24 vdd 1.0837e-17
* device instance cc__24_vref r0 *1 0,0
Ccc__24_vref \$24 vref 1.0837e-17
* device instance cc__24_vss r0 *1 0,0
Ccc__24_vss \$24 vss 5.20075e-16
* device instance cc__25__26 r0 *1 0,0
Ccc__25__26 \$25 \$26 1.0837e-17
* device instance cc__26__59 r0 *1 0,0
Ccc__26__59 \$26 \$59 1.0837e-17
* device instance cc__26__61 r0 *1 0,0
Ccc__26__61 \$26 \$61 1.0837e-17
* device instance cc__26__81 r0 *1 0,0
Ccc__26__81 \$26 \$81 1.0837e-17
* device instance cc__26__90 r0 *1 0,0
Ccc__26__90 \$26 \$90 1.7212e-17
* device instance cc__26__99 r0 *1 0,0
Ccc__26__99 \$26 \$99 1.7212e-17
* device instance cc__26_hi_1_n r0 *1 0,0
Ccc__26_hi_1_n \$26 hi_1_n 1.0837e-17
* device instance cc__26_hi_1_p r0 *1 0,0
Ccc__26_hi_1_p \$26 hi_1_p 1.0837e-17
* device instance cc__26_lo_1_n r0 *1 0,0
Ccc__26_lo_1_n \$26 lo_1_n 1.0837e-17
* device instance cc__26_lo_1_p r0 *1 0,0
Ccc__26_lo_1_p \$26 lo_1_p 1.0837e-17
* device instance cc__26_pinn r0 *1 0,0
Ccc__26_pinn \$26 vinn 1.0837e-17
* device instance cc__26_rel_1_n r0 *1 0,0
Ccc__26_rel_1_n \$26 rel_1_n 1.0837e-17
* device instance cc__26_rel_1_p r0 *1 0,0
Ccc__26_rel_1_p \$26 rel_1_p 1.0837e-17
* device instance cc__26_sel_in r0 *1 0,0
Ccc__26_sel_in \$26 sel_in 2.1675e-17
* device instance cc__26_topn r0 *1 0,0
Ccc__26_topn \$26 topn 1.7212e-17
* device instance cc__26_topp r0 *1 0,0
Ccc__26_topp \$26 topp 1.80912e-16
* device instance cc__26_vcm r0 *1 0,0
Ccc__26_vcm \$26 vcm 5.6099e-17
* device instance cc__26_vdd r0 *1 0,0
Ccc__26_vdd \$26 vdd 1.0837e-17
* device instance cc__26_vref r0 *1 0,0
Ccc__26_vref \$26 vref 1.0837e-17
* device instance cc__26_vss r0 *1 0,0
Ccc__26_vss \$26 vss 5.20075e-16
* device instance cc__43_vcm r0 *1 0,0
Ccc__43_vcm \$43 vcm 3.7724e-17
* device instance cc__45_vcm r0 *1 0,0
Ccc__45_vcm \$45 vcm 1.0837e-17
* device instance cc__73_vcm r0 *1 0,0
Ccc__73_vcm \$73 vcm 1.0837e-17
* device instance cc__83__90 r0 *1 0,0
Ccc__83__90 \$83 \$90 1.0837e-17
* device instance cc__85__90 r0 *1 0,0
Ccc__85__90 \$85 \$90 1.0837e-17
* device instance cc__87__90 r0 *1 0,0
Ccc__87__90 \$87 \$90 1.0837e-17
* device instance cc__89__90 r0 *1 0,0
Ccc__89__90 \$89 \$90 1.0837e-17
* device instance cc__90__99 r0 *1 0,0
Ccc__90__99 \$90 \$99 1.614766e-15
* device instance cc__90_lo_256_n r0 *1 0,0
Ccc__90_lo_256_n \$90 lo_256_n 6.924e-18
* device instance cc__90_sel_in r0 *1 0,0
Ccc__90_sel_in \$90 sel_in 1.0837e-17
* device instance cc__90_topn r0 *1 0,0
Ccc__90_topn \$90 topn 4.2159087e-14
* device instance cc__90_topp r0 *1 0,0
Ccc__90_topp \$90 topp 1.7212e-17
* device instance cc__90_vcm r0 *1 0,0
Ccc__90_vcm \$90 vcm 1.25586e-16
* device instance cc__90_vss r0 *1 0,0
Ccc__90_vss \$90 vss 1.0837e-17
* device instance cc__92__99 r0 *1 0,0
Ccc__92__99 \$92 \$99 1.0837e-17
* device instance cc__94__99 r0 *1 0,0
Ccc__94__99 \$94 \$99 1.0837e-17
* device instance cc__96__99 r0 *1 0,0
Ccc__96__99 \$96 \$99 1.0837e-17
* device instance cc__98__99 r0 *1 0,0
Ccc__98__99 \$98 \$99 1.0837e-17
* device instance cc__99_lo_128_n r0 *1 0,0
Ccc__99_lo_128_n \$99 lo_128_n 6.924e-18
* device instance cc__99_sel_in r0 *1 0,0
Ccc__99_sel_in \$99 sel_in 1.0837e-17
* device instance cc__99_topn r0 *1 0,0
Ccc__99_topn \$99 topn 2.1079544e-14
* device instance cc__99_topp r0 *1 0,0
Ccc__99_topp \$99 topp 1.7212e-17
* device instance cc__99_vcm r0 *1 0,0
Ccc__99_vcm \$99 vcm 7.1399e-17
* device instance cc__99_vss r0 *1 0,0
Ccc__99_vss \$99 vss 1.0837e-17
* device instance cc_hi_16_n_vcm r0 *1 0,0
Ccc_hi_16_n_vcm hi_16_n vcm 1.0837e-17
* device instance cc_hi_16_p_vcm r0 *1 0,0
Ccc_hi_16_p_vcm hi_16_p vcm 1.0837e-17
* device instance cc_lo_16_n_vcm r0 *1 0,0
Ccc_lo_16_n_vcm lo_16_n vcm 1.0837e-17
* device instance cc_lo_16_p_vcm r0 *1 0,0
Ccc_lo_16_p_vcm lo_16_p vcm 1.0837e-17
* device instance cc_pinn_vcm r0 *1 0,0
Ccc_pinn_vcm vinn vcm 2.1675e-17
* device instance cc_pinp_vcm r0 *1 0,0
Ccc_pinp_vcm vinp vcm 1.0837e-17
* device instance cc_rel_16_n_vcm r0 *1 0,0
Ccc_rel_16_n_vcm rel_16_n vcm 1e-19
* device instance cc_rel_16_p_vcm r0 *1 0,0
Ccc_rel_16_p_vcm rel_16_p vcm 1e-19
* device instance cc_sel_in_vcm r0 *1 0,0
Ccc_sel_in_vcm sel_in vcm 3.2512e-17
* device instance cc_topn_topp r0 *1 0,0
Ccc_topn_topp topn topp 5.318e-18
* device instance cc_topn_vcm r0 *1 0,0
Ccc_topn_vcm topn vcm 1.74538e-16
* device instance cc_topn_vdd r0 *1 0,0
Ccc_topn_vdd topn vdd 1.0837e-17
* device instance cc_topn_vss r0 *1 0,0
Ccc_topn_vss topn vss 1.0837e-17
* device instance cc_topp_vcm r0 *1 0,0
Ccc_topp_vcm topp vcm 2.19799e-16
* device instance cc_topp_vdd r0 *1 0,0
Ccc_topp_vdd topp vdd 2.1675e-17
* device instance cc_topp_vss r0 *1 0,0
Ccc_topp_vss topp vss 1.0837e-17
* device instance cc_vcm_vdd r0 *1 0,0
Ccc_vcm_vdd vcm vdd 1.0837e-17
* device instance cc_vcm_vref r0 *1 0,0
Ccc_vcm_vref vcm vref 1.0837e-17
* device instance cc_vcm_vss r0 *1 0,0
Ccc_vcm_vss vcm vss 3.2512e-17
.ENDS ADC_TOP

* ================= extracted core se (single-ended) ==================
vsestart se_start 0 dc 0
vsemode se_mode 0 dc 0
xsectrl clk se_start se_mode se_cmp se_samp_tp_n se_sel_in_n se_drdy se_c9
+ se_c8 se_c7 se_c6 se_c5 se_c4 se_c3 se_c2 se_c1 se_c0 se_rel_n_256p
+ se_sel_hi_n_256p se_sel_lo_n_256p se_rel_n_128p se_sel_hi_n_128p
+ se_sel_lo_n_128p se_rel_n_64p se_sel_hi_n_64p se_sel_lo_n_64p
+ se_rel_n_32p se_sel_hi_n_32p se_sel_lo_n_32p se_rel_n_16p
+ se_sel_hi_n_16p se_sel_lo_n_16p se_rel_n_8p se_sel_hi_n_8p
+ se_sel_lo_n_8p se_rel_n_4p se_sel_hi_n_4p se_sel_lo_n_4p se_rel_n_2p
+ se_sel_hi_n_2p se_sel_lo_n_2p se_rel_n_1p se_sel_hi_n_1p se_sel_lo_n_1p
+ se_rel_n_256n se_sel_hi_n_256n se_sel_lo_n_256n se_rel_n_128n
+ se_sel_hi_n_128n se_sel_lo_n_128n se_rel_n_64n se_sel_hi_n_64n
+ se_sel_lo_n_64n se_rel_n_32n se_sel_hi_n_32n se_sel_lo_n_32n
+ se_rel_n_16n se_sel_hi_n_16n se_sel_lo_n_16n se_rel_n_8n se_sel_hi_n_8n
+ se_sel_lo_n_8n se_rel_n_4n se_sel_hi_n_4n se_sel_lo_n_4n se_rel_n_2n
+ se_sel_hi_n_2n se_sel_lo_n_2n se_rel_n_1n se_sel_hi_n_1n se_sel_lo_n_1n
+ sar_ctrl_a
* Input drive network (DR-0013), same R_s/C_pin gen_adc_top._core()
* uses for the schematic core -- the drive contract is unchanged by
* which core sits behind it.
Rsesp se_vinp se_pinp 25
Csexp se_pinp 0 1n
Rsesn se_vinn se_pinn 25
Csexn se_pinn 0 1n
* ADC_TOP: both CDAC array sides (four-leg bottom-plate switches, local
* drivers) and the per-side top-plate V_cm switch (DR-0014), all in ONE
* flat extracted instance, PMOS-body-remediated and MiM-mapped to the
* native PDK subckt (layout/adc-top/parasitics/remediate_extracted.py).
* Comparator and controller stay schematic-level (Scope item 0).
Xdut se_sel_hi_n_128n se_sel_hi_n_128p se_sel_hi_n_16n se_sel_hi_n_16p
+ se_sel_hi_n_1n se_sel_hi_n_1p se_sel_hi_n_256n se_sel_hi_n_256p
+ se_sel_hi_n_2n se_sel_hi_n_2p se_sel_hi_n_32n se_sel_hi_n_32p
+ se_sel_hi_n_4n se_sel_hi_n_4p se_sel_hi_n_64n se_sel_hi_n_64p
+ se_sel_hi_n_8n se_sel_hi_n_8p se_sel_lo_n_128n se_sel_lo_n_128p
+ se_sel_lo_n_16n se_sel_lo_n_16p se_sel_lo_n_1n se_sel_lo_n_1p
+ se_sel_lo_n_256n se_sel_lo_n_256p se_sel_lo_n_2n se_sel_lo_n_2p
+ se_sel_lo_n_32n se_sel_lo_n_32p se_sel_lo_n_4n se_sel_lo_n_4p
+ se_sel_lo_n_64n se_sel_lo_n_64p se_sel_lo_n_8n se_sel_lo_n_8p
+ se_rel_n_128n se_rel_n_128p se_rel_n_16n se_rel_n_16p se_rel_n_1n
+ se_rel_n_1p se_rel_n_256n se_rel_n_256p se_rel_n_2n se_rel_n_2p
+ se_rel_n_32n se_rel_n_32p se_rel_n_4n se_rel_n_4p se_rel_n_64n
+ se_rel_n_64p se_rel_n_8n se_rel_n_8p se_sel_in_n se_topn se_topp
+ se_samp_tp_n vcmn vddd vrefn 0 0 se_pinp se_pinn ADC_TOP
iseb vddc se_ibias dc 10u
Xsecmp se_topp se_topn cmpclk se_ibias se_cmp se_cmpb vddc 0 comparator
bsecode se_code 0 V =
+ (512)*(v(se_c9)>vth ? 1 : 0) + (256)*(v(se_c8)>vth ? 1 : 0) + (128)*(v(se_c7)>vth ? 1 : 0) + (64)*(v(se_c6)>vth ? 1 : 0) + (32)*(v(se_c5)>vth ? 1 : 0) + (16)*(v(se_c4)>vth ? 1 : 0) + (8)*(v(se_c3)>vth ? 1 : 0) + (4)*(v(se_c2)>vth ? 1 : 0) + (2)*(v(se_c1)>vth ? 1 : 0) + (1)*(v(se_c0)>vth ? 1 : 0)

* ---- ideal shadow DAC + error node (issue #89 Scope items 1/3/8) ----
* Verbatim formula from gen_adc_top._core() -- see that function for
* the charge-conservation derivation. Wired onto the SAME per-weight
* nets gen_extracted_core_tb._wire_pin() already drives.
bsedacp se_dacp 0 V = (1.0/512)*(
+ 256*((v(se_rel_n_256p)*vcm+v(se_sel_hi_n_256p)*vref+v(se_sel_in_n)*v(se_vinp))/vdd_val-vcm) + 128*((v(se_rel_n_128p)*vcm+v(se_sel_hi_n_128p)*vref+v(se_sel_in_n)*v(se_vinp))/vdd_val-vcm) + 64*((v(se_rel_n_64p)*vcm+v(se_sel_hi_n_64p)*vref+v(se_sel_in_n)*v(se_vinp))/vdd_val-vcm) + 32*((v(se_rel_n_32p)*vcm+v(se_sel_hi_n_32p)*vref+v(se_sel_in_n)*v(se_vinp))/vdd_val-vcm) + 16*((v(se_rel_n_16p)*vcm+v(se_sel_hi_n_16p)*vref+v(se_sel_in_n)*v(se_vinp))/vdd_val-vcm) + 8*((v(se_rel_n_8p)*vcm+v(se_sel_hi_n_8p)*vref+v(se_sel_in_n)*v(se_vinp))/vdd_val-vcm) + 4*((v(se_rel_n_4p)*vcm+v(se_sel_hi_n_4p)*vref+v(se_sel_in_n)*v(se_vinp))/vdd_val-vcm) + 2*((v(se_rel_n_2p)*vcm+v(se_sel_hi_n_2p)*vref+v(se_sel_in_n)*v(se_vinp))/vdd_val-vcm) + 1*((v(se_rel_n_1p)*vcm+v(se_sel_hi_n_1p)*vref+v(se_sel_in_n)*v(se_vinp))/vdd_val-vcm) )
bsedacn se_dacn 0 V = (1.0/512)*(
+ 256*((v(se_rel_n_256n)*vcm+v(se_sel_hi_n_256n)*vref+v(se_sel_in_n)*v(se_vinn))/vdd_val-vcm) + 128*((v(se_rel_n_128n)*vcm+v(se_sel_hi_n_128n)*vref+v(se_sel_in_n)*v(se_vinn))/vdd_val-vcm) + 64*((v(se_rel_n_64n)*vcm+v(se_sel_hi_n_64n)*vref+v(se_sel_in_n)*v(se_vinn))/vdd_val-vcm) + 32*((v(se_rel_n_32n)*vcm+v(se_sel_hi_n_32n)*vref+v(se_sel_in_n)*v(se_vinn))/vdd_val-vcm) + 16*((v(se_rel_n_16n)*vcm+v(se_sel_hi_n_16n)*vref+v(se_sel_in_n)*v(se_vinn))/vdd_val-vcm) + 8*((v(se_rel_n_8n)*vcm+v(se_sel_hi_n_8n)*vref+v(se_sel_in_n)*v(se_vinn))/vdd_val-vcm) + 4*((v(se_rel_n_4n)*vcm+v(se_sel_hi_n_4n)*vref+v(se_sel_in_n)*v(se_vinn))/vdd_val-vcm) + 2*((v(se_rel_n_2n)*vcm+v(se_sel_hi_n_2n)*vref+v(se_sel_in_n)*v(se_vinn))/vdd_val-vcm) + 1*((v(se_rel_n_1n)*vcm+v(se_sel_hi_n_1n)*vref+v(se_sel_in_n)*v(se_vinn))/vdd_val-vcm) )
bsedi se_di 0 V = v(se_vinn)-v(se_vinp)+v(se_dacp)-v(se_dacn)
bsee se_err 0 V = (v(se_di)-(v(se_topp)-v(se_topn)))/lsb
* |err| gated to the ten comparator-strobe windows -- verbatim from
* gen_adc_top._core(); MAX over a trial window is that conversion's
* WORST DECISION ERROR. Gating, not holding: see _core()'s own note
* on why a track-and-hold reported the settling transient instead.
bseea se_aerrh 0 V = abs(v(se_err))*(v(cmpclk)>vth ? 1 : 0)
* Decoded output code: NOT redefined here -- _core_extracted() (called
* above, same tag) already emits `b{tag}code`, and a second B-source on
* the same node is an ngspice 'device already exists' error, not a
* harmless override.
