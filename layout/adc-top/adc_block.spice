* extracted by klt extract --deck gf180mcu

* cell ADC_BLOCK
* pin XCMP_pon
* pin XCMP_pop
* pin cmpclk
* pin dout
* pin doutb
* pin hi_128_n
* pin hi_128_p
* pin hi_16_n
* pin hi_16_p
* pin hi_1_n
* pin hi_1_p
* pin hi_256_n
* pin hi_256_p
* pin hi_2_n
* pin hi_2_p
* pin hi_32_n
* pin hi_32_p
* pin hi_4_n
* pin hi_4_p
* pin hi_64_n
* pin hi_64_p
* pin hi_8_n
* pin hi_8_p
* pin ibias
* pin lo_128_n
* pin lo_128_p
* pin lo_16_n
* pin lo_16_p
* pin lo_1_n
* pin lo_1_p
* pin lo_256_n
* pin lo_256_p
* pin lo_2_n
* pin lo_2_p
* pin lo_32_n
* pin lo_32_p
* pin lo_4_n
* pin lo_4_p
* pin lo_64_n
* pin lo_64_p
* pin lo_8_n
* pin lo_8_p
* pin pinn
* pin pinp
* pin rel_128_n
* pin rel_128_p
* pin rel_16_n
* pin rel_16_p
* pin rel_1_n
* pin rel_1_p
* pin rel_256_n
* pin rel_256_p
* pin rel_2_n
* pin rel_2_p
* pin rel_32_n
* pin rel_32_p
* pin rel_4_n
* pin rel_4_p
* pin rel_64_n
* pin rel_64_p
* pin rel_8_n
* pin rel_8_p
* pin sel_in
* pin topn
* pin topp
* pin tp_gn
* pin vcm
* pin vdd
* pin vref
* pin vss
.SUBCKT ADC_BLOCK XCMP_pon XCMP_pop cmpclk dout doutb hi_128_n hi_128_p hi_16_n
+ hi_16_p hi_1_n hi_1_p hi_256_n hi_256_p hi_2_n hi_2_p hi_32_n hi_32_p hi_4_n
+ hi_4_p hi_64_n hi_64_p hi_8_n hi_8_p ibias lo_128_n lo_128_p lo_16_n lo_16_p
+ lo_1_n lo_1_p lo_256_n lo_256_p lo_2_n lo_2_p lo_32_n lo_32_p lo_4_n lo_4_p
+ lo_64_n lo_64_p lo_8_n lo_8_p pinn pinp rel_128_n rel_128_p rel_16_n rel_16_p
+ rel_1_n rel_1_p rel_256_n rel_256_p rel_2_n rel_2_p rel_32_n rel_32_p rel_4_n
+ rel_4_p rel_64_n rel_64_p rel_8_n rel_8_p sel_in topn topp tp_gn vcm vdd vref
+ vss
* device instance $1 r0 *1 1.275,2 nfet
M$1 \$70 sel_in vss vss nfet L=0.35U W=4U AS=4.4P AD=4.4P PS=10.2U PD=10.2U
* device instance $2 r0 *1 4.225,2 nfet
M$2 \$34 rel_256_p vss vss nfet L=0.35U W=4U AS=4.4P AD=4.4P PS=10.2U PD=10.2U
* device instance $3 r0 *1 7.175,2 nfet
M$3 \$36 hi_256_p vss vss nfet L=0.35U W=4U AS=4.4P AD=4.4P PS=10.2U PD=10.2U
* device instance $4 r0 *1 10.125,2 nfet
M$4 \$16 lo_256_p vss vss nfet L=0.35U W=4U AS=4.4P AD=4.4P PS=10.2U PD=10.2U
* device instance $5 r0 *1 13.04,5 nfet
M$5 pinp sel_in \$5 vss nfet L=0.28U W=10U AS=11P AD=11P PS=22.2U PD=22.2U
* device instance $6 r0 *1 15.92,5 nfet
M$6 vcm rel_256_p \$5 vss nfet L=0.28U W=10U AS=11P AD=11P PS=22.2U PD=22.2U
* device instance $7 r0 *1 18.8,5 nfet
M$7 vref hi_256_p \$5 vss nfet L=0.28U W=10U AS=11P AD=11P PS=22.2U PD=22.2U
* device instance $8 r0 *1 21.68,5 nfet
M$8 vss lo_256_p \$5 vss nfet L=0.28U W=10U AS=11P AD=11P PS=22.2U PD=22.2U
* device instance $9 r0 *1 49.715,2 nfet
M$9 \$71 sel_in vss vss nfet L=0.35U W=4U AS=4.4P AD=4.4P PS=10.2U PD=10.2U
* device instance $10 r0 *1 52.665,2 nfet
M$10 \$38 rel_128_p vss vss nfet L=0.35U W=4U AS=4.4P AD=4.4P PS=10.2U PD=10.2U
* device instance $11 r0 *1 55.615,2 nfet
M$11 \$40 hi_128_p vss vss nfet L=0.35U W=4U AS=4.4P AD=4.4P PS=10.2U PD=10.2U
* device instance $12 r0 *1 58.565,2 nfet
M$12 \$18 lo_128_p vss vss nfet L=0.35U W=4U AS=4.4P AD=4.4P PS=10.2U PD=10.2U
* device instance $13 r0 *1 61.48,5 nfet
M$13 pinp sel_in \$7 vss nfet L=0.28U W=10U AS=11P AD=11P PS=22.2U PD=22.2U
* device instance $14 r0 *1 64.36,5 nfet
M$14 vcm rel_128_p \$7 vss nfet L=0.28U W=10U AS=11P AD=11P PS=22.2U PD=22.2U
* device instance $15 r0 *1 67.24,5 nfet
M$15 vref hi_128_p \$7 vss nfet L=0.28U W=10U AS=11P AD=11P PS=22.2U PD=22.2U
* device instance $16 r0 *1 70.12,5 nfet
M$16 vss lo_128_p \$7 vss nfet L=0.28U W=10U AS=11P AD=11P PS=22.2U PD=22.2U
* device instance $17 r0 *1 98.155,2 nfet
M$17 \$72 sel_in vss vss nfet L=0.35U W=4U AS=4.4P AD=4.4P PS=10.2U PD=10.2U
* device instance $18 r0 *1 101.105,2 nfet
M$18 \$42 rel_64_p vss vss nfet L=0.35U W=4U AS=4.4P AD=4.4P PS=10.2U PD=10.2U
* device instance $19 r0 *1 104.055,2 nfet
M$19 \$44 hi_64_p vss vss nfet L=0.35U W=4U AS=4.4P AD=4.4P PS=10.2U PD=10.2U
* device instance $20 r0 *1 107.005,2 nfet
M$20 \$20 lo_64_p vss vss nfet L=0.35U W=4U AS=4.4P AD=4.4P PS=10.2U PD=10.2U
* device instance $21 r0 *1 109.92,5 nfet
M$21 pinp sel_in \$8 vss nfet L=0.28U W=10U AS=11P AD=11P PS=22.2U PD=22.2U
* device instance $22 r0 *1 112.8,5 nfet
M$22 vcm rel_64_p \$8 vss nfet L=0.28U W=10U AS=11P AD=11P PS=22.2U PD=22.2U
* device instance $23 r0 *1 115.68,5 nfet
M$23 vref hi_64_p \$8 vss nfet L=0.28U W=10U AS=11P AD=11P PS=22.2U PD=22.2U
* device instance $24 r0 *1 118.56,5 nfet
M$24 vss lo_64_p \$8 vss nfet L=0.28U W=10U AS=11P AD=11P PS=22.2U PD=22.2U
* device instance $25 r0 *1 146.595,2 nfet
M$25 \$73 sel_in vss vss nfet L=0.35U W=4U AS=4.4P AD=4.4P PS=10.2U PD=10.2U
* device instance $26 r0 *1 149.545,2 nfet
M$26 \$46 rel_32_p vss vss nfet L=0.35U W=4U AS=4.4P AD=4.4P PS=10.2U PD=10.2U
* device instance $27 r0 *1 152.495,2 nfet
M$27 \$48 hi_32_p vss vss nfet L=0.35U W=4U AS=4.4P AD=4.4P PS=10.2U PD=10.2U
* device instance $28 r0 *1 155.445,2 nfet
M$28 \$22 lo_32_p vss vss nfet L=0.35U W=4U AS=4.4P AD=4.4P PS=10.2U PD=10.2U
* device instance $29 r0 *1 158.36,5 nfet
M$29 pinp sel_in \$9 vss nfet L=0.28U W=10U AS=11P AD=11P PS=22.2U PD=22.2U
* device instance $30 r0 *1 161.24,5 nfet
M$30 vcm rel_32_p \$9 vss nfet L=0.28U W=10U AS=11P AD=11P PS=22.2U PD=22.2U
* device instance $31 r0 *1 164.12,5 nfet
M$31 vref hi_32_p \$9 vss nfet L=0.28U W=10U AS=11P AD=11P PS=22.2U PD=22.2U
* device instance $32 r0 *1 167,5 nfet
M$32 vss lo_32_p \$9 vss nfet L=0.28U W=10U AS=11P AD=11P PS=22.2U PD=22.2U
* device instance $33 r0 *1 195.035,2 nfet
M$33 \$74 sel_in vss vss nfet L=0.35U W=4U AS=4.4P AD=4.4P PS=10.2U PD=10.2U
* device instance $34 r0 *1 197.985,2 nfet
M$34 \$50 rel_16_p vss vss nfet L=0.35U W=4U AS=4.4P AD=4.4P PS=10.2U PD=10.2U
* device instance $35 r0 *1 200.935,2 nfet
M$35 \$52 hi_16_p vss vss nfet L=0.35U W=4U AS=4.4P AD=4.4P PS=10.2U PD=10.2U
* device instance $36 r0 *1 203.885,2 nfet
M$36 \$24 lo_16_p vss vss nfet L=0.35U W=4U AS=4.4P AD=4.4P PS=10.2U PD=10.2U
* device instance $37 r0 *1 206.8,5 nfet
M$37 pinp sel_in \$10 vss nfet L=0.28U W=10U AS=11P AD=11P PS=22.2U PD=22.2U
* device instance $38 r0 *1 209.68,5 nfet
M$38 vcm rel_16_p \$10 vss nfet L=0.28U W=10U AS=11P AD=11P PS=22.2U PD=22.2U
* device instance $39 r0 *1 212.56,5 nfet
M$39 vref hi_16_p \$10 vss nfet L=0.28U W=10U AS=11P AD=11P PS=22.2U PD=22.2U
* device instance $40 r0 *1 215.44,5 nfet
M$40 vss lo_16_p \$10 vss nfet L=0.28U W=10U AS=11P AD=11P PS=22.2U PD=22.2U
* device instance $41 r0 *1 243.475,2 nfet
M$41 \$75 sel_in vss vss nfet L=0.35U W=4U AS=4.4P AD=4.4P PS=10.2U PD=10.2U
* device instance $42 r0 *1 246.425,2 nfet
M$42 \$54 rel_8_p vss vss nfet L=0.35U W=4U AS=4.4P AD=4.4P PS=10.2U PD=10.2U
* device instance $43 r0 *1 249.375,2 nfet
M$43 \$56 hi_8_p vss vss nfet L=0.35U W=4U AS=4.4P AD=4.4P PS=10.2U PD=10.2U
* device instance $44 r0 *1 252.325,2 nfet
M$44 \$26 lo_8_p vss vss nfet L=0.35U W=4U AS=4.4P AD=4.4P PS=10.2U PD=10.2U
* device instance $45 r0 *1 255.24,5 nfet
M$45 pinp sel_in \$11 vss nfet L=0.28U W=10U AS=11P AD=11P PS=22.2U PD=22.2U
* device instance $46 r0 *1 258.12,5 nfet
M$46 vcm rel_8_p \$11 vss nfet L=0.28U W=10U AS=11P AD=11P PS=22.2U PD=22.2U
* device instance $47 r0 *1 261,5 nfet
M$47 vref hi_8_p \$11 vss nfet L=0.28U W=10U AS=11P AD=11P PS=22.2U PD=22.2U
* device instance $48 r0 *1 263.88,5 nfet
M$48 vss lo_8_p \$11 vss nfet L=0.28U W=10U AS=11P AD=11P PS=22.2U PD=22.2U
* device instance $49 r0 *1 291.915,2 nfet
M$49 \$76 sel_in vss vss nfet L=0.35U W=4U AS=4.4P AD=4.4P PS=10.2U PD=10.2U
* device instance $50 r0 *1 294.865,2 nfet
M$50 \$58 rel_4_p vss vss nfet L=0.35U W=4U AS=4.4P AD=4.4P PS=10.2U PD=10.2U
* device instance $51 r0 *1 297.815,2 nfet
M$51 \$60 hi_4_p vss vss nfet L=0.35U W=4U AS=4.4P AD=4.4P PS=10.2U PD=10.2U
* device instance $52 r0 *1 300.765,2 nfet
M$52 \$28 lo_4_p vss vss nfet L=0.35U W=4U AS=4.4P AD=4.4P PS=10.2U PD=10.2U
* device instance $53 r0 *1 303.68,5 nfet
M$53 pinp sel_in \$12 vss nfet L=0.28U W=10U AS=11P AD=11P PS=22.2U PD=22.2U
* device instance $54 r0 *1 306.56,5 nfet
M$54 vcm rel_4_p \$12 vss nfet L=0.28U W=10U AS=11P AD=11P PS=22.2U PD=22.2U
* device instance $55 r0 *1 309.44,5 nfet
M$55 vref hi_4_p \$12 vss nfet L=0.28U W=10U AS=11P AD=11P PS=22.2U PD=22.2U
* device instance $56 r0 *1 312.32,5 nfet
M$56 vss lo_4_p \$12 vss nfet L=0.28U W=10U AS=11P AD=11P PS=22.2U PD=22.2U
* device instance $57 r0 *1 340.355,2 nfet
M$57 \$77 sel_in vss vss nfet L=0.35U W=4U AS=4.4P AD=4.4P PS=10.2U PD=10.2U
* device instance $58 r0 *1 343.305,2 nfet
M$58 \$62 rel_2_p vss vss nfet L=0.35U W=4U AS=4.4P AD=4.4P PS=10.2U PD=10.2U
* device instance $59 r0 *1 346.255,2 nfet
M$59 \$64 hi_2_p vss vss nfet L=0.35U W=4U AS=4.4P AD=4.4P PS=10.2U PD=10.2U
* device instance $60 r0 *1 349.205,2 nfet
M$60 \$30 lo_2_p vss vss nfet L=0.35U W=4U AS=4.4P AD=4.4P PS=10.2U PD=10.2U
* device instance $61 r0 *1 352.12,5 nfet
M$61 pinp sel_in \$13 vss nfet L=0.28U W=10U AS=11P AD=11P PS=22.2U PD=22.2U
* device instance $62 r0 *1 355,5 nfet
M$62 vcm rel_2_p \$13 vss nfet L=0.28U W=10U AS=11P AD=11P PS=22.2U PD=22.2U
* device instance $63 r0 *1 357.88,5 nfet
M$63 vref hi_2_p \$13 vss nfet L=0.28U W=10U AS=11P AD=11P PS=22.2U PD=22.2U
* device instance $64 r0 *1 360.76,5 nfet
M$64 vss lo_2_p \$13 vss nfet L=0.28U W=10U AS=11P AD=11P PS=22.2U PD=22.2U
* device instance $65 r0 *1 388.795,2 nfet
M$65 \$78 sel_in vss vss nfet L=0.35U W=4U AS=4.4P AD=4.4P PS=10.2U PD=10.2U
* device instance $66 r0 *1 391.745,2 nfet
M$66 \$66 rel_1_p vss vss nfet L=0.35U W=4U AS=4.4P AD=4.4P PS=10.2U PD=10.2U
* device instance $67 r0 *1 394.695,2 nfet
M$67 \$68 hi_1_p vss vss nfet L=0.35U W=4U AS=4.4P AD=4.4P PS=10.2U PD=10.2U
* device instance $68 r0 *1 397.645,2 nfet
M$68 \$32 lo_1_p vss vss nfet L=0.35U W=4U AS=4.4P AD=4.4P PS=10.2U PD=10.2U
* device instance $69 r0 *1 400.56,5 nfet
M$69 pinp sel_in \$14 vss nfet L=0.28U W=10U AS=11P AD=11P PS=22.2U PD=22.2U
* device instance $70 r0 *1 403.44,5 nfet
M$70 vcm rel_1_p \$14 vss nfet L=0.28U W=10U AS=11P AD=11P PS=22.2U PD=22.2U
* device instance $71 r0 *1 406.32,5 nfet
M$71 vref hi_1_p \$14 vss nfet L=0.28U W=10U AS=11P AD=11P PS=22.2U PD=22.2U
* device instance $72 r0 *1 409.2,5 nfet
M$72 vss lo_1_p \$14 vss nfet L=0.28U W=10U AS=11P AD=11P PS=22.2U PD=22.2U
* device instance $73 r0 *1 1.275,36.96 nfet
M$73 \$79 sel_in vss vss nfet L=0.35U W=4U AS=4.4P AD=4.4P PS=10.2U PD=10.2U
* device instance $74 r0 *1 4.225,36.96 nfet
M$74 \$81 rel_256_n vss vss nfet L=0.35U W=4U AS=4.4P AD=4.4P PS=10.2U PD=10.2U
* device instance $75 r0 *1 7.175,36.96 nfet
M$75 \$83 hi_256_n vss vss nfet L=0.35U W=4U AS=4.4P AD=4.4P PS=10.2U PD=10.2U
* device instance $76 r0 *1 10.125,36.96 nfet
M$76 \$85 lo_256_n vss vss nfet L=0.35U W=4U AS=4.4P AD=4.4P PS=10.2U PD=10.2U
* device instance $77 r0 *1 13.04,39.96 nfet
M$77 pinn sel_in \$86 vss nfet L=0.28U W=10U AS=11P AD=11P PS=22.2U PD=22.2U
* device instance $78 r0 *1 15.92,39.96 nfet
M$78 vcm rel_256_n \$86 vss nfet L=0.28U W=10U AS=11P AD=11P PS=22.2U PD=22.2U
* device instance $79 r0 *1 18.8,39.96 nfet
M$79 vref hi_256_n \$86 vss nfet L=0.28U W=10U AS=11P AD=11P PS=22.2U PD=22.2U
* device instance $80 r0 *1 21.68,39.96 nfet
M$80 vss lo_256_n \$86 vss nfet L=0.28U W=10U AS=11P AD=11P PS=22.2U PD=22.2U
* device instance $81 r0 *1 49.715,36.96 nfet
M$81 \$88 sel_in vss vss nfet L=0.35U W=4U AS=4.4P AD=4.4P PS=10.2U PD=10.2U
* device instance $82 r0 *1 52.665,36.96 nfet
M$82 \$90 rel_128_n vss vss nfet L=0.35U W=4U AS=4.4P AD=4.4P PS=10.2U PD=10.2U
* device instance $83 r0 *1 55.615,36.96 nfet
M$83 \$92 hi_128_n vss vss nfet L=0.35U W=4U AS=4.4P AD=4.4P PS=10.2U PD=10.2U
* device instance $84 r0 *1 58.565,36.96 nfet
M$84 \$94 lo_128_n vss vss nfet L=0.35U W=4U AS=4.4P AD=4.4P PS=10.2U PD=10.2U
* device instance $85 r0 *1 61.48,39.96 nfet
M$85 pinn sel_in \$95 vss nfet L=0.28U W=10U AS=11P AD=11P PS=22.2U PD=22.2U
* device instance $86 r0 *1 64.36,39.96 nfet
M$86 vcm rel_128_n \$95 vss nfet L=0.28U W=10U AS=11P AD=11P PS=22.2U PD=22.2U
* device instance $87 r0 *1 67.24,39.96 nfet
M$87 vref hi_128_n \$95 vss nfet L=0.28U W=10U AS=11P AD=11P PS=22.2U PD=22.2U
* device instance $88 r0 *1 70.12,39.96 nfet
M$88 vss lo_128_n \$95 vss nfet L=0.28U W=10U AS=11P AD=11P PS=22.2U PD=22.2U
* device instance $89 r0 *1 98.155,36.96 nfet
M$89 \$96 sel_in vss vss nfet L=0.35U W=4U AS=4.4P AD=4.4P PS=10.2U PD=10.2U
* device instance $90 r0 *1 101.105,36.96 nfet
M$90 \$98 rel_64_n vss vss nfet L=0.35U W=4U AS=4.4P AD=4.4P PS=10.2U PD=10.2U
* device instance $91 r0 *1 104.055,36.96 nfet
M$91 \$100 hi_64_n vss vss nfet L=0.35U W=4U AS=4.4P AD=4.4P PS=10.2U PD=10.2U
* device instance $92 r0 *1 107.005,36.96 nfet
M$92 \$102 lo_64_n vss vss nfet L=0.35U W=4U AS=4.4P AD=4.4P PS=10.2U PD=10.2U
* device instance $93 r0 *1 109.92,39.96 nfet
M$93 pinn sel_in \$103 vss nfet L=0.28U W=10U AS=11P AD=11P PS=22.2U PD=22.2U
* device instance $94 r0 *1 112.8,39.96 nfet
M$94 vcm rel_64_n \$103 vss nfet L=0.28U W=10U AS=11P AD=11P PS=22.2U PD=22.2U
* device instance $95 r0 *1 115.68,39.96 nfet
M$95 vref hi_64_n \$103 vss nfet L=0.28U W=10U AS=11P AD=11P PS=22.2U PD=22.2U
* device instance $96 r0 *1 118.56,39.96 nfet
M$96 vss lo_64_n \$103 vss nfet L=0.28U W=10U AS=11P AD=11P PS=22.2U PD=22.2U
* device instance $97 r0 *1 146.595,36.96 nfet
M$97 \$104 sel_in vss vss nfet L=0.35U W=4U AS=4.4P AD=4.4P PS=10.2U PD=10.2U
* device instance $98 r0 *1 149.545,36.96 nfet
M$98 \$106 rel_32_n vss vss nfet L=0.35U W=4U AS=4.4P AD=4.4P PS=10.2U PD=10.2U
* device instance $99 r0 *1 152.495,36.96 nfet
M$99 \$108 hi_32_n vss vss nfet L=0.35U W=4U AS=4.4P AD=4.4P PS=10.2U PD=10.2U
* device instance $100 r0 *1 155.445,36.96 nfet
M$100 \$110 lo_32_n vss vss nfet L=0.35U W=4U AS=4.4P AD=4.4P PS=10.2U PD=10.2U
* device instance $101 r0 *1 158.36,39.96 nfet
M$101 pinn sel_in \$111 vss nfet L=0.28U W=10U AS=11P AD=11P PS=22.2U PD=22.2U
* device instance $102 r0 *1 161.24,39.96 nfet
M$102 vcm rel_32_n \$111 vss nfet L=0.28U W=10U AS=11P AD=11P PS=22.2U PD=22.2U
* device instance $103 r0 *1 164.12,39.96 nfet
M$103 vref hi_32_n \$111 vss nfet L=0.28U W=10U AS=11P AD=11P PS=22.2U PD=22.2U
* device instance $104 r0 *1 167,39.96 nfet
M$104 vss lo_32_n \$111 vss nfet L=0.28U W=10U AS=11P AD=11P PS=22.2U PD=22.2U
* device instance $105 r0 *1 195.035,36.96 nfet
M$105 \$112 sel_in vss vss nfet L=0.35U W=4U AS=4.4P AD=4.4P PS=10.2U PD=10.2U
* device instance $106 r0 *1 197.985,36.96 nfet
M$106 \$114 rel_16_n vss vss nfet L=0.35U W=4U AS=4.4P AD=4.4P PS=10.2U PD=10.2U
* device instance $107 r0 *1 200.935,36.96 nfet
M$107 \$116 hi_16_n vss vss nfet L=0.35U W=4U AS=4.4P AD=4.4P PS=10.2U PD=10.2U
* device instance $108 r0 *1 203.885,36.96 nfet
M$108 \$118 lo_16_n vss vss nfet L=0.35U W=4U AS=4.4P AD=4.4P PS=10.2U PD=10.2U
* device instance $109 r0 *1 206.8,39.96 nfet
M$109 pinn sel_in \$119 vss nfet L=0.28U W=10U AS=11P AD=11P PS=22.2U PD=22.2U
* device instance $110 r0 *1 209.68,39.96 nfet
M$110 vcm rel_16_n \$119 vss nfet L=0.28U W=10U AS=11P AD=11P PS=22.2U PD=22.2U
* device instance $111 r0 *1 212.56,39.96 nfet
M$111 vref hi_16_n \$119 vss nfet L=0.28U W=10U AS=11P AD=11P PS=22.2U PD=22.2U
* device instance $112 r0 *1 215.44,39.96 nfet
M$112 vss lo_16_n \$119 vss nfet L=0.28U W=10U AS=11P AD=11P PS=22.2U PD=22.2U
* device instance $113 r0 *1 243.475,36.96 nfet
M$113 \$120 sel_in vss vss nfet L=0.35U W=4U AS=4.4P AD=4.4P PS=10.2U PD=10.2U
* device instance $114 r0 *1 246.425,36.96 nfet
M$114 \$122 rel_8_n vss vss nfet L=0.35U W=4U AS=4.4P AD=4.4P PS=10.2U PD=10.2U
* device instance $115 r0 *1 249.375,36.96 nfet
M$115 \$124 hi_8_n vss vss nfet L=0.35U W=4U AS=4.4P AD=4.4P PS=10.2U PD=10.2U
* device instance $116 r0 *1 252.325,36.96 nfet
M$116 \$126 lo_8_n vss vss nfet L=0.35U W=4U AS=4.4P AD=4.4P PS=10.2U PD=10.2U
* device instance $117 r0 *1 255.24,39.96 nfet
M$117 pinn sel_in \$127 vss nfet L=0.28U W=10U AS=11P AD=11P PS=22.2U PD=22.2U
* device instance $118 r0 *1 258.12,39.96 nfet
M$118 vcm rel_8_n \$127 vss nfet L=0.28U W=10U AS=11P AD=11P PS=22.2U PD=22.2U
* device instance $119 r0 *1 261,39.96 nfet
M$119 vref hi_8_n \$127 vss nfet L=0.28U W=10U AS=11P AD=11P PS=22.2U PD=22.2U
* device instance $120 r0 *1 263.88,39.96 nfet
M$120 vss lo_8_n \$127 vss nfet L=0.28U W=10U AS=11P AD=11P PS=22.2U PD=22.2U
* device instance $121 r0 *1 291.915,36.96 nfet
M$121 \$128 sel_in vss vss nfet L=0.35U W=4U AS=4.4P AD=4.4P PS=10.2U PD=10.2U
* device instance $122 r0 *1 294.865,36.96 nfet
M$122 \$130 rel_4_n vss vss nfet L=0.35U W=4U AS=4.4P AD=4.4P PS=10.2U PD=10.2U
* device instance $123 r0 *1 297.815,36.96 nfet
M$123 \$132 hi_4_n vss vss nfet L=0.35U W=4U AS=4.4P AD=4.4P PS=10.2U PD=10.2U
* device instance $124 r0 *1 300.765,36.96 nfet
M$124 \$134 lo_4_n vss vss nfet L=0.35U W=4U AS=4.4P AD=4.4P PS=10.2U PD=10.2U
* device instance $125 r0 *1 303.68,39.96 nfet
M$125 pinn sel_in \$135 vss nfet L=0.28U W=10U AS=11P AD=11P PS=22.2U PD=22.2U
* device instance $126 r0 *1 306.56,39.96 nfet
M$126 vcm rel_4_n \$135 vss nfet L=0.28U W=10U AS=11P AD=11P PS=22.2U PD=22.2U
* device instance $127 r0 *1 309.44,39.96 nfet
M$127 vref hi_4_n \$135 vss nfet L=0.28U W=10U AS=11P AD=11P PS=22.2U PD=22.2U
* device instance $128 r0 *1 312.32,39.96 nfet
M$128 vss lo_4_n \$135 vss nfet L=0.28U W=10U AS=11P AD=11P PS=22.2U PD=22.2U
* device instance $129 r0 *1 340.355,36.96 nfet
M$129 \$136 sel_in vss vss nfet L=0.35U W=4U AS=4.4P AD=4.4P PS=10.2U PD=10.2U
* device instance $130 r0 *1 343.305,36.96 nfet
M$130 \$138 rel_2_n vss vss nfet L=0.35U W=4U AS=4.4P AD=4.4P PS=10.2U PD=10.2U
* device instance $131 r0 *1 346.255,36.96 nfet
M$131 \$140 hi_2_n vss vss nfet L=0.35U W=4U AS=4.4P AD=4.4P PS=10.2U PD=10.2U
* device instance $132 r0 *1 349.205,36.96 nfet
M$132 \$142 lo_2_n vss vss nfet L=0.35U W=4U AS=4.4P AD=4.4P PS=10.2U PD=10.2U
* device instance $133 r0 *1 352.12,39.96 nfet
M$133 pinn sel_in \$143 vss nfet L=0.28U W=10U AS=11P AD=11P PS=22.2U PD=22.2U
* device instance $134 r0 *1 355,39.96 nfet
M$134 vcm rel_2_n \$143 vss nfet L=0.28U W=10U AS=11P AD=11P PS=22.2U PD=22.2U
* device instance $135 r0 *1 357.88,39.96 nfet
M$135 vref hi_2_n \$143 vss nfet L=0.28U W=10U AS=11P AD=11P PS=22.2U PD=22.2U
* device instance $136 r0 *1 360.76,39.96 nfet
M$136 vss lo_2_n \$143 vss nfet L=0.28U W=10U AS=11P AD=11P PS=22.2U PD=22.2U
* device instance $137 r0 *1 388.795,36.96 nfet
M$137 \$144 sel_in vss vss nfet L=0.35U W=4U AS=4.4P AD=4.4P PS=10.2U PD=10.2U
* device instance $138 r0 *1 391.745,36.96 nfet
M$138 \$146 rel_1_n vss vss nfet L=0.35U W=4U AS=4.4P AD=4.4P PS=10.2U PD=10.2U
* device instance $139 r0 *1 394.695,36.96 nfet
M$139 \$148 hi_1_n vss vss nfet L=0.35U W=4U AS=4.4P AD=4.4P PS=10.2U PD=10.2U
* device instance $140 r0 *1 397.645,36.96 nfet
M$140 \$150 lo_1_n vss vss nfet L=0.35U W=4U AS=4.4P AD=4.4P PS=10.2U PD=10.2U
* device instance $141 r0 *1 400.56,39.96 nfet
M$141 pinn sel_in \$151 vss nfet L=0.28U W=10U AS=11P AD=11P PS=22.2U PD=22.2U
* device instance $142 r0 *1 403.44,39.96 nfet
M$142 vcm rel_1_n \$151 vss nfet L=0.28U W=10U AS=11P AD=11P PS=22.2U PD=22.2U
* device instance $143 r0 *1 406.32,39.96 nfet
M$143 vref hi_1_n \$151 vss nfet L=0.28U W=10U AS=11P AD=11P PS=22.2U PD=22.2U
* device instance $144 r0 *1 409.2,39.96 nfet
M$144 vss lo_1_n \$151 vss nfet L=0.28U W=10U AS=11P AD=11P PS=22.2U PD=22.2U
* device instance $145 r0 *1 444.075,71.92 nfet
M$145 \$168 tp_gn vss vss nfet L=0.35U W=4U AS=4.4P AD=4.4P PS=10.2U PD=10.2U
* device instance $146 r0 *1 446.99,74.92 nfet
M$146 vcm tp_gn topp vss nfet L=0.28U W=10U AS=11P AD=11P PS=22.2U PD=22.2U
* device instance $147 r0 *1 457.535,71.92 nfet
M$147 \$169 tp_gn vss vss nfet L=0.35U W=4U AS=4.4P AD=4.4P PS=10.2U PD=10.2U
* device instance $148 r0 *1 460.45,74.92 nfet
M$148 vcm tp_gn topn vss nfet L=0.28U W=10U AS=11P AD=11P PS=22.2U PD=22.2U
* device instance $149 r0 *1 482.83,75.58 nfet
M$149 ibias ibias vss vss nfet L=2U W=20U AS=22P AD=22P PS=42.2U PD=42.2U
* device instance $150 r0 *1 486.93,85.58 nfet
M$150 XCMP_pon topp \$153 vss nfet L=1U W=40U AS=44P AD=44P PS=82.2U PD=82.2U
* device instance $151 r0 *1 490.53,85.58 nfet
M$151 XCMP_pop topn \$153 vss nfet L=1U W=40U AS=44P AD=44P PS=82.2U PD=82.2U
* device instance $152 r0 *1 494.63,75.58 nfet
M$152 \$153 ibias vss vss nfet L=2U W=20U AS=22P AD=22P PS=42.2U PD=42.2U
* device instance $153 r0 *1 499.305,73.58 nfet
M$153 \$156 cmpclk vss vss nfet L=0.35U W=16U AS=17.6P AD=17.6P PS=34.2U
+ PD=34.2U
* device instance $154 r0 *1 502.33,69.58 nfet
M$154 \$157 XCMP_pop \$156 vss nfet L=0.5U W=8U AS=8.8P AD=8.8P PS=18.2U
+ PD=18.2U
* device instance $155 r0 *1 505.43,69.58 nfet
M$155 \$158 XCMP_pon \$156 vss nfet L=0.5U W=8U AS=8.8P AD=8.8P PS=18.2U
+ PD=18.2U
* device instance $156 r0 *1 508.455,68.58 nfet
M$156 \$160 \$159 \$157 vss nfet L=0.35U W=6U AS=6.6P AD=6.6P PS=14.2U PD=14.2U
* device instance $157 r0 *1 511.405,68.58 nfet
M$157 \$159 \$160 \$158 vss nfet L=0.35U W=6U AS=6.6P AD=6.6P PS=14.2U PD=14.2U
* device instance $158 r0 *1 533.855,66.08 nfet
M$158 \$161 \$160 vss vss nfet L=0.35U W=1U AS=1.1P AD=1.1P PS=4.2U PD=4.2U
* device instance $159 r0 *1 541.555,66.08 nfet
M$159 \$162 \$159 vss vss nfet L=0.35U W=1U AS=1.1P AD=1.1P PS=4.2U PD=4.2U
* device instance $160 r0 *1 549.255,67.58 nfet
M$160 dout \$162 vss vss nfet L=0.35U W=4U AS=4.4P AD=4.4P PS=10.2U PD=10.2U
* device instance $161 r0 *1 552.205,67.58 nfet
M$161 dout doutb vss vss nfet L=0.35U W=4U AS=4.4P AD=4.4P PS=10.2U PD=10.2U
* device instance $162 r0 *1 562.855,67.58 nfet
M$162 doutb \$161 vss vss nfet L=0.35U W=4U AS=4.4P AD=4.4P PS=10.2U PD=10.2U
* device instance $163 r0 *1 565.805,67.58 nfet
M$163 doutb dout vss vss nfet L=0.35U W=4U AS=4.4P AD=4.4P PS=10.2U PD=10.2U
* device instance $164 r0 *1 25.495,4 pfet
M$164 \$70 sel_in vdd vdd pfet L=0.35U W=8U AS=8.8P AD=8.8P PS=18.2U PD=18.2U
* device instance $165 r0 *1 28.445,4 pfet
M$165 \$34 rel_256_p vdd vdd pfet L=0.35U W=8U AS=8.8P AD=8.8P PS=18.2U PD=18.2U
* device instance $166 r0 *1 31.395,4 pfet
M$166 \$36 hi_256_p vdd vdd pfet L=0.35U W=8U AS=8.8P AD=8.8P PS=18.2U PD=18.2U
* device instance $167 r0 *1 34.345,4 pfet
M$167 \$16 lo_256_p vdd vdd pfet L=0.35U W=8U AS=8.8P AD=8.8P PS=18.2U PD=18.2U
* device instance $168 r0 *1 37.26,10 pfet
M$168 pinp \$70 \$5 vdd pfet L=0.28U W=20U AS=22P AD=22P PS=42.2U PD=42.2U
* device instance $169 r0 *1 40.14,10 pfet
M$169 vcm \$34 \$5 vdd pfet L=0.28U W=20U AS=22P AD=22P PS=42.2U PD=42.2U
* device instance $170 r0 *1 43.02,10 pfet
M$170 vref \$36 \$5 vdd pfet L=0.28U W=20U AS=22P AD=22P PS=42.2U PD=42.2U
* device instance $171 r0 *1 45.9,10 pfet
M$171 vss \$16 \$5 vdd pfet L=0.28U W=20U AS=22P AD=22P PS=42.2U PD=42.2U
* device instance $172 r0 *1 73.935,4 pfet
M$172 \$71 sel_in vdd vdd pfet L=0.35U W=8U AS=8.8P AD=8.8P PS=18.2U PD=18.2U
* device instance $173 r0 *1 76.885,4 pfet
M$173 \$38 rel_128_p vdd vdd pfet L=0.35U W=8U AS=8.8P AD=8.8P PS=18.2U PD=18.2U
* device instance $174 r0 *1 79.835,4 pfet
M$174 \$40 hi_128_p vdd vdd pfet L=0.35U W=8U AS=8.8P AD=8.8P PS=18.2U PD=18.2U
* device instance $175 r0 *1 82.785,4 pfet
M$175 \$18 lo_128_p vdd vdd pfet L=0.35U W=8U AS=8.8P AD=8.8P PS=18.2U PD=18.2U
* device instance $176 r0 *1 85.7,10 pfet
M$176 pinp \$71 \$7 vdd pfet L=0.28U W=20U AS=22P AD=22P PS=42.2U PD=42.2U
* device instance $177 r0 *1 88.58,10 pfet
M$177 vcm \$38 \$7 vdd pfet L=0.28U W=20U AS=22P AD=22P PS=42.2U PD=42.2U
* device instance $178 r0 *1 91.46,10 pfet
M$178 vref \$40 \$7 vdd pfet L=0.28U W=20U AS=22P AD=22P PS=42.2U PD=42.2U
* device instance $179 r0 *1 94.34,10 pfet
M$179 vss \$18 \$7 vdd pfet L=0.28U W=20U AS=22P AD=22P PS=42.2U PD=42.2U
* device instance $180 r0 *1 122.375,4 pfet
M$180 \$72 sel_in vdd vdd pfet L=0.35U W=8U AS=8.8P AD=8.8P PS=18.2U PD=18.2U
* device instance $181 r0 *1 125.325,4 pfet
M$181 \$42 rel_64_p vdd vdd pfet L=0.35U W=8U AS=8.8P AD=8.8P PS=18.2U PD=18.2U
* device instance $182 r0 *1 128.275,4 pfet
M$182 \$44 hi_64_p vdd vdd pfet L=0.35U W=8U AS=8.8P AD=8.8P PS=18.2U PD=18.2U
* device instance $183 r0 *1 131.225,4 pfet
M$183 \$20 lo_64_p vdd vdd pfet L=0.35U W=8U AS=8.8P AD=8.8P PS=18.2U PD=18.2U
* device instance $184 r0 *1 134.14,10 pfet
M$184 pinp \$72 \$8 vdd pfet L=0.28U W=20U AS=22P AD=22P PS=42.2U PD=42.2U
* device instance $185 r0 *1 137.02,10 pfet
M$185 vcm \$42 \$8 vdd pfet L=0.28U W=20U AS=22P AD=22P PS=42.2U PD=42.2U
* device instance $186 r0 *1 139.9,10 pfet
M$186 vref \$44 \$8 vdd pfet L=0.28U W=20U AS=22P AD=22P PS=42.2U PD=42.2U
* device instance $187 r0 *1 142.78,10 pfet
M$187 vss \$20 \$8 vdd pfet L=0.28U W=20U AS=22P AD=22P PS=42.2U PD=42.2U
* device instance $188 r0 *1 170.815,4 pfet
M$188 \$73 sel_in vdd vdd pfet L=0.35U W=8U AS=8.8P AD=8.8P PS=18.2U PD=18.2U
* device instance $189 r0 *1 173.765,4 pfet
M$189 \$46 rel_32_p vdd vdd pfet L=0.35U W=8U AS=8.8P AD=8.8P PS=18.2U PD=18.2U
* device instance $190 r0 *1 176.715,4 pfet
M$190 \$48 hi_32_p vdd vdd pfet L=0.35U W=8U AS=8.8P AD=8.8P PS=18.2U PD=18.2U
* device instance $191 r0 *1 179.665,4 pfet
M$191 \$22 lo_32_p vdd vdd pfet L=0.35U W=8U AS=8.8P AD=8.8P PS=18.2U PD=18.2U
* device instance $192 r0 *1 182.58,10 pfet
M$192 pinp \$73 \$9 vdd pfet L=0.28U W=20U AS=22P AD=22P PS=42.2U PD=42.2U
* device instance $193 r0 *1 185.46,10 pfet
M$193 vcm \$46 \$9 vdd pfet L=0.28U W=20U AS=22P AD=22P PS=42.2U PD=42.2U
* device instance $194 r0 *1 188.34,10 pfet
M$194 vref \$48 \$9 vdd pfet L=0.28U W=20U AS=22P AD=22P PS=42.2U PD=42.2U
* device instance $195 r0 *1 191.22,10 pfet
M$195 vss \$22 \$9 vdd pfet L=0.28U W=20U AS=22P AD=22P PS=42.2U PD=42.2U
* device instance $196 r0 *1 219.255,4 pfet
M$196 \$74 sel_in vdd vdd pfet L=0.35U W=8U AS=8.8P AD=8.8P PS=18.2U PD=18.2U
* device instance $197 r0 *1 222.205,4 pfet
M$197 \$50 rel_16_p vdd vdd pfet L=0.35U W=8U AS=8.8P AD=8.8P PS=18.2U PD=18.2U
* device instance $198 r0 *1 225.155,4 pfet
M$198 \$52 hi_16_p vdd vdd pfet L=0.35U W=8U AS=8.8P AD=8.8P PS=18.2U PD=18.2U
* device instance $199 r0 *1 228.105,4 pfet
M$199 \$24 lo_16_p vdd vdd pfet L=0.35U W=8U AS=8.8P AD=8.8P PS=18.2U PD=18.2U
* device instance $200 r0 *1 231.02,10 pfet
M$200 pinp \$74 \$10 vdd pfet L=0.28U W=20U AS=22P AD=22P PS=42.2U PD=42.2U
* device instance $201 r0 *1 233.9,10 pfet
M$201 vcm \$50 \$10 vdd pfet L=0.28U W=20U AS=22P AD=22P PS=42.2U PD=42.2U
* device instance $202 r0 *1 236.78,10 pfet
M$202 vref \$52 \$10 vdd pfet L=0.28U W=20U AS=22P AD=22P PS=42.2U PD=42.2U
* device instance $203 r0 *1 239.66,10 pfet
M$203 vss \$24 \$10 vdd pfet L=0.28U W=20U AS=22P AD=22P PS=42.2U PD=42.2U
* device instance $204 r0 *1 267.695,4 pfet
M$204 \$75 sel_in vdd vdd pfet L=0.35U W=8U AS=8.8P AD=8.8P PS=18.2U PD=18.2U
* device instance $205 r0 *1 270.645,4 pfet
M$205 \$54 rel_8_p vdd vdd pfet L=0.35U W=8U AS=8.8P AD=8.8P PS=18.2U PD=18.2U
* device instance $206 r0 *1 273.595,4 pfet
M$206 \$56 hi_8_p vdd vdd pfet L=0.35U W=8U AS=8.8P AD=8.8P PS=18.2U PD=18.2U
* device instance $207 r0 *1 276.545,4 pfet
M$207 \$26 lo_8_p vdd vdd pfet L=0.35U W=8U AS=8.8P AD=8.8P PS=18.2U PD=18.2U
* device instance $208 r0 *1 279.46,10 pfet
M$208 pinp \$75 \$11 vdd pfet L=0.28U W=20U AS=22P AD=22P PS=42.2U PD=42.2U
* device instance $209 r0 *1 282.34,10 pfet
M$209 vcm \$54 \$11 vdd pfet L=0.28U W=20U AS=22P AD=22P PS=42.2U PD=42.2U
* device instance $210 r0 *1 285.22,10 pfet
M$210 vref \$56 \$11 vdd pfet L=0.28U W=20U AS=22P AD=22P PS=42.2U PD=42.2U
* device instance $211 r0 *1 288.1,10 pfet
M$211 vss \$26 \$11 vdd pfet L=0.28U W=20U AS=22P AD=22P PS=42.2U PD=42.2U
* device instance $212 r0 *1 316.135,4 pfet
M$212 \$76 sel_in vdd vdd pfet L=0.35U W=8U AS=8.8P AD=8.8P PS=18.2U PD=18.2U
* device instance $213 r0 *1 319.085,4 pfet
M$213 \$58 rel_4_p vdd vdd pfet L=0.35U W=8U AS=8.8P AD=8.8P PS=18.2U PD=18.2U
* device instance $214 r0 *1 322.035,4 pfet
M$214 \$60 hi_4_p vdd vdd pfet L=0.35U W=8U AS=8.8P AD=8.8P PS=18.2U PD=18.2U
* device instance $215 r0 *1 324.985,4 pfet
M$215 \$28 lo_4_p vdd vdd pfet L=0.35U W=8U AS=8.8P AD=8.8P PS=18.2U PD=18.2U
* device instance $216 r0 *1 327.9,10 pfet
M$216 pinp \$76 \$12 vdd pfet L=0.28U W=20U AS=22P AD=22P PS=42.2U PD=42.2U
* device instance $217 r0 *1 330.78,10 pfet
M$217 vcm \$58 \$12 vdd pfet L=0.28U W=20U AS=22P AD=22P PS=42.2U PD=42.2U
* device instance $218 r0 *1 333.66,10 pfet
M$218 vref \$60 \$12 vdd pfet L=0.28U W=20U AS=22P AD=22P PS=42.2U PD=42.2U
* device instance $219 r0 *1 336.54,10 pfet
M$219 vss \$28 \$12 vdd pfet L=0.28U W=20U AS=22P AD=22P PS=42.2U PD=42.2U
* device instance $220 r0 *1 364.575,4 pfet
M$220 \$77 sel_in vdd vdd pfet L=0.35U W=8U AS=8.8P AD=8.8P PS=18.2U PD=18.2U
* device instance $221 r0 *1 367.525,4 pfet
M$221 \$62 rel_2_p vdd vdd pfet L=0.35U W=8U AS=8.8P AD=8.8P PS=18.2U PD=18.2U
* device instance $222 r0 *1 370.475,4 pfet
M$222 \$64 hi_2_p vdd vdd pfet L=0.35U W=8U AS=8.8P AD=8.8P PS=18.2U PD=18.2U
* device instance $223 r0 *1 373.425,4 pfet
M$223 \$30 lo_2_p vdd vdd pfet L=0.35U W=8U AS=8.8P AD=8.8P PS=18.2U PD=18.2U
* device instance $224 r0 *1 376.34,10 pfet
M$224 pinp \$77 \$13 vdd pfet L=0.28U W=20U AS=22P AD=22P PS=42.2U PD=42.2U
* device instance $225 r0 *1 379.22,10 pfet
M$225 vcm \$62 \$13 vdd pfet L=0.28U W=20U AS=22P AD=22P PS=42.2U PD=42.2U
* device instance $226 r0 *1 382.1,10 pfet
M$226 vref \$64 \$13 vdd pfet L=0.28U W=20U AS=22P AD=22P PS=42.2U PD=42.2U
* device instance $227 r0 *1 384.98,10 pfet
M$227 vss \$30 \$13 vdd pfet L=0.28U W=20U AS=22P AD=22P PS=42.2U PD=42.2U
* device instance $228 r0 *1 413.015,4 pfet
M$228 \$78 sel_in vdd vdd pfet L=0.35U W=8U AS=8.8P AD=8.8P PS=18.2U PD=18.2U
* device instance $229 r0 *1 415.965,4 pfet
M$229 \$66 rel_1_p vdd vdd pfet L=0.35U W=8U AS=8.8P AD=8.8P PS=18.2U PD=18.2U
* device instance $230 r0 *1 418.915,4 pfet
M$230 \$68 hi_1_p vdd vdd pfet L=0.35U W=8U AS=8.8P AD=8.8P PS=18.2U PD=18.2U
* device instance $231 r0 *1 421.865,4 pfet
M$231 \$32 lo_1_p vdd vdd pfet L=0.35U W=8U AS=8.8P AD=8.8P PS=18.2U PD=18.2U
* device instance $232 r0 *1 424.78,10 pfet
M$232 pinp \$78 \$14 vdd pfet L=0.28U W=20U AS=22P AD=22P PS=42.2U PD=42.2U
* device instance $233 r0 *1 427.66,10 pfet
M$233 vcm \$66 \$14 vdd pfet L=0.28U W=20U AS=22P AD=22P PS=42.2U PD=42.2U
* device instance $234 r0 *1 430.54,10 pfet
M$234 vref \$68 \$14 vdd pfet L=0.28U W=20U AS=22P AD=22P PS=42.2U PD=42.2U
* device instance $235 r0 *1 433.42,10 pfet
M$235 vss \$32 \$14 vdd pfet L=0.28U W=20U AS=22P AD=22P PS=42.2U PD=42.2U
* device instance $236 r0 *1 25.495,38.96 pfet
M$236 \$79 sel_in vdd vdd pfet L=0.35U W=8U AS=8.8P AD=8.8P PS=18.2U PD=18.2U
* device instance $237 r0 *1 28.445,38.96 pfet
M$237 \$81 rel_256_n vdd vdd pfet L=0.35U W=8U AS=8.8P AD=8.8P PS=18.2U PD=18.2U
* device instance $238 r0 *1 31.395,38.96 pfet
M$238 \$83 hi_256_n vdd vdd pfet L=0.35U W=8U AS=8.8P AD=8.8P PS=18.2U PD=18.2U
* device instance $239 r0 *1 34.345,38.96 pfet
M$239 \$85 lo_256_n vdd vdd pfet L=0.35U W=8U AS=8.8P AD=8.8P PS=18.2U PD=18.2U
* device instance $240 r0 *1 37.26,44.96 pfet
M$240 pinn \$79 \$86 vdd pfet L=0.28U W=20U AS=22P AD=22P PS=42.2U PD=42.2U
* device instance $241 r0 *1 40.14,44.96 pfet
M$241 vcm \$81 \$86 vdd pfet L=0.28U W=20U AS=22P AD=22P PS=42.2U PD=42.2U
* device instance $242 r0 *1 43.02,44.96 pfet
M$242 vref \$83 \$86 vdd pfet L=0.28U W=20U AS=22P AD=22P PS=42.2U PD=42.2U
* device instance $243 r0 *1 45.9,44.96 pfet
M$243 vss \$85 \$86 vdd pfet L=0.28U W=20U AS=22P AD=22P PS=42.2U PD=42.2U
* device instance $244 r0 *1 73.935,38.96 pfet
M$244 \$88 sel_in vdd vdd pfet L=0.35U W=8U AS=8.8P AD=8.8P PS=18.2U PD=18.2U
* device instance $245 r0 *1 76.885,38.96 pfet
M$245 \$90 rel_128_n vdd vdd pfet L=0.35U W=8U AS=8.8P AD=8.8P PS=18.2U PD=18.2U
* device instance $246 r0 *1 79.835,38.96 pfet
M$246 \$92 hi_128_n vdd vdd pfet L=0.35U W=8U AS=8.8P AD=8.8P PS=18.2U PD=18.2U
* device instance $247 r0 *1 82.785,38.96 pfet
M$247 \$94 lo_128_n vdd vdd pfet L=0.35U W=8U AS=8.8P AD=8.8P PS=18.2U PD=18.2U
* device instance $248 r0 *1 85.7,44.96 pfet
M$248 pinn \$88 \$95 vdd pfet L=0.28U W=20U AS=22P AD=22P PS=42.2U PD=42.2U
* device instance $249 r0 *1 88.58,44.96 pfet
M$249 vcm \$90 \$95 vdd pfet L=0.28U W=20U AS=22P AD=22P PS=42.2U PD=42.2U
* device instance $250 r0 *1 91.46,44.96 pfet
M$250 vref \$92 \$95 vdd pfet L=0.28U W=20U AS=22P AD=22P PS=42.2U PD=42.2U
* device instance $251 r0 *1 94.34,44.96 pfet
M$251 vss \$94 \$95 vdd pfet L=0.28U W=20U AS=22P AD=22P PS=42.2U PD=42.2U
* device instance $252 r0 *1 122.375,38.96 pfet
M$252 \$96 sel_in vdd vdd pfet L=0.35U W=8U AS=8.8P AD=8.8P PS=18.2U PD=18.2U
* device instance $253 r0 *1 125.325,38.96 pfet
M$253 \$98 rel_64_n vdd vdd pfet L=0.35U W=8U AS=8.8P AD=8.8P PS=18.2U PD=18.2U
* device instance $254 r0 *1 128.275,38.96 pfet
M$254 \$100 hi_64_n vdd vdd pfet L=0.35U W=8U AS=8.8P AD=8.8P PS=18.2U PD=18.2U
* device instance $255 r0 *1 131.225,38.96 pfet
M$255 \$102 lo_64_n vdd vdd pfet L=0.35U W=8U AS=8.8P AD=8.8P PS=18.2U PD=18.2U
* device instance $256 r0 *1 134.14,44.96 pfet
M$256 pinn \$96 \$103 vdd pfet L=0.28U W=20U AS=22P AD=22P PS=42.2U PD=42.2U
* device instance $257 r0 *1 137.02,44.96 pfet
M$257 vcm \$98 \$103 vdd pfet L=0.28U W=20U AS=22P AD=22P PS=42.2U PD=42.2U
* device instance $258 r0 *1 139.9,44.96 pfet
M$258 vref \$100 \$103 vdd pfet L=0.28U W=20U AS=22P AD=22P PS=42.2U PD=42.2U
* device instance $259 r0 *1 142.78,44.96 pfet
M$259 vss \$102 \$103 vdd pfet L=0.28U W=20U AS=22P AD=22P PS=42.2U PD=42.2U
* device instance $260 r0 *1 170.815,38.96 pfet
M$260 \$104 sel_in vdd vdd pfet L=0.35U W=8U AS=8.8P AD=8.8P PS=18.2U PD=18.2U
* device instance $261 r0 *1 173.765,38.96 pfet
M$261 \$106 rel_32_n vdd vdd pfet L=0.35U W=8U AS=8.8P AD=8.8P PS=18.2U PD=18.2U
* device instance $262 r0 *1 176.715,38.96 pfet
M$262 \$108 hi_32_n vdd vdd pfet L=0.35U W=8U AS=8.8P AD=8.8P PS=18.2U PD=18.2U
* device instance $263 r0 *1 179.665,38.96 pfet
M$263 \$110 lo_32_n vdd vdd pfet L=0.35U W=8U AS=8.8P AD=8.8P PS=18.2U PD=18.2U
* device instance $264 r0 *1 182.58,44.96 pfet
M$264 pinn \$104 \$111 vdd pfet L=0.28U W=20U AS=22P AD=22P PS=42.2U PD=42.2U
* device instance $265 r0 *1 185.46,44.96 pfet
M$265 vcm \$106 \$111 vdd pfet L=0.28U W=20U AS=22P AD=22P PS=42.2U PD=42.2U
* device instance $266 r0 *1 188.34,44.96 pfet
M$266 vref \$108 \$111 vdd pfet L=0.28U W=20U AS=22P AD=22P PS=42.2U PD=42.2U
* device instance $267 r0 *1 191.22,44.96 pfet
M$267 vss \$110 \$111 vdd pfet L=0.28U W=20U AS=22P AD=22P PS=42.2U PD=42.2U
* device instance $268 r0 *1 219.255,38.96 pfet
M$268 \$112 sel_in vdd vdd pfet L=0.35U W=8U AS=8.8P AD=8.8P PS=18.2U PD=18.2U
* device instance $269 r0 *1 222.205,38.96 pfet
M$269 \$114 rel_16_n vdd vdd pfet L=0.35U W=8U AS=8.8P AD=8.8P PS=18.2U PD=18.2U
* device instance $270 r0 *1 225.155,38.96 pfet
M$270 \$116 hi_16_n vdd vdd pfet L=0.35U W=8U AS=8.8P AD=8.8P PS=18.2U PD=18.2U
* device instance $271 r0 *1 228.105,38.96 pfet
M$271 \$118 lo_16_n vdd vdd pfet L=0.35U W=8U AS=8.8P AD=8.8P PS=18.2U PD=18.2U
* device instance $272 r0 *1 231.02,44.96 pfet
M$272 pinn \$112 \$119 vdd pfet L=0.28U W=20U AS=22P AD=22P PS=42.2U PD=42.2U
* device instance $273 r0 *1 233.9,44.96 pfet
M$273 vcm \$114 \$119 vdd pfet L=0.28U W=20U AS=22P AD=22P PS=42.2U PD=42.2U
* device instance $274 r0 *1 236.78,44.96 pfet
M$274 vref \$116 \$119 vdd pfet L=0.28U W=20U AS=22P AD=22P PS=42.2U PD=42.2U
* device instance $275 r0 *1 239.66,44.96 pfet
M$275 vss \$118 \$119 vdd pfet L=0.28U W=20U AS=22P AD=22P PS=42.2U PD=42.2U
* device instance $276 r0 *1 267.695,38.96 pfet
M$276 \$120 sel_in vdd vdd pfet L=0.35U W=8U AS=8.8P AD=8.8P PS=18.2U PD=18.2U
* device instance $277 r0 *1 270.645,38.96 pfet
M$277 \$122 rel_8_n vdd vdd pfet L=0.35U W=8U AS=8.8P AD=8.8P PS=18.2U PD=18.2U
* device instance $278 r0 *1 273.595,38.96 pfet
M$278 \$124 hi_8_n vdd vdd pfet L=0.35U W=8U AS=8.8P AD=8.8P PS=18.2U PD=18.2U
* device instance $279 r0 *1 276.545,38.96 pfet
M$279 \$126 lo_8_n vdd vdd pfet L=0.35U W=8U AS=8.8P AD=8.8P PS=18.2U PD=18.2U
* device instance $280 r0 *1 279.46,44.96 pfet
M$280 pinn \$120 \$127 vdd pfet L=0.28U W=20U AS=22P AD=22P PS=42.2U PD=42.2U
* device instance $281 r0 *1 282.34,44.96 pfet
M$281 vcm \$122 \$127 vdd pfet L=0.28U W=20U AS=22P AD=22P PS=42.2U PD=42.2U
* device instance $282 r0 *1 285.22,44.96 pfet
M$282 vref \$124 \$127 vdd pfet L=0.28U W=20U AS=22P AD=22P PS=42.2U PD=42.2U
* device instance $283 r0 *1 288.1,44.96 pfet
M$283 vss \$126 \$127 vdd pfet L=0.28U W=20U AS=22P AD=22P PS=42.2U PD=42.2U
* device instance $284 r0 *1 316.135,38.96 pfet
M$284 \$128 sel_in vdd vdd pfet L=0.35U W=8U AS=8.8P AD=8.8P PS=18.2U PD=18.2U
* device instance $285 r0 *1 319.085,38.96 pfet
M$285 \$130 rel_4_n vdd vdd pfet L=0.35U W=8U AS=8.8P AD=8.8P PS=18.2U PD=18.2U
* device instance $286 r0 *1 322.035,38.96 pfet
M$286 \$132 hi_4_n vdd vdd pfet L=0.35U W=8U AS=8.8P AD=8.8P PS=18.2U PD=18.2U
* device instance $287 r0 *1 324.985,38.96 pfet
M$287 \$134 lo_4_n vdd vdd pfet L=0.35U W=8U AS=8.8P AD=8.8P PS=18.2U PD=18.2U
* device instance $288 r0 *1 327.9,44.96 pfet
M$288 pinn \$128 \$135 vdd pfet L=0.28U W=20U AS=22P AD=22P PS=42.2U PD=42.2U
* device instance $289 r0 *1 330.78,44.96 pfet
M$289 vcm \$130 \$135 vdd pfet L=0.28U W=20U AS=22P AD=22P PS=42.2U PD=42.2U
* device instance $290 r0 *1 333.66,44.96 pfet
M$290 vref \$132 \$135 vdd pfet L=0.28U W=20U AS=22P AD=22P PS=42.2U PD=42.2U
* device instance $291 r0 *1 336.54,44.96 pfet
M$291 vss \$134 \$135 vdd pfet L=0.28U W=20U AS=22P AD=22P PS=42.2U PD=42.2U
* device instance $292 r0 *1 364.575,38.96 pfet
M$292 \$136 sel_in vdd vdd pfet L=0.35U W=8U AS=8.8P AD=8.8P PS=18.2U PD=18.2U
* device instance $293 r0 *1 367.525,38.96 pfet
M$293 \$138 rel_2_n vdd vdd pfet L=0.35U W=8U AS=8.8P AD=8.8P PS=18.2U PD=18.2U
* device instance $294 r0 *1 370.475,38.96 pfet
M$294 \$140 hi_2_n vdd vdd pfet L=0.35U W=8U AS=8.8P AD=8.8P PS=18.2U PD=18.2U
* device instance $295 r0 *1 373.425,38.96 pfet
M$295 \$142 lo_2_n vdd vdd pfet L=0.35U W=8U AS=8.8P AD=8.8P PS=18.2U PD=18.2U
* device instance $296 r0 *1 376.34,44.96 pfet
M$296 pinn \$136 \$143 vdd pfet L=0.28U W=20U AS=22P AD=22P PS=42.2U PD=42.2U
* device instance $297 r0 *1 379.22,44.96 pfet
M$297 vcm \$138 \$143 vdd pfet L=0.28U W=20U AS=22P AD=22P PS=42.2U PD=42.2U
* device instance $298 r0 *1 382.1,44.96 pfet
M$298 vref \$140 \$143 vdd pfet L=0.28U W=20U AS=22P AD=22P PS=42.2U PD=42.2U
* device instance $299 r0 *1 384.98,44.96 pfet
M$299 vss \$142 \$143 vdd pfet L=0.28U W=20U AS=22P AD=22P PS=42.2U PD=42.2U
* device instance $300 r0 *1 413.015,38.96 pfet
M$300 \$144 sel_in vdd vdd pfet L=0.35U W=8U AS=8.8P AD=8.8P PS=18.2U PD=18.2U
* device instance $301 r0 *1 415.965,38.96 pfet
M$301 \$146 rel_1_n vdd vdd pfet L=0.35U W=8U AS=8.8P AD=8.8P PS=18.2U PD=18.2U
* device instance $302 r0 *1 418.915,38.96 pfet
M$302 \$148 hi_1_n vdd vdd pfet L=0.35U W=8U AS=8.8P AD=8.8P PS=18.2U PD=18.2U
* device instance $303 r0 *1 421.865,38.96 pfet
M$303 \$150 lo_1_n vdd vdd pfet L=0.35U W=8U AS=8.8P AD=8.8P PS=18.2U PD=18.2U
* device instance $304 r0 *1 424.78,44.96 pfet
M$304 pinn \$144 \$151 vdd pfet L=0.28U W=20U AS=22P AD=22P PS=42.2U PD=42.2U
* device instance $305 r0 *1 427.66,44.96 pfet
M$305 vcm \$146 \$151 vdd pfet L=0.28U W=20U AS=22P AD=22P PS=42.2U PD=42.2U
* device instance $306 r0 *1 430.54,44.96 pfet
M$306 vref \$148 \$151 vdd pfet L=0.28U W=20U AS=22P AD=22P PS=42.2U PD=42.2U
* device instance $307 r0 *1 433.42,44.96 pfet
M$307 vss \$150 \$151 vdd pfet L=0.28U W=20U AS=22P AD=22P PS=42.2U PD=42.2U
* device instance $308 r0 *1 450.805,73.92 pfet
M$308 \$168 tp_gn vdd vdd pfet L=0.35U W=8U AS=8.8P AD=8.8P PS=18.2U PD=18.2U
* device instance $309 r0 *1 453.72,79.92 pfet
M$309 vcm \$168 topp vdd pfet L=0.28U W=20U AS=22P AD=22P PS=42.2U PD=42.2U
* device instance $310 r0 *1 464.265,73.92 pfet
M$310 \$169 tp_gn vdd vdd pfet L=0.35U W=8U AS=8.8P AD=8.8P PS=18.2U PD=18.2U
* device instance $311 r0 *1 467.18,79.92 pfet
M$311 vcm \$169 topn vdd pfet L=0.28U W=20U AS=22P AD=22P PS=42.2U PD=42.2U
* device instance $312 r0 *1 515.255,69.58 pfet
M$312 \$160 \$159 vdd vdd pfet L=0.35U W=8U AS=8.8P AD=8.8P PS=18.2U PD=18.2U
* device instance $313 r0 *1 518.205,69.58 pfet
M$313 \$159 \$160 vdd vdd pfet L=0.35U W=8U AS=8.8P AD=8.8P PS=18.2U PD=18.2U
* device instance $314 r0 *1 521.155,67.58 pfet
M$314 \$160 cmpclk vdd vdd pfet L=0.35U W=4U AS=4.4P AD=4.4P PS=10.2U PD=10.2U
* device instance $315 r0 *1 524.105,67.58 pfet
M$315 \$159 cmpclk vdd vdd pfet L=0.35U W=4U AS=4.4P AD=4.4P PS=10.2U PD=10.2U
* device instance $316 r0 *1 527.055,66.58 pfet
M$316 \$157 cmpclk vdd vdd pfet L=0.35U W=2U AS=2.2P AD=2.2P PS=6.2U PD=6.2U
* device instance $317 r0 *1 530.005,66.58 pfet
M$317 \$158 cmpclk vdd vdd pfet L=0.35U W=2U AS=2.2P AD=2.2P PS=6.2U PD=6.2U
* device instance $318 r0 *1 537.705,66.58 pfet
M$318 \$161 \$160 vdd vdd pfet L=0.35U W=2U AS=2.2P AD=2.2P PS=6.2U PD=6.2U
* device instance $319 r0 *1 545.405,66.58 pfet
M$319 \$162 \$159 vdd vdd pfet L=0.35U W=2U AS=2.2P AD=2.2P PS=6.2U PD=6.2U
* device instance $320 r0 *1 556.055,69.58 pfet
M$320 \$165 \$162 vdd vdd pfet L=0.35U W=8U AS=8.8P AD=8.8P PS=18.2U PD=18.2U
* device instance $321 r0 *1 559.005,69.58 pfet
M$321 dout doutb \$165 vdd pfet L=0.35U W=8U AS=8.8P AD=8.8P PS=18.2U PD=18.2U
* device instance $322 r0 *1 569.655,69.58 pfet
M$322 \$166 \$161 vdd vdd pfet L=0.35U W=8U AS=8.8P AD=8.8P PS=18.2U PD=18.2U
* device instance $323 r0 *1 572.605,69.58 pfet
M$323 doutb dout \$166 vdd pfet L=0.35U W=8U AS=8.8P AD=8.8P PS=18.2U PD=18.2U
* device instance $324 r0 *1 2.6,72.52 cap_mim_2f0_m4m5_noshield
C$324 \$5 topp 3.56528e-14
* device instance $325 r0 *1 9,72.52 cap_mim_2f0_m4m5_noshield
C$325 \$13 topp 3.56528e-14
* device instance $326 r0 *1 15.4,72.52 cap_mim_2f0_m4m5_noshield
C$326 \$5 topp 3.56528e-14
* device instance $327 r0 *1 21.8,72.52 cap_mim_2f0_m4m5_noshield
C$327 \$12 topp 3.56528e-14
* device instance $328 r0 *1 28.2,72.52 cap_mim_2f0_m4m5_noshield
C$328 \$5 topp 3.56528e-14
* device instance $329 r0 *1 34.6,72.52 cap_mim_2f0_m4m5_noshield
C$329 \$11 topp 3.56528e-14
* device instance $330 r0 *1 41,72.52 cap_mim_2f0_m4m5_noshield
C$330 \$5 topp 3.56528e-14
* device instance $331 r0 *1 47.4,72.52 cap_mim_2f0_m4m5_noshield
C$331 \$11 topp 3.56528e-14
* device instance $332 r0 *1 53.8,72.52 cap_mim_2f0_m4m5_noshield
C$332 \$5 topp 3.56528e-14
* device instance $333 r0 *1 60.2,72.52 cap_mim_2f0_m4m5_noshield
C$333 \$10 topp 3.56528e-14
* device instance $334 r0 *1 66.6,72.52 cap_mim_2f0_m4m5_noshield
C$334 \$5 topp 3.56528e-14
* device instance $335 r0 *1 73,72.52 cap_mim_2f0_m4m5_noshield
C$335 \$10 topp 3.56528e-14
* device instance $336 r0 *1 79.4,72.52 cap_mim_2f0_m4m5_noshield
C$336 \$5 topp 3.56528e-14
* device instance $337 r0 *1 85.8,72.52 cap_mim_2f0_m4m5_noshield
C$337 \$10 topp 3.56528e-14
* device instance $338 r0 *1 92.2,72.52 cap_mim_2f0_m4m5_noshield
C$338 \$5 topp 3.56528e-14
* device instance $339 r0 *1 98.6,72.52 cap_mim_2f0_m4m5_noshield
C$339 \$10 topp 3.56528e-14
* device instance $340 r0 *1 105,72.52 cap_mim_2f0_m4m5_noshield
C$340 \$5 topp 3.56528e-14
* device instance $341 r0 *1 111.4,72.52 cap_mim_2f0_m4m5_noshield
C$341 \$9 topp 3.56528e-14
* device instance $342 r0 *1 117.8,72.52 cap_mim_2f0_m4m5_noshield
C$342 \$5 topp 3.56528e-14
* device instance $343 r0 *1 124.2,72.52 cap_mim_2f0_m4m5_noshield
C$343 \$9 topp 3.56528e-14
* device instance $344 r0 *1 130.6,72.52 cap_mim_2f0_m4m5_noshield
C$344 \$5 topp 3.56528e-14
* device instance $345 r0 *1 137,72.52 cap_mim_2f0_m4m5_noshield
C$345 \$9 topp 3.56528e-14
* device instance $346 r0 *1 143.4,72.52 cap_mim_2f0_m4m5_noshield
C$346 \$5 topp 3.56528e-14
* device instance $347 r0 *1 149.8,72.52 cap_mim_2f0_m4m5_noshield
C$347 \$9 topp 3.56528e-14
* device instance $348 r0 *1 156.2,72.52 cap_mim_2f0_m4m5_noshield
C$348 \$5 topp 3.56528e-14
* device instance $349 r0 *1 162.6,72.52 cap_mim_2f0_m4m5_noshield
C$349 \$9 topp 3.56528e-14
* device instance $350 r0 *1 169,72.52 cap_mim_2f0_m4m5_noshield
C$350 \$5 topp 3.56528e-14
* device instance $351 r0 *1 175.4,72.52 cap_mim_2f0_m4m5_noshield
C$351 \$9 topp 3.56528e-14
* device instance $352 r0 *1 181.8,72.52 cap_mim_2f0_m4m5_noshield
C$352 \$5 topp 3.56528e-14
* device instance $353 r0 *1 188.2,72.52 cap_mim_2f0_m4m5_noshield
C$353 \$9 topp 3.56528e-14
* device instance $354 r0 *1 194.6,72.52 cap_mim_2f0_m4m5_noshield
C$354 \$5 topp 3.56528e-14
* device instance $355 r0 *1 201,72.52 cap_mim_2f0_m4m5_noshield
C$355 \$9 topp 3.56528e-14
* device instance $356 r0 *1 224,72.52 cap_mim_2f0_m4m5_noshield
C$356 \$86 topn 3.56528e-14
* device instance $357 r0 *1 230.4,72.52 cap_mim_2f0_m4m5_noshield
C$357 \$143 topn 3.56528e-14
* device instance $358 r0 *1 236.8,72.52 cap_mim_2f0_m4m5_noshield
C$358 \$86 topn 3.56528e-14
* device instance $359 r0 *1 243.2,72.52 cap_mim_2f0_m4m5_noshield
C$359 \$135 topn 3.56528e-14
* device instance $360 r0 *1 249.6,72.52 cap_mim_2f0_m4m5_noshield
C$360 \$86 topn 3.56528e-14
* device instance $361 r0 *1 256,72.52 cap_mim_2f0_m4m5_noshield
C$361 \$127 topn 3.56528e-14
* device instance $362 r0 *1 262.4,72.52 cap_mim_2f0_m4m5_noshield
C$362 \$86 topn 3.56528e-14
* device instance $363 r0 *1 268.8,72.52 cap_mim_2f0_m4m5_noshield
C$363 \$127 topn 3.56528e-14
* device instance $364 r0 *1 275.2,72.52 cap_mim_2f0_m4m5_noshield
C$364 \$86 topn 3.56528e-14
* device instance $365 r0 *1 281.6,72.52 cap_mim_2f0_m4m5_noshield
C$365 \$119 topn 3.56528e-14
* device instance $366 r0 *1 288,72.52 cap_mim_2f0_m4m5_noshield
C$366 \$86 topn 3.56528e-14
* device instance $367 r0 *1 294.4,72.52 cap_mim_2f0_m4m5_noshield
C$367 \$119 topn 3.56528e-14
* device instance $368 r0 *1 300.8,72.52 cap_mim_2f0_m4m5_noshield
C$368 \$86 topn 3.56528e-14
* device instance $369 r0 *1 307.2,72.52 cap_mim_2f0_m4m5_noshield
C$369 \$119 topn 3.56528e-14
* device instance $370 r0 *1 313.6,72.52 cap_mim_2f0_m4m5_noshield
C$370 \$86 topn 3.56528e-14
* device instance $371 r0 *1 320,72.52 cap_mim_2f0_m4m5_noshield
C$371 \$119 topn 3.56528e-14
* device instance $372 r0 *1 326.4,72.52 cap_mim_2f0_m4m5_noshield
C$372 \$86 topn 3.56528e-14
* device instance $373 r0 *1 332.8,72.52 cap_mim_2f0_m4m5_noshield
C$373 \$111 topn 3.56528e-14
* device instance $374 r0 *1 339.2,72.52 cap_mim_2f0_m4m5_noshield
C$374 \$86 topn 3.56528e-14
* device instance $375 r0 *1 345.6,72.52 cap_mim_2f0_m4m5_noshield
C$375 \$111 topn 3.56528e-14
* device instance $376 r0 *1 352,72.52 cap_mim_2f0_m4m5_noshield
C$376 \$86 topn 3.56528e-14
* device instance $377 r0 *1 358.4,72.52 cap_mim_2f0_m4m5_noshield
C$377 \$111 topn 3.56528e-14
* device instance $378 r0 *1 364.8,72.52 cap_mim_2f0_m4m5_noshield
C$378 \$86 topn 3.56528e-14
* device instance $379 r0 *1 371.2,72.52 cap_mim_2f0_m4m5_noshield
C$379 \$111 topn 3.56528e-14
* device instance $380 r0 *1 377.6,72.52 cap_mim_2f0_m4m5_noshield
C$380 \$86 topn 3.56528e-14
* device instance $381 r0 *1 384,72.52 cap_mim_2f0_m4m5_noshield
C$381 \$111 topn 3.56528e-14
* device instance $382 r0 *1 390.4,72.52 cap_mim_2f0_m4m5_noshield
C$382 \$86 topn 3.56528e-14
* device instance $383 r0 *1 396.8,72.52 cap_mim_2f0_m4m5_noshield
C$383 \$111 topn 3.56528e-14
* device instance $384 r0 *1 403.2,72.52 cap_mim_2f0_m4m5_noshield
C$384 \$86 topn 3.56528e-14
* device instance $385 r0 *1 409.6,72.52 cap_mim_2f0_m4m5_noshield
C$385 \$111 topn 3.56528e-14
* device instance $386 r0 *1 416,72.52 cap_mim_2f0_m4m5_noshield
C$386 \$86 topn 3.56528e-14
* device instance $387 r0 *1 422.4,72.52 cap_mim_2f0_m4m5_noshield
C$387 \$111 topn 3.56528e-14
* device instance $388 r0 *1 2.6,78.92 cap_mim_2f0_m4m5_noshield
C$388 \$5 topp 3.56528e-14
* device instance $389 r0 *1 9,78.92 cap_mim_2f0_m4m5_noshield
C$389 \$8 topp 3.56528e-14
* device instance $390 r0 *1 15.4,78.92 cap_mim_2f0_m4m5_noshield
C$390 \$5 topp 3.56528e-14
* device instance $391 r0 *1 21.8,78.92 cap_mim_2f0_m4m5_noshield
C$391 \$8 topp 3.56528e-14
* device instance $392 r0 *1 28.2,78.92 cap_mim_2f0_m4m5_noshield
C$392 \$5 topp 3.56528e-14
* device instance $393 r0 *1 34.6,78.92 cap_mim_2f0_m4m5_noshield
C$393 \$8 topp 3.56528e-14
* device instance $394 r0 *1 41,78.92 cap_mim_2f0_m4m5_noshield
C$394 \$5 topp 3.56528e-14
* device instance $395 r0 *1 47.4,78.92 cap_mim_2f0_m4m5_noshield
C$395 \$8 topp 3.56528e-14
* device instance $396 r0 *1 53.8,78.92 cap_mim_2f0_m4m5_noshield
C$396 \$5 topp 3.56528e-14
* device instance $397 r0 *1 60.2,78.92 cap_mim_2f0_m4m5_noshield
C$397 \$8 topp 3.56528e-14
* device instance $398 r0 *1 66.6,78.92 cap_mim_2f0_m4m5_noshield
C$398 \$5 topp 3.56528e-14
* device instance $399 r0 *1 73,78.92 cap_mim_2f0_m4m5_noshield
C$399 \$8 topp 3.56528e-14
* device instance $400 r0 *1 79.4,78.92 cap_mim_2f0_m4m5_noshield
C$400 \$5 topp 3.56528e-14
* device instance $401 r0 *1 85.8,78.92 cap_mim_2f0_m4m5_noshield
C$401 \$8 topp 3.56528e-14
* device instance $402 r0 *1 92.2,78.92 cap_mim_2f0_m4m5_noshield
C$402 \$5 topp 3.56528e-14
* device instance $403 r0 *1 98.6,78.92 cap_mim_2f0_m4m5_noshield
C$403 \$8 topp 3.56528e-14
* device instance $404 r0 *1 105,78.92 cap_mim_2f0_m4m5_noshield
C$404 \$5 topp 3.56528e-14
* device instance $405 r0 *1 111.4,78.92 cap_mim_2f0_m4m5_noshield
C$405 \$8 topp 3.56528e-14
* device instance $406 r0 *1 117.8,78.92 cap_mim_2f0_m4m5_noshield
C$406 \$5 topp 3.56528e-14
* device instance $407 r0 *1 124.2,78.92 cap_mim_2f0_m4m5_noshield
C$407 \$8 topp 3.56528e-14
* device instance $408 r0 *1 130.6,78.92 cap_mim_2f0_m4m5_noshield
C$408 \$5 topp 3.56528e-14
* device instance $409 r0 *1 137,78.92 cap_mim_2f0_m4m5_noshield
C$409 \$8 topp 3.56528e-14
* device instance $410 r0 *1 143.4,78.92 cap_mim_2f0_m4m5_noshield
C$410 \$5 topp 3.56528e-14
* device instance $411 r0 *1 149.8,78.92 cap_mim_2f0_m4m5_noshield
C$411 \$8 topp 3.56528e-14
* device instance $412 r0 *1 156.2,78.92 cap_mim_2f0_m4m5_noshield
C$412 \$5 topp 3.56528e-14
* device instance $413 r0 *1 162.6,78.92 cap_mim_2f0_m4m5_noshield
C$413 \$8 topp 3.56528e-14
* device instance $414 r0 *1 169,78.92 cap_mim_2f0_m4m5_noshield
C$414 \$5 topp 3.56528e-14
* device instance $415 r0 *1 175.4,78.92 cap_mim_2f0_m4m5_noshield
C$415 \$8 topp 3.56528e-14
* device instance $416 r0 *1 181.8,78.92 cap_mim_2f0_m4m5_noshield
C$416 \$5 topp 3.56528e-14
* device instance $417 r0 *1 188.2,78.92 cap_mim_2f0_m4m5_noshield
C$417 \$8 topp 3.56528e-14
* device instance $418 r0 *1 194.6,78.92 cap_mim_2f0_m4m5_noshield
C$418 \$5 topp 3.56528e-14
* device instance $419 r0 *1 201,78.92 cap_mim_2f0_m4m5_noshield
C$419 \$8 topp 3.56528e-14
* device instance $420 r0 *1 224,78.92 cap_mim_2f0_m4m5_noshield
C$420 \$86 topn 3.56528e-14
* device instance $421 r0 *1 230.4,78.92 cap_mim_2f0_m4m5_noshield
C$421 \$103 topn 3.56528e-14
* device instance $422 r0 *1 236.8,78.92 cap_mim_2f0_m4m5_noshield
C$422 \$86 topn 3.56528e-14
* device instance $423 r0 *1 243.2,78.92 cap_mim_2f0_m4m5_noshield
C$423 \$103 topn 3.56528e-14
* device instance $424 r0 *1 249.6,78.92 cap_mim_2f0_m4m5_noshield
C$424 \$86 topn 3.56528e-14
* device instance $425 r0 *1 256,78.92 cap_mim_2f0_m4m5_noshield
C$425 \$103 topn 3.56528e-14
* device instance $426 r0 *1 262.4,78.92 cap_mim_2f0_m4m5_noshield
C$426 \$86 topn 3.56528e-14
* device instance $427 r0 *1 268.8,78.92 cap_mim_2f0_m4m5_noshield
C$427 \$103 topn 3.56528e-14
* device instance $428 r0 *1 275.2,78.92 cap_mim_2f0_m4m5_noshield
C$428 \$86 topn 3.56528e-14
* device instance $429 r0 *1 281.6,78.92 cap_mim_2f0_m4m5_noshield
C$429 \$103 topn 3.56528e-14
* device instance $430 r0 *1 288,78.92 cap_mim_2f0_m4m5_noshield
C$430 \$86 topn 3.56528e-14
* device instance $431 r0 *1 294.4,78.92 cap_mim_2f0_m4m5_noshield
C$431 \$103 topn 3.56528e-14
* device instance $432 r0 *1 300.8,78.92 cap_mim_2f0_m4m5_noshield
C$432 \$86 topn 3.56528e-14
* device instance $433 r0 *1 307.2,78.92 cap_mim_2f0_m4m5_noshield
C$433 \$103 topn 3.56528e-14
* device instance $434 r0 *1 313.6,78.92 cap_mim_2f0_m4m5_noshield
C$434 \$86 topn 3.56528e-14
* device instance $435 r0 *1 320,78.92 cap_mim_2f0_m4m5_noshield
C$435 \$103 topn 3.56528e-14
* device instance $436 r0 *1 326.4,78.92 cap_mim_2f0_m4m5_noshield
C$436 \$86 topn 3.56528e-14
* device instance $437 r0 *1 332.8,78.92 cap_mim_2f0_m4m5_noshield
C$437 \$103 topn 3.56528e-14
* device instance $438 r0 *1 339.2,78.92 cap_mim_2f0_m4m5_noshield
C$438 \$86 topn 3.56528e-14
* device instance $439 r0 *1 345.6,78.92 cap_mim_2f0_m4m5_noshield
C$439 \$103 topn 3.56528e-14
* device instance $440 r0 *1 352,78.92 cap_mim_2f0_m4m5_noshield
C$440 \$86 topn 3.56528e-14
* device instance $441 r0 *1 358.4,78.92 cap_mim_2f0_m4m5_noshield
C$441 \$103 topn 3.56528e-14
* device instance $442 r0 *1 364.8,78.92 cap_mim_2f0_m4m5_noshield
C$442 \$86 topn 3.56528e-14
* device instance $443 r0 *1 371.2,78.92 cap_mim_2f0_m4m5_noshield
C$443 \$103 topn 3.56528e-14
* device instance $444 r0 *1 377.6,78.92 cap_mim_2f0_m4m5_noshield
C$444 \$86 topn 3.56528e-14
* device instance $445 r0 *1 384,78.92 cap_mim_2f0_m4m5_noshield
C$445 \$103 topn 3.56528e-14
* device instance $446 r0 *1 390.4,78.92 cap_mim_2f0_m4m5_noshield
C$446 \$86 topn 3.56528e-14
* device instance $447 r0 *1 396.8,78.92 cap_mim_2f0_m4m5_noshield
C$447 \$103 topn 3.56528e-14
* device instance $448 r0 *1 403.2,78.92 cap_mim_2f0_m4m5_noshield
C$448 \$86 topn 3.56528e-14
* device instance $449 r0 *1 409.6,78.92 cap_mim_2f0_m4m5_noshield
C$449 \$103 topn 3.56528e-14
* device instance $450 r0 *1 416,78.92 cap_mim_2f0_m4m5_noshield
C$450 \$86 topn 3.56528e-14
* device instance $451 r0 *1 422.4,78.92 cap_mim_2f0_m4m5_noshield
C$451 \$103 topn 3.56528e-14
* device instance $452 r0 *1 2.6,85.32 cap_mim_2f0_m4m5_noshield
C$452 \$5 topp 3.56528e-14
* device instance $453 r0 *1 9,85.32 cap_mim_2f0_m4m5_noshield
C$453 \$7 topp 3.56528e-14
* device instance $454 r0 *1 15.4,85.32 cap_mim_2f0_m4m5_noshield
C$454 \$5 topp 3.56528e-14
* device instance $455 r0 *1 21.8,85.32 cap_mim_2f0_m4m5_noshield
C$455 \$7 topp 3.56528e-14
* device instance $456 r0 *1 28.2,85.32 cap_mim_2f0_m4m5_noshield
C$456 \$5 topp 3.56528e-14
* device instance $457 r0 *1 34.6,85.32 cap_mim_2f0_m4m5_noshield
C$457 \$7 topp 3.56528e-14
* device instance $458 r0 *1 41,85.32 cap_mim_2f0_m4m5_noshield
C$458 \$5 topp 3.56528e-14
* device instance $459 r0 *1 47.4,85.32 cap_mim_2f0_m4m5_noshield
C$459 \$7 topp 3.56528e-14
* device instance $460 r0 *1 53.8,85.32 cap_mim_2f0_m4m5_noshield
C$460 \$5 topp 3.56528e-14
* device instance $461 r0 *1 60.2,85.32 cap_mim_2f0_m4m5_noshield
C$461 \$7 topp 3.56528e-14
* device instance $462 r0 *1 66.6,85.32 cap_mim_2f0_m4m5_noshield
C$462 \$5 topp 3.56528e-14
* device instance $463 r0 *1 73,85.32 cap_mim_2f0_m4m5_noshield
C$463 \$7 topp 3.56528e-14
* device instance $464 r0 *1 79.4,85.32 cap_mim_2f0_m4m5_noshield
C$464 \$5 topp 3.56528e-14
* device instance $465 r0 *1 85.8,85.32 cap_mim_2f0_m4m5_noshield
C$465 \$7 topp 3.56528e-14
* device instance $466 r0 *1 92.2,85.32 cap_mim_2f0_m4m5_noshield
C$466 \$5 topp 3.56528e-14
* device instance $467 r0 *1 98.6,85.32 cap_mim_2f0_m4m5_noshield
C$467 \$7 topp 3.56528e-14
* device instance $468 r0 *1 105,85.32 cap_mim_2f0_m4m5_noshield
C$468 \$5 topp 3.56528e-14
* device instance $469 r0 *1 111.4,85.32 cap_mim_2f0_m4m5_noshield
C$469 \$7 topp 3.56528e-14
* device instance $470 r0 *1 117.8,85.32 cap_mim_2f0_m4m5_noshield
C$470 \$5 topp 3.56528e-14
* device instance $471 r0 *1 124.2,85.32 cap_mim_2f0_m4m5_noshield
C$471 \$7 topp 3.56528e-14
* device instance $472 r0 *1 130.6,85.32 cap_mim_2f0_m4m5_noshield
C$472 \$5 topp 3.56528e-14
* device instance $473 r0 *1 137,85.32 cap_mim_2f0_m4m5_noshield
C$473 \$7 topp 3.56528e-14
* device instance $474 r0 *1 143.4,85.32 cap_mim_2f0_m4m5_noshield
C$474 \$5 topp 3.56528e-14
* device instance $475 r0 *1 149.8,85.32 cap_mim_2f0_m4m5_noshield
C$475 \$7 topp 3.56528e-14
* device instance $476 r0 *1 156.2,85.32 cap_mim_2f0_m4m5_noshield
C$476 \$5 topp 3.56528e-14
* device instance $477 r0 *1 162.6,85.32 cap_mim_2f0_m4m5_noshield
C$477 \$7 topp 3.56528e-14
* device instance $478 r0 *1 169,85.32 cap_mim_2f0_m4m5_noshield
C$478 \$5 topp 3.56528e-14
* device instance $479 r0 *1 175.4,85.32 cap_mim_2f0_m4m5_noshield
C$479 \$7 topp 3.56528e-14
* device instance $480 r0 *1 181.8,85.32 cap_mim_2f0_m4m5_noshield
C$480 \$5 topp 3.56528e-14
* device instance $481 r0 *1 188.2,85.32 cap_mim_2f0_m4m5_noshield
C$481 \$7 topp 3.56528e-14
* device instance $482 r0 *1 194.6,85.32 cap_mim_2f0_m4m5_noshield
C$482 \$5 topp 3.56528e-14
* device instance $483 r0 *1 201,85.32 cap_mim_2f0_m4m5_noshield
C$483 \$7 topp 3.56528e-14
* device instance $484 r0 *1 224,85.32 cap_mim_2f0_m4m5_noshield
C$484 \$86 topn 3.56528e-14
* device instance $485 r0 *1 230.4,85.32 cap_mim_2f0_m4m5_noshield
C$485 \$95 topn 3.56528e-14
* device instance $486 r0 *1 236.8,85.32 cap_mim_2f0_m4m5_noshield
C$486 \$86 topn 3.56528e-14
* device instance $487 r0 *1 243.2,85.32 cap_mim_2f0_m4m5_noshield
C$487 \$95 topn 3.56528e-14
* device instance $488 r0 *1 249.6,85.32 cap_mim_2f0_m4m5_noshield
C$488 \$86 topn 3.56528e-14
* device instance $489 r0 *1 256,85.32 cap_mim_2f0_m4m5_noshield
C$489 \$95 topn 3.56528e-14
* device instance $490 r0 *1 262.4,85.32 cap_mim_2f0_m4m5_noshield
C$490 \$86 topn 3.56528e-14
* device instance $491 r0 *1 268.8,85.32 cap_mim_2f0_m4m5_noshield
C$491 \$95 topn 3.56528e-14
* device instance $492 r0 *1 275.2,85.32 cap_mim_2f0_m4m5_noshield
C$492 \$86 topn 3.56528e-14
* device instance $493 r0 *1 281.6,85.32 cap_mim_2f0_m4m5_noshield
C$493 \$95 topn 3.56528e-14
* device instance $494 r0 *1 288,85.32 cap_mim_2f0_m4m5_noshield
C$494 \$86 topn 3.56528e-14
* device instance $495 r0 *1 294.4,85.32 cap_mim_2f0_m4m5_noshield
C$495 \$95 topn 3.56528e-14
* device instance $496 r0 *1 300.8,85.32 cap_mim_2f0_m4m5_noshield
C$496 \$86 topn 3.56528e-14
* device instance $497 r0 *1 307.2,85.32 cap_mim_2f0_m4m5_noshield
C$497 \$95 topn 3.56528e-14
* device instance $498 r0 *1 313.6,85.32 cap_mim_2f0_m4m5_noshield
C$498 \$86 topn 3.56528e-14
* device instance $499 r0 *1 320,85.32 cap_mim_2f0_m4m5_noshield
C$499 \$95 topn 3.56528e-14
* device instance $500 r0 *1 326.4,85.32 cap_mim_2f0_m4m5_noshield
C$500 \$86 topn 3.56528e-14
* device instance $501 r0 *1 332.8,85.32 cap_mim_2f0_m4m5_noshield
C$501 \$95 topn 3.56528e-14
* device instance $502 r0 *1 339.2,85.32 cap_mim_2f0_m4m5_noshield
C$502 \$86 topn 3.56528e-14
* device instance $503 r0 *1 345.6,85.32 cap_mim_2f0_m4m5_noshield
C$503 \$95 topn 3.56528e-14
* device instance $504 r0 *1 352,85.32 cap_mim_2f0_m4m5_noshield
C$504 \$86 topn 3.56528e-14
* device instance $505 r0 *1 358.4,85.32 cap_mim_2f0_m4m5_noshield
C$505 \$95 topn 3.56528e-14
* device instance $506 r0 *1 364.8,85.32 cap_mim_2f0_m4m5_noshield
C$506 \$86 topn 3.56528e-14
* device instance $507 r0 *1 371.2,85.32 cap_mim_2f0_m4m5_noshield
C$507 \$95 topn 3.56528e-14
* device instance $508 r0 *1 377.6,85.32 cap_mim_2f0_m4m5_noshield
C$508 \$86 topn 3.56528e-14
* device instance $509 r0 *1 384,85.32 cap_mim_2f0_m4m5_noshield
C$509 \$95 topn 3.56528e-14
* device instance $510 r0 *1 390.4,85.32 cap_mim_2f0_m4m5_noshield
C$510 \$86 topn 3.56528e-14
* device instance $511 r0 *1 396.8,85.32 cap_mim_2f0_m4m5_noshield
C$511 \$95 topn 3.56528e-14
* device instance $512 r0 *1 403.2,85.32 cap_mim_2f0_m4m5_noshield
C$512 \$86 topn 3.56528e-14
* device instance $513 r0 *1 409.6,85.32 cap_mim_2f0_m4m5_noshield
C$513 \$95 topn 3.56528e-14
* device instance $514 r0 *1 416,85.32 cap_mim_2f0_m4m5_noshield
C$514 \$86 topn 3.56528e-14
* device instance $515 r0 *1 422.4,85.32 cap_mim_2f0_m4m5_noshield
C$515 \$95 topn 3.56528e-14
* device instance $516 r0 *1 2.6,91.72 cap_mim_2f0_m4m5_noshield
C$516 \$5 topp 3.56528e-14
* device instance $517 r0 *1 9,91.72 cap_mim_2f0_m4m5_noshield
C$517 \$7 topp 3.56528e-14
* device instance $518 r0 *1 15.4,91.72 cap_mim_2f0_m4m5_noshield
C$518 \$5 topp 3.56528e-14
* device instance $519 r0 *1 21.8,91.72 cap_mim_2f0_m4m5_noshield
C$519 \$7 topp 3.56528e-14
* device instance $520 r0 *1 28.2,91.72 cap_mim_2f0_m4m5_noshield
C$520 \$5 topp 3.56528e-14
* device instance $521 r0 *1 34.6,91.72 cap_mim_2f0_m4m5_noshield
C$521 \$7 topp 3.56528e-14
* device instance $522 r0 *1 41,91.72 cap_mim_2f0_m4m5_noshield
C$522 \$5 topp 3.56528e-14
* device instance $523 r0 *1 47.4,91.72 cap_mim_2f0_m4m5_noshield
C$523 \$7 topp 3.56528e-14
* device instance $524 r0 *1 53.8,91.72 cap_mim_2f0_m4m5_noshield
C$524 \$5 topp 3.56528e-14
* device instance $525 r0 *1 60.2,91.72 cap_mim_2f0_m4m5_noshield
C$525 \$7 topp 3.56528e-14
* device instance $526 r0 *1 66.6,91.72 cap_mim_2f0_m4m5_noshield
C$526 \$5 topp 3.56528e-14
* device instance $527 r0 *1 73,91.72 cap_mim_2f0_m4m5_noshield
C$527 \$7 topp 3.56528e-14
* device instance $528 r0 *1 79.4,91.72 cap_mim_2f0_m4m5_noshield
C$528 \$5 topp 3.56528e-14
* device instance $529 r0 *1 85.8,91.72 cap_mim_2f0_m4m5_noshield
C$529 \$7 topp 3.56528e-14
* device instance $530 r0 *1 92.2,91.72 cap_mim_2f0_m4m5_noshield
C$530 \$5 topp 3.56528e-14
* device instance $531 r0 *1 98.6,91.72 cap_mim_2f0_m4m5_noshield
C$531 \$7 topp 3.56528e-14
* device instance $532 r0 *1 105,91.72 cap_mim_2f0_m4m5_noshield
C$532 \$5 topp 3.56528e-14
* device instance $533 r0 *1 111.4,91.72 cap_mim_2f0_m4m5_noshield
C$533 \$7 topp 3.56528e-14
* device instance $534 r0 *1 117.8,91.72 cap_mim_2f0_m4m5_noshield
C$534 \$5 topp 3.56528e-14
* device instance $535 r0 *1 124.2,91.72 cap_mim_2f0_m4m5_noshield
C$535 \$7 topp 3.56528e-14
* device instance $536 r0 *1 130.6,91.72 cap_mim_2f0_m4m5_noshield
C$536 \$5 topp 3.56528e-14
* device instance $537 r0 *1 137,91.72 cap_mim_2f0_m4m5_noshield
C$537 \$7 topp 3.56528e-14
* device instance $538 r0 *1 143.4,91.72 cap_mim_2f0_m4m5_noshield
C$538 \$5 topp 3.56528e-14
* device instance $539 r0 *1 149.8,91.72 cap_mim_2f0_m4m5_noshield
C$539 \$7 topp 3.56528e-14
* device instance $540 r0 *1 156.2,91.72 cap_mim_2f0_m4m5_noshield
C$540 \$5 topp 3.56528e-14
* device instance $541 r0 *1 162.6,91.72 cap_mim_2f0_m4m5_noshield
C$541 \$7 topp 3.56528e-14
* device instance $542 r0 *1 169,91.72 cap_mim_2f0_m4m5_noshield
C$542 \$5 topp 3.56528e-14
* device instance $543 r0 *1 175.4,91.72 cap_mim_2f0_m4m5_noshield
C$543 \$7 topp 3.56528e-14
* device instance $544 r0 *1 181.8,91.72 cap_mim_2f0_m4m5_noshield
C$544 \$5 topp 3.56528e-14
* device instance $545 r0 *1 188.2,91.72 cap_mim_2f0_m4m5_noshield
C$545 \$7 topp 3.56528e-14
* device instance $546 r0 *1 194.6,91.72 cap_mim_2f0_m4m5_noshield
C$546 \$5 topp 3.56528e-14
* device instance $547 r0 *1 201,91.72 cap_mim_2f0_m4m5_noshield
C$547 \$7 topp 3.56528e-14
* device instance $548 r0 *1 224,91.72 cap_mim_2f0_m4m5_noshield
C$548 \$86 topn 3.56528e-14
* device instance $549 r0 *1 230.4,91.72 cap_mim_2f0_m4m5_noshield
C$549 \$95 topn 3.56528e-14
* device instance $550 r0 *1 236.8,91.72 cap_mim_2f0_m4m5_noshield
C$550 \$86 topn 3.56528e-14
* device instance $551 r0 *1 243.2,91.72 cap_mim_2f0_m4m5_noshield
C$551 \$95 topn 3.56528e-14
* device instance $552 r0 *1 249.6,91.72 cap_mim_2f0_m4m5_noshield
C$552 \$86 topn 3.56528e-14
* device instance $553 r0 *1 256,91.72 cap_mim_2f0_m4m5_noshield
C$553 \$95 topn 3.56528e-14
* device instance $554 r0 *1 262.4,91.72 cap_mim_2f0_m4m5_noshield
C$554 \$86 topn 3.56528e-14
* device instance $555 r0 *1 268.8,91.72 cap_mim_2f0_m4m5_noshield
C$555 \$95 topn 3.56528e-14
* device instance $556 r0 *1 275.2,91.72 cap_mim_2f0_m4m5_noshield
C$556 \$86 topn 3.56528e-14
* device instance $557 r0 *1 281.6,91.72 cap_mim_2f0_m4m5_noshield
C$557 \$95 topn 3.56528e-14
* device instance $558 r0 *1 288,91.72 cap_mim_2f0_m4m5_noshield
C$558 \$86 topn 3.56528e-14
* device instance $559 r0 *1 294.4,91.72 cap_mim_2f0_m4m5_noshield
C$559 \$95 topn 3.56528e-14
* device instance $560 r0 *1 300.8,91.72 cap_mim_2f0_m4m5_noshield
C$560 \$86 topn 3.56528e-14
* device instance $561 r0 *1 307.2,91.72 cap_mim_2f0_m4m5_noshield
C$561 \$95 topn 3.56528e-14
* device instance $562 r0 *1 313.6,91.72 cap_mim_2f0_m4m5_noshield
C$562 \$86 topn 3.56528e-14
* device instance $563 r0 *1 320,91.72 cap_mim_2f0_m4m5_noshield
C$563 \$95 topn 3.56528e-14
* device instance $564 r0 *1 326.4,91.72 cap_mim_2f0_m4m5_noshield
C$564 \$86 topn 3.56528e-14
* device instance $565 r0 *1 332.8,91.72 cap_mim_2f0_m4m5_noshield
C$565 \$95 topn 3.56528e-14
* device instance $566 r0 *1 339.2,91.72 cap_mim_2f0_m4m5_noshield
C$566 \$86 topn 3.56528e-14
* device instance $567 r0 *1 345.6,91.72 cap_mim_2f0_m4m5_noshield
C$567 \$95 topn 3.56528e-14
* device instance $568 r0 *1 352,91.72 cap_mim_2f0_m4m5_noshield
C$568 \$86 topn 3.56528e-14
* device instance $569 r0 *1 358.4,91.72 cap_mim_2f0_m4m5_noshield
C$569 \$95 topn 3.56528e-14
* device instance $570 r0 *1 364.8,91.72 cap_mim_2f0_m4m5_noshield
C$570 \$86 topn 3.56528e-14
* device instance $571 r0 *1 371.2,91.72 cap_mim_2f0_m4m5_noshield
C$571 \$95 topn 3.56528e-14
* device instance $572 r0 *1 377.6,91.72 cap_mim_2f0_m4m5_noshield
C$572 \$86 topn 3.56528e-14
* device instance $573 r0 *1 384,91.72 cap_mim_2f0_m4m5_noshield
C$573 \$95 topn 3.56528e-14
* device instance $574 r0 *1 390.4,91.72 cap_mim_2f0_m4m5_noshield
C$574 \$86 topn 3.56528e-14
* device instance $575 r0 *1 396.8,91.72 cap_mim_2f0_m4m5_noshield
C$575 \$95 topn 3.56528e-14
* device instance $576 r0 *1 403.2,91.72 cap_mim_2f0_m4m5_noshield
C$576 \$86 topn 3.56528e-14
* device instance $577 r0 *1 409.6,91.72 cap_mim_2f0_m4m5_noshield
C$577 \$95 topn 3.56528e-14
* device instance $578 r0 *1 416,91.72 cap_mim_2f0_m4m5_noshield
C$578 \$86 topn 3.56528e-14
* device instance $579 r0 *1 422.4,91.72 cap_mim_2f0_m4m5_noshield
C$579 \$95 topn 3.56528e-14
* device instance $580 r0 *1 2.6,98.12 cap_mim_2f0_m4m5_noshield
C$580 \$7 topp 3.56528e-14
* device instance $581 r0 *1 9,98.12 cap_mim_2f0_m4m5_noshield
C$581 \$5 topp 3.56528e-14
* device instance $582 r0 *1 15.4,98.12 cap_mim_2f0_m4m5_noshield
C$582 \$7 topp 3.56528e-14
* device instance $583 r0 *1 21.8,98.12 cap_mim_2f0_m4m5_noshield
C$583 \$5 topp 3.56528e-14
* device instance $584 r0 *1 28.2,98.12 cap_mim_2f0_m4m5_noshield
C$584 \$7 topp 3.56528e-14
* device instance $585 r0 *1 34.6,98.12 cap_mim_2f0_m4m5_noshield
C$585 \$5 topp 3.56528e-14
* device instance $586 r0 *1 41,98.12 cap_mim_2f0_m4m5_noshield
C$586 \$7 topp 3.56528e-14
* device instance $587 r0 *1 47.4,98.12 cap_mim_2f0_m4m5_noshield
C$587 \$5 topp 3.56528e-14
* device instance $588 r0 *1 53.8,98.12 cap_mim_2f0_m4m5_noshield
C$588 \$7 topp 3.56528e-14
* device instance $589 r0 *1 60.2,98.12 cap_mim_2f0_m4m5_noshield
C$589 \$5 topp 3.56528e-14
* device instance $590 r0 *1 66.6,98.12 cap_mim_2f0_m4m5_noshield
C$590 \$7 topp 3.56528e-14
* device instance $591 r0 *1 73,98.12 cap_mim_2f0_m4m5_noshield
C$591 \$5 topp 3.56528e-14
* device instance $592 r0 *1 79.4,98.12 cap_mim_2f0_m4m5_noshield
C$592 \$7 topp 3.56528e-14
* device instance $593 r0 *1 85.8,98.12 cap_mim_2f0_m4m5_noshield
C$593 \$5 topp 3.56528e-14
* device instance $594 r0 *1 92.2,98.12 cap_mim_2f0_m4m5_noshield
C$594 \$7 topp 3.56528e-14
* device instance $595 r0 *1 98.6,98.12 cap_mim_2f0_m4m5_noshield
C$595 \$5 topp 3.56528e-14
* device instance $596 r0 *1 105,98.12 cap_mim_2f0_m4m5_noshield
C$596 \$7 topp 3.56528e-14
* device instance $597 r0 *1 111.4,98.12 cap_mim_2f0_m4m5_noshield
C$597 \$5 topp 3.56528e-14
* device instance $598 r0 *1 117.8,98.12 cap_mim_2f0_m4m5_noshield
C$598 \$7 topp 3.56528e-14
* device instance $599 r0 *1 124.2,98.12 cap_mim_2f0_m4m5_noshield
C$599 \$5 topp 3.56528e-14
* device instance $600 r0 *1 130.6,98.12 cap_mim_2f0_m4m5_noshield
C$600 \$7 topp 3.56528e-14
* device instance $601 r0 *1 137,98.12 cap_mim_2f0_m4m5_noshield
C$601 \$5 topp 3.56528e-14
* device instance $602 r0 *1 143.4,98.12 cap_mim_2f0_m4m5_noshield
C$602 \$7 topp 3.56528e-14
* device instance $603 r0 *1 149.8,98.12 cap_mim_2f0_m4m5_noshield
C$603 \$5 topp 3.56528e-14
* device instance $604 r0 *1 156.2,98.12 cap_mim_2f0_m4m5_noshield
C$604 \$7 topp 3.56528e-14
* device instance $605 r0 *1 162.6,98.12 cap_mim_2f0_m4m5_noshield
C$605 \$5 topp 3.56528e-14
* device instance $606 r0 *1 169,98.12 cap_mim_2f0_m4m5_noshield
C$606 \$7 topp 3.56528e-14
* device instance $607 r0 *1 175.4,98.12 cap_mim_2f0_m4m5_noshield
C$607 \$5 topp 3.56528e-14
* device instance $608 r0 *1 181.8,98.12 cap_mim_2f0_m4m5_noshield
C$608 \$7 topp 3.56528e-14
* device instance $609 r0 *1 188.2,98.12 cap_mim_2f0_m4m5_noshield
C$609 \$5 topp 3.56528e-14
* device instance $610 r0 *1 194.6,98.12 cap_mim_2f0_m4m5_noshield
C$610 \$7 topp 3.56528e-14
* device instance $611 r0 *1 201,98.12 cap_mim_2f0_m4m5_noshield
C$611 \$5 topp 3.56528e-14
* device instance $612 r0 *1 224,98.12 cap_mim_2f0_m4m5_noshield
C$612 \$95 topn 3.56528e-14
* device instance $613 r0 *1 230.4,98.12 cap_mim_2f0_m4m5_noshield
C$613 \$86 topn 3.56528e-14
* device instance $614 r0 *1 236.8,98.12 cap_mim_2f0_m4m5_noshield
C$614 \$95 topn 3.56528e-14
* device instance $615 r0 *1 243.2,98.12 cap_mim_2f0_m4m5_noshield
C$615 \$86 topn 3.56528e-14
* device instance $616 r0 *1 249.6,98.12 cap_mim_2f0_m4m5_noshield
C$616 \$95 topn 3.56528e-14
* device instance $617 r0 *1 256,98.12 cap_mim_2f0_m4m5_noshield
C$617 \$86 topn 3.56528e-14
* device instance $618 r0 *1 262.4,98.12 cap_mim_2f0_m4m5_noshield
C$618 \$95 topn 3.56528e-14
* device instance $619 r0 *1 268.8,98.12 cap_mim_2f0_m4m5_noshield
C$619 \$86 topn 3.56528e-14
* device instance $620 r0 *1 275.2,98.12 cap_mim_2f0_m4m5_noshield
C$620 \$95 topn 3.56528e-14
* device instance $621 r0 *1 281.6,98.12 cap_mim_2f0_m4m5_noshield
C$621 \$86 topn 3.56528e-14
* device instance $622 r0 *1 288,98.12 cap_mim_2f0_m4m5_noshield
C$622 \$95 topn 3.56528e-14
* device instance $623 r0 *1 294.4,98.12 cap_mim_2f0_m4m5_noshield
C$623 \$86 topn 3.56528e-14
* device instance $624 r0 *1 300.8,98.12 cap_mim_2f0_m4m5_noshield
C$624 \$95 topn 3.56528e-14
* device instance $625 r0 *1 307.2,98.12 cap_mim_2f0_m4m5_noshield
C$625 \$86 topn 3.56528e-14
* device instance $626 r0 *1 313.6,98.12 cap_mim_2f0_m4m5_noshield
C$626 \$95 topn 3.56528e-14
* device instance $627 r0 *1 320,98.12 cap_mim_2f0_m4m5_noshield
C$627 \$86 topn 3.56528e-14
* device instance $628 r0 *1 326.4,98.12 cap_mim_2f0_m4m5_noshield
C$628 \$95 topn 3.56528e-14
* device instance $629 r0 *1 332.8,98.12 cap_mim_2f0_m4m5_noshield
C$629 \$86 topn 3.56528e-14
* device instance $630 r0 *1 339.2,98.12 cap_mim_2f0_m4m5_noshield
C$630 \$95 topn 3.56528e-14
* device instance $631 r0 *1 345.6,98.12 cap_mim_2f0_m4m5_noshield
C$631 \$86 topn 3.56528e-14
* device instance $632 r0 *1 352,98.12 cap_mim_2f0_m4m5_noshield
C$632 \$95 topn 3.56528e-14
* device instance $633 r0 *1 358.4,98.12 cap_mim_2f0_m4m5_noshield
C$633 \$86 topn 3.56528e-14
* device instance $634 r0 *1 364.8,98.12 cap_mim_2f0_m4m5_noshield
C$634 \$95 topn 3.56528e-14
* device instance $635 r0 *1 371.2,98.12 cap_mim_2f0_m4m5_noshield
C$635 \$86 topn 3.56528e-14
* device instance $636 r0 *1 377.6,98.12 cap_mim_2f0_m4m5_noshield
C$636 \$95 topn 3.56528e-14
* device instance $637 r0 *1 384,98.12 cap_mim_2f0_m4m5_noshield
C$637 \$86 topn 3.56528e-14
* device instance $638 r0 *1 390.4,98.12 cap_mim_2f0_m4m5_noshield
C$638 \$95 topn 3.56528e-14
* device instance $639 r0 *1 396.8,98.12 cap_mim_2f0_m4m5_noshield
C$639 \$86 topn 3.56528e-14
* device instance $640 r0 *1 403.2,98.12 cap_mim_2f0_m4m5_noshield
C$640 \$95 topn 3.56528e-14
* device instance $641 r0 *1 409.6,98.12 cap_mim_2f0_m4m5_noshield
C$641 \$86 topn 3.56528e-14
* device instance $642 r0 *1 416,98.12 cap_mim_2f0_m4m5_noshield
C$642 \$95 topn 3.56528e-14
* device instance $643 r0 *1 422.4,98.12 cap_mim_2f0_m4m5_noshield
C$643 \$86 topn 3.56528e-14
* device instance $644 r0 *1 2.6,104.52 cap_mim_2f0_m4m5_noshield
C$644 \$7 topp 3.56528e-14
* device instance $645 r0 *1 9,104.52 cap_mim_2f0_m4m5_noshield
C$645 \$5 topp 3.56528e-14
* device instance $646 r0 *1 15.4,104.52 cap_mim_2f0_m4m5_noshield
C$646 \$7 topp 3.56528e-14
* device instance $647 r0 *1 21.8,104.52 cap_mim_2f0_m4m5_noshield
C$647 \$5 topp 3.56528e-14
* device instance $648 r0 *1 28.2,104.52 cap_mim_2f0_m4m5_noshield
C$648 \$7 topp 3.56528e-14
* device instance $649 r0 *1 34.6,104.52 cap_mim_2f0_m4m5_noshield
C$649 \$5 topp 3.56528e-14
* device instance $650 r0 *1 41,104.52 cap_mim_2f0_m4m5_noshield
C$650 \$7 topp 3.56528e-14
* device instance $651 r0 *1 47.4,104.52 cap_mim_2f0_m4m5_noshield
C$651 \$5 topp 3.56528e-14
* device instance $652 r0 *1 53.8,104.52 cap_mim_2f0_m4m5_noshield
C$652 \$7 topp 3.56528e-14
* device instance $653 r0 *1 60.2,104.52 cap_mim_2f0_m4m5_noshield
C$653 \$5 topp 3.56528e-14
* device instance $654 r0 *1 66.6,104.52 cap_mim_2f0_m4m5_noshield
C$654 \$7 topp 3.56528e-14
* device instance $655 r0 *1 73,104.52 cap_mim_2f0_m4m5_noshield
C$655 \$5 topp 3.56528e-14
* device instance $656 r0 *1 79.4,104.52 cap_mim_2f0_m4m5_noshield
C$656 \$7 topp 3.56528e-14
* device instance $657 r0 *1 85.8,104.52 cap_mim_2f0_m4m5_noshield
C$657 \$5 topp 3.56528e-14
* device instance $658 r0 *1 92.2,104.52 cap_mim_2f0_m4m5_noshield
C$658 \$7 topp 3.56528e-14
* device instance $659 r0 *1 98.6,104.52 cap_mim_2f0_m4m5_noshield
C$659 \$5 topp 3.56528e-14
* device instance $660 r0 *1 105,104.52 cap_mim_2f0_m4m5_noshield
C$660 \$7 topp 3.56528e-14
* device instance $661 r0 *1 111.4,104.52 cap_mim_2f0_m4m5_noshield
C$661 \$5 topp 3.56528e-14
* device instance $662 r0 *1 117.8,104.52 cap_mim_2f0_m4m5_noshield
C$662 \$7 topp 3.56528e-14
* device instance $663 r0 *1 124.2,104.52 cap_mim_2f0_m4m5_noshield
C$663 \$5 topp 3.56528e-14
* device instance $664 r0 *1 130.6,104.52 cap_mim_2f0_m4m5_noshield
C$664 \$7 topp 3.56528e-14
* device instance $665 r0 *1 137,104.52 cap_mim_2f0_m4m5_noshield
C$665 \$5 topp 3.56528e-14
* device instance $666 r0 *1 143.4,104.52 cap_mim_2f0_m4m5_noshield
C$666 \$7 topp 3.56528e-14
* device instance $667 r0 *1 149.8,104.52 cap_mim_2f0_m4m5_noshield
C$667 \$5 topp 3.56528e-14
* device instance $668 r0 *1 156.2,104.52 cap_mim_2f0_m4m5_noshield
C$668 \$7 topp 3.56528e-14
* device instance $669 r0 *1 162.6,104.52 cap_mim_2f0_m4m5_noshield
C$669 \$5 topp 3.56528e-14
* device instance $670 r0 *1 169,104.52 cap_mim_2f0_m4m5_noshield
C$670 \$7 topp 3.56528e-14
* device instance $671 r0 *1 175.4,104.52 cap_mim_2f0_m4m5_noshield
C$671 \$5 topp 3.56528e-14
* device instance $672 r0 *1 181.8,104.52 cap_mim_2f0_m4m5_noshield
C$672 \$7 topp 3.56528e-14
* device instance $673 r0 *1 188.2,104.52 cap_mim_2f0_m4m5_noshield
C$673 \$5 topp 3.56528e-14
* device instance $674 r0 *1 194.6,104.52 cap_mim_2f0_m4m5_noshield
C$674 \$7 topp 3.56528e-14
* device instance $675 r0 *1 201,104.52 cap_mim_2f0_m4m5_noshield
C$675 \$5 topp 3.56528e-14
* device instance $676 r0 *1 224,104.52 cap_mim_2f0_m4m5_noshield
C$676 \$95 topn 3.56528e-14
* device instance $677 r0 *1 230.4,104.52 cap_mim_2f0_m4m5_noshield
C$677 \$86 topn 3.56528e-14
* device instance $678 r0 *1 236.8,104.52 cap_mim_2f0_m4m5_noshield
C$678 \$95 topn 3.56528e-14
* device instance $679 r0 *1 243.2,104.52 cap_mim_2f0_m4m5_noshield
C$679 \$86 topn 3.56528e-14
* device instance $680 r0 *1 249.6,104.52 cap_mim_2f0_m4m5_noshield
C$680 \$95 topn 3.56528e-14
* device instance $681 r0 *1 256,104.52 cap_mim_2f0_m4m5_noshield
C$681 \$86 topn 3.56528e-14
* device instance $682 r0 *1 262.4,104.52 cap_mim_2f0_m4m5_noshield
C$682 \$95 topn 3.56528e-14
* device instance $683 r0 *1 268.8,104.52 cap_mim_2f0_m4m5_noshield
C$683 \$86 topn 3.56528e-14
* device instance $684 r0 *1 275.2,104.52 cap_mim_2f0_m4m5_noshield
C$684 \$95 topn 3.56528e-14
* device instance $685 r0 *1 281.6,104.52 cap_mim_2f0_m4m5_noshield
C$685 \$86 topn 3.56528e-14
* device instance $686 r0 *1 288,104.52 cap_mim_2f0_m4m5_noshield
C$686 \$95 topn 3.56528e-14
* device instance $687 r0 *1 294.4,104.52 cap_mim_2f0_m4m5_noshield
C$687 \$86 topn 3.56528e-14
* device instance $688 r0 *1 300.8,104.52 cap_mim_2f0_m4m5_noshield
C$688 \$95 topn 3.56528e-14
* device instance $689 r0 *1 307.2,104.52 cap_mim_2f0_m4m5_noshield
C$689 \$86 topn 3.56528e-14
* device instance $690 r0 *1 313.6,104.52 cap_mim_2f0_m4m5_noshield
C$690 \$95 topn 3.56528e-14
* device instance $691 r0 *1 320,104.52 cap_mim_2f0_m4m5_noshield
C$691 \$86 topn 3.56528e-14
* device instance $692 r0 *1 326.4,104.52 cap_mim_2f0_m4m5_noshield
C$692 \$95 topn 3.56528e-14
* device instance $693 r0 *1 332.8,104.52 cap_mim_2f0_m4m5_noshield
C$693 \$86 topn 3.56528e-14
* device instance $694 r0 *1 339.2,104.52 cap_mim_2f0_m4m5_noshield
C$694 \$95 topn 3.56528e-14
* device instance $695 r0 *1 345.6,104.52 cap_mim_2f0_m4m5_noshield
C$695 \$86 topn 3.56528e-14
* device instance $696 r0 *1 352,104.52 cap_mim_2f0_m4m5_noshield
C$696 \$95 topn 3.56528e-14
* device instance $697 r0 *1 358.4,104.52 cap_mim_2f0_m4m5_noshield
C$697 \$86 topn 3.56528e-14
* device instance $698 r0 *1 364.8,104.52 cap_mim_2f0_m4m5_noshield
C$698 \$95 topn 3.56528e-14
* device instance $699 r0 *1 371.2,104.52 cap_mim_2f0_m4m5_noshield
C$699 \$86 topn 3.56528e-14
* device instance $700 r0 *1 377.6,104.52 cap_mim_2f0_m4m5_noshield
C$700 \$95 topn 3.56528e-14
* device instance $701 r0 *1 384,104.52 cap_mim_2f0_m4m5_noshield
C$701 \$86 topn 3.56528e-14
* device instance $702 r0 *1 390.4,104.52 cap_mim_2f0_m4m5_noshield
C$702 \$95 topn 3.56528e-14
* device instance $703 r0 *1 396.8,104.52 cap_mim_2f0_m4m5_noshield
C$703 \$86 topn 3.56528e-14
* device instance $704 r0 *1 403.2,104.52 cap_mim_2f0_m4m5_noshield
C$704 \$95 topn 3.56528e-14
* device instance $705 r0 *1 409.6,104.52 cap_mim_2f0_m4m5_noshield
C$705 \$86 topn 3.56528e-14
* device instance $706 r0 *1 416,104.52 cap_mim_2f0_m4m5_noshield
C$706 \$95 topn 3.56528e-14
* device instance $707 r0 *1 422.4,104.52 cap_mim_2f0_m4m5_noshield
C$707 \$86 topn 3.56528e-14
* device instance $708 r0 *1 2.6,110.92 cap_mim_2f0_m4m5_noshield
C$708 \$8 topp 3.56528e-14
* device instance $709 r0 *1 9,110.92 cap_mim_2f0_m4m5_noshield
C$709 \$5 topp 3.56528e-14
* device instance $710 r0 *1 15.4,110.92 cap_mim_2f0_m4m5_noshield
C$710 \$8 topp 3.56528e-14
* device instance $711 r0 *1 21.8,110.92 cap_mim_2f0_m4m5_noshield
C$711 \$5 topp 3.56528e-14
* device instance $712 r0 *1 28.2,110.92 cap_mim_2f0_m4m5_noshield
C$712 \$8 topp 3.56528e-14
* device instance $713 r0 *1 34.6,110.92 cap_mim_2f0_m4m5_noshield
C$713 \$5 topp 3.56528e-14
* device instance $714 r0 *1 41,110.92 cap_mim_2f0_m4m5_noshield
C$714 \$8 topp 3.56528e-14
* device instance $715 r0 *1 47.4,110.92 cap_mim_2f0_m4m5_noshield
C$715 \$5 topp 3.56528e-14
* device instance $716 r0 *1 53.8,110.92 cap_mim_2f0_m4m5_noshield
C$716 \$8 topp 3.56528e-14
* device instance $717 r0 *1 60.2,110.92 cap_mim_2f0_m4m5_noshield
C$717 \$5 topp 3.56528e-14
* device instance $718 r0 *1 66.6,110.92 cap_mim_2f0_m4m5_noshield
C$718 \$8 topp 3.56528e-14
* device instance $719 r0 *1 73,110.92 cap_mim_2f0_m4m5_noshield
C$719 \$5 topp 3.56528e-14
* device instance $720 r0 *1 79.4,110.92 cap_mim_2f0_m4m5_noshield
C$720 \$8 topp 3.56528e-14
* device instance $721 r0 *1 85.8,110.92 cap_mim_2f0_m4m5_noshield
C$721 \$5 topp 3.56528e-14
* device instance $722 r0 *1 92.2,110.92 cap_mim_2f0_m4m5_noshield
C$722 \$8 topp 3.56528e-14
* device instance $723 r0 *1 98.6,110.92 cap_mim_2f0_m4m5_noshield
C$723 \$5 topp 3.56528e-14
* device instance $724 r0 *1 105,110.92 cap_mim_2f0_m4m5_noshield
C$724 \$8 topp 3.56528e-14
* device instance $725 r0 *1 111.4,110.92 cap_mim_2f0_m4m5_noshield
C$725 \$5 topp 3.56528e-14
* device instance $726 r0 *1 117.8,110.92 cap_mim_2f0_m4m5_noshield
C$726 \$8 topp 3.56528e-14
* device instance $727 r0 *1 124.2,110.92 cap_mim_2f0_m4m5_noshield
C$727 \$5 topp 3.56528e-14
* device instance $728 r0 *1 130.6,110.92 cap_mim_2f0_m4m5_noshield
C$728 \$8 topp 3.56528e-14
* device instance $729 r0 *1 137,110.92 cap_mim_2f0_m4m5_noshield
C$729 \$5 topp 3.56528e-14
* device instance $730 r0 *1 143.4,110.92 cap_mim_2f0_m4m5_noshield
C$730 \$8 topp 3.56528e-14
* device instance $731 r0 *1 149.8,110.92 cap_mim_2f0_m4m5_noshield
C$731 \$5 topp 3.56528e-14
* device instance $732 r0 *1 156.2,110.92 cap_mim_2f0_m4m5_noshield
C$732 \$8 topp 3.56528e-14
* device instance $733 r0 *1 162.6,110.92 cap_mim_2f0_m4m5_noshield
C$733 \$5 topp 3.56528e-14
* device instance $734 r0 *1 169,110.92 cap_mim_2f0_m4m5_noshield
C$734 \$8 topp 3.56528e-14
* device instance $735 r0 *1 175.4,110.92 cap_mim_2f0_m4m5_noshield
C$735 \$5 topp 3.56528e-14
* device instance $736 r0 *1 181.8,110.92 cap_mim_2f0_m4m5_noshield
C$736 \$8 topp 3.56528e-14
* device instance $737 r0 *1 188.2,110.92 cap_mim_2f0_m4m5_noshield
C$737 \$5 topp 3.56528e-14
* device instance $738 r0 *1 194.6,110.92 cap_mim_2f0_m4m5_noshield
C$738 \$8 topp 3.56528e-14
* device instance $739 r0 *1 201,110.92 cap_mim_2f0_m4m5_noshield
C$739 \$5 topp 3.56528e-14
* device instance $740 r0 *1 224,110.92 cap_mim_2f0_m4m5_noshield
C$740 \$103 topn 3.56528e-14
* device instance $741 r0 *1 230.4,110.92 cap_mim_2f0_m4m5_noshield
C$741 \$86 topn 3.56528e-14
* device instance $742 r0 *1 236.8,110.92 cap_mim_2f0_m4m5_noshield
C$742 \$103 topn 3.56528e-14
* device instance $743 r0 *1 243.2,110.92 cap_mim_2f0_m4m5_noshield
C$743 \$86 topn 3.56528e-14
* device instance $744 r0 *1 249.6,110.92 cap_mim_2f0_m4m5_noshield
C$744 \$103 topn 3.56528e-14
* device instance $745 r0 *1 256,110.92 cap_mim_2f0_m4m5_noshield
C$745 \$86 topn 3.56528e-14
* device instance $746 r0 *1 262.4,110.92 cap_mim_2f0_m4m5_noshield
C$746 \$103 topn 3.56528e-14
* device instance $747 r0 *1 268.8,110.92 cap_mim_2f0_m4m5_noshield
C$747 \$86 topn 3.56528e-14
* device instance $748 r0 *1 275.2,110.92 cap_mim_2f0_m4m5_noshield
C$748 \$103 topn 3.56528e-14
* device instance $749 r0 *1 281.6,110.92 cap_mim_2f0_m4m5_noshield
C$749 \$86 topn 3.56528e-14
* device instance $750 r0 *1 288,110.92 cap_mim_2f0_m4m5_noshield
C$750 \$103 topn 3.56528e-14
* device instance $751 r0 *1 294.4,110.92 cap_mim_2f0_m4m5_noshield
C$751 \$86 topn 3.56528e-14
* device instance $752 r0 *1 300.8,110.92 cap_mim_2f0_m4m5_noshield
C$752 \$103 topn 3.56528e-14
* device instance $753 r0 *1 307.2,110.92 cap_mim_2f0_m4m5_noshield
C$753 \$86 topn 3.56528e-14
* device instance $754 r0 *1 313.6,110.92 cap_mim_2f0_m4m5_noshield
C$754 \$103 topn 3.56528e-14
* device instance $755 r0 *1 320,110.92 cap_mim_2f0_m4m5_noshield
C$755 \$86 topn 3.56528e-14
* device instance $756 r0 *1 326.4,110.92 cap_mim_2f0_m4m5_noshield
C$756 \$103 topn 3.56528e-14
* device instance $757 r0 *1 332.8,110.92 cap_mim_2f0_m4m5_noshield
C$757 \$86 topn 3.56528e-14
* device instance $758 r0 *1 339.2,110.92 cap_mim_2f0_m4m5_noshield
C$758 \$103 topn 3.56528e-14
* device instance $759 r0 *1 345.6,110.92 cap_mim_2f0_m4m5_noshield
C$759 \$86 topn 3.56528e-14
* device instance $760 r0 *1 352,110.92 cap_mim_2f0_m4m5_noshield
C$760 \$103 topn 3.56528e-14
* device instance $761 r0 *1 358.4,110.92 cap_mim_2f0_m4m5_noshield
C$761 \$86 topn 3.56528e-14
* device instance $762 r0 *1 364.8,110.92 cap_mim_2f0_m4m5_noshield
C$762 \$103 topn 3.56528e-14
* device instance $763 r0 *1 371.2,110.92 cap_mim_2f0_m4m5_noshield
C$763 \$86 topn 3.56528e-14
* device instance $764 r0 *1 377.6,110.92 cap_mim_2f0_m4m5_noshield
C$764 \$103 topn 3.56528e-14
* device instance $765 r0 *1 384,110.92 cap_mim_2f0_m4m5_noshield
C$765 \$86 topn 3.56528e-14
* device instance $766 r0 *1 390.4,110.92 cap_mim_2f0_m4m5_noshield
C$766 \$103 topn 3.56528e-14
* device instance $767 r0 *1 396.8,110.92 cap_mim_2f0_m4m5_noshield
C$767 \$86 topn 3.56528e-14
* device instance $768 r0 *1 403.2,110.92 cap_mim_2f0_m4m5_noshield
C$768 \$103 topn 3.56528e-14
* device instance $769 r0 *1 409.6,110.92 cap_mim_2f0_m4m5_noshield
C$769 \$86 topn 3.56528e-14
* device instance $770 r0 *1 416,110.92 cap_mim_2f0_m4m5_noshield
C$770 \$103 topn 3.56528e-14
* device instance $771 r0 *1 422.4,110.92 cap_mim_2f0_m4m5_noshield
C$771 \$86 topn 3.56528e-14
* device instance $772 r0 *1 2.6,117.32 cap_mim_2f0_m4m5_noshield
C$772 \$9 topp 3.56528e-14
* device instance $773 r0 *1 9,117.32 cap_mim_2f0_m4m5_noshield
C$773 \$5 topp 3.56528e-14
* device instance $774 r0 *1 15.4,117.32 cap_mim_2f0_m4m5_noshield
C$774 \$9 topp 3.56528e-14
* device instance $775 r0 *1 21.8,117.32 cap_mim_2f0_m4m5_noshield
C$775 \$5 topp 3.56528e-14
* device instance $776 r0 *1 28.2,117.32 cap_mim_2f0_m4m5_noshield
C$776 \$9 topp 3.56528e-14
* device instance $777 r0 *1 34.6,117.32 cap_mim_2f0_m4m5_noshield
C$777 \$5 topp 3.56528e-14
* device instance $778 r0 *1 41,117.32 cap_mim_2f0_m4m5_noshield
C$778 \$9 topp 3.56528e-14
* device instance $779 r0 *1 47.4,117.32 cap_mim_2f0_m4m5_noshield
C$779 \$5 topp 3.56528e-14
* device instance $780 r0 *1 53.8,117.32 cap_mim_2f0_m4m5_noshield
C$780 \$9 topp 3.56528e-14
* device instance $781 r0 *1 60.2,117.32 cap_mim_2f0_m4m5_noshield
C$781 \$5 topp 3.56528e-14
* device instance $782 r0 *1 66.6,117.32 cap_mim_2f0_m4m5_noshield
C$782 \$9 topp 3.56528e-14
* device instance $783 r0 *1 73,117.32 cap_mim_2f0_m4m5_noshield
C$783 \$5 topp 3.56528e-14
* device instance $784 r0 *1 79.4,117.32 cap_mim_2f0_m4m5_noshield
C$784 \$9 topp 3.56528e-14
* device instance $785 r0 *1 85.8,117.32 cap_mim_2f0_m4m5_noshield
C$785 \$5 topp 3.56528e-14
* device instance $786 r0 *1 92.2,117.32 cap_mim_2f0_m4m5_noshield
C$786 \$9 topp 3.56528e-14
* device instance $787 r0 *1 98.6,117.32 cap_mim_2f0_m4m5_noshield
C$787 \$5 topp 3.56528e-14
* device instance $788 r0 *1 105,117.32 cap_mim_2f0_m4m5_noshield
C$788 \$10 topp 3.56528e-14
* device instance $789 r0 *1 111.4,117.32 cap_mim_2f0_m4m5_noshield
C$789 \$5 topp 3.56528e-14
* device instance $790 r0 *1 117.8,117.32 cap_mim_2f0_m4m5_noshield
C$790 \$10 topp 3.56528e-14
* device instance $791 r0 *1 124.2,117.32 cap_mim_2f0_m4m5_noshield
C$791 \$5 topp 3.56528e-14
* device instance $792 r0 *1 130.6,117.32 cap_mim_2f0_m4m5_noshield
C$792 \$10 topp 3.56528e-14
* device instance $793 r0 *1 137,117.32 cap_mim_2f0_m4m5_noshield
C$793 \$5 topp 3.56528e-14
* device instance $794 r0 *1 143.4,117.32 cap_mim_2f0_m4m5_noshield
C$794 \$10 topp 3.56528e-14
* device instance $795 r0 *1 149.8,117.32 cap_mim_2f0_m4m5_noshield
C$795 \$5 topp 3.56528e-14
* device instance $796 r0 *1 156.2,117.32 cap_mim_2f0_m4m5_noshield
C$796 \$11 topp 3.56528e-14
* device instance $797 r0 *1 162.6,117.32 cap_mim_2f0_m4m5_noshield
C$797 \$5 topp 3.56528e-14
* device instance $798 r0 *1 169,117.32 cap_mim_2f0_m4m5_noshield
C$798 \$11 topp 3.56528e-14
* device instance $799 r0 *1 175.4,117.32 cap_mim_2f0_m4m5_noshield
C$799 \$5 topp 3.56528e-14
* device instance $800 r0 *1 181.8,117.32 cap_mim_2f0_m4m5_noshield
C$800 \$12 topp 3.56528e-14
* device instance $801 r0 *1 188.2,117.32 cap_mim_2f0_m4m5_noshield
C$801 \$5 topp 3.56528e-14
* device instance $802 r0 *1 194.6,117.32 cap_mim_2f0_m4m5_noshield
C$802 \$14 topp 3.56528e-14
* device instance $803 r0 *1 201,117.32 cap_mim_2f0_m4m5_noshield
C$803 \$5 topp 3.56528e-14
* device instance $804 r0 *1 224,117.32 cap_mim_2f0_m4m5_noshield
C$804 \$111 topn 3.56528e-14
* device instance $805 r0 *1 230.4,117.32 cap_mim_2f0_m4m5_noshield
C$805 \$86 topn 3.56528e-14
* device instance $806 r0 *1 236.8,117.32 cap_mim_2f0_m4m5_noshield
C$806 \$111 topn 3.56528e-14
* device instance $807 r0 *1 243.2,117.32 cap_mim_2f0_m4m5_noshield
C$807 \$86 topn 3.56528e-14
* device instance $808 r0 *1 249.6,117.32 cap_mim_2f0_m4m5_noshield
C$808 \$111 topn 3.56528e-14
* device instance $809 r0 *1 256,117.32 cap_mim_2f0_m4m5_noshield
C$809 \$86 topn 3.56528e-14
* device instance $810 r0 *1 262.4,117.32 cap_mim_2f0_m4m5_noshield
C$810 \$111 topn 3.56528e-14
* device instance $811 r0 *1 268.8,117.32 cap_mim_2f0_m4m5_noshield
C$811 \$86 topn 3.56528e-14
* device instance $812 r0 *1 275.2,117.32 cap_mim_2f0_m4m5_noshield
C$812 \$111 topn 3.56528e-14
* device instance $813 r0 *1 281.6,117.32 cap_mim_2f0_m4m5_noshield
C$813 \$86 topn 3.56528e-14
* device instance $814 r0 *1 288,117.32 cap_mim_2f0_m4m5_noshield
C$814 \$111 topn 3.56528e-14
* device instance $815 r0 *1 294.4,117.32 cap_mim_2f0_m4m5_noshield
C$815 \$86 topn 3.56528e-14
* device instance $816 r0 *1 300.8,117.32 cap_mim_2f0_m4m5_noshield
C$816 \$111 topn 3.56528e-14
* device instance $817 r0 *1 307.2,117.32 cap_mim_2f0_m4m5_noshield
C$817 \$86 topn 3.56528e-14
* device instance $818 r0 *1 313.6,117.32 cap_mim_2f0_m4m5_noshield
C$818 \$111 topn 3.56528e-14
* device instance $819 r0 *1 320,117.32 cap_mim_2f0_m4m5_noshield
C$819 \$86 topn 3.56528e-14
* device instance $820 r0 *1 326.4,117.32 cap_mim_2f0_m4m5_noshield
C$820 \$119 topn 3.56528e-14
* device instance $821 r0 *1 332.8,117.32 cap_mim_2f0_m4m5_noshield
C$821 \$86 topn 3.56528e-14
* device instance $822 r0 *1 339.2,117.32 cap_mim_2f0_m4m5_noshield
C$822 \$119 topn 3.56528e-14
* device instance $823 r0 *1 345.6,117.32 cap_mim_2f0_m4m5_noshield
C$823 \$86 topn 3.56528e-14
* device instance $824 r0 *1 352,117.32 cap_mim_2f0_m4m5_noshield
C$824 \$119 topn 3.56528e-14
* device instance $825 r0 *1 358.4,117.32 cap_mim_2f0_m4m5_noshield
C$825 \$86 topn 3.56528e-14
* device instance $826 r0 *1 364.8,117.32 cap_mim_2f0_m4m5_noshield
C$826 \$119 topn 3.56528e-14
* device instance $827 r0 *1 371.2,117.32 cap_mim_2f0_m4m5_noshield
C$827 \$86 topn 3.56528e-14
* device instance $828 r0 *1 377.6,117.32 cap_mim_2f0_m4m5_noshield
C$828 \$127 topn 3.56528e-14
* device instance $829 r0 *1 384,117.32 cap_mim_2f0_m4m5_noshield
C$829 \$86 topn 3.56528e-14
* device instance $830 r0 *1 390.4,117.32 cap_mim_2f0_m4m5_noshield
C$830 \$127 topn 3.56528e-14
* device instance $831 r0 *1 396.8,117.32 cap_mim_2f0_m4m5_noshield
C$831 \$86 topn 3.56528e-14
* device instance $832 r0 *1 403.2,117.32 cap_mim_2f0_m4m5_noshield
C$832 \$135 topn 3.56528e-14
* device instance $833 r0 *1 409.6,117.32 cap_mim_2f0_m4m5_noshield
C$833 \$86 topn 3.56528e-14
* device instance $834 r0 *1 416,117.32 cap_mim_2f0_m4m5_noshield
C$834 \$151 topn 3.56528e-14
* device instance $835 r0 *1 422.4,117.32 cap_mim_2f0_m4m5_noshield
C$835 \$86 topn 3.56528e-14
* device instance $836 r0 *1 2.6,123.72 cap_mim_2f0_m4m5_noshield
C$836 \$5 topp 3.56528e-14
* device instance $837 r0 *1 9,123.72 cap_mim_2f0_m4m5_noshield
C$837 vcm topp 3.56528e-14
* device instance $838 r0 *1 15.4,123.72 cap_mim_2f0_m4m5_noshield
C$838 \$5 topp 3.56528e-14
* device instance $839 r0 *1 21.8,123.72 cap_mim_2f0_m4m5_noshield
C$839 \$12 topp 3.56528e-14
* device instance $840 r0 *1 28.2,123.72 cap_mim_2f0_m4m5_noshield
C$840 \$5 topp 3.56528e-14
* device instance $841 r0 *1 34.6,123.72 cap_mim_2f0_m4m5_noshield
C$841 \$11 topp 3.56528e-14
* device instance $842 r0 *1 41,123.72 cap_mim_2f0_m4m5_noshield
C$842 \$5 topp 3.56528e-14
* device instance $843 r0 *1 47.4,123.72 cap_mim_2f0_m4m5_noshield
C$843 \$11 topp 3.56528e-14
* device instance $844 r0 *1 53.8,123.72 cap_mim_2f0_m4m5_noshield
C$844 \$5 topp 3.56528e-14
* device instance $845 r0 *1 60.2,123.72 cap_mim_2f0_m4m5_noshield
C$845 \$10 topp 3.56528e-14
* device instance $846 r0 *1 66.6,123.72 cap_mim_2f0_m4m5_noshield
C$846 \$5 topp 3.56528e-14
* device instance $847 r0 *1 73,123.72 cap_mim_2f0_m4m5_noshield
C$847 \$10 topp 3.56528e-14
* device instance $848 r0 *1 79.4,123.72 cap_mim_2f0_m4m5_noshield
C$848 \$5 topp 3.56528e-14
* device instance $849 r0 *1 85.8,123.72 cap_mim_2f0_m4m5_noshield
C$849 \$10 topp 3.56528e-14
* device instance $850 r0 *1 92.2,123.72 cap_mim_2f0_m4m5_noshield
C$850 \$5 topp 3.56528e-14
* device instance $851 r0 *1 98.6,123.72 cap_mim_2f0_m4m5_noshield
C$851 \$10 topp 3.56528e-14
* device instance $852 r0 *1 105,123.72 cap_mim_2f0_m4m5_noshield
C$852 \$5 topp 3.56528e-14
* device instance $853 r0 *1 111.4,123.72 cap_mim_2f0_m4m5_noshield
C$853 \$9 topp 3.56528e-14
* device instance $854 r0 *1 117.8,123.72 cap_mim_2f0_m4m5_noshield
C$854 \$5 topp 3.56528e-14
* device instance $855 r0 *1 124.2,123.72 cap_mim_2f0_m4m5_noshield
C$855 \$9 topp 3.56528e-14
* device instance $856 r0 *1 130.6,123.72 cap_mim_2f0_m4m5_noshield
C$856 \$5 topp 3.56528e-14
* device instance $857 r0 *1 137,123.72 cap_mim_2f0_m4m5_noshield
C$857 \$9 topp 3.56528e-14
* device instance $858 r0 *1 143.4,123.72 cap_mim_2f0_m4m5_noshield
C$858 \$5 topp 3.56528e-14
* device instance $859 r0 *1 149.8,123.72 cap_mim_2f0_m4m5_noshield
C$859 \$9 topp 3.56528e-14
* device instance $860 r0 *1 156.2,123.72 cap_mim_2f0_m4m5_noshield
C$860 \$5 topp 3.56528e-14
* device instance $861 r0 *1 162.6,123.72 cap_mim_2f0_m4m5_noshield
C$861 \$9 topp 3.56528e-14
* device instance $862 r0 *1 169,123.72 cap_mim_2f0_m4m5_noshield
C$862 \$5 topp 3.56528e-14
* device instance $863 r0 *1 175.4,123.72 cap_mim_2f0_m4m5_noshield
C$863 \$9 topp 3.56528e-14
* device instance $864 r0 *1 181.8,123.72 cap_mim_2f0_m4m5_noshield
C$864 \$5 topp 3.56528e-14
* device instance $865 r0 *1 188.2,123.72 cap_mim_2f0_m4m5_noshield
C$865 \$9 topp 3.56528e-14
* device instance $866 r0 *1 194.6,123.72 cap_mim_2f0_m4m5_noshield
C$866 \$5 topp 3.56528e-14
* device instance $867 r0 *1 201,123.72 cap_mim_2f0_m4m5_noshield
C$867 \$9 topp 3.56528e-14
* device instance $868 r0 *1 224,123.72 cap_mim_2f0_m4m5_noshield
C$868 \$86 topn 3.56528e-14
* device instance $869 r0 *1 230.4,123.72 cap_mim_2f0_m4m5_noshield
C$869 vcm topn 3.56528e-14
* device instance $870 r0 *1 236.8,123.72 cap_mim_2f0_m4m5_noshield
C$870 \$86 topn 3.56528e-14
* device instance $871 r0 *1 243.2,123.72 cap_mim_2f0_m4m5_noshield
C$871 \$135 topn 3.56528e-14
* device instance $872 r0 *1 249.6,123.72 cap_mim_2f0_m4m5_noshield
C$872 \$86 topn 3.56528e-14
* device instance $873 r0 *1 256,123.72 cap_mim_2f0_m4m5_noshield
C$873 \$127 topn 3.56528e-14
* device instance $874 r0 *1 262.4,123.72 cap_mim_2f0_m4m5_noshield
C$874 \$86 topn 3.56528e-14
* device instance $875 r0 *1 268.8,123.72 cap_mim_2f0_m4m5_noshield
C$875 \$127 topn 3.56528e-14
* device instance $876 r0 *1 275.2,123.72 cap_mim_2f0_m4m5_noshield
C$876 \$86 topn 3.56528e-14
* device instance $877 r0 *1 281.6,123.72 cap_mim_2f0_m4m5_noshield
C$877 \$119 topn 3.56528e-14
* device instance $878 r0 *1 288,123.72 cap_mim_2f0_m4m5_noshield
C$878 \$86 topn 3.56528e-14
* device instance $879 r0 *1 294.4,123.72 cap_mim_2f0_m4m5_noshield
C$879 \$119 topn 3.56528e-14
* device instance $880 r0 *1 300.8,123.72 cap_mim_2f0_m4m5_noshield
C$880 \$86 topn 3.56528e-14
* device instance $881 r0 *1 307.2,123.72 cap_mim_2f0_m4m5_noshield
C$881 \$119 topn 3.56528e-14
* device instance $882 r0 *1 313.6,123.72 cap_mim_2f0_m4m5_noshield
C$882 \$86 topn 3.56528e-14
* device instance $883 r0 *1 320,123.72 cap_mim_2f0_m4m5_noshield
C$883 \$119 topn 3.56528e-14
* device instance $884 r0 *1 326.4,123.72 cap_mim_2f0_m4m5_noshield
C$884 \$86 topn 3.56528e-14
* device instance $885 r0 *1 332.8,123.72 cap_mim_2f0_m4m5_noshield
C$885 \$111 topn 3.56528e-14
* device instance $886 r0 *1 339.2,123.72 cap_mim_2f0_m4m5_noshield
C$886 \$86 topn 3.56528e-14
* device instance $887 r0 *1 345.6,123.72 cap_mim_2f0_m4m5_noshield
C$887 \$111 topn 3.56528e-14
* device instance $888 r0 *1 352,123.72 cap_mim_2f0_m4m5_noshield
C$888 \$86 topn 3.56528e-14
* device instance $889 r0 *1 358.4,123.72 cap_mim_2f0_m4m5_noshield
C$889 \$111 topn 3.56528e-14
* device instance $890 r0 *1 364.8,123.72 cap_mim_2f0_m4m5_noshield
C$890 \$86 topn 3.56528e-14
* device instance $891 r0 *1 371.2,123.72 cap_mim_2f0_m4m5_noshield
C$891 \$111 topn 3.56528e-14
* device instance $892 r0 *1 377.6,123.72 cap_mim_2f0_m4m5_noshield
C$892 \$86 topn 3.56528e-14
* device instance $893 r0 *1 384,123.72 cap_mim_2f0_m4m5_noshield
C$893 \$111 topn 3.56528e-14
* device instance $894 r0 *1 390.4,123.72 cap_mim_2f0_m4m5_noshield
C$894 \$86 topn 3.56528e-14
* device instance $895 r0 *1 396.8,123.72 cap_mim_2f0_m4m5_noshield
C$895 \$111 topn 3.56528e-14
* device instance $896 r0 *1 403.2,123.72 cap_mim_2f0_m4m5_noshield
C$896 \$86 topn 3.56528e-14
* device instance $897 r0 *1 409.6,123.72 cap_mim_2f0_m4m5_noshield
C$897 \$111 topn 3.56528e-14
* device instance $898 r0 *1 416,123.72 cap_mim_2f0_m4m5_noshield
C$898 \$86 topn 3.56528e-14
* device instance $899 r0 *1 422.4,123.72 cap_mim_2f0_m4m5_noshield
C$899 \$111 topn 3.56528e-14
* device instance $900 r0 *1 2.6,130.12 cap_mim_2f0_m4m5_noshield
C$900 \$5 topp 3.56528e-14
* device instance $901 r0 *1 9,130.12 cap_mim_2f0_m4m5_noshield
C$901 \$8 topp 3.56528e-14
* device instance $902 r0 *1 15.4,130.12 cap_mim_2f0_m4m5_noshield
C$902 \$5 topp 3.56528e-14
* device instance $903 r0 *1 21.8,130.12 cap_mim_2f0_m4m5_noshield
C$903 \$8 topp 3.56528e-14
* device instance $904 r0 *1 28.2,130.12 cap_mim_2f0_m4m5_noshield
C$904 \$5 topp 3.56528e-14
* device instance $905 r0 *1 34.6,130.12 cap_mim_2f0_m4m5_noshield
C$905 \$8 topp 3.56528e-14
* device instance $906 r0 *1 41,130.12 cap_mim_2f0_m4m5_noshield
C$906 \$5 topp 3.56528e-14
* device instance $907 r0 *1 47.4,130.12 cap_mim_2f0_m4m5_noshield
C$907 \$8 topp 3.56528e-14
* device instance $908 r0 *1 53.8,130.12 cap_mim_2f0_m4m5_noshield
C$908 \$5 topp 3.56528e-14
* device instance $909 r0 *1 60.2,130.12 cap_mim_2f0_m4m5_noshield
C$909 \$8 topp 3.56528e-14
* device instance $910 r0 *1 66.6,130.12 cap_mim_2f0_m4m5_noshield
C$910 \$5 topp 3.56528e-14
* device instance $911 r0 *1 73,130.12 cap_mim_2f0_m4m5_noshield
C$911 \$8 topp 3.56528e-14
* device instance $912 r0 *1 79.4,130.12 cap_mim_2f0_m4m5_noshield
C$912 \$5 topp 3.56528e-14
* device instance $913 r0 *1 85.8,130.12 cap_mim_2f0_m4m5_noshield
C$913 \$8 topp 3.56528e-14
* device instance $914 r0 *1 92.2,130.12 cap_mim_2f0_m4m5_noshield
C$914 \$5 topp 3.56528e-14
* device instance $915 r0 *1 98.6,130.12 cap_mim_2f0_m4m5_noshield
C$915 \$8 topp 3.56528e-14
* device instance $916 r0 *1 105,130.12 cap_mim_2f0_m4m5_noshield
C$916 \$5 topp 3.56528e-14
* device instance $917 r0 *1 111.4,130.12 cap_mim_2f0_m4m5_noshield
C$917 \$8 topp 3.56528e-14
* device instance $918 r0 *1 117.8,130.12 cap_mim_2f0_m4m5_noshield
C$918 \$5 topp 3.56528e-14
* device instance $919 r0 *1 124.2,130.12 cap_mim_2f0_m4m5_noshield
C$919 \$8 topp 3.56528e-14
* device instance $920 r0 *1 130.6,130.12 cap_mim_2f0_m4m5_noshield
C$920 \$5 topp 3.56528e-14
* device instance $921 r0 *1 137,130.12 cap_mim_2f0_m4m5_noshield
C$921 \$8 topp 3.56528e-14
* device instance $922 r0 *1 143.4,130.12 cap_mim_2f0_m4m5_noshield
C$922 \$5 topp 3.56528e-14
* device instance $923 r0 *1 149.8,130.12 cap_mim_2f0_m4m5_noshield
C$923 \$8 topp 3.56528e-14
* device instance $924 r0 *1 156.2,130.12 cap_mim_2f0_m4m5_noshield
C$924 \$5 topp 3.56528e-14
* device instance $925 r0 *1 162.6,130.12 cap_mim_2f0_m4m5_noshield
C$925 \$8 topp 3.56528e-14
* device instance $926 r0 *1 169,130.12 cap_mim_2f0_m4m5_noshield
C$926 \$5 topp 3.56528e-14
* device instance $927 r0 *1 175.4,130.12 cap_mim_2f0_m4m5_noshield
C$927 \$8 topp 3.56528e-14
* device instance $928 r0 *1 181.8,130.12 cap_mim_2f0_m4m5_noshield
C$928 \$5 topp 3.56528e-14
* device instance $929 r0 *1 188.2,130.12 cap_mim_2f0_m4m5_noshield
C$929 \$8 topp 3.56528e-14
* device instance $930 r0 *1 194.6,130.12 cap_mim_2f0_m4m5_noshield
C$930 \$5 topp 3.56528e-14
* device instance $931 r0 *1 201,130.12 cap_mim_2f0_m4m5_noshield
C$931 \$8 topp 3.56528e-14
* device instance $932 r0 *1 224,130.12 cap_mim_2f0_m4m5_noshield
C$932 \$86 topn 3.56528e-14
* device instance $933 r0 *1 230.4,130.12 cap_mim_2f0_m4m5_noshield
C$933 \$103 topn 3.56528e-14
* device instance $934 r0 *1 236.8,130.12 cap_mim_2f0_m4m5_noshield
C$934 \$86 topn 3.56528e-14
* device instance $935 r0 *1 243.2,130.12 cap_mim_2f0_m4m5_noshield
C$935 \$103 topn 3.56528e-14
* device instance $936 r0 *1 249.6,130.12 cap_mim_2f0_m4m5_noshield
C$936 \$86 topn 3.56528e-14
* device instance $937 r0 *1 256,130.12 cap_mim_2f0_m4m5_noshield
C$937 \$103 topn 3.56528e-14
* device instance $938 r0 *1 262.4,130.12 cap_mim_2f0_m4m5_noshield
C$938 \$86 topn 3.56528e-14
* device instance $939 r0 *1 268.8,130.12 cap_mim_2f0_m4m5_noshield
C$939 \$103 topn 3.56528e-14
* device instance $940 r0 *1 275.2,130.12 cap_mim_2f0_m4m5_noshield
C$940 \$86 topn 3.56528e-14
* device instance $941 r0 *1 281.6,130.12 cap_mim_2f0_m4m5_noshield
C$941 \$103 topn 3.56528e-14
* device instance $942 r0 *1 288,130.12 cap_mim_2f0_m4m5_noshield
C$942 \$86 topn 3.56528e-14
* device instance $943 r0 *1 294.4,130.12 cap_mim_2f0_m4m5_noshield
C$943 \$103 topn 3.56528e-14
* device instance $944 r0 *1 300.8,130.12 cap_mim_2f0_m4m5_noshield
C$944 \$86 topn 3.56528e-14
* device instance $945 r0 *1 307.2,130.12 cap_mim_2f0_m4m5_noshield
C$945 \$103 topn 3.56528e-14
* device instance $946 r0 *1 313.6,130.12 cap_mim_2f0_m4m5_noshield
C$946 \$86 topn 3.56528e-14
* device instance $947 r0 *1 320,130.12 cap_mim_2f0_m4m5_noshield
C$947 \$103 topn 3.56528e-14
* device instance $948 r0 *1 326.4,130.12 cap_mim_2f0_m4m5_noshield
C$948 \$86 topn 3.56528e-14
* device instance $949 r0 *1 332.8,130.12 cap_mim_2f0_m4m5_noshield
C$949 \$103 topn 3.56528e-14
* device instance $950 r0 *1 339.2,130.12 cap_mim_2f0_m4m5_noshield
C$950 \$86 topn 3.56528e-14
* device instance $951 r0 *1 345.6,130.12 cap_mim_2f0_m4m5_noshield
C$951 \$103 topn 3.56528e-14
* device instance $952 r0 *1 352,130.12 cap_mim_2f0_m4m5_noshield
C$952 \$86 topn 3.56528e-14
* device instance $953 r0 *1 358.4,130.12 cap_mim_2f0_m4m5_noshield
C$953 \$103 topn 3.56528e-14
* device instance $954 r0 *1 364.8,130.12 cap_mim_2f0_m4m5_noshield
C$954 \$86 topn 3.56528e-14
* device instance $955 r0 *1 371.2,130.12 cap_mim_2f0_m4m5_noshield
C$955 \$103 topn 3.56528e-14
* device instance $956 r0 *1 377.6,130.12 cap_mim_2f0_m4m5_noshield
C$956 \$86 topn 3.56528e-14
* device instance $957 r0 *1 384,130.12 cap_mim_2f0_m4m5_noshield
C$957 \$103 topn 3.56528e-14
* device instance $958 r0 *1 390.4,130.12 cap_mim_2f0_m4m5_noshield
C$958 \$86 topn 3.56528e-14
* device instance $959 r0 *1 396.8,130.12 cap_mim_2f0_m4m5_noshield
C$959 \$103 topn 3.56528e-14
* device instance $960 r0 *1 403.2,130.12 cap_mim_2f0_m4m5_noshield
C$960 \$86 topn 3.56528e-14
* device instance $961 r0 *1 409.6,130.12 cap_mim_2f0_m4m5_noshield
C$961 \$103 topn 3.56528e-14
* device instance $962 r0 *1 416,130.12 cap_mim_2f0_m4m5_noshield
C$962 \$86 topn 3.56528e-14
* device instance $963 r0 *1 422.4,130.12 cap_mim_2f0_m4m5_noshield
C$963 \$103 topn 3.56528e-14
* device instance $964 r0 *1 2.6,136.52 cap_mim_2f0_m4m5_noshield
C$964 \$5 topp 3.56528e-14
* device instance $965 r0 *1 9,136.52 cap_mim_2f0_m4m5_noshield
C$965 \$7 topp 3.56528e-14
* device instance $966 r0 *1 15.4,136.52 cap_mim_2f0_m4m5_noshield
C$966 \$5 topp 3.56528e-14
* device instance $967 r0 *1 21.8,136.52 cap_mim_2f0_m4m5_noshield
C$967 \$7 topp 3.56528e-14
* device instance $968 r0 *1 28.2,136.52 cap_mim_2f0_m4m5_noshield
C$968 \$5 topp 3.56528e-14
* device instance $969 r0 *1 34.6,136.52 cap_mim_2f0_m4m5_noshield
C$969 \$7 topp 3.56528e-14
* device instance $970 r0 *1 41,136.52 cap_mim_2f0_m4m5_noshield
C$970 \$5 topp 3.56528e-14
* device instance $971 r0 *1 47.4,136.52 cap_mim_2f0_m4m5_noshield
C$971 \$7 topp 3.56528e-14
* device instance $972 r0 *1 53.8,136.52 cap_mim_2f0_m4m5_noshield
C$972 \$5 topp 3.56528e-14
* device instance $973 r0 *1 60.2,136.52 cap_mim_2f0_m4m5_noshield
C$973 \$7 topp 3.56528e-14
* device instance $974 r0 *1 66.6,136.52 cap_mim_2f0_m4m5_noshield
C$974 \$5 topp 3.56528e-14
* device instance $975 r0 *1 73,136.52 cap_mim_2f0_m4m5_noshield
C$975 \$7 topp 3.56528e-14
* device instance $976 r0 *1 79.4,136.52 cap_mim_2f0_m4m5_noshield
C$976 \$5 topp 3.56528e-14
* device instance $977 r0 *1 85.8,136.52 cap_mim_2f0_m4m5_noshield
C$977 \$7 topp 3.56528e-14
* device instance $978 r0 *1 92.2,136.52 cap_mim_2f0_m4m5_noshield
C$978 \$5 topp 3.56528e-14
* device instance $979 r0 *1 98.6,136.52 cap_mim_2f0_m4m5_noshield
C$979 \$7 topp 3.56528e-14
* device instance $980 r0 *1 105,136.52 cap_mim_2f0_m4m5_noshield
C$980 \$5 topp 3.56528e-14
* device instance $981 r0 *1 111.4,136.52 cap_mim_2f0_m4m5_noshield
C$981 \$7 topp 3.56528e-14
* device instance $982 r0 *1 117.8,136.52 cap_mim_2f0_m4m5_noshield
C$982 \$5 topp 3.56528e-14
* device instance $983 r0 *1 124.2,136.52 cap_mim_2f0_m4m5_noshield
C$983 \$7 topp 3.56528e-14
* device instance $984 r0 *1 130.6,136.52 cap_mim_2f0_m4m5_noshield
C$984 \$5 topp 3.56528e-14
* device instance $985 r0 *1 137,136.52 cap_mim_2f0_m4m5_noshield
C$985 \$7 topp 3.56528e-14
* device instance $986 r0 *1 143.4,136.52 cap_mim_2f0_m4m5_noshield
C$986 \$5 topp 3.56528e-14
* device instance $987 r0 *1 149.8,136.52 cap_mim_2f0_m4m5_noshield
C$987 \$7 topp 3.56528e-14
* device instance $988 r0 *1 156.2,136.52 cap_mim_2f0_m4m5_noshield
C$988 \$5 topp 3.56528e-14
* device instance $989 r0 *1 162.6,136.52 cap_mim_2f0_m4m5_noshield
C$989 \$7 topp 3.56528e-14
* device instance $990 r0 *1 169,136.52 cap_mim_2f0_m4m5_noshield
C$990 \$5 topp 3.56528e-14
* device instance $991 r0 *1 175.4,136.52 cap_mim_2f0_m4m5_noshield
C$991 \$7 topp 3.56528e-14
* device instance $992 r0 *1 181.8,136.52 cap_mim_2f0_m4m5_noshield
C$992 \$5 topp 3.56528e-14
* device instance $993 r0 *1 188.2,136.52 cap_mim_2f0_m4m5_noshield
C$993 \$7 topp 3.56528e-14
* device instance $994 r0 *1 194.6,136.52 cap_mim_2f0_m4m5_noshield
C$994 \$5 topp 3.56528e-14
* device instance $995 r0 *1 201,136.52 cap_mim_2f0_m4m5_noshield
C$995 \$7 topp 3.56528e-14
* device instance $996 r0 *1 224,136.52 cap_mim_2f0_m4m5_noshield
C$996 \$86 topn 3.56528e-14
* device instance $997 r0 *1 230.4,136.52 cap_mim_2f0_m4m5_noshield
C$997 \$95 topn 3.56528e-14
* device instance $998 r0 *1 236.8,136.52 cap_mim_2f0_m4m5_noshield
C$998 \$86 topn 3.56528e-14
* device instance $999 r0 *1 243.2,136.52 cap_mim_2f0_m4m5_noshield
C$999 \$95 topn 3.56528e-14
* device instance $1000 r0 *1 249.6,136.52 cap_mim_2f0_m4m5_noshield
C$1000 \$86 topn 3.56528e-14
* device instance $1001 r0 *1 256,136.52 cap_mim_2f0_m4m5_noshield
C$1001 \$95 topn 3.56528e-14
* device instance $1002 r0 *1 262.4,136.52 cap_mim_2f0_m4m5_noshield
C$1002 \$86 topn 3.56528e-14
* device instance $1003 r0 *1 268.8,136.52 cap_mim_2f0_m4m5_noshield
C$1003 \$95 topn 3.56528e-14
* device instance $1004 r0 *1 275.2,136.52 cap_mim_2f0_m4m5_noshield
C$1004 \$86 topn 3.56528e-14
* device instance $1005 r0 *1 281.6,136.52 cap_mim_2f0_m4m5_noshield
C$1005 \$95 topn 3.56528e-14
* device instance $1006 r0 *1 288,136.52 cap_mim_2f0_m4m5_noshield
C$1006 \$86 topn 3.56528e-14
* device instance $1007 r0 *1 294.4,136.52 cap_mim_2f0_m4m5_noshield
C$1007 \$95 topn 3.56528e-14
* device instance $1008 r0 *1 300.8,136.52 cap_mim_2f0_m4m5_noshield
C$1008 \$86 topn 3.56528e-14
* device instance $1009 r0 *1 307.2,136.52 cap_mim_2f0_m4m5_noshield
C$1009 \$95 topn 3.56528e-14
* device instance $1010 r0 *1 313.6,136.52 cap_mim_2f0_m4m5_noshield
C$1010 \$86 topn 3.56528e-14
* device instance $1011 r0 *1 320,136.52 cap_mim_2f0_m4m5_noshield
C$1011 \$95 topn 3.56528e-14
* device instance $1012 r0 *1 326.4,136.52 cap_mim_2f0_m4m5_noshield
C$1012 \$86 topn 3.56528e-14
* device instance $1013 r0 *1 332.8,136.52 cap_mim_2f0_m4m5_noshield
C$1013 \$95 topn 3.56528e-14
* device instance $1014 r0 *1 339.2,136.52 cap_mim_2f0_m4m5_noshield
C$1014 \$86 topn 3.56528e-14
* device instance $1015 r0 *1 345.6,136.52 cap_mim_2f0_m4m5_noshield
C$1015 \$95 topn 3.56528e-14
* device instance $1016 r0 *1 352,136.52 cap_mim_2f0_m4m5_noshield
C$1016 \$86 topn 3.56528e-14
* device instance $1017 r0 *1 358.4,136.52 cap_mim_2f0_m4m5_noshield
C$1017 \$95 topn 3.56528e-14
* device instance $1018 r0 *1 364.8,136.52 cap_mim_2f0_m4m5_noshield
C$1018 \$86 topn 3.56528e-14
* device instance $1019 r0 *1 371.2,136.52 cap_mim_2f0_m4m5_noshield
C$1019 \$95 topn 3.56528e-14
* device instance $1020 r0 *1 377.6,136.52 cap_mim_2f0_m4m5_noshield
C$1020 \$86 topn 3.56528e-14
* device instance $1021 r0 *1 384,136.52 cap_mim_2f0_m4m5_noshield
C$1021 \$95 topn 3.56528e-14
* device instance $1022 r0 *1 390.4,136.52 cap_mim_2f0_m4m5_noshield
C$1022 \$86 topn 3.56528e-14
* device instance $1023 r0 *1 396.8,136.52 cap_mim_2f0_m4m5_noshield
C$1023 \$95 topn 3.56528e-14
* device instance $1024 r0 *1 403.2,136.52 cap_mim_2f0_m4m5_noshield
C$1024 \$86 topn 3.56528e-14
* device instance $1025 r0 *1 409.6,136.52 cap_mim_2f0_m4m5_noshield
C$1025 \$95 topn 3.56528e-14
* device instance $1026 r0 *1 416,136.52 cap_mim_2f0_m4m5_noshield
C$1026 \$86 topn 3.56528e-14
* device instance $1027 r0 *1 422.4,136.52 cap_mim_2f0_m4m5_noshield
C$1027 \$95 topn 3.56528e-14
* device instance $1028 r0 *1 2.6,142.92 cap_mim_2f0_m4m5_noshield
C$1028 \$5 topp 3.56528e-14
* device instance $1029 r0 *1 9,142.92 cap_mim_2f0_m4m5_noshield
C$1029 \$7 topp 3.56528e-14
* device instance $1030 r0 *1 15.4,142.92 cap_mim_2f0_m4m5_noshield
C$1030 \$5 topp 3.56528e-14
* device instance $1031 r0 *1 21.8,142.92 cap_mim_2f0_m4m5_noshield
C$1031 \$7 topp 3.56528e-14
* device instance $1032 r0 *1 28.2,142.92 cap_mim_2f0_m4m5_noshield
C$1032 \$5 topp 3.56528e-14
* device instance $1033 r0 *1 34.6,142.92 cap_mim_2f0_m4m5_noshield
C$1033 \$7 topp 3.56528e-14
* device instance $1034 r0 *1 41,142.92 cap_mim_2f0_m4m5_noshield
C$1034 \$5 topp 3.56528e-14
* device instance $1035 r0 *1 47.4,142.92 cap_mim_2f0_m4m5_noshield
C$1035 \$7 topp 3.56528e-14
* device instance $1036 r0 *1 53.8,142.92 cap_mim_2f0_m4m5_noshield
C$1036 \$5 topp 3.56528e-14
* device instance $1037 r0 *1 60.2,142.92 cap_mim_2f0_m4m5_noshield
C$1037 \$7 topp 3.56528e-14
* device instance $1038 r0 *1 66.6,142.92 cap_mim_2f0_m4m5_noshield
C$1038 \$5 topp 3.56528e-14
* device instance $1039 r0 *1 73,142.92 cap_mim_2f0_m4m5_noshield
C$1039 \$7 topp 3.56528e-14
* device instance $1040 r0 *1 79.4,142.92 cap_mim_2f0_m4m5_noshield
C$1040 \$5 topp 3.56528e-14
* device instance $1041 r0 *1 85.8,142.92 cap_mim_2f0_m4m5_noshield
C$1041 \$7 topp 3.56528e-14
* device instance $1042 r0 *1 92.2,142.92 cap_mim_2f0_m4m5_noshield
C$1042 \$5 topp 3.56528e-14
* device instance $1043 r0 *1 98.6,142.92 cap_mim_2f0_m4m5_noshield
C$1043 \$7 topp 3.56528e-14
* device instance $1044 r0 *1 105,142.92 cap_mim_2f0_m4m5_noshield
C$1044 \$5 topp 3.56528e-14
* device instance $1045 r0 *1 111.4,142.92 cap_mim_2f0_m4m5_noshield
C$1045 \$7 topp 3.56528e-14
* device instance $1046 r0 *1 117.8,142.92 cap_mim_2f0_m4m5_noshield
C$1046 \$5 topp 3.56528e-14
* device instance $1047 r0 *1 124.2,142.92 cap_mim_2f0_m4m5_noshield
C$1047 \$7 topp 3.56528e-14
* device instance $1048 r0 *1 130.6,142.92 cap_mim_2f0_m4m5_noshield
C$1048 \$5 topp 3.56528e-14
* device instance $1049 r0 *1 137,142.92 cap_mim_2f0_m4m5_noshield
C$1049 \$7 topp 3.56528e-14
* device instance $1050 r0 *1 143.4,142.92 cap_mim_2f0_m4m5_noshield
C$1050 \$5 topp 3.56528e-14
* device instance $1051 r0 *1 149.8,142.92 cap_mim_2f0_m4m5_noshield
C$1051 \$7 topp 3.56528e-14
* device instance $1052 r0 *1 156.2,142.92 cap_mim_2f0_m4m5_noshield
C$1052 \$5 topp 3.56528e-14
* device instance $1053 r0 *1 162.6,142.92 cap_mim_2f0_m4m5_noshield
C$1053 \$7 topp 3.56528e-14
* device instance $1054 r0 *1 169,142.92 cap_mim_2f0_m4m5_noshield
C$1054 \$5 topp 3.56528e-14
* device instance $1055 r0 *1 175.4,142.92 cap_mim_2f0_m4m5_noshield
C$1055 \$7 topp 3.56528e-14
* device instance $1056 r0 *1 181.8,142.92 cap_mim_2f0_m4m5_noshield
C$1056 \$5 topp 3.56528e-14
* device instance $1057 r0 *1 188.2,142.92 cap_mim_2f0_m4m5_noshield
C$1057 \$7 topp 3.56528e-14
* device instance $1058 r0 *1 194.6,142.92 cap_mim_2f0_m4m5_noshield
C$1058 \$5 topp 3.56528e-14
* device instance $1059 r0 *1 201,142.92 cap_mim_2f0_m4m5_noshield
C$1059 \$7 topp 3.56528e-14
* device instance $1060 r0 *1 224,142.92 cap_mim_2f0_m4m5_noshield
C$1060 \$86 topn 3.56528e-14
* device instance $1061 r0 *1 230.4,142.92 cap_mim_2f0_m4m5_noshield
C$1061 \$95 topn 3.56528e-14
* device instance $1062 r0 *1 236.8,142.92 cap_mim_2f0_m4m5_noshield
C$1062 \$86 topn 3.56528e-14
* device instance $1063 r0 *1 243.2,142.92 cap_mim_2f0_m4m5_noshield
C$1063 \$95 topn 3.56528e-14
* device instance $1064 r0 *1 249.6,142.92 cap_mim_2f0_m4m5_noshield
C$1064 \$86 topn 3.56528e-14
* device instance $1065 r0 *1 256,142.92 cap_mim_2f0_m4m5_noshield
C$1065 \$95 topn 3.56528e-14
* device instance $1066 r0 *1 262.4,142.92 cap_mim_2f0_m4m5_noshield
C$1066 \$86 topn 3.56528e-14
* device instance $1067 r0 *1 268.8,142.92 cap_mim_2f0_m4m5_noshield
C$1067 \$95 topn 3.56528e-14
* device instance $1068 r0 *1 275.2,142.92 cap_mim_2f0_m4m5_noshield
C$1068 \$86 topn 3.56528e-14
* device instance $1069 r0 *1 281.6,142.92 cap_mim_2f0_m4m5_noshield
C$1069 \$95 topn 3.56528e-14
* device instance $1070 r0 *1 288,142.92 cap_mim_2f0_m4m5_noshield
C$1070 \$86 topn 3.56528e-14
* device instance $1071 r0 *1 294.4,142.92 cap_mim_2f0_m4m5_noshield
C$1071 \$95 topn 3.56528e-14
* device instance $1072 r0 *1 300.8,142.92 cap_mim_2f0_m4m5_noshield
C$1072 \$86 topn 3.56528e-14
* device instance $1073 r0 *1 307.2,142.92 cap_mim_2f0_m4m5_noshield
C$1073 \$95 topn 3.56528e-14
* device instance $1074 r0 *1 313.6,142.92 cap_mim_2f0_m4m5_noshield
C$1074 \$86 topn 3.56528e-14
* device instance $1075 r0 *1 320,142.92 cap_mim_2f0_m4m5_noshield
C$1075 \$95 topn 3.56528e-14
* device instance $1076 r0 *1 326.4,142.92 cap_mim_2f0_m4m5_noshield
C$1076 \$86 topn 3.56528e-14
* device instance $1077 r0 *1 332.8,142.92 cap_mim_2f0_m4m5_noshield
C$1077 \$95 topn 3.56528e-14
* device instance $1078 r0 *1 339.2,142.92 cap_mim_2f0_m4m5_noshield
C$1078 \$86 topn 3.56528e-14
* device instance $1079 r0 *1 345.6,142.92 cap_mim_2f0_m4m5_noshield
C$1079 \$95 topn 3.56528e-14
* device instance $1080 r0 *1 352,142.92 cap_mim_2f0_m4m5_noshield
C$1080 \$86 topn 3.56528e-14
* device instance $1081 r0 *1 358.4,142.92 cap_mim_2f0_m4m5_noshield
C$1081 \$95 topn 3.56528e-14
* device instance $1082 r0 *1 364.8,142.92 cap_mim_2f0_m4m5_noshield
C$1082 \$86 topn 3.56528e-14
* device instance $1083 r0 *1 371.2,142.92 cap_mim_2f0_m4m5_noshield
C$1083 \$95 topn 3.56528e-14
* device instance $1084 r0 *1 377.6,142.92 cap_mim_2f0_m4m5_noshield
C$1084 \$86 topn 3.56528e-14
* device instance $1085 r0 *1 384,142.92 cap_mim_2f0_m4m5_noshield
C$1085 \$95 topn 3.56528e-14
* device instance $1086 r0 *1 390.4,142.92 cap_mim_2f0_m4m5_noshield
C$1086 \$86 topn 3.56528e-14
* device instance $1087 r0 *1 396.8,142.92 cap_mim_2f0_m4m5_noshield
C$1087 \$95 topn 3.56528e-14
* device instance $1088 r0 *1 403.2,142.92 cap_mim_2f0_m4m5_noshield
C$1088 \$86 topn 3.56528e-14
* device instance $1089 r0 *1 409.6,142.92 cap_mim_2f0_m4m5_noshield
C$1089 \$95 topn 3.56528e-14
* device instance $1090 r0 *1 416,142.92 cap_mim_2f0_m4m5_noshield
C$1090 \$86 topn 3.56528e-14
* device instance $1091 r0 *1 422.4,142.92 cap_mim_2f0_m4m5_noshield
C$1091 \$95 topn 3.56528e-14
* device instance $1092 r0 *1 2.6,149.32 cap_mim_2f0_m4m5_noshield
C$1092 \$7 topp 3.56528e-14
* device instance $1093 r0 *1 9,149.32 cap_mim_2f0_m4m5_noshield
C$1093 \$5 topp 3.56528e-14
* device instance $1094 r0 *1 15.4,149.32 cap_mim_2f0_m4m5_noshield
C$1094 \$7 topp 3.56528e-14
* device instance $1095 r0 *1 21.8,149.32 cap_mim_2f0_m4m5_noshield
C$1095 \$5 topp 3.56528e-14
* device instance $1096 r0 *1 28.2,149.32 cap_mim_2f0_m4m5_noshield
C$1096 \$7 topp 3.56528e-14
* device instance $1097 r0 *1 34.6,149.32 cap_mim_2f0_m4m5_noshield
C$1097 \$5 topp 3.56528e-14
* device instance $1098 r0 *1 41,149.32 cap_mim_2f0_m4m5_noshield
C$1098 \$7 topp 3.56528e-14
* device instance $1099 r0 *1 47.4,149.32 cap_mim_2f0_m4m5_noshield
C$1099 \$5 topp 3.56528e-14
* device instance $1100 r0 *1 53.8,149.32 cap_mim_2f0_m4m5_noshield
C$1100 \$7 topp 3.56528e-14
* device instance $1101 r0 *1 60.2,149.32 cap_mim_2f0_m4m5_noshield
C$1101 \$5 topp 3.56528e-14
* device instance $1102 r0 *1 66.6,149.32 cap_mim_2f0_m4m5_noshield
C$1102 \$7 topp 3.56528e-14
* device instance $1103 r0 *1 73,149.32 cap_mim_2f0_m4m5_noshield
C$1103 \$5 topp 3.56528e-14
* device instance $1104 r0 *1 79.4,149.32 cap_mim_2f0_m4m5_noshield
C$1104 \$7 topp 3.56528e-14
* device instance $1105 r0 *1 85.8,149.32 cap_mim_2f0_m4m5_noshield
C$1105 \$5 topp 3.56528e-14
* device instance $1106 r0 *1 92.2,149.32 cap_mim_2f0_m4m5_noshield
C$1106 \$7 topp 3.56528e-14
* device instance $1107 r0 *1 98.6,149.32 cap_mim_2f0_m4m5_noshield
C$1107 \$5 topp 3.56528e-14
* device instance $1108 r0 *1 105,149.32 cap_mim_2f0_m4m5_noshield
C$1108 \$7 topp 3.56528e-14
* device instance $1109 r0 *1 111.4,149.32 cap_mim_2f0_m4m5_noshield
C$1109 \$5 topp 3.56528e-14
* device instance $1110 r0 *1 117.8,149.32 cap_mim_2f0_m4m5_noshield
C$1110 \$7 topp 3.56528e-14
* device instance $1111 r0 *1 124.2,149.32 cap_mim_2f0_m4m5_noshield
C$1111 \$5 topp 3.56528e-14
* device instance $1112 r0 *1 130.6,149.32 cap_mim_2f0_m4m5_noshield
C$1112 \$7 topp 3.56528e-14
* device instance $1113 r0 *1 137,149.32 cap_mim_2f0_m4m5_noshield
C$1113 \$5 topp 3.56528e-14
* device instance $1114 r0 *1 143.4,149.32 cap_mim_2f0_m4m5_noshield
C$1114 \$7 topp 3.56528e-14
* device instance $1115 r0 *1 149.8,149.32 cap_mim_2f0_m4m5_noshield
C$1115 \$5 topp 3.56528e-14
* device instance $1116 r0 *1 156.2,149.32 cap_mim_2f0_m4m5_noshield
C$1116 \$7 topp 3.56528e-14
* device instance $1117 r0 *1 162.6,149.32 cap_mim_2f0_m4m5_noshield
C$1117 \$5 topp 3.56528e-14
* device instance $1118 r0 *1 169,149.32 cap_mim_2f0_m4m5_noshield
C$1118 \$7 topp 3.56528e-14
* device instance $1119 r0 *1 175.4,149.32 cap_mim_2f0_m4m5_noshield
C$1119 \$5 topp 3.56528e-14
* device instance $1120 r0 *1 181.8,149.32 cap_mim_2f0_m4m5_noshield
C$1120 \$7 topp 3.56528e-14
* device instance $1121 r0 *1 188.2,149.32 cap_mim_2f0_m4m5_noshield
C$1121 \$5 topp 3.56528e-14
* device instance $1122 r0 *1 194.6,149.32 cap_mim_2f0_m4m5_noshield
C$1122 \$7 topp 3.56528e-14
* device instance $1123 r0 *1 201,149.32 cap_mim_2f0_m4m5_noshield
C$1123 \$5 topp 3.56528e-14
* device instance $1124 r0 *1 224,149.32 cap_mim_2f0_m4m5_noshield
C$1124 \$95 topn 3.56528e-14
* device instance $1125 r0 *1 230.4,149.32 cap_mim_2f0_m4m5_noshield
C$1125 \$86 topn 3.56528e-14
* device instance $1126 r0 *1 236.8,149.32 cap_mim_2f0_m4m5_noshield
C$1126 \$95 topn 3.56528e-14
* device instance $1127 r0 *1 243.2,149.32 cap_mim_2f0_m4m5_noshield
C$1127 \$86 topn 3.56528e-14
* device instance $1128 r0 *1 249.6,149.32 cap_mim_2f0_m4m5_noshield
C$1128 \$95 topn 3.56528e-14
* device instance $1129 r0 *1 256,149.32 cap_mim_2f0_m4m5_noshield
C$1129 \$86 topn 3.56528e-14
* device instance $1130 r0 *1 262.4,149.32 cap_mim_2f0_m4m5_noshield
C$1130 \$95 topn 3.56528e-14
* device instance $1131 r0 *1 268.8,149.32 cap_mim_2f0_m4m5_noshield
C$1131 \$86 topn 3.56528e-14
* device instance $1132 r0 *1 275.2,149.32 cap_mim_2f0_m4m5_noshield
C$1132 \$95 topn 3.56528e-14
* device instance $1133 r0 *1 281.6,149.32 cap_mim_2f0_m4m5_noshield
C$1133 \$86 topn 3.56528e-14
* device instance $1134 r0 *1 288,149.32 cap_mim_2f0_m4m5_noshield
C$1134 \$95 topn 3.56528e-14
* device instance $1135 r0 *1 294.4,149.32 cap_mim_2f0_m4m5_noshield
C$1135 \$86 topn 3.56528e-14
* device instance $1136 r0 *1 300.8,149.32 cap_mim_2f0_m4m5_noshield
C$1136 \$95 topn 3.56528e-14
* device instance $1137 r0 *1 307.2,149.32 cap_mim_2f0_m4m5_noshield
C$1137 \$86 topn 3.56528e-14
* device instance $1138 r0 *1 313.6,149.32 cap_mim_2f0_m4m5_noshield
C$1138 \$95 topn 3.56528e-14
* device instance $1139 r0 *1 320,149.32 cap_mim_2f0_m4m5_noshield
C$1139 \$86 topn 3.56528e-14
* device instance $1140 r0 *1 326.4,149.32 cap_mim_2f0_m4m5_noshield
C$1140 \$95 topn 3.56528e-14
* device instance $1141 r0 *1 332.8,149.32 cap_mim_2f0_m4m5_noshield
C$1141 \$86 topn 3.56528e-14
* device instance $1142 r0 *1 339.2,149.32 cap_mim_2f0_m4m5_noshield
C$1142 \$95 topn 3.56528e-14
* device instance $1143 r0 *1 345.6,149.32 cap_mim_2f0_m4m5_noshield
C$1143 \$86 topn 3.56528e-14
* device instance $1144 r0 *1 352,149.32 cap_mim_2f0_m4m5_noshield
C$1144 \$95 topn 3.56528e-14
* device instance $1145 r0 *1 358.4,149.32 cap_mim_2f0_m4m5_noshield
C$1145 \$86 topn 3.56528e-14
* device instance $1146 r0 *1 364.8,149.32 cap_mim_2f0_m4m5_noshield
C$1146 \$95 topn 3.56528e-14
* device instance $1147 r0 *1 371.2,149.32 cap_mim_2f0_m4m5_noshield
C$1147 \$86 topn 3.56528e-14
* device instance $1148 r0 *1 377.6,149.32 cap_mim_2f0_m4m5_noshield
C$1148 \$95 topn 3.56528e-14
* device instance $1149 r0 *1 384,149.32 cap_mim_2f0_m4m5_noshield
C$1149 \$86 topn 3.56528e-14
* device instance $1150 r0 *1 390.4,149.32 cap_mim_2f0_m4m5_noshield
C$1150 \$95 topn 3.56528e-14
* device instance $1151 r0 *1 396.8,149.32 cap_mim_2f0_m4m5_noshield
C$1151 \$86 topn 3.56528e-14
* device instance $1152 r0 *1 403.2,149.32 cap_mim_2f0_m4m5_noshield
C$1152 \$95 topn 3.56528e-14
* device instance $1153 r0 *1 409.6,149.32 cap_mim_2f0_m4m5_noshield
C$1153 \$86 topn 3.56528e-14
* device instance $1154 r0 *1 416,149.32 cap_mim_2f0_m4m5_noshield
C$1154 \$95 topn 3.56528e-14
* device instance $1155 r0 *1 422.4,149.32 cap_mim_2f0_m4m5_noshield
C$1155 \$86 topn 3.56528e-14
* device instance $1156 r0 *1 2.6,155.72 cap_mim_2f0_m4m5_noshield
C$1156 \$7 topp 3.56528e-14
* device instance $1157 r0 *1 9,155.72 cap_mim_2f0_m4m5_noshield
C$1157 \$5 topp 3.56528e-14
* device instance $1158 r0 *1 15.4,155.72 cap_mim_2f0_m4m5_noshield
C$1158 \$7 topp 3.56528e-14
* device instance $1159 r0 *1 21.8,155.72 cap_mim_2f0_m4m5_noshield
C$1159 \$5 topp 3.56528e-14
* device instance $1160 r0 *1 28.2,155.72 cap_mim_2f0_m4m5_noshield
C$1160 \$7 topp 3.56528e-14
* device instance $1161 r0 *1 34.6,155.72 cap_mim_2f0_m4m5_noshield
C$1161 \$5 topp 3.56528e-14
* device instance $1162 r0 *1 41,155.72 cap_mim_2f0_m4m5_noshield
C$1162 \$7 topp 3.56528e-14
* device instance $1163 r0 *1 47.4,155.72 cap_mim_2f0_m4m5_noshield
C$1163 \$5 topp 3.56528e-14
* device instance $1164 r0 *1 53.8,155.72 cap_mim_2f0_m4m5_noshield
C$1164 \$7 topp 3.56528e-14
* device instance $1165 r0 *1 60.2,155.72 cap_mim_2f0_m4m5_noshield
C$1165 \$5 topp 3.56528e-14
* device instance $1166 r0 *1 66.6,155.72 cap_mim_2f0_m4m5_noshield
C$1166 \$7 topp 3.56528e-14
* device instance $1167 r0 *1 73,155.72 cap_mim_2f0_m4m5_noshield
C$1167 \$5 topp 3.56528e-14
* device instance $1168 r0 *1 79.4,155.72 cap_mim_2f0_m4m5_noshield
C$1168 \$7 topp 3.56528e-14
* device instance $1169 r0 *1 85.8,155.72 cap_mim_2f0_m4m5_noshield
C$1169 \$5 topp 3.56528e-14
* device instance $1170 r0 *1 92.2,155.72 cap_mim_2f0_m4m5_noshield
C$1170 \$7 topp 3.56528e-14
* device instance $1171 r0 *1 98.6,155.72 cap_mim_2f0_m4m5_noshield
C$1171 \$5 topp 3.56528e-14
* device instance $1172 r0 *1 105,155.72 cap_mim_2f0_m4m5_noshield
C$1172 \$7 topp 3.56528e-14
* device instance $1173 r0 *1 111.4,155.72 cap_mim_2f0_m4m5_noshield
C$1173 \$5 topp 3.56528e-14
* device instance $1174 r0 *1 117.8,155.72 cap_mim_2f0_m4m5_noshield
C$1174 \$7 topp 3.56528e-14
* device instance $1175 r0 *1 124.2,155.72 cap_mim_2f0_m4m5_noshield
C$1175 \$5 topp 3.56528e-14
* device instance $1176 r0 *1 130.6,155.72 cap_mim_2f0_m4m5_noshield
C$1176 \$7 topp 3.56528e-14
* device instance $1177 r0 *1 137,155.72 cap_mim_2f0_m4m5_noshield
C$1177 \$5 topp 3.56528e-14
* device instance $1178 r0 *1 143.4,155.72 cap_mim_2f0_m4m5_noshield
C$1178 \$7 topp 3.56528e-14
* device instance $1179 r0 *1 149.8,155.72 cap_mim_2f0_m4m5_noshield
C$1179 \$5 topp 3.56528e-14
* device instance $1180 r0 *1 156.2,155.72 cap_mim_2f0_m4m5_noshield
C$1180 \$7 topp 3.56528e-14
* device instance $1181 r0 *1 162.6,155.72 cap_mim_2f0_m4m5_noshield
C$1181 \$5 topp 3.56528e-14
* device instance $1182 r0 *1 169,155.72 cap_mim_2f0_m4m5_noshield
C$1182 \$7 topp 3.56528e-14
* device instance $1183 r0 *1 175.4,155.72 cap_mim_2f0_m4m5_noshield
C$1183 \$5 topp 3.56528e-14
* device instance $1184 r0 *1 181.8,155.72 cap_mim_2f0_m4m5_noshield
C$1184 \$7 topp 3.56528e-14
* device instance $1185 r0 *1 188.2,155.72 cap_mim_2f0_m4m5_noshield
C$1185 \$5 topp 3.56528e-14
* device instance $1186 r0 *1 194.6,155.72 cap_mim_2f0_m4m5_noshield
C$1186 \$7 topp 3.56528e-14
* device instance $1187 r0 *1 201,155.72 cap_mim_2f0_m4m5_noshield
C$1187 \$5 topp 3.56528e-14
* device instance $1188 r0 *1 224,155.72 cap_mim_2f0_m4m5_noshield
C$1188 \$95 topn 3.56528e-14
* device instance $1189 r0 *1 230.4,155.72 cap_mim_2f0_m4m5_noshield
C$1189 \$86 topn 3.56528e-14
* device instance $1190 r0 *1 236.8,155.72 cap_mim_2f0_m4m5_noshield
C$1190 \$95 topn 3.56528e-14
* device instance $1191 r0 *1 243.2,155.72 cap_mim_2f0_m4m5_noshield
C$1191 \$86 topn 3.56528e-14
* device instance $1192 r0 *1 249.6,155.72 cap_mim_2f0_m4m5_noshield
C$1192 \$95 topn 3.56528e-14
* device instance $1193 r0 *1 256,155.72 cap_mim_2f0_m4m5_noshield
C$1193 \$86 topn 3.56528e-14
* device instance $1194 r0 *1 262.4,155.72 cap_mim_2f0_m4m5_noshield
C$1194 \$95 topn 3.56528e-14
* device instance $1195 r0 *1 268.8,155.72 cap_mim_2f0_m4m5_noshield
C$1195 \$86 topn 3.56528e-14
* device instance $1196 r0 *1 275.2,155.72 cap_mim_2f0_m4m5_noshield
C$1196 \$95 topn 3.56528e-14
* device instance $1197 r0 *1 281.6,155.72 cap_mim_2f0_m4m5_noshield
C$1197 \$86 topn 3.56528e-14
* device instance $1198 r0 *1 288,155.72 cap_mim_2f0_m4m5_noshield
C$1198 \$95 topn 3.56528e-14
* device instance $1199 r0 *1 294.4,155.72 cap_mim_2f0_m4m5_noshield
C$1199 \$86 topn 3.56528e-14
* device instance $1200 r0 *1 300.8,155.72 cap_mim_2f0_m4m5_noshield
C$1200 \$95 topn 3.56528e-14
* device instance $1201 r0 *1 307.2,155.72 cap_mim_2f0_m4m5_noshield
C$1201 \$86 topn 3.56528e-14
* device instance $1202 r0 *1 313.6,155.72 cap_mim_2f0_m4m5_noshield
C$1202 \$95 topn 3.56528e-14
* device instance $1203 r0 *1 320,155.72 cap_mim_2f0_m4m5_noshield
C$1203 \$86 topn 3.56528e-14
* device instance $1204 r0 *1 326.4,155.72 cap_mim_2f0_m4m5_noshield
C$1204 \$95 topn 3.56528e-14
* device instance $1205 r0 *1 332.8,155.72 cap_mim_2f0_m4m5_noshield
C$1205 \$86 topn 3.56528e-14
* device instance $1206 r0 *1 339.2,155.72 cap_mim_2f0_m4m5_noshield
C$1206 \$95 topn 3.56528e-14
* device instance $1207 r0 *1 345.6,155.72 cap_mim_2f0_m4m5_noshield
C$1207 \$86 topn 3.56528e-14
* device instance $1208 r0 *1 352,155.72 cap_mim_2f0_m4m5_noshield
C$1208 \$95 topn 3.56528e-14
* device instance $1209 r0 *1 358.4,155.72 cap_mim_2f0_m4m5_noshield
C$1209 \$86 topn 3.56528e-14
* device instance $1210 r0 *1 364.8,155.72 cap_mim_2f0_m4m5_noshield
C$1210 \$95 topn 3.56528e-14
* device instance $1211 r0 *1 371.2,155.72 cap_mim_2f0_m4m5_noshield
C$1211 \$86 topn 3.56528e-14
* device instance $1212 r0 *1 377.6,155.72 cap_mim_2f0_m4m5_noshield
C$1212 \$95 topn 3.56528e-14
* device instance $1213 r0 *1 384,155.72 cap_mim_2f0_m4m5_noshield
C$1213 \$86 topn 3.56528e-14
* device instance $1214 r0 *1 390.4,155.72 cap_mim_2f0_m4m5_noshield
C$1214 \$95 topn 3.56528e-14
* device instance $1215 r0 *1 396.8,155.72 cap_mim_2f0_m4m5_noshield
C$1215 \$86 topn 3.56528e-14
* device instance $1216 r0 *1 403.2,155.72 cap_mim_2f0_m4m5_noshield
C$1216 \$95 topn 3.56528e-14
* device instance $1217 r0 *1 409.6,155.72 cap_mim_2f0_m4m5_noshield
C$1217 \$86 topn 3.56528e-14
* device instance $1218 r0 *1 416,155.72 cap_mim_2f0_m4m5_noshield
C$1218 \$95 topn 3.56528e-14
* device instance $1219 r0 *1 422.4,155.72 cap_mim_2f0_m4m5_noshield
C$1219 \$86 topn 3.56528e-14
* device instance $1220 r0 *1 2.6,162.12 cap_mim_2f0_m4m5_noshield
C$1220 \$8 topp 3.56528e-14
* device instance $1221 r0 *1 9,162.12 cap_mim_2f0_m4m5_noshield
C$1221 \$5 topp 3.56528e-14
* device instance $1222 r0 *1 15.4,162.12 cap_mim_2f0_m4m5_noshield
C$1222 \$8 topp 3.56528e-14
* device instance $1223 r0 *1 21.8,162.12 cap_mim_2f0_m4m5_noshield
C$1223 \$5 topp 3.56528e-14
* device instance $1224 r0 *1 28.2,162.12 cap_mim_2f0_m4m5_noshield
C$1224 \$8 topp 3.56528e-14
* device instance $1225 r0 *1 34.6,162.12 cap_mim_2f0_m4m5_noshield
C$1225 \$5 topp 3.56528e-14
* device instance $1226 r0 *1 41,162.12 cap_mim_2f0_m4m5_noshield
C$1226 \$8 topp 3.56528e-14
* device instance $1227 r0 *1 47.4,162.12 cap_mim_2f0_m4m5_noshield
C$1227 \$5 topp 3.56528e-14
* device instance $1228 r0 *1 53.8,162.12 cap_mim_2f0_m4m5_noshield
C$1228 \$8 topp 3.56528e-14
* device instance $1229 r0 *1 60.2,162.12 cap_mim_2f0_m4m5_noshield
C$1229 \$5 topp 3.56528e-14
* device instance $1230 r0 *1 66.6,162.12 cap_mim_2f0_m4m5_noshield
C$1230 \$8 topp 3.56528e-14
* device instance $1231 r0 *1 73,162.12 cap_mim_2f0_m4m5_noshield
C$1231 \$5 topp 3.56528e-14
* device instance $1232 r0 *1 79.4,162.12 cap_mim_2f0_m4m5_noshield
C$1232 \$8 topp 3.56528e-14
* device instance $1233 r0 *1 85.8,162.12 cap_mim_2f0_m4m5_noshield
C$1233 \$5 topp 3.56528e-14
* device instance $1234 r0 *1 92.2,162.12 cap_mim_2f0_m4m5_noshield
C$1234 \$8 topp 3.56528e-14
* device instance $1235 r0 *1 98.6,162.12 cap_mim_2f0_m4m5_noshield
C$1235 \$5 topp 3.56528e-14
* device instance $1236 r0 *1 105,162.12 cap_mim_2f0_m4m5_noshield
C$1236 \$8 topp 3.56528e-14
* device instance $1237 r0 *1 111.4,162.12 cap_mim_2f0_m4m5_noshield
C$1237 \$5 topp 3.56528e-14
* device instance $1238 r0 *1 117.8,162.12 cap_mim_2f0_m4m5_noshield
C$1238 \$8 topp 3.56528e-14
* device instance $1239 r0 *1 124.2,162.12 cap_mim_2f0_m4m5_noshield
C$1239 \$5 topp 3.56528e-14
* device instance $1240 r0 *1 130.6,162.12 cap_mim_2f0_m4m5_noshield
C$1240 \$8 topp 3.56528e-14
* device instance $1241 r0 *1 137,162.12 cap_mim_2f0_m4m5_noshield
C$1241 \$5 topp 3.56528e-14
* device instance $1242 r0 *1 143.4,162.12 cap_mim_2f0_m4m5_noshield
C$1242 \$8 topp 3.56528e-14
* device instance $1243 r0 *1 149.8,162.12 cap_mim_2f0_m4m5_noshield
C$1243 \$5 topp 3.56528e-14
* device instance $1244 r0 *1 156.2,162.12 cap_mim_2f0_m4m5_noshield
C$1244 \$8 topp 3.56528e-14
* device instance $1245 r0 *1 162.6,162.12 cap_mim_2f0_m4m5_noshield
C$1245 \$5 topp 3.56528e-14
* device instance $1246 r0 *1 169,162.12 cap_mim_2f0_m4m5_noshield
C$1246 \$8 topp 3.56528e-14
* device instance $1247 r0 *1 175.4,162.12 cap_mim_2f0_m4m5_noshield
C$1247 \$5 topp 3.56528e-14
* device instance $1248 r0 *1 181.8,162.12 cap_mim_2f0_m4m5_noshield
C$1248 \$8 topp 3.56528e-14
* device instance $1249 r0 *1 188.2,162.12 cap_mim_2f0_m4m5_noshield
C$1249 \$5 topp 3.56528e-14
* device instance $1250 r0 *1 194.6,162.12 cap_mim_2f0_m4m5_noshield
C$1250 \$8 topp 3.56528e-14
* device instance $1251 r0 *1 201,162.12 cap_mim_2f0_m4m5_noshield
C$1251 \$5 topp 3.56528e-14
* device instance $1252 r0 *1 224,162.12 cap_mim_2f0_m4m5_noshield
C$1252 \$103 topn 3.56528e-14
* device instance $1253 r0 *1 230.4,162.12 cap_mim_2f0_m4m5_noshield
C$1253 \$86 topn 3.56528e-14
* device instance $1254 r0 *1 236.8,162.12 cap_mim_2f0_m4m5_noshield
C$1254 \$103 topn 3.56528e-14
* device instance $1255 r0 *1 243.2,162.12 cap_mim_2f0_m4m5_noshield
C$1255 \$86 topn 3.56528e-14
* device instance $1256 r0 *1 249.6,162.12 cap_mim_2f0_m4m5_noshield
C$1256 \$103 topn 3.56528e-14
* device instance $1257 r0 *1 256,162.12 cap_mim_2f0_m4m5_noshield
C$1257 \$86 topn 3.56528e-14
* device instance $1258 r0 *1 262.4,162.12 cap_mim_2f0_m4m5_noshield
C$1258 \$103 topn 3.56528e-14
* device instance $1259 r0 *1 268.8,162.12 cap_mim_2f0_m4m5_noshield
C$1259 \$86 topn 3.56528e-14
* device instance $1260 r0 *1 275.2,162.12 cap_mim_2f0_m4m5_noshield
C$1260 \$103 topn 3.56528e-14
* device instance $1261 r0 *1 281.6,162.12 cap_mim_2f0_m4m5_noshield
C$1261 \$86 topn 3.56528e-14
* device instance $1262 r0 *1 288,162.12 cap_mim_2f0_m4m5_noshield
C$1262 \$103 topn 3.56528e-14
* device instance $1263 r0 *1 294.4,162.12 cap_mim_2f0_m4m5_noshield
C$1263 \$86 topn 3.56528e-14
* device instance $1264 r0 *1 300.8,162.12 cap_mim_2f0_m4m5_noshield
C$1264 \$103 topn 3.56528e-14
* device instance $1265 r0 *1 307.2,162.12 cap_mim_2f0_m4m5_noshield
C$1265 \$86 topn 3.56528e-14
* device instance $1266 r0 *1 313.6,162.12 cap_mim_2f0_m4m5_noshield
C$1266 \$103 topn 3.56528e-14
* device instance $1267 r0 *1 320,162.12 cap_mim_2f0_m4m5_noshield
C$1267 \$86 topn 3.56528e-14
* device instance $1268 r0 *1 326.4,162.12 cap_mim_2f0_m4m5_noshield
C$1268 \$103 topn 3.56528e-14
* device instance $1269 r0 *1 332.8,162.12 cap_mim_2f0_m4m5_noshield
C$1269 \$86 topn 3.56528e-14
* device instance $1270 r0 *1 339.2,162.12 cap_mim_2f0_m4m5_noshield
C$1270 \$103 topn 3.56528e-14
* device instance $1271 r0 *1 345.6,162.12 cap_mim_2f0_m4m5_noshield
C$1271 \$86 topn 3.56528e-14
* device instance $1272 r0 *1 352,162.12 cap_mim_2f0_m4m5_noshield
C$1272 \$103 topn 3.56528e-14
* device instance $1273 r0 *1 358.4,162.12 cap_mim_2f0_m4m5_noshield
C$1273 \$86 topn 3.56528e-14
* device instance $1274 r0 *1 364.8,162.12 cap_mim_2f0_m4m5_noshield
C$1274 \$103 topn 3.56528e-14
* device instance $1275 r0 *1 371.2,162.12 cap_mim_2f0_m4m5_noshield
C$1275 \$86 topn 3.56528e-14
* device instance $1276 r0 *1 377.6,162.12 cap_mim_2f0_m4m5_noshield
C$1276 \$103 topn 3.56528e-14
* device instance $1277 r0 *1 384,162.12 cap_mim_2f0_m4m5_noshield
C$1277 \$86 topn 3.56528e-14
* device instance $1278 r0 *1 390.4,162.12 cap_mim_2f0_m4m5_noshield
C$1278 \$103 topn 3.56528e-14
* device instance $1279 r0 *1 396.8,162.12 cap_mim_2f0_m4m5_noshield
C$1279 \$86 topn 3.56528e-14
* device instance $1280 r0 *1 403.2,162.12 cap_mim_2f0_m4m5_noshield
C$1280 \$103 topn 3.56528e-14
* device instance $1281 r0 *1 409.6,162.12 cap_mim_2f0_m4m5_noshield
C$1281 \$86 topn 3.56528e-14
* device instance $1282 r0 *1 416,162.12 cap_mim_2f0_m4m5_noshield
C$1282 \$103 topn 3.56528e-14
* device instance $1283 r0 *1 422.4,162.12 cap_mim_2f0_m4m5_noshield
C$1283 \$86 topn 3.56528e-14
* device instance $1284 r0 *1 2.6,168.52 cap_mim_2f0_m4m5_noshield
C$1284 \$9 topp 3.56528e-14
* device instance $1285 r0 *1 9,168.52 cap_mim_2f0_m4m5_noshield
C$1285 \$5 topp 3.56528e-14
* device instance $1286 r0 *1 15.4,168.52 cap_mim_2f0_m4m5_noshield
C$1286 \$9 topp 3.56528e-14
* device instance $1287 r0 *1 21.8,168.52 cap_mim_2f0_m4m5_noshield
C$1287 \$5 topp 3.56528e-14
* device instance $1288 r0 *1 28.2,168.52 cap_mim_2f0_m4m5_noshield
C$1288 \$9 topp 3.56528e-14
* device instance $1289 r0 *1 34.6,168.52 cap_mim_2f0_m4m5_noshield
C$1289 \$5 topp 3.56528e-14
* device instance $1290 r0 *1 41,168.52 cap_mim_2f0_m4m5_noshield
C$1290 \$9 topp 3.56528e-14
* device instance $1291 r0 *1 47.4,168.52 cap_mim_2f0_m4m5_noshield
C$1291 \$5 topp 3.56528e-14
* device instance $1292 r0 *1 53.8,168.52 cap_mim_2f0_m4m5_noshield
C$1292 \$9 topp 3.56528e-14
* device instance $1293 r0 *1 60.2,168.52 cap_mim_2f0_m4m5_noshield
C$1293 \$5 topp 3.56528e-14
* device instance $1294 r0 *1 66.6,168.52 cap_mim_2f0_m4m5_noshield
C$1294 \$9 topp 3.56528e-14
* device instance $1295 r0 *1 73,168.52 cap_mim_2f0_m4m5_noshield
C$1295 \$5 topp 3.56528e-14
* device instance $1296 r0 *1 79.4,168.52 cap_mim_2f0_m4m5_noshield
C$1296 \$9 topp 3.56528e-14
* device instance $1297 r0 *1 85.8,168.52 cap_mim_2f0_m4m5_noshield
C$1297 \$5 topp 3.56528e-14
* device instance $1298 r0 *1 92.2,168.52 cap_mim_2f0_m4m5_noshield
C$1298 \$9 topp 3.56528e-14
* device instance $1299 r0 *1 98.6,168.52 cap_mim_2f0_m4m5_noshield
C$1299 \$5 topp 3.56528e-14
* device instance $1300 r0 *1 105,168.52 cap_mim_2f0_m4m5_noshield
C$1300 \$10 topp 3.56528e-14
* device instance $1301 r0 *1 111.4,168.52 cap_mim_2f0_m4m5_noshield
C$1301 \$5 topp 3.56528e-14
* device instance $1302 r0 *1 117.8,168.52 cap_mim_2f0_m4m5_noshield
C$1302 \$10 topp 3.56528e-14
* device instance $1303 r0 *1 124.2,168.52 cap_mim_2f0_m4m5_noshield
C$1303 \$5 topp 3.56528e-14
* device instance $1304 r0 *1 130.6,168.52 cap_mim_2f0_m4m5_noshield
C$1304 \$10 topp 3.56528e-14
* device instance $1305 r0 *1 137,168.52 cap_mim_2f0_m4m5_noshield
C$1305 \$5 topp 3.56528e-14
* device instance $1306 r0 *1 143.4,168.52 cap_mim_2f0_m4m5_noshield
C$1306 \$10 topp 3.56528e-14
* device instance $1307 r0 *1 149.8,168.52 cap_mim_2f0_m4m5_noshield
C$1307 \$5 topp 3.56528e-14
* device instance $1308 r0 *1 156.2,168.52 cap_mim_2f0_m4m5_noshield
C$1308 \$11 topp 3.56528e-14
* device instance $1309 r0 *1 162.6,168.52 cap_mim_2f0_m4m5_noshield
C$1309 \$5 topp 3.56528e-14
* device instance $1310 r0 *1 169,168.52 cap_mim_2f0_m4m5_noshield
C$1310 \$11 topp 3.56528e-14
* device instance $1311 r0 *1 175.4,168.52 cap_mim_2f0_m4m5_noshield
C$1311 \$5 topp 3.56528e-14
* device instance $1312 r0 *1 181.8,168.52 cap_mim_2f0_m4m5_noshield
C$1312 \$12 topp 3.56528e-14
* device instance $1313 r0 *1 188.2,168.52 cap_mim_2f0_m4m5_noshield
C$1313 \$5 topp 3.56528e-14
* device instance $1314 r0 *1 194.6,168.52 cap_mim_2f0_m4m5_noshield
C$1314 \$13 topp 3.56528e-14
* device instance $1315 r0 *1 201,168.52 cap_mim_2f0_m4m5_noshield
C$1315 \$5 topp 3.56528e-14
* device instance $1316 r0 *1 224,168.52 cap_mim_2f0_m4m5_noshield
C$1316 \$111 topn 3.56528e-14
* device instance $1317 r0 *1 230.4,168.52 cap_mim_2f0_m4m5_noshield
C$1317 \$86 topn 3.56528e-14
* device instance $1318 r0 *1 236.8,168.52 cap_mim_2f0_m4m5_noshield
C$1318 \$111 topn 3.56528e-14
* device instance $1319 r0 *1 243.2,168.52 cap_mim_2f0_m4m5_noshield
C$1319 \$86 topn 3.56528e-14
* device instance $1320 r0 *1 249.6,168.52 cap_mim_2f0_m4m5_noshield
C$1320 \$111 topn 3.56528e-14
* device instance $1321 r0 *1 256,168.52 cap_mim_2f0_m4m5_noshield
C$1321 \$86 topn 3.56528e-14
* device instance $1322 r0 *1 262.4,168.52 cap_mim_2f0_m4m5_noshield
C$1322 \$111 topn 3.56528e-14
* device instance $1323 r0 *1 268.8,168.52 cap_mim_2f0_m4m5_noshield
C$1323 \$86 topn 3.56528e-14
* device instance $1324 r0 *1 275.2,168.52 cap_mim_2f0_m4m5_noshield
C$1324 \$111 topn 3.56528e-14
* device instance $1325 r0 *1 281.6,168.52 cap_mim_2f0_m4m5_noshield
C$1325 \$86 topn 3.56528e-14
* device instance $1326 r0 *1 288,168.52 cap_mim_2f0_m4m5_noshield
C$1326 \$111 topn 3.56528e-14
* device instance $1327 r0 *1 294.4,168.52 cap_mim_2f0_m4m5_noshield
C$1327 \$86 topn 3.56528e-14
* device instance $1328 r0 *1 300.8,168.52 cap_mim_2f0_m4m5_noshield
C$1328 \$111 topn 3.56528e-14
* device instance $1329 r0 *1 307.2,168.52 cap_mim_2f0_m4m5_noshield
C$1329 \$86 topn 3.56528e-14
* device instance $1330 r0 *1 313.6,168.52 cap_mim_2f0_m4m5_noshield
C$1330 \$111 topn 3.56528e-14
* device instance $1331 r0 *1 320,168.52 cap_mim_2f0_m4m5_noshield
C$1331 \$86 topn 3.56528e-14
* device instance $1332 r0 *1 326.4,168.52 cap_mim_2f0_m4m5_noshield
C$1332 \$119 topn 3.56528e-14
* device instance $1333 r0 *1 332.8,168.52 cap_mim_2f0_m4m5_noshield
C$1333 \$86 topn 3.56528e-14
* device instance $1334 r0 *1 339.2,168.52 cap_mim_2f0_m4m5_noshield
C$1334 \$119 topn 3.56528e-14
* device instance $1335 r0 *1 345.6,168.52 cap_mim_2f0_m4m5_noshield
C$1335 \$86 topn 3.56528e-14
* device instance $1336 r0 *1 352,168.52 cap_mim_2f0_m4m5_noshield
C$1336 \$119 topn 3.56528e-14
* device instance $1337 r0 *1 358.4,168.52 cap_mim_2f0_m4m5_noshield
C$1337 \$86 topn 3.56528e-14
* device instance $1338 r0 *1 364.8,168.52 cap_mim_2f0_m4m5_noshield
C$1338 \$119 topn 3.56528e-14
* device instance $1339 r0 *1 371.2,168.52 cap_mim_2f0_m4m5_noshield
C$1339 \$86 topn 3.56528e-14
* device instance $1340 r0 *1 377.6,168.52 cap_mim_2f0_m4m5_noshield
C$1340 \$127 topn 3.56528e-14
* device instance $1341 r0 *1 384,168.52 cap_mim_2f0_m4m5_noshield
C$1341 \$86 topn 3.56528e-14
* device instance $1342 r0 *1 390.4,168.52 cap_mim_2f0_m4m5_noshield
C$1342 \$127 topn 3.56528e-14
* device instance $1343 r0 *1 396.8,168.52 cap_mim_2f0_m4m5_noshield
C$1343 \$86 topn 3.56528e-14
* device instance $1344 r0 *1 403.2,168.52 cap_mim_2f0_m4m5_noshield
C$1344 \$135 topn 3.56528e-14
* device instance $1345 r0 *1 409.6,168.52 cap_mim_2f0_m4m5_noshield
C$1345 \$86 topn 3.56528e-14
* device instance $1346 r0 *1 416,168.52 cap_mim_2f0_m4m5_noshield
C$1346 \$143 topn 3.56528e-14
* device instance $1347 r0 *1 422.4,168.52 cap_mim_2f0_m4m5_noshield
C$1347 \$86 topn 3.56528e-14
* device instance $1348 r0 *1 577.68,84.805 ppolyf_u_1k
R$1348 vdd XCMP_pop vss 150000 ppolyf_u_1k L=150U W=1U
* device instance $1349 r0 *1 584.03,84.805 ppolyf_u_1k
R$1349 vdd XCMP_pon vss 150000 ppolyf_u_1k L=150U W=1U
.ENDS ADC_BLOCK
