* Flat LVS reference for COMPARATOR_NORES.
*
* GENERATED by layout/adc-top/gen_comparator.py from
* design/comparator/comparator.spice's `.subckt comparator` -- do not
* edit. See layout/adc-top/lib/netlist.py for why the layout and this
* reference come from the same parsed design netlist.
*
* Deliberate, documented differences from the schematic, each forced by
* `klt extract`'s gf180mcu ExtractionDeck (see layout/adc-top/README.md):
*   - NMOS bodies on the deck's `vsubs` global (no tap layer);
*   - PMOS bodies on their own Nwell island's net, one per placed
*     group, not on `vdd` (the deck never connects `nwell` to
*     `contact`);
*   - `Vpp`/`Vpn`, the schematic's zero-volt top-plate current probes,
*     are net aliases, not components.
*   - the load resistor bodies are NOT drawn in this cell, on
*     purpose: with them drawn, the deck's lack of a resistor device
*     class shorts `pop`/`pon` onto `vdd` and LVS stops being able to
*     tell the two preamp outputs apart. This case keeps them
*     distinct so the preamp-to-latch connectivity is genuinely
*     verified. The full COMPARATOR cell carries the resistors.
*
* Runnable by hand:  klt lvs layout/adc-top/comparator_nores.lvs.json --format json
.SUBCKT COMPARATOR_NORES clk dout doutb ibias vdd vinn vinp vss vsubs
MXpre_Xmb ibias ibias vss vsubs nfet L=2U W=20U
MXpre_Xmt Xpre.ptail ibias vss vsubs nfet L=2U W=20U
MXpre_Xmip pon vinp Xpre.ptail vsubs nfet L=1U W=40U
MXpre_Xmin pop vinn Xpre.ptail vsubs nfet L=1U W=40U
MXlat_Xmlt Xlat.ltail clk vss vsubs nfet L=0.35U W=16U
MXlat_Xmlp Xlat.dip pop Xlat.ltail vsubs nfet L=0.5U W=8U
MXlat_Xmln Xlat.din pon Xlat.ltail vsubs nfet L=0.5U W=8U
MXlat_Xmnp outn outp Xlat.dip vsubs nfet L=0.35U W=6U
MXlat_Xmnn outp outn Xlat.din vsubs nfet L=0.35U W=6U
MXlat_Xmpp outn outp vdd nw_latch pfet L=0.35U W=8U
MXlat_Xmpn outp outn vdd nw_latch pfet L=0.35U W=8U
MXlat_Xmrp outn clk vdd nw_latch pfet L=0.35U W=4U
MXlat_Xmrn outp clk vdd nw_latch pfet L=0.35U W=4U
MXlat_Xmrd Xlat.dip clk vdd nw_latch pfet L=0.35U W=2U
MXlat_Xmre Xlat.din clk vdd nw_latch pfet L=0.35U W=2U
MXis_Xp sset outn vdd nw_isop pfet L=0.35U W=2U
MXis_Xn sset outn vss vsubs nfet L=0.35U W=1U
MXir_Xp srst outp vdd nw_ison pfet L=0.35U W=2U
MXir_Xn srst outp vss vsubs nfet L=0.35U W=1U
MXno1_Xp1 Xno1.ps srst vdd nw_nor1 pfet L=0.35U W=8U
MXno1_Xp2 dout doutb Xno1.ps nw_nor1 pfet L=0.35U W=8U
MXno1_Xn1 dout srst vss vsubs nfet L=0.35U W=4U
MXno1_Xn2 dout doutb vss vsubs nfet L=0.35U W=4U
MXno2_Xp1 Xno2.ps sset vdd nw_nor2 pfet L=0.35U W=8U
MXno2_Xp2 doutb dout Xno2.ps nw_nor2 pfet L=0.35U W=8U
MXno2_Xn1 doutb sset vss vsubs nfet L=0.35U W=4U
MXno2_Xn2 doutb dout vss vsubs nfet L=0.35U W=4U
.ENDS COMPARATOR_NORES
