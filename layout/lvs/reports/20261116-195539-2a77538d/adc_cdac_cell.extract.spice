* extracted by klt extract --deck gf180mcu

* cell ADC_CDAC_CELL
* pin bp
* pin gn_hi
* pin gn_in
* pin gn_lo
* pin gn_rel
* pin top
* pin vcm
* pin vdd
* pin vin
* pin vref
* pin vss
* pin vsubs
.SUBCKT ADC_CDAC_CELL bp gn_hi gn_in gn_lo gn_rel top vcm vdd vin vref vss vsubs
* device instance $1 r0 *1 1.275,2 nfet
M$1 \$13 gn_in vss vsubs nfet L=0.35U W=4U AS=4.4P AD=4.4P PS=10.2U PD=10.2U
* device instance $2 r0 *1 4.225,2 nfet
M$2 \$7 gn_rel vss vsubs nfet L=0.35U W=4U AS=4.4P AD=4.4P PS=10.2U PD=10.2U
* device instance $3 r0 *1 7.175,2 nfet
M$3 \$9 gn_hi vss vsubs nfet L=0.35U W=4U AS=4.4P AD=4.4P PS=10.2U PD=10.2U
* device instance $4 r0 *1 10.125,2 nfet
M$4 \$5 gn_lo vss vsubs nfet L=0.35U W=4U AS=4.4P AD=4.4P PS=10.2U PD=10.2U
* device instance $5 r0 *1 13.04,5 nfet
M$5 vin gn_in bp vsubs nfet L=0.28U W=10U AS=11P AD=11P PS=22.2U PD=22.2U
* device instance $6 r0 *1 15.92,5 nfet
M$6 vcm gn_rel bp vsubs nfet L=0.28U W=10U AS=11P AD=11P PS=22.2U PD=22.2U
* device instance $7 r0 *1 18.8,5 nfet
M$7 vref gn_hi bp vsubs nfet L=0.28U W=10U AS=11P AD=11P PS=22.2U PD=22.2U
* device instance $8 r0 *1 21.68,5 nfet
M$8 vss gn_lo bp vsubs nfet L=0.28U W=10U AS=11P AD=11P PS=22.2U PD=22.2U
* device instance $9 r0 *1 25.495,4 pfet
M$9 \$13 gn_in vdd vdd pfet L=0.35U W=8U AS=8.8P AD=8.8P PS=18.2U PD=18.2U
* device instance $10 r0 *1 28.445,4 pfet
M$10 \$7 gn_rel vdd vdd pfet L=0.35U W=8U AS=8.8P AD=8.8P PS=18.2U PD=18.2U
* device instance $11 r0 *1 31.395,4 pfet
M$11 \$9 gn_hi vdd vdd pfet L=0.35U W=8U AS=8.8P AD=8.8P PS=18.2U PD=18.2U
* device instance $12 r0 *1 34.345,4 pfet
M$12 \$5 gn_lo vdd vdd pfet L=0.35U W=8U AS=8.8P AD=8.8P PS=18.2U PD=18.2U
* device instance $13 r0 *1 37.26,10 pfet
M$13 vin \$13 bp vdd pfet L=0.28U W=20U AS=22P AD=22P PS=42.2U PD=42.2U
* device instance $14 r0 *1 40.14,10 pfet
M$14 vcm \$7 bp vdd pfet L=0.28U W=20U AS=22P AD=22P PS=42.2U PD=42.2U
* device instance $15 r0 *1 43.02,10 pfet
M$15 vref \$9 bp vdd pfet L=0.28U W=20U AS=22P AD=22P PS=42.2U PD=42.2U
* device instance $16 r0 *1 45.9,10 pfet
M$16 vss \$5 bp vdd pfet L=0.28U W=20U AS=22P AD=22P PS=42.2U PD=42.2U
* device instance $17 r0 *1 23.57,23.6 cap_mim_2f0_m4m5_noshield
C$17 bp top 3.56528e-14
.ENDS ADC_CDAC_CELL
