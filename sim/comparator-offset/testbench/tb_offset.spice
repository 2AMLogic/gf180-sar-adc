* tb_offset -- deterministic (mismatch-free) DC behaviour of the comparator
* preamplifier: gain, bias point, headroom, and the SYMMETRY null control.
*
* Netlist FRAGMENT. The harness supplies the models, the corner .lib
* sections, .temp, the .control block and .end (sim/harness/README.md).
* Parameters provided by the harness: vdd_val, vdd_nom, temp_c.
*
* WHAT THIS ANSWERS (issue #9)
*
* 1. Preamp gain A_v over PVT. A_v is what divides the StrongARM latch's
*    offset and noise down to the comparator input, so the worst-corner
*    A_v -- not the nominal one -- is what the offset and noise budgets in
*    spec/comparator-budget-memo.md are allowed to lean on.
*
* 2. Gain at the common modes DR-0006 actually produces. The ratified
*    switching scheme (MCS/Vcm, top-plate sampling) holds the comparator's
*    input common mode CONSTANT at V_cm = V_REF/2 = 1.65 V in differential
*    mode, and moves it by residue/2 in single-ended mode -- which is
*    +/-0.825 V at the free MSB decision and halves at every trial after
*    it. Two consequences, and this testbench covers both:
*      - the ACCURACY-critical common modes are the late trials, where the
*        residue is a few LSB and the excursion is a few millivolts. The
*        1.60 / 1.65 / 1.70 V instances bracket that with +/-50 mV, ~5x
*        more excursion than the late trials ever see.
*      - the EXTREME common modes (0.825 / 2.475 V) occur only at the
*        first trials, where the differential residue is hundreds of
*        millivolts and the decision is easy. Those instances are here as
*        a FUNCTIONAL check (does the stage still amplify with the right
*        sign?), not as an accuracy claim.
*
* 3. The symmetry null control. With no mismatch the preamp is exactly
*    symmetric, so its differential output at zero input must be zero to
*    numerical precision. `sym_uv` asserts that. It is what makes the
*    Monte Carlo record next door (sim/comparator-offset-mc/) a
*    measurement of MISMATCH rather than of some systematic asymmetry
*    baked into the netlist -- e.g. a mis-typed device width, which would
*    otherwise show up as a plausible-looking offset sigma.
*
* WHY THE PREAMP ALONE, NOT THE FULL COMPARATOR. At DC the StrongARM
* latch is in reset (clk low): its tail is off and its input pair presents
* pure gate capacitance to pop/pon, so it draws no current and shifts no
* DC node. Instantiating it here would triple the device count and add a
* metastable SR latch for nothing. The load it *does* present -- gate
* capacitance, which sets the preamp's noise bandwidth -- is included
* where it matters, in sim/comparator-preamp-noise/.
*
* Ten preamp instances, in (common mode, differential input) pairs. Each
* pair shares its common mode; one member sees 0 V differential and the
* other +2 mV, so the gain at that common mode is a difference of two
* operating points on IDENTICAL (mismatch-free) devices, which is exact.

* CONVERGENCE. Every preamp branch is a forced current pushed into a
* diode-connected FET, which from ngspice's all-zero initial guess is an
* open circuit -- so the direct Newton solve fails and the simulator
* falls back to dynamic gmin stepping. It still reaches the right answer,
* but ~50x slower, which matters a great deal in the Monte Carlo deck
* next door (300 draws x 45 PVT points). A `.nodeset` is a first-iteration
* HINT only: ngspice releases the hinted nodes and re-solves, so the
* reported operating point is the true DC solution, not the hint. The
* hints below are deliberately coarse and supply-scaled; being wrong by a
* few hundred millivolts at a corner costs speed, never accuracy.
.nodeset v(ibn_a)=0.75 v(pop_a)='vdd_val-0.8' v(pon_a)='vdd_val-0.8'
.nodeset v(ibn_b)=0.75 v(pop_b)='vdd_val-0.8' v(pon_b)='vdd_val-0.8'
.nodeset v(ibn_c)=0.75 v(pop_c)='vdd_val-0.8' v(pon_c)='vdd_val-0.8'
.nodeset v(ibn_d)=0.75 v(pop_d)='vdd_val-0.8' v(pon_d)='vdd_val-0.8'
.nodeset v(ibn_e)=0.75 v(pop_e)='vdd_val-0.8' v(pon_e)='vdd_val-0.8'
.nodeset v(ibn_f)=0.75 v(pop_f)='vdd_val-0.8' v(pon_f)='vdd_val-0.8'
.nodeset v(ibn_g)=0.75 v(pop_g)='vdd_val-0.8' v(pon_g)='vdd_val-0.8'
.nodeset v(ibn_h)=0.75 v(pop_h)='vdd_val-0.8' v(pon_h)='vdd_val-0.8'
.nodeset v(ibn_i)=0.75 v(pop_i)='vdd_val-0.8' v(pon_i)='vdd_val-0.8'
.nodeset v(ibn_j)=0.75 v(pop_j)='vdd_val-0.8' v(pon_j)='vdd_val-0.8'

.param dvp=2m
.param vcm_nom=1.65
.param vcm_dn=1.60
.param vcm_up=1.70
.param vcm_lo=0.825
.param vcm_hi=2.475
.param ib=10u

vsup vdd 0 dc {vdd_val}

* Shared differential stimuli: 0 V and the +2 mV gain probe.
vd0 vd0 0 dc 0
vd1 vd1 0 dc {dvp}

* --- CM = 1.65 V (differential mode; the accuracy-critical point) -------
vcm_a  cm_a 0 dc {vcm_nom}
Eap_a  ap_a cm_a vd0 0 0.5
Ean_a  an_a cm_a vd0 0 -0.5
ib_a   vdd  ibn_a dc {ib}
Xa     ap_a an_a ibn_a pop_a pon_a vdd 0 preamp

Eap_b  ap_b cm_a vd1 0 0.5
Ean_b  an_b cm_a vd1 0 -0.5
ib_b   vdd  ibn_b dc {ib}
Xb     ap_b an_b ibn_b pop_b pon_b vdd 0 preamp

* --- CM = 1.60 V (late-trial excursion, low side) -----------------------
vcm_c  cm_c 0 dc {vcm_dn}
Eap_c  ap_c cm_c vd0 0 0.5
Ean_c  an_c cm_c vd0 0 -0.5
ib_c   vdd  ibn_c dc {ib}
Xc     ap_c an_c ibn_c pop_c pon_c vdd 0 preamp

Eap_d  ap_d cm_c vd1 0 0.5
Ean_d  an_d cm_c vd1 0 -0.5
ib_d   vdd  ibn_d dc {ib}
Xd     ap_d an_d ibn_d pop_d pon_d vdd 0 preamp

* --- CM = 1.70 V (late-trial excursion, high side) ----------------------
vcm_e  cm_e 0 dc {vcm_up}
Eap_e  ap_e cm_e vd0 0 0.5
Ean_e  an_e cm_e vd0 0 -0.5
ib_e   vdd  ibn_e dc {ib}
Xe     ap_e an_e ibn_e pop_e pon_e vdd 0 preamp

Eap_f  ap_f cm_e vd1 0 0.5
Ean_f  an_f cm_e vd1 0 -0.5
ib_f   vdd  ibn_f dc {ib}
Xf     ap_f an_f ibn_f pop_f pon_f vdd 0 preamp

* --- CM = 0.825 V (single-ended MSB trial, low extreme; FUNCTIONAL) -----
vcm_g  cm_g 0 dc {vcm_lo}
Eap_g  ap_g cm_g vd0 0 0.5
Ean_g  an_g cm_g vd0 0 -0.5
ib_g   vdd  ibn_g dc {ib}
Xg     ap_g an_g ibn_g pop_g pon_g vdd 0 preamp

Eap_h  ap_h cm_g vd1 0 0.5
Ean_h  an_h cm_g vd1 0 -0.5
ib_h   vdd  ibn_h dc {ib}
Xh     ap_h an_h ibn_h pop_h pon_h vdd 0 preamp

* --- CM = 2.475 V (single-ended MSB trial, high extreme; FUNCTIONAL) ----
vcm_i  cm_i 0 dc {vcm_hi}
Eap_i  ap_i cm_i vd0 0 0.5
Ean_i  an_i cm_i vd0 0 -0.5
ib_i   vdd  ibn_i dc {ib}
Xi     ap_i an_i ibn_i pop_i pon_i vdd 0 preamp

Eap_j  ap_j cm_i vd1 0 0.5
Ean_j  an_j cm_i vd1 0 -0.5
ib_j   vdd  ibn_j dc {ib}
Xj     ap_j an_j ibn_j pop_j pon_j vdd 0 preamp

* --- Load-resistor probe -----------------------------------------------
* One more ppolyf_u_2k, identical to the preamp loads, carrying a forced
* 1 uA so that v(rprobe) reads the load resistance directly (1 uA * R).
* It separates "the gain moved because gm moved" from "the gain moved
* because the poly sheet moved" -- and it is the only thing in this deck
* that is sensitive to the resistor corner sections, so it is also the
* per-axis sensitivity anchor for those.
irp    0 rprobe dc 1u
Xrp    rprobe 0 0 ppolyf_u_2k r_width=1u r_length=75u

* --- COMPARATOR-NETLIST-BEGIN (verbatim-copied into every testbench) ---
.subckt preamp vinp vinn ibias pop pon vdd vss
* 1:1 NMOS current mirror; ibias is forced into the diode branch.
Xmb  ibias ibias vss vss nfet_03v3 w=20u l=2u
Xmt  ptail ibias vss vss nfet_03v3 w=20u l=2u
* Input pair. The device whose gate is vinp drives the INVERTING node
* pon, so v(pop) - v(pon) = +A_v * (v(vinp) - v(vinn)).
Xmip pon vinp ptail vss nfet_03v3 w=40u l=1u
Xmin pop vinn ptail vss nfet_03v3 w=40u l=1u
* Unsalicided 2 kohm/sq p+ poly loads, 75 squares = 150 kohm nominal.
* Third terminal is the substrate/body contact.
Xrlp vdd pop vss ppolyf_u_2k r_width=1u r_length=75u
Xrln vdd pon vss ppolyf_u_2k r_width=1u r_length=75u
.ends preamp

.subckt sarlatch inp inn clk outp outn vdd vss
* clk low  -> tail off; outp/outn/dip/din precharged to vdd
* clk high -> tail on; the input pair discharges dip/din at rates set by
*             v(inp)/v(inn), then the cross-coupled pairs regenerate.
Xmlt ltail clk   vss   vss nfet_03v3 w=16u l=0.35u
Xmlp dip   inp   ltail vss nfet_03v3 w=8u  l=0.5u
Xmln din   inn   ltail vss nfet_03v3 w=8u  l=0.5u
Xmnp outn  outp  dip   vss nfet_03v3 w=6u  l=0.35u
Xmnn outp  outn  din   vss nfet_03v3 w=6u  l=0.35u
Xmpp outn  outp  vdd   vdd pfet_03v3 w=8u  l=0.35u
Xmpn outp  outn  vdd   vdd pfet_03v3 w=8u  l=0.35u
Xmrp outn  clk   vdd   vdd pfet_03v3 w=4u  l=0.35u
Xmrn outp  clk   vdd   vdd pfet_03v3 w=4u  l=0.35u
Xmrd dip   clk   vdd   vdd pfet_03v3 w=2u  l=0.35u
Xmre din   clk   vdd   vdd pfet_03v3 w=2u  l=0.35u
.ends sarlatch

.subckt nand2 a b y vdd vss
Xp1 y  a vdd vdd pfet_03v3 w=8u l=0.35u
Xp2 y  b vdd vdd pfet_03v3 w=8u l=0.35u
Xn1 y  a ns  vss nfet_03v3 w=8u l=0.35u
Xn2 ns b vss vss nfet_03v3 w=8u l=0.35u
.ends nand2

.subckt comparator vinp vinn clk ibias dout doutb vdd vss
Xpre preamp_in1 preamp_in2 ibias pop pon vdd vss preamp
Xlat pop pon clk outp outn vdd vss sarlatch
* Both StrongARM outputs precharge HIGH, so the decision arrives as an
* active-low pulse on exactly one of them; a NAND SR latch holds it.
* dout goes HIGH when outn falls, i.e. when v(vinp) > v(vinn).
Xna1 outn  doutb dout  vdd vss nand2
Xna2 outp  dout  doutb vdd vss nand2
* Input pass-through (zero-volt sources) so a testbench can probe the
* current the comparator draws from each CDAC top plate directly.
Vpp preamp_in1 vinp dc 0
Vpn preamp_in2 vinn dc 0
.ends comparator
* --- COMPARATOR-NETLIST-END ---
