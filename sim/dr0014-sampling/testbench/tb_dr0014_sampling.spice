* ==================================================================
* tb_dr0014_sampling -- THE FOUR TERMS DR-0014'S DERIVATION ASSUMES
* AWAY, each as a measured number (issue #61).
*
* GENERATED by design/adc-top/gen_adc_top.py -- do not edit.
*
* DR-0014 moves the sampling phase from the CDAC top plate to the
* bottom plates. Its charge-balance derivation shows that
* k = C_arr/(C_arr + C_par) then multiplies the sampled input and
* every DAC step alike, so it cancels from the comparator's decision
* instead of dividing the DAC step alone. That derivation is exact
* only if four things are negligible, and the record itself says so:
*
*   1. the top-plate V_cm switch's own charge injection, and its
*      side-to-side MISMATCH (the injection is claimed to be
*      signal-independent -- an offset -- which is the classic reason
*      to sample on the bottom plate, and is SHOWN here, not assumed);
*   2. the bottom-plate input switches' injection, which happens one
*      whole bit cycle AFTER the top-plate switch has opened, i.e.
*      onto a node that is already isolated;
*   3. the fourth leg's cost in bit-trial settling -- one more T-gate's
*      junction and overlap load on every bottom plate, against the
*      31.25 ns settling half of the bit cycle;
*   4. the second-order residue left by C_par MISMATCH between the two
*      sides, i.e. what survives the first-order cancellation.
*
* It also re-takes the two measurements DR-0014 invalidated the prior
* evidence for: the sampling path's own gain error and linearity
* (DR-0012/DR-0013's 0.421 LSB was measured on a dedicated top-plate
* switch that no longer exists), and the series R_on of the new input
* path -- nine parallel cell T-gates per side, not one 40u/80u switch.
*
* METHOD. One transient carries DR-0014's real two-phase schedule on
* DR-0003's 62.5 ns clock:
*   0 .. 187.5 ns      acquire: top plate held at V_cm by its own
*                     switch, every bottom plate on V_in
*   187.5 ns          THE SAMPLING INSTANT -- the top-plate switch
*                     opens and the top node floats
*   250 ns          the bottom plates leave V_in for V_cm, one
*                     whole bit cycle later
*   375 ns          one bit trial: weight 256 engaged, p side to
*                     V_REF and n side to GND (MCS, DR-0011)
*
* Nothing else moves at the sampling instant, which is what makes
* term 1 DIRECTLY measurable: the top plate sits at V_cm before that
* edge by construction, so its displacement after it IS the switch's
* injection, with no reference simulation and no subtraction of two
* large numbers. Term 2 is read the same way at the f = 0 level, where
* both sides sit at V_cm and the ideal sampled step is exactly zero.
*
* V_REF AND V_cm ARE IDEAL SOURCES HERE, deliberately, and this is the
* one place this deck differs from sim/adc-inl-dnl/. DR-0002's
* reference network is a shared node; with 18 array sides on one deck
* it would couple every branch to every other and the A/B comparisons
* below -- which are differences of two branches -- would report that
* coupling as the effect under test. Reference droop is a real term
* and it is measured, with the real network, by sim/adc-inl-dnl/ and
* sim/adc-power/; it is not double-counted here.
*
* EVERY QUANTITY IS PUBLISHED IN LSB, computed by a B-source inside
* the netlist rather than by the measure expression, because the
* harness does not expose `.param lsb` to the `.control` block and LSB
* is supply-dependent (ratiometric spec, README.md note [c]).
* ==================================================================

.param vref={vdd_val}
.param vcm={vdd_val/2}
.param lsb={vdd_val/1024}
.param ibias=10u

* ---- rails -------------------------------------------------------
vddd vddd 0 dc {vdd_val}
vddt vddt 0 dc {vdd_val}
vddc vddc 0 dc {vdd_val}
vrefs vrefn 0 dc {vref}
vcms vcmn 0 dc {vcm}
vonh onh 0 dc {vdd_val}
vonl onl 0 dc 0
* The comparator strobe is held LOW: the latch is in reset and the
* preamp is tracking, which is the state the top plate is in while a
* DAC step settles. Kickback on the strobe edge is a different
* quantity and a different deck (sim/comparator-kickback/).
vcmpstrobe cmpstrobe 0 dc 0

* ---- DR-0014's two-phase sample, as pure edges --------------------
* Each control is one clean edge from an ideal source. The controller
* that generates them from the phase ring is verified separately and
* exhaustively by sim/sar-logic-functional/ (the four-leg one-hot
* invariant and the measured samp_tp -> samp_bp lead); re-deriving
* them here would make this deck's numbers depend on that logic's
* delays instead of on the analog terms it exists to measure.
* `nrel` rises exactly as `smpbp` falls, with matched 100 ps edges --
* the delay balance design/sar-logic/ builds smpb and engnb to hold.
vsmptp smptp 0 pulse({vdd_val} 0 187.5n 100p 100p 10u 20u)
vsmpbp smpbp 0 pulse({vdd_val} 0 250n 100p 100p 10u 20u)
vnrel  nrel  0 pulse(0 {vdd_val} 250n 100p 100p 10u 20u)
* weight 256's release leg: engaged at the trial, so it is high only
* between the end of the sample and the trial edge.
vnrel256 nrel256 0 pwl(0 0 250n 0 250.1n {vdd_val} 375n {vdd_val} 375.1n 0)
vhi256 hi256 0 pulse(0 {vdd_val} 375n 100p 100p 10u 20u)
vlo256 lo256 0 pulse(0 {vdd_val} 375n 100p 100p 10u 20u)
* the settling branches never sample, so their weight-256 release leg
* is high from t = 0 until the trial edge.
vbrel brel 0 pwl(0 {vdd_val} 375n {vdd_val} 375.1n 0)

* ==================================================================
* GROUP A -- terms 1 and 2, plus the sampling path's gain and
* linearity. Five differential pairs, identical except for the input.
* ==================================================================
* ---- pair a0: differential input f = -0.900 x V_cm
va0srcp a0_srcp 0 dc {vcm*0.09999999999999998}
Ra0sp a0_srcp a0_pinp 25
Ca0xp a0_pinp 0 1n
Xa0tswp a0_topp vcmn smptp vddt 0 adc_tp_sw
Xa0arrp a0_topp a0_pinp vrefn vcmn 0 vddd smpbp nrel256 hi256 onl nrel onl
+ onl nrel onl onl nrel onl onl nrel onl onl nrel onl onl nrel onl onl
+ nrel onl onl nrel onl onl adc_cdac_side
va0srcn a0_srcn 0 dc {vcm*1.9}
Ra0sn a0_srcn a0_pinn 25
Ca0xn a0_pinn 0 1n
Xa0tswn a0_topn vcmn smptp vddt 0 adc_tp_sw
Xa0arrn a0_topn a0_pinn vrefn vcmn 0 vddd smpbp nrel256 onl lo256 nrel onl
+ onl nrel onl onl nrel onl onl nrel onl onl nrel onl onl nrel onl onl
+ nrel onl onl nrel onl onl adc_cdac_side
ia0b vddc a0_ib dc {ibias}
Xa0cmp a0_topp a0_topn cmpstrobe a0_ib a0_do a0_dob vddc 0 comparator
.nodeset v(a0_do)=0 v(a0_dob)={vdd_val}
ba0dp a0_dp 0 V = (v(a0_topp)-vcm)/lsb
ba0dn a0_dn 0 V = (v(a0_topn)-vcm)/lsb
ba0dd a0_dd 0 V = (v(a0_topp)-v(a0_topn))/lsb

* ---- pair a1: differential input f = -0.450 x V_cm
va1srcp a1_srcp 0 dc {vcm*0.55}
Ra1sp a1_srcp a1_pinp 25
Ca1xp a1_pinp 0 1n
Xa1tswp a1_topp vcmn smptp vddt 0 adc_tp_sw
Xa1arrp a1_topp a1_pinp vrefn vcmn 0 vddd smpbp nrel256 hi256 onl nrel onl
+ onl nrel onl onl nrel onl onl nrel onl onl nrel onl onl nrel onl onl
+ nrel onl onl nrel onl onl adc_cdac_side
va1srcn a1_srcn 0 dc {vcm*1.45}
Ra1sn a1_srcn a1_pinn 25
Ca1xn a1_pinn 0 1n
Xa1tswn a1_topn vcmn smptp vddt 0 adc_tp_sw
Xa1arrn a1_topn a1_pinn vrefn vcmn 0 vddd smpbp nrel256 onl lo256 nrel onl
+ onl nrel onl onl nrel onl onl nrel onl onl nrel onl onl nrel onl onl
+ nrel onl onl nrel onl onl adc_cdac_side
ia1b vddc a1_ib dc {ibias}
Xa1cmp a1_topp a1_topn cmpstrobe a1_ib a1_do a1_dob vddc 0 comparator
.nodeset v(a1_do)=0 v(a1_dob)={vdd_val}
ba1dp a1_dp 0 V = (v(a1_topp)-vcm)/lsb
ba1dn a1_dn 0 V = (v(a1_topn)-vcm)/lsb
ba1dd a1_dd 0 V = (v(a1_topp)-v(a1_topn))/lsb

* ---- pair a2: differential input f = +0.000 x V_cm
va2srcp a2_srcp 0 dc {vcm*1.0}
Ra2sp a2_srcp a2_pinp 25
Ca2xp a2_pinp 0 1n
Xa2tswp a2_topp vcmn smptp vddt 0 adc_tp_sw
Xa2arrp a2_topp a2_pinp vrefn vcmn 0 vddd smpbp nrel256 hi256 onl nrel onl
+ onl nrel onl onl nrel onl onl nrel onl onl nrel onl onl nrel onl onl
+ nrel onl onl nrel onl onl adc_cdac_side
va2srcn a2_srcn 0 dc {vcm*1.0}
Ra2sn a2_srcn a2_pinn 25
Ca2xn a2_pinn 0 1n
Xa2tswn a2_topn vcmn smptp vddt 0 adc_tp_sw
Xa2arrn a2_topn a2_pinn vrefn vcmn 0 vddd smpbp nrel256 onl lo256 nrel onl
+ onl nrel onl onl nrel onl onl nrel onl onl nrel onl onl nrel onl onl
+ nrel onl onl nrel onl onl adc_cdac_side
ia2b vddc a2_ib dc {ibias}
Xa2cmp a2_topp a2_topn cmpstrobe a2_ib a2_do a2_dob vddc 0 comparator
.nodeset v(a2_do)=0 v(a2_dob)={vdd_val}
ba2dp a2_dp 0 V = (v(a2_topp)-vcm)/lsb
ba2dn a2_dn 0 V = (v(a2_topn)-vcm)/lsb
ba2dd a2_dd 0 V = (v(a2_topp)-v(a2_topn))/lsb

* ---- pair a3: differential input f = +0.450 x V_cm
va3srcp a3_srcp 0 dc {vcm*1.45}
Ra3sp a3_srcp a3_pinp 25
Ca3xp a3_pinp 0 1n
Xa3tswp a3_topp vcmn smptp vddt 0 adc_tp_sw
Xa3arrp a3_topp a3_pinp vrefn vcmn 0 vddd smpbp nrel256 hi256 onl nrel onl
+ onl nrel onl onl nrel onl onl nrel onl onl nrel onl onl nrel onl onl
+ nrel onl onl nrel onl onl adc_cdac_side
va3srcn a3_srcn 0 dc {vcm*0.55}
Ra3sn a3_srcn a3_pinn 25
Ca3xn a3_pinn 0 1n
Xa3tswn a3_topn vcmn smptp vddt 0 adc_tp_sw
Xa3arrn a3_topn a3_pinn vrefn vcmn 0 vddd smpbp nrel256 onl lo256 nrel onl
+ onl nrel onl onl nrel onl onl nrel onl onl nrel onl onl nrel onl onl
+ nrel onl onl nrel onl onl adc_cdac_side
ia3b vddc a3_ib dc {ibias}
Xa3cmp a3_topp a3_topn cmpstrobe a3_ib a3_do a3_dob vddc 0 comparator
.nodeset v(a3_do)=0 v(a3_dob)={vdd_val}
ba3dp a3_dp 0 V = (v(a3_topp)-vcm)/lsb
ba3dn a3_dn 0 V = (v(a3_topn)-vcm)/lsb
ba3dd a3_dd 0 V = (v(a3_topp)-v(a3_topn))/lsb

* ---- pair a4: differential input f = +0.900 x V_cm
va4srcp a4_srcp 0 dc {vcm*1.9}
Ra4sp a4_srcp a4_pinp 25
Ca4xp a4_pinp 0 1n
Xa4tswp a4_topp vcmn smptp vddt 0 adc_tp_sw
Xa4arrp a4_topp a4_pinp vrefn vcmn 0 vddd smpbp nrel256 hi256 onl nrel onl
+ onl nrel onl onl nrel onl onl nrel onl onl nrel onl onl nrel onl onl
+ nrel onl onl nrel onl onl adc_cdac_side
va4srcn a4_srcn 0 dc {vcm*0.09999999999999998}
Ra4sn a4_srcn a4_pinn 25
Ca4xn a4_pinn 0 1n
Xa4tswn a4_topn vcmn smptp vddt 0 adc_tp_sw
Xa4arrn a4_topn a4_pinn vrefn vcmn 0 vddd smpbp nrel256 onl lo256 nrel onl
+ onl nrel onl onl nrel onl onl nrel onl onl nrel onl onl nrel onl onl
+ nrel onl onl nrel onl onl adc_cdac_side
ia4b vddc a4_ib dc {ibias}
Xa4cmp a4_topp a4_topn cmpstrobe a4_ib a4_do a4_dob vddc 0 comparator
.nodeset v(a4_do)=0 v(a4_dob)={vdd_val}
ba4dp a4_dp 0 V = (v(a4_topp)-vcm)/lsb
ba4dn a4_dn 0 V = (v(a4_topn)-vcm)/lsb
ba4dd a4_dd 0 V = (v(a4_topp)-v(a4_topn))/lsb

* ==================================================================
* GROUP B -- term 3. Two single sides, engaged into the same weight-
* 256 trial from the same released state, differing ONLY in whether
* the cell carries DR-0014's fourth leg. Neither samples: `smpbp` is
* not routed to them and their inputs sit at V_cm, so what is
* compared is the bit trial alone.
* ==================================================================
* b4: the DR-0014 four-leg cell, fourth leg present but off
Xb4tsw b4_top vcmn smptp vddt 0 adc_tp_sw
Xb4arr b4_top vcmn vrefn vcmn 0 vddd onl brel hi256 onl onh onl onl onh
+ onl onl onh onl onl onh onl onl onh onl onl onh onl onl onh onl onl onh
+ onl onl adc_cdac_side
ib4b vddc b4_ib dc {ibias}
Xb4cmp b4_top vcmn cmpstrobe b4_ib b4_do b4_dob vddc 0 comparator
.nodeset v(b4_do)=0 v(b4_dob)={vdd_val}
bb4d b4_d 0 V = (v(b4_top)-vcm)/lsb

* b3: the DR-0011 three-leg cell, everything else identical
Xb3tsw b3_top vcmn smptp vddt 0 adc_tp_sw
Xb3arr b3_top vrefn vcmn 0 vddd brel hi256 onl onh onl onl onh onl onl onh
+ onl onl onh onl onl onh onl onl onh onl onl onh onl onl onh onl onl
+ tb3_cdac_side
ib3b vddc b3_ib dc {ibias}
Xb3cmp b3_top vcmn cmpstrobe b3_ib b3_do b3_dob vddc 0 comparator
.nodeset v(b3_do)=0 v(b3_dob)={vdd_val}
bb3d b3_d 0 V = (v(b3_top)-vcm)/lsb

* ==================================================================
* GROUP C -- term 4. The same pair as group A's level 3 (f = +0.450),
* with a deliberate capacitance imbalance on the p top plate. Group
* A's a3 IS the matched reference -- same input, same controls, same
* deck -- so the difference is attributable to the imbalance alone.
* ==================================================================
* ---- pair c0: differential input f = +0.450 x V_cm, +10 fF on the p top plate
vc0srcp c0_srcp 0 dc {vcm*1.45}
Rc0sp c0_srcp c0_pinp 25
Cc0xp c0_pinp 0 1n
Xc0tswp c0_topp vcmn smptp vddt 0 adc_tp_sw
Xc0arrp c0_topp c0_pinp vrefn vcmn 0 vddd smpbp nrel256 hi256 onl nrel onl
+ onl nrel onl onl nrel onl onl nrel onl onl nrel onl onl nrel onl onl
+ nrel onl onl nrel onl onl adc_cdac_side
vc0srcn c0_srcn 0 dc {vcm*0.55}
Rc0sn c0_srcn c0_pinn 25
Cc0xn c0_pinn 0 1n
Xc0tswn c0_topn vcmn smptp vddt 0 adc_tp_sw
Xc0arrn c0_topn c0_pinn vrefn vcmn 0 vddd smpbp nrel256 onl lo256 nrel onl
+ onl nrel onl onl nrel onl onl nrel onl onl nrel onl onl nrel onl onl
+ nrel onl onl nrel onl onl adc_cdac_side
Cc0dcpar c0_topp 0 10f
ic0b vddc c0_ib dc {ibias}
Xc0cmp c0_topp c0_topn cmpstrobe c0_ib c0_do c0_dob vddc 0 comparator
.nodeset v(c0_do)=0 v(c0_dob)={vdd_val}
bc0dp c0_dp 0 V = (v(c0_topp)-vcm)/lsb
bc0dn c0_dn 0 V = (v(c0_topn)-vcm)/lsb
bc0dd c0_dd 0 V = (v(c0_topp)-v(c0_topn))/lsb

* ---- pair c1: differential input f = +0.450 x V_cm, +30 fF on the p top plate
vc1srcp c1_srcp 0 dc {vcm*1.45}
Rc1sp c1_srcp c1_pinp 25
Cc1xp c1_pinp 0 1n
Xc1tswp c1_topp vcmn smptp vddt 0 adc_tp_sw
Xc1arrp c1_topp c1_pinp vrefn vcmn 0 vddd smpbp nrel256 hi256 onl nrel onl
+ onl nrel onl onl nrel onl onl nrel onl onl nrel onl onl nrel onl onl
+ nrel onl onl nrel onl onl adc_cdac_side
vc1srcn c1_srcn 0 dc {vcm*0.55}
Rc1sn c1_srcn c1_pinn 25
Cc1xn c1_pinn 0 1n
Xc1tswn c1_topn vcmn smptp vddt 0 adc_tp_sw
Xc1arrn c1_topn c1_pinn vrefn vcmn 0 vddd smpbp nrel256 onl lo256 nrel onl
+ onl nrel onl onl nrel onl onl nrel onl onl nrel onl onl nrel onl onl
+ nrel onl onl nrel onl onl adc_cdac_side
Cc1dcpar c1_topp 0 30f
ic1b vddc c1_ib dc {ibias}
Xc1cmp c1_topp c1_topn cmpstrobe c1_ib c1_do c1_dob vddc 0 comparator
.nodeset v(c1_do)=0 v(c1_dob)={vdd_val}
bc1dp c1_dp 0 V = (v(c1_topp)-vcm)/lsb
bc1dn c1_dn 0 V = (v(c1_topn)-vcm)/lsb
bc1dd c1_dd 0 V = (v(c1_topp)-v(c1_topn))/lsb

* ---- pair c2: differential input f = +0.450 x V_cm, +100 fF on the p top plate
vc2srcp c2_srcp 0 dc {vcm*1.45}
Rc2sp c2_srcp c2_pinp 25
Cc2xp c2_pinp 0 1n
Xc2tswp c2_topp vcmn smptp vddt 0 adc_tp_sw
Xc2arrp c2_topp c2_pinp vrefn vcmn 0 vddd smpbp nrel256 hi256 onl nrel onl
+ onl nrel onl onl nrel onl onl nrel onl onl nrel onl onl nrel onl onl
+ nrel onl onl nrel onl onl adc_cdac_side
vc2srcn c2_srcn 0 dc {vcm*0.55}
Rc2sn c2_srcn c2_pinn 25
Cc2xn c2_pinn 0 1n
Xc2tswn c2_topn vcmn smptp vddt 0 adc_tp_sw
Xc2arrn c2_topn c2_pinn vrefn vcmn 0 vddd smpbp nrel256 onl lo256 nrel onl
+ onl nrel onl onl nrel onl onl nrel onl onl nrel onl onl nrel onl onl
+ nrel onl onl nrel onl onl adc_cdac_side
Cc2dcpar c2_topp 0 100f
ic2b vddc c2_ib dc {ibias}
Xc2cmp c2_topp c2_topn cmpstrobe c2_ib c2_do c2_dob vddc 0 comparator
.nodeset v(c2_do)=0 v(c2_dob)={vdd_val}
bc2dp c2_dp 0 V = (v(c2_topp)-vcm)/lsb
bc2dn c2_dn 0 V = (v(c2_topn)-vcm)/lsb
bc2dd c2_dd 0 V = (v(c2_topp)-v(c2_topn))/lsb

* ==================================================================
* GROUP D -- the ratified Input-structure row's series R_on, re-taken
* for the path DR-0014 actually built. The input no longer reaches
* the array through one dedicated 40u/80u dummy-compensated T-gate
* (156-570 ohm, sim/device-switch-ron/ + sim/track-switch-sampling/):
* it reaches it through NINE 10u/20u cell T-gates per side, one per
* weight, in parallel. Forced-voltage / measured-current, the same
* method sim/device-switch-ron/ uses, at five ratiometric levels.
* ==================================================================
* r0: nine parallel legs at V_in = 0.05 x V_DD
vr0s r0_s 0 dc {0.05*vdd_val}
vr0d r0_d 0 dc {0.05*vdd_val-0.001}
Xr0g0 r0_s r0_d onh onl vddd adc_tgate wn=10u wp=20u
Xr0g1 r0_s r0_d onh onl vddd adc_tgate wn=10u wp=20u
Xr0g2 r0_s r0_d onh onl vddd adc_tgate wn=10u wp=20u
Xr0g3 r0_s r0_d onh onl vddd adc_tgate wn=10u wp=20u
Xr0g4 r0_s r0_d onh onl vddd adc_tgate wn=10u wp=20u
Xr0g5 r0_s r0_d onh onl vddd adc_tgate wn=10u wp=20u
Xr0g6 r0_s r0_d onh onl vddd adc_tgate wn=10u wp=20u
Xr0g7 r0_s r0_d onh onl vddd adc_tgate wn=10u wp=20u
Xr0g8 r0_s r0_d onh onl vddd adc_tgate wn=10u wp=20u

* r1: nine parallel legs at V_in = 0.275 x V_DD
vr1s r1_s 0 dc {0.275*vdd_val}
vr1d r1_d 0 dc {0.275*vdd_val-0.001}
Xr1g0 r1_s r1_d onh onl vddd adc_tgate wn=10u wp=20u
Xr1g1 r1_s r1_d onh onl vddd adc_tgate wn=10u wp=20u
Xr1g2 r1_s r1_d onh onl vddd adc_tgate wn=10u wp=20u
Xr1g3 r1_s r1_d onh onl vddd adc_tgate wn=10u wp=20u
Xr1g4 r1_s r1_d onh onl vddd adc_tgate wn=10u wp=20u
Xr1g5 r1_s r1_d onh onl vddd adc_tgate wn=10u wp=20u
Xr1g6 r1_s r1_d onh onl vddd adc_tgate wn=10u wp=20u
Xr1g7 r1_s r1_d onh onl vddd adc_tgate wn=10u wp=20u
Xr1g8 r1_s r1_d onh onl vddd adc_tgate wn=10u wp=20u

* r2: nine parallel legs at V_in = 0.5 x V_DD
vr2s r2_s 0 dc {0.5*vdd_val}
vr2d r2_d 0 dc {0.5*vdd_val-0.001}
Xr2g0 r2_s r2_d onh onl vddd adc_tgate wn=10u wp=20u
Xr2g1 r2_s r2_d onh onl vddd adc_tgate wn=10u wp=20u
Xr2g2 r2_s r2_d onh onl vddd adc_tgate wn=10u wp=20u
Xr2g3 r2_s r2_d onh onl vddd adc_tgate wn=10u wp=20u
Xr2g4 r2_s r2_d onh onl vddd adc_tgate wn=10u wp=20u
Xr2g5 r2_s r2_d onh onl vddd adc_tgate wn=10u wp=20u
Xr2g6 r2_s r2_d onh onl vddd adc_tgate wn=10u wp=20u
Xr2g7 r2_s r2_d onh onl vddd adc_tgate wn=10u wp=20u
Xr2g8 r2_s r2_d onh onl vddd adc_tgate wn=10u wp=20u

* r3: nine parallel legs at V_in = 0.725 x V_DD
vr3s r3_s 0 dc {0.725*vdd_val}
vr3d r3_d 0 dc {0.725*vdd_val-0.001}
Xr3g0 r3_s r3_d onh onl vddd adc_tgate wn=10u wp=20u
Xr3g1 r3_s r3_d onh onl vddd adc_tgate wn=10u wp=20u
Xr3g2 r3_s r3_d onh onl vddd adc_tgate wn=10u wp=20u
Xr3g3 r3_s r3_d onh onl vddd adc_tgate wn=10u wp=20u
Xr3g4 r3_s r3_d onh onl vddd adc_tgate wn=10u wp=20u
Xr3g5 r3_s r3_d onh onl vddd adc_tgate wn=10u wp=20u
Xr3g6 r3_s r3_d onh onl vddd adc_tgate wn=10u wp=20u
Xr3g7 r3_s r3_d onh onl vddd adc_tgate wn=10u wp=20u
Xr3g8 r3_s r3_d onh onl vddd adc_tgate wn=10u wp=20u

* r4: nine parallel legs at V_in = 0.95 x V_DD
vr4s r4_s 0 dc {0.95*vdd_val}
vr4d r4_d 0 dc {0.95*vdd_val-0.001}
Xr4g0 r4_s r4_d onh onl vddd adc_tgate wn=10u wp=20u
Xr4g1 r4_s r4_d onh onl vddd adc_tgate wn=10u wp=20u
Xr4g2 r4_s r4_d onh onl vddd adc_tgate wn=10u wp=20u
Xr4g3 r4_s r4_d onh onl vddd adc_tgate wn=10u wp=20u
Xr4g4 r4_s r4_d onh onl vddd adc_tgate wn=10u wp=20u
Xr4g5 r4_s r4_d onh onl vddd adc_tgate wn=10u wp=20u
Xr4g6 r4_s r4_d onh onl vddd adc_tgate wn=10u wp=20u
Xr4g7 r4_s r4_d onh onl vddd adc_tgate wn=10u wp=20u
Xr4g8 r4_s r4_d onh onl vddd adc_tgate wn=10u wp=20u

* ---- DR-0011 three-leg reference cell (deck-local A/B partner) ------
* The three legs call the SAME folded adc_tgate_f the shipped cell's
* legs call (DR-0050), so this stays exactly `adc_cdac_cell` minus
* the fourth leg and its driver -- the property
* test_the_three_leg_ab_partner_is_the_shipped_cell_minus_one_leg
* asserts and DR-0014's Term-3 attribution rests on.
.subckt tb3_cdac_cell top vref vcm vss vdd gn_rel gn_hi gn_lo
+ cw=10u cl=10u
Xc  top bp mim_cap_2f0 c_width='cw' c_length='cl'
Xdr gn_rel gp_rel vdd vss adc_drv
Xdh gn_hi  gp_hi  vdd vss adc_drv
Xdl gn_lo  gp_lo  vdd vss adc_drv
Xsr vcm  bp gn_rel gp_rel vdd adc_tgate_f
Xsh vref bp gn_hi  gp_hi  vdd adc_tgate_f
Xsl vss  bp gn_lo  gp_lo  vdd adc_tgate_f
.ends tb3_cdac_cell

.subckt tb3_cdac_side top vref vcm vss vdd rel_256 hi_256 lo_256 rel_128
+ hi_128 lo_128 rel_64 hi_64 lo_64 rel_32 hi_32 lo_32 rel_16 hi_16 lo_16
+ rel_8 hi_8 lo_8 rel_4 hi_4 lo_4 rel_2 hi_2 lo_2 rel_1 hi_1 lo_1
X256 top vref vcm vss vdd rel_256 hi_256 lo_256 tb3_cdac_cell cw=67.4846u cl=67.4846u
X128 top vref vcm vss vdd rel_128 hi_128 lo_128 tb3_cdac_cell cw=47.6489u cl=47.6489u
X64 top vref vcm vss vdd rel_64 hi_64 lo_64 tb3_cdac_cell cw=33.6232u cl=33.6232u
X32 top vref vcm vss vdd rel_32 hi_32 lo_32 tb3_cdac_cell cw=23.7056u cl=23.7056u
X16 top vref vcm vss vdd rel_16 hi_16 lo_16 tb3_cdac_cell cw=16.6931u cl=16.6931u
X8 top vref vcm vss vdd rel_8 hi_8 lo_8 tb3_cdac_cell cw=11.7349u cl=11.7349u
X4 top vref vcm vss vdd rel_4 hi_4 lo_4 tb3_cdac_cell cw=8.2293u cl=8.2293u
X2 top vref vcm vss vdd rel_2 hi_2 lo_2 tb3_cdac_cell cw=5.7513u cl=5.7513u
X1 top vref vcm vss vdd rel_1 hi_1 lo_1 tb3_cdac_cell cw=4.0000u cl=4.0000u
Xterm top vcm mim_cap_2f0 c_width=4.0000u c_length=4.0000u
.ends tb3_cdac_side

* ==================================================================
* The three netlists below are COPIES, kept honest by unit tests:
*   design/comparator/comparator.spice   (test_comparator_netlist)
*   design/sar-logic/sar_ctrl.spice      (test_sar_logic_netlist)
*   design/adc-top/adc_top.spice         (test_adc_top_netlist)
* sim/harness/testbench.py rejects .include in a fragment, so a
* testbench has to carry its DUT inline; generating the copies is
* what stops them drifting from the design they claim to verify.
* ==================================================================

* --- COMPARATOR-NETLIST-BEGIN (verbatim-copied into every testbench) ---
.subckt preamp vinp vinn ibias pop pon vdd vss
* 1:1 NMOS current mirror; ibias is forced into the diode branch.
Xmb  ibias ibias vss vss nfet_03v3 w=20u l=2u
Xmt  ptail ibias vss vss nfet_03v3 w=20u l=2u
* Input pair. The device whose gate is vinp drives the INVERTING node
* pon, so v(pop) - v(pon) = +A_v * (v(vinp) - v(vinn)).
Xmip pon vinp ptail vss nfet_03v3 w=40u l=1u
Xmin pop vinn ptail vss nfet_03v3 w=40u l=1u
* Unsalicided 1 kohm/sq p+ poly loads, 150 squares = 150 kohm nominal.
* Third terminal is the substrate/body contact. `ppolyf_u_1k`, not the
* 2 kohm/sq `ppolyf_u_2k` an earlier revision assumed: issue #118 drew
* SAB(49/0)+RES_MK(110/5)+Resistor(62/0) markers over the load-resistor
* bodies so `klt extract`'s gf180mcu deck recognises them as real devices
* instead of a Poly2 short, and at this repo's pinned klt commit that
* marker geometry can only select `ppolyf_u_1k` (1000 ohm/sq) -- the
* `_2k`/`_3k` flavours share the identical drawn geometry and are chosen by
* a build-time deck option this curated deck does not implement
* (`2AMLogic/klayout-tools#595`, open). `r_length` is doubled (75u -> 150u)
* at the same `r_width=1u` to preserve the 150 kohm target at the new
* sheet-rho -- see layout/adc-top/README.md "Resistors".
Xrlp vdd pop vss ppolyf_u_1k r_width=1u r_length=150u
Xrln vdd pon vss ppolyf_u_1k r_width=1u r_length=150u
.ends preamp

.subckt sarlatch inp inn clk outp outn vdd vss
* clk low  -> tail off; outp/outn/dip/din precharged to vdd
* clk high -> tail on; the input pair discharges dip/din at rates set by
*             v(inp)/v(inn), then the cross-coupled pairs regenerate.
Xmlt ltail clk   vss   vss nfet_03v3 w=16u l=0.35u
Xmlp dip   inp   ltail vss nfet_03v3 w=8u  l=0.5u
Xmln din   inn   ltail vss nfet_03v3 w=8u  l=0.5u
Xmnp outn  outp  dip   vss nfet_03v3 w=6u  l=0.35u
Xmnn outp  outn  din   vss nfet_03v3 w=6u  l=0.35u
Xmpp outn  outp  vdd   vdd pfet_03v3 w=8u  l=0.35u
Xmpn outp  outn  vdd   vdd pfet_03v3 w=8u  l=0.35u
Xmrp outn  clk   vdd   vdd pfet_03v3 w=4u  l=0.35u
Xmrn outp  clk   vdd   vdd pfet_03v3 w=4u  l=0.35u
Xmrd dip   clk   vdd   vdd pfet_03v3 w=2u  l=0.35u
Xmre din   clk   vdd   vdd pfet_03v3 w=2u  l=0.35u
.ends sarlatch

* Minimum-ish isolation inverter. Deliberately small: it is the only
* thing the regeneration nodes drive, so its gate capacitance is added
* directly to the latch's own output nodes and shows up as regeneration
* time.
.subckt inv a y vdd vss
Xp y a vdd vdd pfet_03v3 w=2u   l=0.35u
Xn y a vss vss nfet_03v3 w=1u   l=0.35u
.ends inv

.subckt nor2 a b y vdd vss
Xp1 ps a vdd vdd pfet_03v3 w=8u l=0.35u
Xp2 y  b ps  vdd pfet_03v3 w=8u l=0.35u
Xn1 y  a vss vss nfet_03v3 w=4u l=0.35u
Xn2 y  b vss vss nfet_03v3 w=4u l=0.35u
.ends nor2

.subckt comparator vinp vinn clk ibias dout doutb vdd vss
Xpre preamp_in1 preamp_in2 ibias pop pon vdd vss preamp
Xlat pop pon clk outp outn vdd vss sarlatch
* THE ISOLATION INVERTERS ARE NOT OPTIONAL -- they fix a measured
* hysteresis defect. Both StrongARM outputs precharge HIGH, so the
* decision arrives as an active-low pulse on exactly one of them, and
* the obvious way to hold it is a NAND SR latch wired straight to
* outp/outn. That circuit was built first and MEASURED: after deciding
* one way it would not flip back until the input reached ~10 mV of the
* opposite polarity -- about 3 LSB of hysteresis, which in a SAR (where
* the same comparator makes ten successive decisions on a shrinking
* residue) is a code-dependent error, not an offset.
*
* The cause is that a NAND SR latch's HELD STATE loads the two
* regeneration nodes asymmetrically. Wired directly, the node driving
* the NAND whose output is LOW sees that output swing when it falls
* (Miller-multiplied C_gd, ~26 fF against a regeneration node of a few
* tens of fF), while its twin drives a NAND whose output is already
* HIGH and stays there. The latch is therefore biased toward keeping
* the answer it already holds.
*
* Interposing one small inverter per side removes the coupling: the
* inverters are identical, both of their inputs precharge to V_DD, and
* neither loading depends on what the SR latch is holding. The SR latch
* becomes NOR-type because the inverters make the decision pulses
* active-HIGH. dout goes HIGH when outn falls, i.e. when
* v(vinp) > v(vinn), exactly as before.
Xis outn sset vdd vss inv
Xir outp srst vdd vss inv
Xno1 srst doutb dout  vdd vss nor2
Xno2 sset dout  doutb vdd vss nor2
* Input pass-through (zero-volt sources) so a testbench can probe the
* current the comparator draws from each CDAC top plate directly.
Vpp preamp_in1 vinp dc 0
Vpn preamp_in2 vinn dc 0
.ends comparator
* --- COMPARATOR-NETLIST-END ---

* ------------------------------------------------------------------
* sar_ctrl.spice -- synchronous SAR control logic, rung-1 abstraction
*
* GENERATED by design/sar-logic/gen_sar_logic.py -- do not edit.
*
* Ideal XSPICE event-driven digital primitives (digital.cm: d_dff,
* d_and, d_or, d_inverter) plus adc_bridge/dac_bridge at the analog
* boundary. This is rung 1 of the fidelity ladder in DR-0010: it fixes
* the SEQUENCING and the SWITCH DECODE, and deliberately says nothing
* about gf180mcu gate delay (rung 3 / sim/sar-logic-cell-delay/ owns
* that).
*
* Conversion, M = 16 clocks (DR-0003), with DR-0014's TWO-PHASE
* BOTTOM-PLATE sample laid inside the same 4-clock sample window:
*   ph0..ph2   acquire  samp_tp and samp_bp both asserted: the top
*                       plate is held at Vcm by its own switch and
*                       every bottom plate tracks V_in through the
*                       cell's fourth leg
*   ph2->ph3   THE SAMPLING INSTANT -- samp_tp falls, the top-plate
*                       switch opens and the top node floats
*   ph3        the bottom plates stay on V_in one more clock
*   ph3->ph4   samp_bp falls a full bit cycle after the sampling
*                       instant: the bottom plates leave V_in for Vcm
*                       onto a node that is ALREADY isolated, which
*                       is the whole reason bottom-plate sampling is
*                       worth a fourth leg (DR-0014, README note [d])
*   ph4        trial 1  free MSB -- no array switching at all, the
*                       comparator decides the sign of the sampled
*                       residue (DR-0014 keeps DR-0011's free MSB)
*   ph5..ph13  trials 2..10, weights 256,128,...,1 engaged in turn
*   ph14       output register loads the 10 decisions
*   ph15       drdy asserted; array released back to Vcm
*
* Switch decode per weight w and side s -- FOUR one-hot legs per cell
* now, not three -- from the slice's own engage flag `eng`, the
* direction bit `dir` (= the decision of the PREVIOUS trial, which is
* also that trial's output bit) and the shared sample control `smp`:
*   in  = smp                      bottom plate on V_in (DR-0014)
*   rel = !eng & !smp              bottom plate parked at Vcm
*   p-side:  hi = eng &  dir       -> V_REF      lo = eng & !dir -> GND
*   n-side:  hi = eng & !dir       -> V_REF      lo = eng &  dir -> GND
*   n-side is additionally gated by `mode` (1 = differential): in
*   single-ended mode every n-side cell stays released to Vcm for the
*   whole conversion, per DR-0011 -- driving it too would double every
*   step and cost a bit of resolution. The `in` leg is NOT mode-gated:
*   both sides must acquire their own input pin, and DR-0011's mode
*   rule is about bit trials, not about the sample phase.
*   `eng` is zero for the whole sample window, so exactly one of the
*   four legs conducts at every instant -- the invariant
*   sim/sar-logic-functional/ measures directly as sw_conflict_*.
*
* Sign convention, RE-DERIVED FOR DR-0014 and the one place the
* superseded record's decode could not simply be carried forward.
* Sampling on the bottom plate INVERTS the residue with respect to the
* input: after the sample, top_p - top_n = -k*(V_inp - V_inn). The
* comparator is wired conventionally (cmp = 1 when top_p > top_n), so
* the controller inverts it ONCE at its own boundary --
*
*     dec = !cmp    = 1 when the sampled input is ABOVE the DAC's
*                     current estimate, i.e. 'add this weight'
*
* -- and `dir` therefore still holds the OUTPUT BIT of its position,
* exactly as under DR-0011, at the cost of the hi/lo assignment above
* being the mirror of DR-0011's. Inverting only one of the two would
* either diverge (right code polarity, wrong feedback direction) or
* emit the one's complement of the code (right feedback, wrong bits);
* both were checked against the closed loop before this form was
* chosen, and sim/sar-logic-functional/ falsifies either error on
* every one of the 1024 codes in both modes.
* ------------------------------------------------------------------

* --- ideal digital primitives -------------------------------------
.model sarl_dff d_dff(clk_delay=0.5n set_delay=0.5n
+ reset_delay=0.5n ic=0 rise_delay=0.5n fall_delay=0.5n)
.model sarl_dff1 d_dff(clk_delay=0.5n set_delay=0.5n
+ reset_delay=0.5n ic=1 rise_delay=0.5n fall_delay=0.5n)
.model sarl_and d_and(rise_delay=0.2n fall_delay=0.2n input_load=0)
.model sarl_or d_or(rise_delay=0.2n fall_delay=0.2n input_load=0)
.model sarl_inv d_inverter(rise_delay=0.2n fall_delay=0.2n
+ input_load=0)

* --- enabled bit register -----------------------------------------
* Captures `d` on the clock edge that ENDS the phase in which `en` is
* asserted, and holds otherwise. Written as an explicit D-mux rather
* than a gated clock: gating the clock with a phase signal that itself
* changes one gate delay after the clock edge creates a spurious
* rising edge on the gated clock, which is a real bug in a real
* implementation, not just in this model.
.subckt sar_bitreg clk d en q qb
a_inv en enb sarl_inv
a_sel [en d] dsel sarl_and
a_hold [enb q] dhold sarl_and
a_mux [dsel dhold] dnext sarl_or
a_ff dnext clk NULL NULL q qb sarl_dff
.ends sar_bitreg

* --- one bit slice: engage flag + direction bit + switch decode -----
* `arm`     one-hot phase pulse of the trial BEFORE this slice's own
*           trial: the slice engages on the edge entering its trial,
*           and the direction bit captures the decision made during
*           `arm` (which is also this bit position's output bit).
* `endconv` forces the engage flag low on the edge leaving the last
*           trial, releasing the whole array back to Vcm for the next
*           sample phase.
* `dec`     the comparator decision in OUTPUT-BIT polarity (= !cmp;
*           see the sign-convention note in the header).
* `smpb`    the inverse of the shared bottom-plate sample control,
*           distributed already-inverted so that all four legs of the
*           cell come out at the SAME logic depth. That is not
*           cosmetic: `rel` and the V_in leg are complementary during
*           the sample window, so a one-gate depth difference between
*           them opens a window in which a cell drives V_in and Vcm at
*           once -- which is exactly what the one-hot invariant is
*           there to catch, and it would catch this generator.
.subckt sar_slice clk dec mode arm endconv smpb dir dirb
+ rel_p hi_p lo_p rel_n hi_n lo_n
a_set [arm eng] eng_set sarl_or
a_ninv endconv nend sarl_inv
a_keep [eng_set nend] eng_d sarl_and
a_ff eng_d clk NULL NULL eng engb sarl_dff
xdir clk dec arm dir dirb sar_bitreg
* p side: always driven
a_relp [engb smpb] rel_p sarl_and
a_hip [eng dir] hi_p sarl_and
a_lop [eng dirb] lo_p sarl_and
* n side: driven only in differential mode (DR-0011). `engnb` is built
* as !eng | !mode rather than as an inverter on `engn`, so that it
* lands at the same depth as `engn` and rel_n/hi_n/lo_n switch
* together -- the same delay-balance argument as `smpb` above.
a_engn [eng mode] engn sarl_and
a_modeb mode modeb sarl_inv
a_engnb [engb modeb] engnb sarl_or
a_reln [engnb smpb] rel_n sarl_and
a_hin [engn dirb] hi_n sarl_and
a_lon [engn dir] lo_n sarl_and
.ends sar_slice

* --- 16-phase one-hot sequencer ------------------------------------
* A one-hot ring, seeded by ph15's ic=1 so the very first clock edge
* enters ph0 (sample) with exactly one token in the ring. `start`
* forces a synchronous restart: it sets stage 0 and clears every other
* stage on the same edge, so an asserted `start` cannot inject a
* SECOND token alongside the circulating one.
.subckt sar_seq clk start ph0 ph1 ph2 ph3 ph4 ph5 ph6 ph7 ph8 ph9 ph10 ph11 ph12 ph13 ph14 ph15
a_nstart start nstart sarl_inv
a_d0 [ph15 start] d0 sarl_or
a_ff0 d0 clk NULL NULL ph0 ph0b sarl_dff
a_d1 [ph0 nstart] d1 sarl_and
a_ff1 d1 clk NULL NULL ph1 ph1b sarl_dff
a_d2 [ph1 nstart] d2 sarl_and
a_ff2 d2 clk NULL NULL ph2 ph2b sarl_dff
a_d3 [ph2 nstart] d3 sarl_and
a_ff3 d3 clk NULL NULL ph3 ph3b sarl_dff
a_d4 [ph3 nstart] d4 sarl_and
a_ff4 d4 clk NULL NULL ph4 ph4b sarl_dff
a_d5 [ph4 nstart] d5 sarl_and
a_ff5 d5 clk NULL NULL ph5 ph5b sarl_dff
a_d6 [ph5 nstart] d6 sarl_and
a_ff6 d6 clk NULL NULL ph6 ph6b sarl_dff
a_d7 [ph6 nstart] d7 sarl_and
a_ff7 d7 clk NULL NULL ph7 ph7b sarl_dff
a_d8 [ph7 nstart] d8 sarl_and
a_ff8 d8 clk NULL NULL ph8 ph8b sarl_dff
a_d9 [ph8 nstart] d9 sarl_and
a_ff9 d9 clk NULL NULL ph9 ph9b sarl_dff
a_d10 [ph9 nstart] d10 sarl_and
a_ff10 d10 clk NULL NULL ph10 ph10b sarl_dff
a_d11 [ph10 nstart] d11 sarl_and
a_ff11 d11 clk NULL NULL ph11 ph11b sarl_dff
a_d12 [ph11 nstart] d12 sarl_and
a_ff12 d12 clk NULL NULL ph12 ph12b sarl_dff
a_d13 [ph12 nstart] d13 sarl_and
a_ff13 d13 clk NULL NULL ph13 ph13b sarl_dff
a_d14 [ph13 nstart] d14 sarl_and
a_ff14 d14 clk NULL NULL ph14 ph14b sarl_dff
a_d15 [ph14 nstart] d15 sarl_and
a_ff15 d15 clk NULL NULL ph15 ph15b sarl_dff1
.ends sar_seq

* --- digital top ----------------------------------------------------
.subckt sar_ctrl clk start mode cmp samp_tp samp_bp drdy b9 b8 b7 b6 b5 b4
+ b3 b2 b1 b0 rel_256p hi_256p lo_256p rel_128p hi_128p lo_128p rel_64p
+ hi_64p lo_64p rel_32p hi_32p lo_32p rel_16p hi_16p lo_16p rel_8p hi_8p
+ lo_8p rel_4p hi_4p lo_4p rel_2p hi_2p lo_2p rel_1p hi_1p lo_1p rel_256n
+ hi_256n lo_256n rel_128n hi_128n lo_128n rel_64n hi_64n lo_64n rel_32n
+ hi_32n lo_32n rel_16n hi_16n lo_16n rel_8n hi_8n lo_8n rel_4n hi_4n
+ lo_4n rel_2n hi_2n lo_2n rel_1n hi_1n lo_1n
xseq clk start ph0 ph1 ph2 ph3 ph4 ph5 ph6 ph7 ph8 ph9 ph10 ph11 ph12 ph13 ph14 ph15 sar_seq
* ---- DR-0014's two-phase sample ----------------------------------
* `samp_tp` closes the top-plate switch for ph0..ph2 and opens it on
* the edge into ph3: THAT edge is the sampling instant. `samp_bp`
* keeps every bottom plate on V_in for the whole 4-clock window, so
* the input legs turn off one full clock LATER, onto a top node that
* is already floating. Both are one-hot phase ORs off the same ring:
* one external clock, rising edges only (DR-0008), no gated or
* inverted clock anywhere in the sample path.
* `samp_bp` is emitted through smpb -> inverter rather than straight
* off the OR so that it lands at the SAME logic depth as each cell's
* `rel`, which is AND(engb, smpb). Those two legs are complementary
* across the sample boundary, so a one-gate depth difference would
* leave every cell driving V_in and V_cm together for 0.2 ns.
a_samp4 [ph0 ph1 ph2 ph3] samp4 sarl_or
a_samptp [ph0 ph1 ph2] samp_tp sarl_or
a_smpb samp4 smpb sarl_inv
a_sampbp smpb samp_bp sarl_inv
* The comparator decision, inverted once here into output-bit
* polarity: bottom-plate sampling inverts the residue with respect to
* the input (DR-0014). See the header's sign-convention note.
a_dec cmp dec sarl_inv
a_drdy ph15 drdy_n sarl_inv
a_drdy2 drdy_n drdy sarl_inv
xs256 clk dec mode ph4 ph13 smpb q9 q9b rel_256p hi_256p lo_256p rel_256n hi_256n lo_256n sar_slice
xs128 clk dec mode ph5 ph13 smpb q8 q8b rel_128p hi_128p lo_128p rel_128n hi_128n lo_128n sar_slice
xs64 clk dec mode ph6 ph13 smpb q7 q7b rel_64p hi_64p lo_64p rel_64n hi_64n lo_64n sar_slice
xs32 clk dec mode ph7 ph13 smpb q6 q6b rel_32p hi_32p lo_32p rel_32n hi_32n lo_32n sar_slice
xs16 clk dec mode ph8 ph13 smpb q5 q5b rel_16p hi_16p lo_16p rel_16n hi_16n lo_16n sar_slice
xs8 clk dec mode ph9 ph13 smpb q4 q4b rel_8p hi_8p lo_8p rel_8n hi_8n lo_8n sar_slice
xs4 clk dec mode ph10 ph13 smpb q3 q3b rel_4p hi_4p lo_4p rel_4n hi_4n lo_4n sar_slice
xs2 clk dec mode ph11 ph13 smpb q2 q2b rel_2p hi_2p lo_2p rel_2n hi_2n lo_2n sar_slice
xs1 clk dec mode ph12 ph13 smpb q1 q1b rel_1p hi_1p lo_1p rel_1n hi_1n lo_1n sar_slice
xb0 clk dec ph13 q0 q0b sar_bitreg
* 10-bit parallel output register (DR-0005: in scope, SPI deferred)
xo9 clk q9 ph14 b9 b9b sar_bitreg
xo8 clk q8 ph14 b8 b8b sar_bitreg
xo7 clk q7 ph14 b7 b7b sar_bitreg
xo6 clk q6 ph14 b6 b6b sar_bitreg
xo5 clk q5 ph14 b5 b5b sar_bitreg
xo4 clk q4 ph14 b4 b4b sar_bitreg
xo3 clk q3 ph14 b3 b3b sar_bitreg
xo2 clk q2 ph14 b2 b2b sar_bitreg
xo1 clk q1 ph14 b1 b1b sar_bitreg
xo0 clk q0 ph14 b0 b0b sar_bitreg
.ends sar_ctrl

* --- analog-boundary wrapper ----------------------------------------
* Presents the controller at the analog boundary with the port names
* design/cdac/cdac_array.sch uses, so the two connect directly. Only
* the NMOS-gate (active-high) half of each T-gate leg is routed out of
* the controller; `sar_tgate_drv` below makes the PMOS gate locally at
* the cell. Bridges are VECTOR instances on purpose: 54 scalar
* dac_bridges would put 54 separate sources in the analog matrix.
* DR-0014's two additions ride on the SCALAR bridge group with drdy
* and the code bits, not on the 54-wide array bus: `sel_in_n` is one
* broadcast net feeding every cell's fourth leg and `samp_tp_n` is the
* per-side top-plate switch, so the array control bus grows from 54 to
* 55 wires, not to 72.
.subckt sar_ctrl_a clk start mode cmp samp_tp_n sel_in_n drdy c9 c8 c7 c6
+ c5 c4 c3 c2 c1 c0 rel_n_256p sel_hi_n_256p sel_lo_n_256p rel_n_128p
+ sel_hi_n_128p sel_lo_n_128p rel_n_64p sel_hi_n_64p sel_lo_n_64p
+ rel_n_32p sel_hi_n_32p sel_lo_n_32p rel_n_16p sel_hi_n_16p sel_lo_n_16p
+ rel_n_8p sel_hi_n_8p sel_lo_n_8p rel_n_4p sel_hi_n_4p sel_lo_n_4p
+ rel_n_2p sel_hi_n_2p sel_lo_n_2p rel_n_1p sel_hi_n_1p sel_lo_n_1p
+ rel_n_256n sel_hi_n_256n sel_lo_n_256n rel_n_128n sel_hi_n_128n
+ sel_lo_n_128n rel_n_64n sel_hi_n_64n sel_lo_n_64n rel_n_32n sel_hi_n_32n
+ sel_lo_n_32n rel_n_16n sel_hi_n_16n sel_lo_n_16n rel_n_8n sel_hi_n_8n
+ sel_lo_n_8n rel_n_4n sel_hi_n_4n sel_lo_n_4n rel_n_2n sel_hi_n_2n
+ sel_lo_n_2n rel_n_1n sel_hi_n_1n sel_lo_n_1n
a_in [clk start mode cmp] [dclk dstart dmode dcmp] sarl_adc
xctrl dclk dstart dmode dcmp dsamp_tp dsamp_bp ddrdy db9 db8 db7 db6 db5
+ db4 db3 db2 db1 db0 drel_256p dhi_256p dlo_256p drel_128p dhi_128p
+ dlo_128p drel_64p dhi_64p dlo_64p drel_32p dhi_32p dlo_32p drel_16p
+ dhi_16p dlo_16p drel_8p dhi_8p dlo_8p drel_4p dhi_4p dlo_4p drel_2p
+ dhi_2p dlo_2p drel_1p dhi_1p dlo_1p drel_256n dhi_256n dlo_256n
+ drel_128n dhi_128n dlo_128n drel_64n dhi_64n dlo_64n drel_32n dhi_32n
+ dlo_32n drel_16n dhi_16n dlo_16n drel_8n dhi_8n dlo_8n drel_4n dhi_4n
+ dlo_4n drel_2n dhi_2n dlo_2n drel_1n dhi_1n dlo_1n sar_ctrl
a_dout [dsamp_tp dsamp_bp ddrdy db9 db8 db7 db6 db5 db4 db3 db2 db1 db0]
+ [samp_tp_n sel_in_n drdy c9 c8 c7 c6 c5 c4 c3 c2 c1 c0] sarl_dac
a_gn [drel_256p dhi_256p dlo_256p drel_128p dhi_128p dlo_128p drel_64p dhi_64p dlo_64p drel_32p dhi_32p dlo_32p drel_16p dhi_16p dlo_16p drel_8p dhi_8p dlo_8p drel_4p dhi_4p dlo_4p drel_2p dhi_2p dlo_2p drel_1p dhi_1p dlo_1p drel_256n dhi_256n dlo_256n drel_128n dhi_128n dlo_128n drel_64n dhi_64n dlo_64n drel_32n dhi_32n dlo_32n drel_16n dhi_16n dlo_16n drel_8n dhi_8n dlo_8n drel_4n dhi_4n dlo_4n drel_2n dhi_2n dlo_2n drel_1n dhi_1n dlo_1n]
+ [rel_n_256p sel_hi_n_256p sel_lo_n_256p rel_n_128p sel_hi_n_128p sel_lo_n_128p rel_n_64p sel_hi_n_64p sel_lo_n_64p rel_n_32p sel_hi_n_32p sel_lo_n_32p rel_n_16p sel_hi_n_16p sel_lo_n_16p rel_n_8p sel_hi_n_8p sel_lo_n_8p rel_n_4p sel_hi_n_4p sel_lo_n_4p rel_n_2p sel_hi_n_2p sel_lo_n_2p rel_n_1p sel_hi_n_1p sel_lo_n_1p rel_n_256n sel_hi_n_256n sel_lo_n_256n rel_n_128n sel_hi_n_128n sel_lo_n_128n rel_n_64n sel_hi_n_64n sel_lo_n_64n rel_n_32n sel_hi_n_32n sel_lo_n_32n rel_n_16n sel_hi_n_16n sel_lo_n_16n rel_n_8n sel_hi_n_8n sel_lo_n_8n rel_n_4n sel_hi_n_4n sel_lo_n_4n rel_n_2n sel_hi_n_2n sel_lo_n_2n rel_n_1n sel_hi_n_1n sel_lo_n_1n] sarl_dac
.ends sar_ctrl_a

* --- local T-gate driver -------------------------------------------
* One per T-gate leg, placed with the CDAC cell (#15/#16), not with
* the controller: `gn` is the controller's active-high control and
* `gp` the complementary PMOS gate. Modelled as an ideal inverter at
* rung 1; at rung 3 it is one standard-cell inverter.
.subckt sar_tgate_drv gn gp
a_adc gn dgn sarl_adc
a_inv dgn dgp sarl_inv
a_dac dgp gp sarl_dac
.ends sar_tgate_drv

* Bridge models. Thresholds and rails track the PVT point's supply, so
* the supply axis of the corner grid actually moves something in this
* otherwise PVT-invariant model.
.model sarl_adc adc_bridge(in_low={vdd_val*0.4} in_high={vdd_val*0.6})
.model sarl_dac dac_bridge(out_low=0 out_high={vdd_val}
+ out_undef={vdd_val/2} t_rise=0.3n t_fall=0.3n)

* ==================================================================
* adc_top.spice -- the SAR ADC analog core: CDAC array, its four-leg
* bottom-plate switch network and the local drivers, and the
* top-plate V_cm switch DR-0014's sampling phase turns on.
*
* GENERATED by design/adc-top/gen_adc_top.py -- do not edit.
*
* This library holds ONLY what is not already owned by another
* canonical file. The comparator lives in design/comparator/
* comparator.spice and the SAR controller in design/sar-logic/
* sar_ctrl.spice; the testbenches under sim/adc-*/ inline all three.
*
* Fidelity (DR-0010): everything here is transistor level. The
* sequencer and the output register stay at rung 1 (ideal XSPICE
* primitives) because the open gf180mcu PDK ships no 3.3 V standard-
* cell library -- the gap DR-0010 names as an open precondition of
* rung 3. The T-gate DRIVERS are transistor level even so: they are
* custom cells placed with the CDAC (design/sar-logic/README.md), not
* standard cells, so the library gap does not apply to them, and they
* are the dominant digital load in a SAR ADC.
* ==================================================================

* --- ADC-TOP-NETLIST-BEGIN (verbatim-copied into every testbench) ---
* ---- switches ----------------------------------------------------
* CDAC bottom-plate T-gate, unfolded form. The CONVERTER's decode
* banks no longer instantiate this subckt -- DR-0050 folds their
* T-gate PMOS into a shared-source/drain pair (`adc_tgate_f` below)
* -- but it stays the library's parametrised T-gate: `adc_tp_sw`
* (whose fold is out of DR-0050's scope: its row is not
* height-critical) and the testbench replicas that must match
* sim/device-switch-ron/ and sim/cdac-bit-settling/'s characterised
* geometry still call it, so R_on carries the corner sensitivity
* those records already characterised.
.subckt adc_tgate vin vout gn gp vdd wn=10u wp=20u
XN vin gn vout 0   nfet_03v3 w='wn' l=0.28u
XP vin gp vout vdd pfet_03v3 w='wp' l=0.28u
.ends adc_tgate

* The RATIFIED decode-bank T-gate (DR-0050): electrically the same
* device as adc_tgate wn=10u wp=20u -- the PMOS is two parallel
* wp=10u fingers, i.e. unchanged parallel W -- and the netlist side
* of the layout's shared-source/drain fold (issue #936 measured the
* candidate, -13,434.100 um^2 / -10.26 % on ADC_BLOCK; DR-0050
* adopts it). Stating the fingers HERE is what keeps the schematic
* and the extracted deck one netlist: the layout draws each pair as
* one abutting mirrored island whose shared diffusion carries the
* same net on both sides, so the extracted stream states exactly
* these two devices. Literal widths -- the fold is one specific
* ratio, not a parameterised sweep, so nothing downstream depends
* on expression evaluation.
.subckt adc_tgate_f vin vout gn gp vdd
XN  vin gn vout 0   nfet_03v3 w=10u l=0.28u
XP1 vin gp vout vdd pfet_03v3 w=10u l=0.28u
XP2 vin gp vout vdd pfet_03v3 w=10u l=0.28u
.ends adc_tgate_f

* Dedicated top-plate input sampling switch: dummy-compensated T-gate,
* DR-0007 (track switch) / DR-0013. NO LONGER IN THE CONVERTER --
* DR-0014 samples on the bottom plates, so the input reaches the array
* through the nine cell T-gates of each side's fourth leg and this
* switch is gone from adc_cdac_side and from every adc-* deck. It is
* kept in the library because sim/top-plate-cpar/ instantiates it to
* measure the SUPERSEDED topology's top-plate load set -- the measured
* evidence DR-0014's Context rests on -- and because #61 re-takes that
* measurement on the new topology from this same library. Identical
* device text to the `tgate_dum` subckt sim/track-switch-sampling/
* measured the ratified gain-error number with, at the same default
* rd = 7/16.
.subckt adc_tgate_dum vin vout clk clkb vdd wn=40u wp=80u rd=0.4375
XN  vin  clk  vout 0   nfet_03v3 w='wn' l=0.28u
XP  vin  clkb vout vdd pfet_03v3 w='wp' l=0.28u
XDN vout clkb vout 0   nfet_03v3 w='wn*rd' l=0.28u
XDP vout clk  vout vdd pfet_03v3 w='wp*rd' l=0.28u
.ends adc_tgate_dum

* Local T-gate driver -- one per leg, placed with the CDAC cell. This
* is design/sar-logic/sar_ctrl.spice's `sar_tgate_drv` promoted from
* its rung-1 ideal inverter to real devices: the controller routes
* only the active-high (NMOS gate) half of each leg, and the
* complementary PMOS gate is made here.
.subckt adc_drv a y vdd vss
Xp y a vdd vdd pfet_03v3 w=8u l=0.35u
Xn y a vss vss nfet_03v3 w=4u l=0.35u
.ends adc_drv

* ---- top-plate V_cm switch (DR-0014) ------------------------------
* One per array side. Closed for ph0..ph2 and OPENED ON THE EDGE INTO
* ph3 -- that edge is the sampling instant, and it is the reason the
* whole record exists: with the top plate released before the bottom
* plates move, the sampled input and every subsequent DAC step land in
* the same numerator over the same denominator, so C_arr/(C_arr+C_par)
* cancels from the comparator's decision instead of dividing the DAC
* step alone.
*
* Plain T-gate at the CDAC bottom-plate geometry -- deliberately NOT
* dummy-compensated, and this is a choice, not an omission. DR-0013's
* dummies exist because the OLD sampling switch opened with an
* input-dependent voltage on its channel. This switch always opens
* with its node at V_cm, so its injection is signal-independent: a
* fixed offset, common to both sides, which differential operation
* removes and which DR-0007's Offset row already covers. Adding
* dummies would instead re-hang two permanently-connected MOS
* capacitors on the top plate -- the 194 fF sim/top-plate-cpar/
* measured as 66 % of C_par -- which no longer costs gain under this
* record but does cost bit-trial settling. The residual side-to-side
* MISMATCH of this injection is one of the four things DR-0014's
* Consequences require #61 to measure; it is not claimed here.
*
* Sizing, from the acquisition it has to support: it holds the top
* node at V_cm while the bottom plates slew, so its own time constant
* is R_on * (C_arr + C_par) = 570 ohm * 9.1 pF = 5.2 ns worst case,
* i.e. 36 tau inside the 187.5 ns acquisition window and 0.21 of the
* input network's own 25 ns tau. The lag it leaves at the sampling
* instant is (tau_sw/tau_in)*exp(-7.5) = 1.1e-4 of the input step --
* 0.12 LSB at full scale, and LINEAR in the input, so it is a gain
* term and not a linearity term. Widening it would buy that back at
* the price of more injection to mismatch, which is the term this
* topology cannot cancel.
.subckt adc_tp_sw top vcm gn vdd vss
Xd gn gp vdd vss adc_drv
Xs vcm top gn gp vdd adc_tgate wn=10u wp=20u
.ends adc_tp_sw

* ---- one CDAC cell ------------------------------------------------
* A weight-w block of unit capacitors and its FOUR-way bottom-plate
* switch: driven to V_in while sampling (DR-0014's fourth leg),
* released to V_cm, or engaged to V_REF or GND (DR-0011, unchanged).
* Exactly one leg conducts at a time -- the four-leg one-hot invariant
* sim/sar-logic-functional/ checks on the control side.
*
* All four legs are the same T-gate -- DR-0050's folded `adc_tgate_f`,
* PMOS stated as two parallel wp=10u fingers. That is what makes the
* cell one repeated device rather than four different ones, and it is
* why the Input-structure row's series R_on has to be re-measured
* rather than carried over (DR-0014, and #61 owns it): the input now
* reaches the array through nine of these in parallel, instead of
* through one dedicated 40u/80u switch. Under DR-0050 the re-take
* moves only through junction parasitics -- parallel W per T-gate is
* unchanged (20u = 2 x 10u), exactly as issue #940's campaign
* re-runs measure.
.subckt adc_cdac_cell top vin vref vcm vss vdd gn_in gn_rel gn_hi gn_lo
+ cw=10u cl=10u
Xc  top bp mim_cap_2f0 c_width='cw' c_length='cl'
Xdi gn_in  gp_in  vdd vss adc_drv
Xdr gn_rel gp_rel vdd vss adc_drv
Xdh gn_hi  gp_hi  vdd vss adc_drv
Xdl gn_lo  gp_lo  vdd vss adc_drv
Xsi vin  bp gn_in  gp_in  vdd adc_tgate_f
Xsr vcm  bp gn_rel gp_rel vdd adc_tgate_f
Xsh vref bp gn_hi  gp_hi  vdd adc_tgate_f
Xsl vss  bp gn_lo  gp_lo  vdd adc_tgate_f
.ends adc_cdac_cell

* ---- one array side -----------------------------------------------
* DR-0011: 2^(N-1) = 512 unit positions per side -- nine binary
* weighted blocks (256..1, 511 units) plus one terminating unit fixed
* to V_cm. C_u = 35.6528 fF (spec/cdac-sizing-memo.md Sec 4), so the
* per-side track-mode capacitance is 512 * C_u = 18.254 pF, which is
* the C_in the ratified Input-structure row publishes.
*
* Each block is drawn as ONE capacitor of the block's total area, not
* as w separate unit cells. That is exact for this campaign and it is
* deliberate: these records verify the NOMINAL design over PVT, where
* unit-to-unit mismatch is zero by construction, and the statistical
* spread of the same array is sim/mc-cdac-mismatch/'s claim, taken at
* nominal PVT with a behavioural model because the open PDK ships no
* local capacitor mismatch model at all. Drawing 1022 unit cells here
* would multiply simulation cost by ~50x and change no number.
*
* Areas from the measured MiM density law (devchar Sec 1.2),
* C(s) = 1.99*s^2 + 0.9532*s fF for a square of side s um:
*   w=256  C =   9127.12 fF  ->  s = 67.4846 um
*   w=128  C =   4563.56 fF  ->  s = 47.6489 um
*   w= 64  C =   2281.78 fF  ->  s = 33.6232 um
*   w= 32  C =   1140.89 fF  ->  s = 23.7056 um
*   w= 16  C =    570.44 fF  ->  s = 16.6931 um
*   w=  8  C =    285.22 fF  ->  s = 11.7349 um
*   w=  4  C =    142.61 fF  ->  s = 8.2293 um
*   w=  2  C =     71.31 fF  ->  s = 5.7513 um
*   w=  1  C =     35.65 fF  ->  s = 4.0000 um
*
* `sel_in` is ONE port, not nine: every cell's fourth leg is driven by
* the same broadcast control, because all bottom plates sample
* together by construction (design/sar-logic/README.md states the same
* bus-width argument from the controller side). The per-cell decode is
* still four one-hot legs; one of the four is shared.
.subckt adc_cdac_side top vin vref vcm vss vdd sel_in rel_256 hi_256
+ lo_256 rel_128 hi_128 lo_128 rel_64 hi_64 lo_64 rel_32 hi_32 lo_32
+ rel_16 hi_16 lo_16 rel_8 hi_8 lo_8 rel_4 hi_4 lo_4 rel_2 hi_2 lo_2 rel_1
+ hi_1 lo_1
X256 top vin vref vcm vss vdd sel_in rel_256 hi_256 lo_256 adc_cdac_cell cw=67.4846u cl=67.4846u
X128 top vin vref vcm vss vdd sel_in rel_128 hi_128 lo_128 adc_cdac_cell cw=47.6489u cl=47.6489u
X64 top vin vref vcm vss vdd sel_in rel_64 hi_64 lo_64 adc_cdac_cell cw=33.6232u cl=33.6232u
X32 top vin vref vcm vss vdd sel_in rel_32 hi_32 lo_32 adc_cdac_cell cw=23.7056u cl=23.7056u
X16 top vin vref vcm vss vdd sel_in rel_16 hi_16 lo_16 adc_cdac_cell cw=16.6931u cl=16.6931u
X8 top vin vref vcm vss vdd sel_in rel_8 hi_8 lo_8 adc_cdac_cell cw=11.7349u cl=11.7349u
X4 top vin vref vcm vss vdd sel_in rel_4 hi_4 lo_4 adc_cdac_cell cw=8.2293u cl=8.2293u
X2 top vin vref vcm vss vdd sel_in rel_2 hi_2 lo_2 adc_cdac_cell cw=5.7513u cl=5.7513u
X1 top vin vref vcm vss vdd sel_in rel_1 hi_1 lo_1 adc_cdac_cell cw=4.0000u cl=4.0000u
* terminating unit: DR-0011's 512th position, fixed to V_cm, never
* switched -- it is what makes the weight-1 trial resolve exactly one
* LSB of full scale rather than one part in 511. Under DR-0014 it is
* also the one unit that does NOT track V_in during acquisition, so
* the capacitance the input PIN drives is 511*C_u = 18.219 pF while the
* C_arr the charge balance runs on is still 512*C_u = 18.254 pF. The
* 0.2 % difference sits inside the ratified Input-structure row's own
* rounding and does not change DR-0013's <= 30 ns drive contract.
Xterm top vcm mim_cap_2f0 c_width=4.0000u c_length=4.0000u
.ends adc_cdac_side
* --- ADC-TOP-NETLIST-END ---
