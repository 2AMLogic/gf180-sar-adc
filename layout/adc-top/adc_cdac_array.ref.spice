* Flat LVS reference for the ADC_CDAC_ARRAY proof cell.
*
* GENERATED by layout/adc-top/gen_adc_top.py -- do not edit. This is
* the array-scale analogue of cells/adc_cdac_cell's single wired unit
* (issue #70/#82): every one of the 512 real unit positions is drawn
* as a RECOGNISED cap_mim_2f0_m4m5_noshield (CAP_MK/MIM_L_MK, Via4 up
* to the Metal5 top-plate mesh) and its bottom plate is tied, by the
* per-weight interconnect draw_cdac_array(device=True) draws, to its
* weight's Metal1 trunk pin. Issue #81.
*
* The 512 units partition by weight exactly as the common-centroid
* tiling assigns them:
*   bp_256, bp_128, bp_64, bp_32, bp_16, bp_8, bp_4, bp_2, bp_1, bp_term.
* Each unit's capacitance is the
* extraction deck's own area-only MiM model of the drawn 2.7136 um
* plate (14.73 fF), the same value cells/adc_cdac_cell's reference
* uses and the same 14.6% below the PDK model card's area+fringe
* number for that plate -- a modelling delta no layout change closes,
* reported in the LVS record rather than absorbed here.
*
* NOT the block: adc_top/adc_block still draw this array device=False
* (their per-weight bottom plates are not yet routed to the decode
* banks), so their references still omit these caps. This cell proves
* the array construction in isolation; block integration is the
* deferred follow-up. See layout/adc-top/README.md.
*
* Runnable by hand:
*   klt lvs layout/adc-top/adc_cdac_array.lvs.json --format json
.SUBCKT ADC_CDAC_ARRAY top bp_256 bp_128 bp_64 bp_32 bp_16 bp_8 bp_4 bp_2 bp_1 bp_term
CXc_256_0 bp_256 top 1.4731592e-14 cap_mim_2f0_m4m5_noshield
CXc_256_1 bp_256 top 1.4731592e-14 cap_mim_2f0_m4m5_noshield
CXc_256_2 bp_256 top 1.4731592e-14 cap_mim_2f0_m4m5_noshield
CXc_256_3 bp_256 top 1.4731592e-14 cap_mim_2f0_m4m5_noshield
CXc_256_4 bp_256 top 1.4731592e-14 cap_mim_2f0_m4m5_noshield
CXc_256_5 bp_256 top 1.4731592e-14 cap_mim_2f0_m4m5_noshield
CXc_256_6 bp_256 top 1.4731592e-14 cap_mim_2f0_m4m5_noshield
CXc_256_7 bp_256 top 1.4731592e-14 cap_mim_2f0_m4m5_noshield
CXc_256_8 bp_256 top 1.4731592e-14 cap_mim_2f0_m4m5_noshield
CXc_256_9 bp_256 top 1.4731592e-14 cap_mim_2f0_m4m5_noshield
CXc_256_10 bp_256 top 1.4731592e-14 cap_mim_2f0_m4m5_noshield
CXc_256_11 bp_256 top 1.4731592e-14 cap_mim_2f0_m4m5_noshield
CXc_256_12 bp_256 top 1.4731592e-14 cap_mim_2f0_m4m5_noshield
CXc_256_13 bp_256 top 1.4731592e-14 cap_mim_2f0_m4m5_noshield
CXc_256_14 bp_256 top 1.4731592e-14 cap_mim_2f0_m4m5_noshield
CXc_256_15 bp_256 top 1.4731592e-14 cap_mim_2f0_m4m5_noshield
CXc_256_16 bp_256 top 1.4731592e-14 cap_mim_2f0_m4m5_noshield
CXc_256_17 bp_256 top 1.4731592e-14 cap_mim_2f0_m4m5_noshield
CXc_256_18 bp_256 top 1.4731592e-14 cap_mim_2f0_m4m5_noshield
CXc_256_19 bp_256 top 1.4731592e-14 cap_mim_2f0_m4m5_noshield
CXc_256_20 bp_256 top 1.4731592e-14 cap_mim_2f0_m4m5_noshield
CXc_256_21 bp_256 top 1.4731592e-14 cap_mim_2f0_m4m5_noshield
CXc_256_22 bp_256 top 1.4731592e-14 cap_mim_2f0_m4m5_noshield
CXc_256_23 bp_256 top 1.4731592e-14 cap_mim_2f0_m4m5_noshield
CXc_256_24 bp_256 top 1.4731592e-14 cap_mim_2f0_m4m5_noshield
CXc_256_25 bp_256 top 1.4731592e-14 cap_mim_2f0_m4m5_noshield
CXc_256_26 bp_256 top 1.4731592e-14 cap_mim_2f0_m4m5_noshield
CXc_256_27 bp_256 top 1.4731592e-14 cap_mim_2f0_m4m5_noshield
CXc_256_28 bp_256 top 1.4731592e-14 cap_mim_2f0_m4m5_noshield
CXc_256_29 bp_256 top 1.4731592e-14 cap_mim_2f0_m4m5_noshield
CXc_256_30 bp_256 top 1.4731592e-14 cap_mim_2f0_m4m5_noshield
CXc_256_31 bp_256 top 1.4731592e-14 cap_mim_2f0_m4m5_noshield
CXc_256_32 bp_256 top 1.4731592e-14 cap_mim_2f0_m4m5_noshield
CXc_256_33 bp_256 top 1.4731592e-14 cap_mim_2f0_m4m5_noshield
CXc_256_34 bp_256 top 1.4731592e-14 cap_mim_2f0_m4m5_noshield
CXc_256_35 bp_256 top 1.4731592e-14 cap_mim_2f0_m4m5_noshield
CXc_256_36 bp_256 top 1.4731592e-14 cap_mim_2f0_m4m5_noshield
CXc_256_37 bp_256 top 1.4731592e-14 cap_mim_2f0_m4m5_noshield
CXc_256_38 bp_256 top 1.4731592e-14 cap_mim_2f0_m4m5_noshield
CXc_256_39 bp_256 top 1.4731592e-14 cap_mim_2f0_m4m5_noshield
CXc_256_40 bp_256 top 1.4731592e-14 cap_mim_2f0_m4m5_noshield
CXc_256_41 bp_256 top 1.4731592e-14 cap_mim_2f0_m4m5_noshield
CXc_256_42 bp_256 top 1.4731592e-14 cap_mim_2f0_m4m5_noshield
CXc_256_43 bp_256 top 1.4731592e-14 cap_mim_2f0_m4m5_noshield
CXc_256_44 bp_256 top 1.4731592e-14 cap_mim_2f0_m4m5_noshield
CXc_256_45 bp_256 top 1.4731592e-14 cap_mim_2f0_m4m5_noshield
CXc_256_46 bp_256 top 1.4731592e-14 cap_mim_2f0_m4m5_noshield
CXc_256_47 bp_256 top 1.4731592e-14 cap_mim_2f0_m4m5_noshield
CXc_256_48 bp_256 top 1.4731592e-14 cap_mim_2f0_m4m5_noshield
CXc_256_49 bp_256 top 1.4731592e-14 cap_mim_2f0_m4m5_noshield
CXc_256_50 bp_256 top 1.4731592e-14 cap_mim_2f0_m4m5_noshield
CXc_256_51 bp_256 top 1.4731592e-14 cap_mim_2f0_m4m5_noshield
CXc_256_52 bp_256 top 1.4731592e-14 cap_mim_2f0_m4m5_noshield
CXc_256_53 bp_256 top 1.4731592e-14 cap_mim_2f0_m4m5_noshield
CXc_256_54 bp_256 top 1.4731592e-14 cap_mim_2f0_m4m5_noshield
CXc_256_55 bp_256 top 1.4731592e-14 cap_mim_2f0_m4m5_noshield
CXc_256_56 bp_256 top 1.4731592e-14 cap_mim_2f0_m4m5_noshield
CXc_256_57 bp_256 top 1.4731592e-14 cap_mim_2f0_m4m5_noshield
CXc_256_58 bp_256 top 1.4731592e-14 cap_mim_2f0_m4m5_noshield
CXc_256_59 bp_256 top 1.4731592e-14 cap_mim_2f0_m4m5_noshield
CXc_256_60 bp_256 top 1.4731592e-14 cap_mim_2f0_m4m5_noshield
CXc_256_61 bp_256 top 1.4731592e-14 cap_mim_2f0_m4m5_noshield
CXc_256_62 bp_256 top 1.4731592e-14 cap_mim_2f0_m4m5_noshield
CXc_256_63 bp_256 top 1.4731592e-14 cap_mim_2f0_m4m5_noshield
CXc_256_64 bp_256 top 1.4731592e-14 cap_mim_2f0_m4m5_noshield
CXc_256_65 bp_256 top 1.4731592e-14 cap_mim_2f0_m4m5_noshield
CXc_256_66 bp_256 top 1.4731592e-14 cap_mim_2f0_m4m5_noshield
CXc_256_67 bp_256 top 1.4731592e-14 cap_mim_2f0_m4m5_noshield
CXc_256_68 bp_256 top 1.4731592e-14 cap_mim_2f0_m4m5_noshield
CXc_256_69 bp_256 top 1.4731592e-14 cap_mim_2f0_m4m5_noshield
CXc_256_70 bp_256 top 1.4731592e-14 cap_mim_2f0_m4m5_noshield
CXc_256_71 bp_256 top 1.4731592e-14 cap_mim_2f0_m4m5_noshield
CXc_256_72 bp_256 top 1.4731592e-14 cap_mim_2f0_m4m5_noshield
CXc_256_73 bp_256 top 1.4731592e-14 cap_mim_2f0_m4m5_noshield
CXc_256_74 bp_256 top 1.4731592e-14 cap_mim_2f0_m4m5_noshield
CXc_256_75 bp_256 top 1.4731592e-14 cap_mim_2f0_m4m5_noshield
CXc_256_76 bp_256 top 1.4731592e-14 cap_mim_2f0_m4m5_noshield
CXc_256_77 bp_256 top 1.4731592e-14 cap_mim_2f0_m4m5_noshield
CXc_256_78 bp_256 top 1.4731592e-14 cap_mim_2f0_m4m5_noshield
CXc_256_79 bp_256 top 1.4731592e-14 cap_mim_2f0_m4m5_noshield
CXc_256_80 bp_256 top 1.4731592e-14 cap_mim_2f0_m4m5_noshield
CXc_256_81 bp_256 top 1.4731592e-14 cap_mim_2f0_m4m5_noshield
CXc_256_82 bp_256 top 1.4731592e-14 cap_mim_2f0_m4m5_noshield
CXc_256_83 bp_256 top 1.4731592e-14 cap_mim_2f0_m4m5_noshield
CXc_256_84 bp_256 top 1.4731592e-14 cap_mim_2f0_m4m5_noshield
CXc_256_85 bp_256 top 1.4731592e-14 cap_mim_2f0_m4m5_noshield
CXc_256_86 bp_256 top 1.4731592e-14 cap_mim_2f0_m4m5_noshield
CXc_256_87 bp_256 top 1.4731592e-14 cap_mim_2f0_m4m5_noshield
CXc_256_88 bp_256 top 1.4731592e-14 cap_mim_2f0_m4m5_noshield
CXc_256_89 bp_256 top 1.4731592e-14 cap_mim_2f0_m4m5_noshield
CXc_256_90 bp_256 top 1.4731592e-14 cap_mim_2f0_m4m5_noshield
CXc_256_91 bp_256 top 1.4731592e-14 cap_mim_2f0_m4m5_noshield
CXc_256_92 bp_256 top 1.4731592e-14 cap_mim_2f0_m4m5_noshield
CXc_256_93 bp_256 top 1.4731592e-14 cap_mim_2f0_m4m5_noshield
CXc_256_94 bp_256 top 1.4731592e-14 cap_mim_2f0_m4m5_noshield
CXc_256_95 bp_256 top 1.4731592e-14 cap_mim_2f0_m4m5_noshield
CXc_256_96 bp_256 top 1.4731592e-14 cap_mim_2f0_m4m5_noshield
CXc_256_97 bp_256 top 1.4731592e-14 cap_mim_2f0_m4m5_noshield
CXc_256_98 bp_256 top 1.4731592e-14 cap_mim_2f0_m4m5_noshield
CXc_256_99 bp_256 top 1.4731592e-14 cap_mim_2f0_m4m5_noshield
CXc_256_100 bp_256 top 1.4731592e-14 cap_mim_2f0_m4m5_noshield
CXc_256_101 bp_256 top 1.4731592e-14 cap_mim_2f0_m4m5_noshield
CXc_256_102 bp_256 top 1.4731592e-14 cap_mim_2f0_m4m5_noshield
CXc_256_103 bp_256 top 1.4731592e-14 cap_mim_2f0_m4m5_noshield
CXc_256_104 bp_256 top 1.4731592e-14 cap_mim_2f0_m4m5_noshield
CXc_256_105 bp_256 top 1.4731592e-14 cap_mim_2f0_m4m5_noshield
CXc_256_106 bp_256 top 1.4731592e-14 cap_mim_2f0_m4m5_noshield
CXc_256_107 bp_256 top 1.4731592e-14 cap_mim_2f0_m4m5_noshield
CXc_256_108 bp_256 top 1.4731592e-14 cap_mim_2f0_m4m5_noshield
CXc_256_109 bp_256 top 1.4731592e-14 cap_mim_2f0_m4m5_noshield
CXc_256_110 bp_256 top 1.4731592e-14 cap_mim_2f0_m4m5_noshield
CXc_256_111 bp_256 top 1.4731592e-14 cap_mim_2f0_m4m5_noshield
CXc_256_112 bp_256 top 1.4731592e-14 cap_mim_2f0_m4m5_noshield
CXc_256_113 bp_256 top 1.4731592e-14 cap_mim_2f0_m4m5_noshield
CXc_256_114 bp_256 top 1.4731592e-14 cap_mim_2f0_m4m5_noshield
CXc_256_115 bp_256 top 1.4731592e-14 cap_mim_2f0_m4m5_noshield
CXc_256_116 bp_256 top 1.4731592e-14 cap_mim_2f0_m4m5_noshield
CXc_256_117 bp_256 top 1.4731592e-14 cap_mim_2f0_m4m5_noshield
CXc_256_118 bp_256 top 1.4731592e-14 cap_mim_2f0_m4m5_noshield
CXc_256_119 bp_256 top 1.4731592e-14 cap_mim_2f0_m4m5_noshield
CXc_256_120 bp_256 top 1.4731592e-14 cap_mim_2f0_m4m5_noshield
CXc_256_121 bp_256 top 1.4731592e-14 cap_mim_2f0_m4m5_noshield
CXc_256_122 bp_256 top 1.4731592e-14 cap_mim_2f0_m4m5_noshield
CXc_256_123 bp_256 top 1.4731592e-14 cap_mim_2f0_m4m5_noshield
CXc_256_124 bp_256 top 1.4731592e-14 cap_mim_2f0_m4m5_noshield
CXc_256_125 bp_256 top 1.4731592e-14 cap_mim_2f0_m4m5_noshield
CXc_256_126 bp_256 top 1.4731592e-14 cap_mim_2f0_m4m5_noshield
CXc_256_127 bp_256 top 1.4731592e-14 cap_mim_2f0_m4m5_noshield
CXc_256_128 bp_256 top 1.4731592e-14 cap_mim_2f0_m4m5_noshield
CXc_256_129 bp_256 top 1.4731592e-14 cap_mim_2f0_m4m5_noshield
CXc_256_130 bp_256 top 1.4731592e-14 cap_mim_2f0_m4m5_noshield
CXc_256_131 bp_256 top 1.4731592e-14 cap_mim_2f0_m4m5_noshield
CXc_256_132 bp_256 top 1.4731592e-14 cap_mim_2f0_m4m5_noshield
CXc_256_133 bp_256 top 1.4731592e-14 cap_mim_2f0_m4m5_noshield
CXc_256_134 bp_256 top 1.4731592e-14 cap_mim_2f0_m4m5_noshield
CXc_256_135 bp_256 top 1.4731592e-14 cap_mim_2f0_m4m5_noshield
CXc_256_136 bp_256 top 1.4731592e-14 cap_mim_2f0_m4m5_noshield
CXc_256_137 bp_256 top 1.4731592e-14 cap_mim_2f0_m4m5_noshield
CXc_256_138 bp_256 top 1.4731592e-14 cap_mim_2f0_m4m5_noshield
CXc_256_139 bp_256 top 1.4731592e-14 cap_mim_2f0_m4m5_noshield
CXc_256_140 bp_256 top 1.4731592e-14 cap_mim_2f0_m4m5_noshield
CXc_256_141 bp_256 top 1.4731592e-14 cap_mim_2f0_m4m5_noshield
CXc_256_142 bp_256 top 1.4731592e-14 cap_mim_2f0_m4m5_noshield
CXc_256_143 bp_256 top 1.4731592e-14 cap_mim_2f0_m4m5_noshield
CXc_256_144 bp_256 top 1.4731592e-14 cap_mim_2f0_m4m5_noshield
CXc_256_145 bp_256 top 1.4731592e-14 cap_mim_2f0_m4m5_noshield
CXc_256_146 bp_256 top 1.4731592e-14 cap_mim_2f0_m4m5_noshield
CXc_256_147 bp_256 top 1.4731592e-14 cap_mim_2f0_m4m5_noshield
CXc_256_148 bp_256 top 1.4731592e-14 cap_mim_2f0_m4m5_noshield
CXc_256_149 bp_256 top 1.4731592e-14 cap_mim_2f0_m4m5_noshield
CXc_256_150 bp_256 top 1.4731592e-14 cap_mim_2f0_m4m5_noshield
CXc_256_151 bp_256 top 1.4731592e-14 cap_mim_2f0_m4m5_noshield
CXc_256_152 bp_256 top 1.4731592e-14 cap_mim_2f0_m4m5_noshield
CXc_256_153 bp_256 top 1.4731592e-14 cap_mim_2f0_m4m5_noshield
CXc_256_154 bp_256 top 1.4731592e-14 cap_mim_2f0_m4m5_noshield
CXc_256_155 bp_256 top 1.4731592e-14 cap_mim_2f0_m4m5_noshield
CXc_256_156 bp_256 top 1.4731592e-14 cap_mim_2f0_m4m5_noshield
CXc_256_157 bp_256 top 1.4731592e-14 cap_mim_2f0_m4m5_noshield
CXc_256_158 bp_256 top 1.4731592e-14 cap_mim_2f0_m4m5_noshield
CXc_256_159 bp_256 top 1.4731592e-14 cap_mim_2f0_m4m5_noshield
CXc_256_160 bp_256 top 1.4731592e-14 cap_mim_2f0_m4m5_noshield
CXc_256_161 bp_256 top 1.4731592e-14 cap_mim_2f0_m4m5_noshield
CXc_256_162 bp_256 top 1.4731592e-14 cap_mim_2f0_m4m5_noshield
CXc_256_163 bp_256 top 1.4731592e-14 cap_mim_2f0_m4m5_noshield
CXc_256_164 bp_256 top 1.4731592e-14 cap_mim_2f0_m4m5_noshield
CXc_256_165 bp_256 top 1.4731592e-14 cap_mim_2f0_m4m5_noshield
CXc_256_166 bp_256 top 1.4731592e-14 cap_mim_2f0_m4m5_noshield
CXc_256_167 bp_256 top 1.4731592e-14 cap_mim_2f0_m4m5_noshield
CXc_256_168 bp_256 top 1.4731592e-14 cap_mim_2f0_m4m5_noshield
CXc_256_169 bp_256 top 1.4731592e-14 cap_mim_2f0_m4m5_noshield
CXc_256_170 bp_256 top 1.4731592e-14 cap_mim_2f0_m4m5_noshield
CXc_256_171 bp_256 top 1.4731592e-14 cap_mim_2f0_m4m5_noshield
CXc_256_172 bp_256 top 1.4731592e-14 cap_mim_2f0_m4m5_noshield
CXc_256_173 bp_256 top 1.4731592e-14 cap_mim_2f0_m4m5_noshield
CXc_256_174 bp_256 top 1.4731592e-14 cap_mim_2f0_m4m5_noshield
CXc_256_175 bp_256 top 1.4731592e-14 cap_mim_2f0_m4m5_noshield
CXc_256_176 bp_256 top 1.4731592e-14 cap_mim_2f0_m4m5_noshield
CXc_256_177 bp_256 top 1.4731592e-14 cap_mim_2f0_m4m5_noshield
CXc_256_178 bp_256 top 1.4731592e-14 cap_mim_2f0_m4m5_noshield
CXc_256_179 bp_256 top 1.4731592e-14 cap_mim_2f0_m4m5_noshield
CXc_256_180 bp_256 top 1.4731592e-14 cap_mim_2f0_m4m5_noshield
CXc_256_181 bp_256 top 1.4731592e-14 cap_mim_2f0_m4m5_noshield
CXc_256_182 bp_256 top 1.4731592e-14 cap_mim_2f0_m4m5_noshield
CXc_256_183 bp_256 top 1.4731592e-14 cap_mim_2f0_m4m5_noshield
CXc_256_184 bp_256 top 1.4731592e-14 cap_mim_2f0_m4m5_noshield
CXc_256_185 bp_256 top 1.4731592e-14 cap_mim_2f0_m4m5_noshield
CXc_256_186 bp_256 top 1.4731592e-14 cap_mim_2f0_m4m5_noshield
CXc_256_187 bp_256 top 1.4731592e-14 cap_mim_2f0_m4m5_noshield
CXc_256_188 bp_256 top 1.4731592e-14 cap_mim_2f0_m4m5_noshield
CXc_256_189 bp_256 top 1.4731592e-14 cap_mim_2f0_m4m5_noshield
CXc_256_190 bp_256 top 1.4731592e-14 cap_mim_2f0_m4m5_noshield
CXc_256_191 bp_256 top 1.4731592e-14 cap_mim_2f0_m4m5_noshield
CXc_256_192 bp_256 top 1.4731592e-14 cap_mim_2f0_m4m5_noshield
CXc_256_193 bp_256 top 1.4731592e-14 cap_mim_2f0_m4m5_noshield
CXc_256_194 bp_256 top 1.4731592e-14 cap_mim_2f0_m4m5_noshield
CXc_256_195 bp_256 top 1.4731592e-14 cap_mim_2f0_m4m5_noshield
CXc_256_196 bp_256 top 1.4731592e-14 cap_mim_2f0_m4m5_noshield
CXc_256_197 bp_256 top 1.4731592e-14 cap_mim_2f0_m4m5_noshield
CXc_256_198 bp_256 top 1.4731592e-14 cap_mim_2f0_m4m5_noshield
CXc_256_199 bp_256 top 1.4731592e-14 cap_mim_2f0_m4m5_noshield
CXc_256_200 bp_256 top 1.4731592e-14 cap_mim_2f0_m4m5_noshield
CXc_256_201 bp_256 top 1.4731592e-14 cap_mim_2f0_m4m5_noshield
CXc_256_202 bp_256 top 1.4731592e-14 cap_mim_2f0_m4m5_noshield
CXc_256_203 bp_256 top 1.4731592e-14 cap_mim_2f0_m4m5_noshield
CXc_256_204 bp_256 top 1.4731592e-14 cap_mim_2f0_m4m5_noshield
CXc_256_205 bp_256 top 1.4731592e-14 cap_mim_2f0_m4m5_noshield
CXc_256_206 bp_256 top 1.4731592e-14 cap_mim_2f0_m4m5_noshield
CXc_256_207 bp_256 top 1.4731592e-14 cap_mim_2f0_m4m5_noshield
CXc_256_208 bp_256 top 1.4731592e-14 cap_mim_2f0_m4m5_noshield
CXc_256_209 bp_256 top 1.4731592e-14 cap_mim_2f0_m4m5_noshield
CXc_256_210 bp_256 top 1.4731592e-14 cap_mim_2f0_m4m5_noshield
CXc_256_211 bp_256 top 1.4731592e-14 cap_mim_2f0_m4m5_noshield
CXc_256_212 bp_256 top 1.4731592e-14 cap_mim_2f0_m4m5_noshield
CXc_256_213 bp_256 top 1.4731592e-14 cap_mim_2f0_m4m5_noshield
CXc_256_214 bp_256 top 1.4731592e-14 cap_mim_2f0_m4m5_noshield
CXc_256_215 bp_256 top 1.4731592e-14 cap_mim_2f0_m4m5_noshield
CXc_256_216 bp_256 top 1.4731592e-14 cap_mim_2f0_m4m5_noshield
CXc_256_217 bp_256 top 1.4731592e-14 cap_mim_2f0_m4m5_noshield
CXc_256_218 bp_256 top 1.4731592e-14 cap_mim_2f0_m4m5_noshield
CXc_256_219 bp_256 top 1.4731592e-14 cap_mim_2f0_m4m5_noshield
CXc_256_220 bp_256 top 1.4731592e-14 cap_mim_2f0_m4m5_noshield
CXc_256_221 bp_256 top 1.4731592e-14 cap_mim_2f0_m4m5_noshield
CXc_256_222 bp_256 top 1.4731592e-14 cap_mim_2f0_m4m5_noshield
CXc_256_223 bp_256 top 1.4731592e-14 cap_mim_2f0_m4m5_noshield
CXc_256_224 bp_256 top 1.4731592e-14 cap_mim_2f0_m4m5_noshield
CXc_256_225 bp_256 top 1.4731592e-14 cap_mim_2f0_m4m5_noshield
CXc_256_226 bp_256 top 1.4731592e-14 cap_mim_2f0_m4m5_noshield
CXc_256_227 bp_256 top 1.4731592e-14 cap_mim_2f0_m4m5_noshield
CXc_256_228 bp_256 top 1.4731592e-14 cap_mim_2f0_m4m5_noshield
CXc_256_229 bp_256 top 1.4731592e-14 cap_mim_2f0_m4m5_noshield
CXc_256_230 bp_256 top 1.4731592e-14 cap_mim_2f0_m4m5_noshield
CXc_256_231 bp_256 top 1.4731592e-14 cap_mim_2f0_m4m5_noshield
CXc_256_232 bp_256 top 1.4731592e-14 cap_mim_2f0_m4m5_noshield
CXc_256_233 bp_256 top 1.4731592e-14 cap_mim_2f0_m4m5_noshield
CXc_256_234 bp_256 top 1.4731592e-14 cap_mim_2f0_m4m5_noshield
CXc_256_235 bp_256 top 1.4731592e-14 cap_mim_2f0_m4m5_noshield
CXc_256_236 bp_256 top 1.4731592e-14 cap_mim_2f0_m4m5_noshield
CXc_256_237 bp_256 top 1.4731592e-14 cap_mim_2f0_m4m5_noshield
CXc_256_238 bp_256 top 1.4731592e-14 cap_mim_2f0_m4m5_noshield
CXc_256_239 bp_256 top 1.4731592e-14 cap_mim_2f0_m4m5_noshield
CXc_256_240 bp_256 top 1.4731592e-14 cap_mim_2f0_m4m5_noshield
CXc_256_241 bp_256 top 1.4731592e-14 cap_mim_2f0_m4m5_noshield
CXc_256_242 bp_256 top 1.4731592e-14 cap_mim_2f0_m4m5_noshield
CXc_256_243 bp_256 top 1.4731592e-14 cap_mim_2f0_m4m5_noshield
CXc_256_244 bp_256 top 1.4731592e-14 cap_mim_2f0_m4m5_noshield
CXc_256_245 bp_256 top 1.4731592e-14 cap_mim_2f0_m4m5_noshield
CXc_256_246 bp_256 top 1.4731592e-14 cap_mim_2f0_m4m5_noshield
CXc_256_247 bp_256 top 1.4731592e-14 cap_mim_2f0_m4m5_noshield
CXc_256_248 bp_256 top 1.4731592e-14 cap_mim_2f0_m4m5_noshield
CXc_256_249 bp_256 top 1.4731592e-14 cap_mim_2f0_m4m5_noshield
CXc_256_250 bp_256 top 1.4731592e-14 cap_mim_2f0_m4m5_noshield
CXc_256_251 bp_256 top 1.4731592e-14 cap_mim_2f0_m4m5_noshield
CXc_256_252 bp_256 top 1.4731592e-14 cap_mim_2f0_m4m5_noshield
CXc_256_253 bp_256 top 1.4731592e-14 cap_mim_2f0_m4m5_noshield
CXc_256_254 bp_256 top 1.4731592e-14 cap_mim_2f0_m4m5_noshield
CXc_256_255 bp_256 top 1.4731592e-14 cap_mim_2f0_m4m5_noshield
CXc_128_0 bp_128 top 1.4731592e-14 cap_mim_2f0_m4m5_noshield
CXc_128_1 bp_128 top 1.4731592e-14 cap_mim_2f0_m4m5_noshield
CXc_128_2 bp_128 top 1.4731592e-14 cap_mim_2f0_m4m5_noshield
CXc_128_3 bp_128 top 1.4731592e-14 cap_mim_2f0_m4m5_noshield
CXc_128_4 bp_128 top 1.4731592e-14 cap_mim_2f0_m4m5_noshield
CXc_128_5 bp_128 top 1.4731592e-14 cap_mim_2f0_m4m5_noshield
CXc_128_6 bp_128 top 1.4731592e-14 cap_mim_2f0_m4m5_noshield
CXc_128_7 bp_128 top 1.4731592e-14 cap_mim_2f0_m4m5_noshield
CXc_128_8 bp_128 top 1.4731592e-14 cap_mim_2f0_m4m5_noshield
CXc_128_9 bp_128 top 1.4731592e-14 cap_mim_2f0_m4m5_noshield
CXc_128_10 bp_128 top 1.4731592e-14 cap_mim_2f0_m4m5_noshield
CXc_128_11 bp_128 top 1.4731592e-14 cap_mim_2f0_m4m5_noshield
CXc_128_12 bp_128 top 1.4731592e-14 cap_mim_2f0_m4m5_noshield
CXc_128_13 bp_128 top 1.4731592e-14 cap_mim_2f0_m4m5_noshield
CXc_128_14 bp_128 top 1.4731592e-14 cap_mim_2f0_m4m5_noshield
CXc_128_15 bp_128 top 1.4731592e-14 cap_mim_2f0_m4m5_noshield
CXc_128_16 bp_128 top 1.4731592e-14 cap_mim_2f0_m4m5_noshield
CXc_128_17 bp_128 top 1.4731592e-14 cap_mim_2f0_m4m5_noshield
CXc_128_18 bp_128 top 1.4731592e-14 cap_mim_2f0_m4m5_noshield
CXc_128_19 bp_128 top 1.4731592e-14 cap_mim_2f0_m4m5_noshield
CXc_128_20 bp_128 top 1.4731592e-14 cap_mim_2f0_m4m5_noshield
CXc_128_21 bp_128 top 1.4731592e-14 cap_mim_2f0_m4m5_noshield
CXc_128_22 bp_128 top 1.4731592e-14 cap_mim_2f0_m4m5_noshield
CXc_128_23 bp_128 top 1.4731592e-14 cap_mim_2f0_m4m5_noshield
CXc_128_24 bp_128 top 1.4731592e-14 cap_mim_2f0_m4m5_noshield
CXc_128_25 bp_128 top 1.4731592e-14 cap_mim_2f0_m4m5_noshield
CXc_128_26 bp_128 top 1.4731592e-14 cap_mim_2f0_m4m5_noshield
CXc_128_27 bp_128 top 1.4731592e-14 cap_mim_2f0_m4m5_noshield
CXc_128_28 bp_128 top 1.4731592e-14 cap_mim_2f0_m4m5_noshield
CXc_128_29 bp_128 top 1.4731592e-14 cap_mim_2f0_m4m5_noshield
CXc_128_30 bp_128 top 1.4731592e-14 cap_mim_2f0_m4m5_noshield
CXc_128_31 bp_128 top 1.4731592e-14 cap_mim_2f0_m4m5_noshield
CXc_128_32 bp_128 top 1.4731592e-14 cap_mim_2f0_m4m5_noshield
CXc_128_33 bp_128 top 1.4731592e-14 cap_mim_2f0_m4m5_noshield
CXc_128_34 bp_128 top 1.4731592e-14 cap_mim_2f0_m4m5_noshield
CXc_128_35 bp_128 top 1.4731592e-14 cap_mim_2f0_m4m5_noshield
CXc_128_36 bp_128 top 1.4731592e-14 cap_mim_2f0_m4m5_noshield
CXc_128_37 bp_128 top 1.4731592e-14 cap_mim_2f0_m4m5_noshield
CXc_128_38 bp_128 top 1.4731592e-14 cap_mim_2f0_m4m5_noshield
CXc_128_39 bp_128 top 1.4731592e-14 cap_mim_2f0_m4m5_noshield
CXc_128_40 bp_128 top 1.4731592e-14 cap_mim_2f0_m4m5_noshield
CXc_128_41 bp_128 top 1.4731592e-14 cap_mim_2f0_m4m5_noshield
CXc_128_42 bp_128 top 1.4731592e-14 cap_mim_2f0_m4m5_noshield
CXc_128_43 bp_128 top 1.4731592e-14 cap_mim_2f0_m4m5_noshield
CXc_128_44 bp_128 top 1.4731592e-14 cap_mim_2f0_m4m5_noshield
CXc_128_45 bp_128 top 1.4731592e-14 cap_mim_2f0_m4m5_noshield
CXc_128_46 bp_128 top 1.4731592e-14 cap_mim_2f0_m4m5_noshield
CXc_128_47 bp_128 top 1.4731592e-14 cap_mim_2f0_m4m5_noshield
CXc_128_48 bp_128 top 1.4731592e-14 cap_mim_2f0_m4m5_noshield
CXc_128_49 bp_128 top 1.4731592e-14 cap_mim_2f0_m4m5_noshield
CXc_128_50 bp_128 top 1.4731592e-14 cap_mim_2f0_m4m5_noshield
CXc_128_51 bp_128 top 1.4731592e-14 cap_mim_2f0_m4m5_noshield
CXc_128_52 bp_128 top 1.4731592e-14 cap_mim_2f0_m4m5_noshield
CXc_128_53 bp_128 top 1.4731592e-14 cap_mim_2f0_m4m5_noshield
CXc_128_54 bp_128 top 1.4731592e-14 cap_mim_2f0_m4m5_noshield
CXc_128_55 bp_128 top 1.4731592e-14 cap_mim_2f0_m4m5_noshield
CXc_128_56 bp_128 top 1.4731592e-14 cap_mim_2f0_m4m5_noshield
CXc_128_57 bp_128 top 1.4731592e-14 cap_mim_2f0_m4m5_noshield
CXc_128_58 bp_128 top 1.4731592e-14 cap_mim_2f0_m4m5_noshield
CXc_128_59 bp_128 top 1.4731592e-14 cap_mim_2f0_m4m5_noshield
CXc_128_60 bp_128 top 1.4731592e-14 cap_mim_2f0_m4m5_noshield
CXc_128_61 bp_128 top 1.4731592e-14 cap_mim_2f0_m4m5_noshield
CXc_128_62 bp_128 top 1.4731592e-14 cap_mim_2f0_m4m5_noshield
CXc_128_63 bp_128 top 1.4731592e-14 cap_mim_2f0_m4m5_noshield
CXc_128_64 bp_128 top 1.4731592e-14 cap_mim_2f0_m4m5_noshield
CXc_128_65 bp_128 top 1.4731592e-14 cap_mim_2f0_m4m5_noshield
CXc_128_66 bp_128 top 1.4731592e-14 cap_mim_2f0_m4m5_noshield
CXc_128_67 bp_128 top 1.4731592e-14 cap_mim_2f0_m4m5_noshield
CXc_128_68 bp_128 top 1.4731592e-14 cap_mim_2f0_m4m5_noshield
CXc_128_69 bp_128 top 1.4731592e-14 cap_mim_2f0_m4m5_noshield
CXc_128_70 bp_128 top 1.4731592e-14 cap_mim_2f0_m4m5_noshield
CXc_128_71 bp_128 top 1.4731592e-14 cap_mim_2f0_m4m5_noshield
CXc_128_72 bp_128 top 1.4731592e-14 cap_mim_2f0_m4m5_noshield
CXc_128_73 bp_128 top 1.4731592e-14 cap_mim_2f0_m4m5_noshield
CXc_128_74 bp_128 top 1.4731592e-14 cap_mim_2f0_m4m5_noshield
CXc_128_75 bp_128 top 1.4731592e-14 cap_mim_2f0_m4m5_noshield
CXc_128_76 bp_128 top 1.4731592e-14 cap_mim_2f0_m4m5_noshield
CXc_128_77 bp_128 top 1.4731592e-14 cap_mim_2f0_m4m5_noshield
CXc_128_78 bp_128 top 1.4731592e-14 cap_mim_2f0_m4m5_noshield
CXc_128_79 bp_128 top 1.4731592e-14 cap_mim_2f0_m4m5_noshield
CXc_128_80 bp_128 top 1.4731592e-14 cap_mim_2f0_m4m5_noshield
CXc_128_81 bp_128 top 1.4731592e-14 cap_mim_2f0_m4m5_noshield
CXc_128_82 bp_128 top 1.4731592e-14 cap_mim_2f0_m4m5_noshield
CXc_128_83 bp_128 top 1.4731592e-14 cap_mim_2f0_m4m5_noshield
CXc_128_84 bp_128 top 1.4731592e-14 cap_mim_2f0_m4m5_noshield
CXc_128_85 bp_128 top 1.4731592e-14 cap_mim_2f0_m4m5_noshield
CXc_128_86 bp_128 top 1.4731592e-14 cap_mim_2f0_m4m5_noshield
CXc_128_87 bp_128 top 1.4731592e-14 cap_mim_2f0_m4m5_noshield
CXc_128_88 bp_128 top 1.4731592e-14 cap_mim_2f0_m4m5_noshield
CXc_128_89 bp_128 top 1.4731592e-14 cap_mim_2f0_m4m5_noshield
CXc_128_90 bp_128 top 1.4731592e-14 cap_mim_2f0_m4m5_noshield
CXc_128_91 bp_128 top 1.4731592e-14 cap_mim_2f0_m4m5_noshield
CXc_128_92 bp_128 top 1.4731592e-14 cap_mim_2f0_m4m5_noshield
CXc_128_93 bp_128 top 1.4731592e-14 cap_mim_2f0_m4m5_noshield
CXc_128_94 bp_128 top 1.4731592e-14 cap_mim_2f0_m4m5_noshield
CXc_128_95 bp_128 top 1.4731592e-14 cap_mim_2f0_m4m5_noshield
CXc_128_96 bp_128 top 1.4731592e-14 cap_mim_2f0_m4m5_noshield
CXc_128_97 bp_128 top 1.4731592e-14 cap_mim_2f0_m4m5_noshield
CXc_128_98 bp_128 top 1.4731592e-14 cap_mim_2f0_m4m5_noshield
CXc_128_99 bp_128 top 1.4731592e-14 cap_mim_2f0_m4m5_noshield
CXc_128_100 bp_128 top 1.4731592e-14 cap_mim_2f0_m4m5_noshield
CXc_128_101 bp_128 top 1.4731592e-14 cap_mim_2f0_m4m5_noshield
CXc_128_102 bp_128 top 1.4731592e-14 cap_mim_2f0_m4m5_noshield
CXc_128_103 bp_128 top 1.4731592e-14 cap_mim_2f0_m4m5_noshield
CXc_128_104 bp_128 top 1.4731592e-14 cap_mim_2f0_m4m5_noshield
CXc_128_105 bp_128 top 1.4731592e-14 cap_mim_2f0_m4m5_noshield
CXc_128_106 bp_128 top 1.4731592e-14 cap_mim_2f0_m4m5_noshield
CXc_128_107 bp_128 top 1.4731592e-14 cap_mim_2f0_m4m5_noshield
CXc_128_108 bp_128 top 1.4731592e-14 cap_mim_2f0_m4m5_noshield
CXc_128_109 bp_128 top 1.4731592e-14 cap_mim_2f0_m4m5_noshield
CXc_128_110 bp_128 top 1.4731592e-14 cap_mim_2f0_m4m5_noshield
CXc_128_111 bp_128 top 1.4731592e-14 cap_mim_2f0_m4m5_noshield
CXc_128_112 bp_128 top 1.4731592e-14 cap_mim_2f0_m4m5_noshield
CXc_128_113 bp_128 top 1.4731592e-14 cap_mim_2f0_m4m5_noshield
CXc_128_114 bp_128 top 1.4731592e-14 cap_mim_2f0_m4m5_noshield
CXc_128_115 bp_128 top 1.4731592e-14 cap_mim_2f0_m4m5_noshield
CXc_128_116 bp_128 top 1.4731592e-14 cap_mim_2f0_m4m5_noshield
CXc_128_117 bp_128 top 1.4731592e-14 cap_mim_2f0_m4m5_noshield
CXc_128_118 bp_128 top 1.4731592e-14 cap_mim_2f0_m4m5_noshield
CXc_128_119 bp_128 top 1.4731592e-14 cap_mim_2f0_m4m5_noshield
CXc_128_120 bp_128 top 1.4731592e-14 cap_mim_2f0_m4m5_noshield
CXc_128_121 bp_128 top 1.4731592e-14 cap_mim_2f0_m4m5_noshield
CXc_128_122 bp_128 top 1.4731592e-14 cap_mim_2f0_m4m5_noshield
CXc_128_123 bp_128 top 1.4731592e-14 cap_mim_2f0_m4m5_noshield
CXc_128_124 bp_128 top 1.4731592e-14 cap_mim_2f0_m4m5_noshield
CXc_128_125 bp_128 top 1.4731592e-14 cap_mim_2f0_m4m5_noshield
CXc_128_126 bp_128 top 1.4731592e-14 cap_mim_2f0_m4m5_noshield
CXc_128_127 bp_128 top 1.4731592e-14 cap_mim_2f0_m4m5_noshield
CXc_64_0 bp_64 top 1.4731592e-14 cap_mim_2f0_m4m5_noshield
CXc_64_1 bp_64 top 1.4731592e-14 cap_mim_2f0_m4m5_noshield
CXc_64_2 bp_64 top 1.4731592e-14 cap_mim_2f0_m4m5_noshield
CXc_64_3 bp_64 top 1.4731592e-14 cap_mim_2f0_m4m5_noshield
CXc_64_4 bp_64 top 1.4731592e-14 cap_mim_2f0_m4m5_noshield
CXc_64_5 bp_64 top 1.4731592e-14 cap_mim_2f0_m4m5_noshield
CXc_64_6 bp_64 top 1.4731592e-14 cap_mim_2f0_m4m5_noshield
CXc_64_7 bp_64 top 1.4731592e-14 cap_mim_2f0_m4m5_noshield
CXc_64_8 bp_64 top 1.4731592e-14 cap_mim_2f0_m4m5_noshield
CXc_64_9 bp_64 top 1.4731592e-14 cap_mim_2f0_m4m5_noshield
CXc_64_10 bp_64 top 1.4731592e-14 cap_mim_2f0_m4m5_noshield
CXc_64_11 bp_64 top 1.4731592e-14 cap_mim_2f0_m4m5_noshield
CXc_64_12 bp_64 top 1.4731592e-14 cap_mim_2f0_m4m5_noshield
CXc_64_13 bp_64 top 1.4731592e-14 cap_mim_2f0_m4m5_noshield
CXc_64_14 bp_64 top 1.4731592e-14 cap_mim_2f0_m4m5_noshield
CXc_64_15 bp_64 top 1.4731592e-14 cap_mim_2f0_m4m5_noshield
CXc_64_16 bp_64 top 1.4731592e-14 cap_mim_2f0_m4m5_noshield
CXc_64_17 bp_64 top 1.4731592e-14 cap_mim_2f0_m4m5_noshield
CXc_64_18 bp_64 top 1.4731592e-14 cap_mim_2f0_m4m5_noshield
CXc_64_19 bp_64 top 1.4731592e-14 cap_mim_2f0_m4m5_noshield
CXc_64_20 bp_64 top 1.4731592e-14 cap_mim_2f0_m4m5_noshield
CXc_64_21 bp_64 top 1.4731592e-14 cap_mim_2f0_m4m5_noshield
CXc_64_22 bp_64 top 1.4731592e-14 cap_mim_2f0_m4m5_noshield
CXc_64_23 bp_64 top 1.4731592e-14 cap_mim_2f0_m4m5_noshield
CXc_64_24 bp_64 top 1.4731592e-14 cap_mim_2f0_m4m5_noshield
CXc_64_25 bp_64 top 1.4731592e-14 cap_mim_2f0_m4m5_noshield
CXc_64_26 bp_64 top 1.4731592e-14 cap_mim_2f0_m4m5_noshield
CXc_64_27 bp_64 top 1.4731592e-14 cap_mim_2f0_m4m5_noshield
CXc_64_28 bp_64 top 1.4731592e-14 cap_mim_2f0_m4m5_noshield
CXc_64_29 bp_64 top 1.4731592e-14 cap_mim_2f0_m4m5_noshield
CXc_64_30 bp_64 top 1.4731592e-14 cap_mim_2f0_m4m5_noshield
CXc_64_31 bp_64 top 1.4731592e-14 cap_mim_2f0_m4m5_noshield
CXc_64_32 bp_64 top 1.4731592e-14 cap_mim_2f0_m4m5_noshield
CXc_64_33 bp_64 top 1.4731592e-14 cap_mim_2f0_m4m5_noshield
CXc_64_34 bp_64 top 1.4731592e-14 cap_mim_2f0_m4m5_noshield
CXc_64_35 bp_64 top 1.4731592e-14 cap_mim_2f0_m4m5_noshield
CXc_64_36 bp_64 top 1.4731592e-14 cap_mim_2f0_m4m5_noshield
CXc_64_37 bp_64 top 1.4731592e-14 cap_mim_2f0_m4m5_noshield
CXc_64_38 bp_64 top 1.4731592e-14 cap_mim_2f0_m4m5_noshield
CXc_64_39 bp_64 top 1.4731592e-14 cap_mim_2f0_m4m5_noshield
CXc_64_40 bp_64 top 1.4731592e-14 cap_mim_2f0_m4m5_noshield
CXc_64_41 bp_64 top 1.4731592e-14 cap_mim_2f0_m4m5_noshield
CXc_64_42 bp_64 top 1.4731592e-14 cap_mim_2f0_m4m5_noshield
CXc_64_43 bp_64 top 1.4731592e-14 cap_mim_2f0_m4m5_noshield
CXc_64_44 bp_64 top 1.4731592e-14 cap_mim_2f0_m4m5_noshield
CXc_64_45 bp_64 top 1.4731592e-14 cap_mim_2f0_m4m5_noshield
CXc_64_46 bp_64 top 1.4731592e-14 cap_mim_2f0_m4m5_noshield
CXc_64_47 bp_64 top 1.4731592e-14 cap_mim_2f0_m4m5_noshield
CXc_64_48 bp_64 top 1.4731592e-14 cap_mim_2f0_m4m5_noshield
CXc_64_49 bp_64 top 1.4731592e-14 cap_mim_2f0_m4m5_noshield
CXc_64_50 bp_64 top 1.4731592e-14 cap_mim_2f0_m4m5_noshield
CXc_64_51 bp_64 top 1.4731592e-14 cap_mim_2f0_m4m5_noshield
CXc_64_52 bp_64 top 1.4731592e-14 cap_mim_2f0_m4m5_noshield
CXc_64_53 bp_64 top 1.4731592e-14 cap_mim_2f0_m4m5_noshield
CXc_64_54 bp_64 top 1.4731592e-14 cap_mim_2f0_m4m5_noshield
CXc_64_55 bp_64 top 1.4731592e-14 cap_mim_2f0_m4m5_noshield
CXc_64_56 bp_64 top 1.4731592e-14 cap_mim_2f0_m4m5_noshield
CXc_64_57 bp_64 top 1.4731592e-14 cap_mim_2f0_m4m5_noshield
CXc_64_58 bp_64 top 1.4731592e-14 cap_mim_2f0_m4m5_noshield
CXc_64_59 bp_64 top 1.4731592e-14 cap_mim_2f0_m4m5_noshield
CXc_64_60 bp_64 top 1.4731592e-14 cap_mim_2f0_m4m5_noshield
CXc_64_61 bp_64 top 1.4731592e-14 cap_mim_2f0_m4m5_noshield
CXc_64_62 bp_64 top 1.4731592e-14 cap_mim_2f0_m4m5_noshield
CXc_64_63 bp_64 top 1.4731592e-14 cap_mim_2f0_m4m5_noshield
CXc_32_0 bp_32 top 1.4731592e-14 cap_mim_2f0_m4m5_noshield
CXc_32_1 bp_32 top 1.4731592e-14 cap_mim_2f0_m4m5_noshield
CXc_32_2 bp_32 top 1.4731592e-14 cap_mim_2f0_m4m5_noshield
CXc_32_3 bp_32 top 1.4731592e-14 cap_mim_2f0_m4m5_noshield
CXc_32_4 bp_32 top 1.4731592e-14 cap_mim_2f0_m4m5_noshield
CXc_32_5 bp_32 top 1.4731592e-14 cap_mim_2f0_m4m5_noshield
CXc_32_6 bp_32 top 1.4731592e-14 cap_mim_2f0_m4m5_noshield
CXc_32_7 bp_32 top 1.4731592e-14 cap_mim_2f0_m4m5_noshield
CXc_32_8 bp_32 top 1.4731592e-14 cap_mim_2f0_m4m5_noshield
CXc_32_9 bp_32 top 1.4731592e-14 cap_mim_2f0_m4m5_noshield
CXc_32_10 bp_32 top 1.4731592e-14 cap_mim_2f0_m4m5_noshield
CXc_32_11 bp_32 top 1.4731592e-14 cap_mim_2f0_m4m5_noshield
CXc_32_12 bp_32 top 1.4731592e-14 cap_mim_2f0_m4m5_noshield
CXc_32_13 bp_32 top 1.4731592e-14 cap_mim_2f0_m4m5_noshield
CXc_32_14 bp_32 top 1.4731592e-14 cap_mim_2f0_m4m5_noshield
CXc_32_15 bp_32 top 1.4731592e-14 cap_mim_2f0_m4m5_noshield
CXc_32_16 bp_32 top 1.4731592e-14 cap_mim_2f0_m4m5_noshield
CXc_32_17 bp_32 top 1.4731592e-14 cap_mim_2f0_m4m5_noshield
CXc_32_18 bp_32 top 1.4731592e-14 cap_mim_2f0_m4m5_noshield
CXc_32_19 bp_32 top 1.4731592e-14 cap_mim_2f0_m4m5_noshield
CXc_32_20 bp_32 top 1.4731592e-14 cap_mim_2f0_m4m5_noshield
CXc_32_21 bp_32 top 1.4731592e-14 cap_mim_2f0_m4m5_noshield
CXc_32_22 bp_32 top 1.4731592e-14 cap_mim_2f0_m4m5_noshield
CXc_32_23 bp_32 top 1.4731592e-14 cap_mim_2f0_m4m5_noshield
CXc_32_24 bp_32 top 1.4731592e-14 cap_mim_2f0_m4m5_noshield
CXc_32_25 bp_32 top 1.4731592e-14 cap_mim_2f0_m4m5_noshield
CXc_32_26 bp_32 top 1.4731592e-14 cap_mim_2f0_m4m5_noshield
CXc_32_27 bp_32 top 1.4731592e-14 cap_mim_2f0_m4m5_noshield
CXc_32_28 bp_32 top 1.4731592e-14 cap_mim_2f0_m4m5_noshield
CXc_32_29 bp_32 top 1.4731592e-14 cap_mim_2f0_m4m5_noshield
CXc_32_30 bp_32 top 1.4731592e-14 cap_mim_2f0_m4m5_noshield
CXc_32_31 bp_32 top 1.4731592e-14 cap_mim_2f0_m4m5_noshield
CXc_16_0 bp_16 top 1.4731592e-14 cap_mim_2f0_m4m5_noshield
CXc_16_1 bp_16 top 1.4731592e-14 cap_mim_2f0_m4m5_noshield
CXc_16_2 bp_16 top 1.4731592e-14 cap_mim_2f0_m4m5_noshield
CXc_16_3 bp_16 top 1.4731592e-14 cap_mim_2f0_m4m5_noshield
CXc_16_4 bp_16 top 1.4731592e-14 cap_mim_2f0_m4m5_noshield
CXc_16_5 bp_16 top 1.4731592e-14 cap_mim_2f0_m4m5_noshield
CXc_16_6 bp_16 top 1.4731592e-14 cap_mim_2f0_m4m5_noshield
CXc_16_7 bp_16 top 1.4731592e-14 cap_mim_2f0_m4m5_noshield
CXc_16_8 bp_16 top 1.4731592e-14 cap_mim_2f0_m4m5_noshield
CXc_16_9 bp_16 top 1.4731592e-14 cap_mim_2f0_m4m5_noshield
CXc_16_10 bp_16 top 1.4731592e-14 cap_mim_2f0_m4m5_noshield
CXc_16_11 bp_16 top 1.4731592e-14 cap_mim_2f0_m4m5_noshield
CXc_16_12 bp_16 top 1.4731592e-14 cap_mim_2f0_m4m5_noshield
CXc_16_13 bp_16 top 1.4731592e-14 cap_mim_2f0_m4m5_noshield
CXc_16_14 bp_16 top 1.4731592e-14 cap_mim_2f0_m4m5_noshield
CXc_16_15 bp_16 top 1.4731592e-14 cap_mim_2f0_m4m5_noshield
CXc_8_0 bp_8 top 1.4731592e-14 cap_mim_2f0_m4m5_noshield
CXc_8_1 bp_8 top 1.4731592e-14 cap_mim_2f0_m4m5_noshield
CXc_8_2 bp_8 top 1.4731592e-14 cap_mim_2f0_m4m5_noshield
CXc_8_3 bp_8 top 1.4731592e-14 cap_mim_2f0_m4m5_noshield
CXc_8_4 bp_8 top 1.4731592e-14 cap_mim_2f0_m4m5_noshield
CXc_8_5 bp_8 top 1.4731592e-14 cap_mim_2f0_m4m5_noshield
CXc_8_6 bp_8 top 1.4731592e-14 cap_mim_2f0_m4m5_noshield
CXc_8_7 bp_8 top 1.4731592e-14 cap_mim_2f0_m4m5_noshield
CXc_4_0 bp_4 top 1.4731592e-14 cap_mim_2f0_m4m5_noshield
CXc_4_1 bp_4 top 1.4731592e-14 cap_mim_2f0_m4m5_noshield
CXc_4_2 bp_4 top 1.4731592e-14 cap_mim_2f0_m4m5_noshield
CXc_4_3 bp_4 top 1.4731592e-14 cap_mim_2f0_m4m5_noshield
CXc_2_0 bp_2 top 1.4731592e-14 cap_mim_2f0_m4m5_noshield
CXc_2_1 bp_2 top 1.4731592e-14 cap_mim_2f0_m4m5_noshield
CXc_1_0 bp_1 top 1.4731592e-14 cap_mim_2f0_m4m5_noshield
CXc_term_0 bp_term top 1.4731592e-14 cap_mim_2f0_m4m5_noshield
.ENDS ADC_CDAC_ARRAY
