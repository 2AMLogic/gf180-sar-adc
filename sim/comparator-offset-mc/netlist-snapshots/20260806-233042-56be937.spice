* Frozen netlist snapshot for record 20260806-233042-56be937
* source     : sim/comparator-offset-mc/testbench/tb_offset_mc.spice
* sha256     : 6e35348539e0f628934d8bb67f64f07b0689e3f281b7a0e0189340fe1b5054bf
* This is a verbatim copy taken at record time. Do not edit.
* tb_offset_mc -- Monte Carlo of the comparator preamplifier's
* input-referred offset, and of its dependence on the input common mode.
*
* Netlist FRAGMENT. The harness supplies the models, the corner .lib
* sections, .temp, the .control block and .end (sim/harness/README.md).
* The Monte Carlo loop itself lives in the manifest's `analyses` block.
*
* WHAT THIS ANSWERS (issue #9)
*
* 1. sigma(V_os) of the preamp, the DOMINANT term in the comparator's
*    total input-referred offset. The ratified spec bounds untrimmed
*    offset at <= 2 LSB (README.md#target-specification note [e]), i.e.
*    3*sigma <= 6.445 mV at LSB_se = 3.2227 mV, so the whole comparator
*    gets sigma_os <= 2.148 mV and this term has to fit inside it
*    alongside the latch's contribution, which is derived rather than
*    measured (spec/comparator-budget-memo.md S3.3).
*
* 2. THE CODE-CORRELATED PART, which is the part that actually threatens
*    linearity. Per prior-art-survey S3.1 a STATIC offset in a
*    single-comparator SAR is a whole-converter offset -- removable by a
*    one-time digital subtraction -- and only becomes a linearity error
*    if it VARIES within a conversion. DR-0006 leaves the input common
*    mode constant in differential mode, but in single-ended mode it
*    moves by residue/2, so the offset can vary from trial to trial. The
*    three common-mode points here (1.60 / 1.65 / 1.70 V) measure
*    sigma(V_os(V_cm +/- 50 mV) - V_os(V_cm)) directly, on the SAME
*    Monte Carlo population, so the code-correlated residue is a
*    measured difference and not a difference of two independent
*    estimates. +/-50 mV is ~5x the excursion the accuracy-critical late
*    trials ever see (the residue, and with it the excursion, halves at
*    every trial).
*
* 3. WHETHER THE LOAD RESISTORS CONTRIBUTE AT ALL. They do not, in this
*    PDK -- and that is a finding, not an assumption. See the null
*    control at the bottom of this file.
*
* METHOD. ONE two-point DC sweep per Monte Carlo draw, on the SAME
* instances -- `dc vd 0 2m 2m`:
*   point [0], 0 V differential input -> d0 = v(pop) - v(pon) = -A_v*V_os
*   point [1], +2 mV                  -> d1,  so A_v = (d1-d0)/2 mV
*   V_os = -d0/A_v
* A two-point sweep rather than two `op` commands, deliberately: both
* points then land in ONE ngspice plot, so d0 and d1 are indices of the
* same vector. Two separate `op`s put them in two different plots, and
* the second `let` cannot see the first plot's scalar -- which is a silent
* failure mode, not a loud one, because the accumulators just stop
* updating.
*
* Taking A_v per draw rather than per corner removes the ~1 % mismatch
* spread of the gain itself from the offset estimate, and gives the deck a
* self-check: `av_sigma_pct` is small ONLY IF the two sweep points share
* one mismatch draw. If the sweep re-drew mismatch per point, (d1-d0)
* would be dominated by the difference of two independent offsets -- each
* ~1.2 mV against a 2 mV probe -- and the extracted gain would scatter by
* tens of percent. That check is in the manifest and is load-bearing.
*
* CONVERGENCE. Each preamp branch is a forced current pushed into a
* diode-connected FET, which from ngspice's all-zero initial guess is an
* open circuit: the direct Newton solve fails and the simulator falls
* back to dynamic gmin stepping. It reaches the right answer either way,
* but ~50x slower -- and this deck solves 300 draws at each of 45 PVT
* points, so that is the difference between a 2-minute record and a
* 2-hour one. The `.nodeset` below is a first-iteration HINT only:
* ngspice releases the hinted nodes and re-solves, so every operating
* point reported here is the true DC solution and the hint cannot bias
* the measured offset distribution. The hints are coarse and
* supply-scaled; being wrong by a few hundred millivolts at a corner
* costs speed, never accuracy.
*
* PREAMP ONLY. At DC the StrongARM latch is in reset: tail off, input
* pair purely capacitive, no DC current and no DC node moved. Its own
* offset is a separate, much smaller term (divided by A_v) and is
* derived in spec/comparator-budget-memo.md S3.3, because it needs a
* transient because a reset-and-regenerate latch has no DC operating
* point at all.
*
* THE PDK's OWN MISMATCH SWITCH. sw_stat_mismatch MUST be set in this
* fragment, not in the manifest's params: the harness emits manifest
* params ahead of the model includes, and design.ngspice sets
* sw_stat_mismatch = 0, so a manifest param would be silently overridden
* and the whole Monte Carlo would collapse to sigma = 0. sw_stat_global
* is held at 0 so this is a mismatch-only population (the process axis is
* swept separately by the corner runner).
.param sw_stat_mismatch=1
.param sw_stat_global=0

.nodeset v(ibn)=0.75 v(pop)='vdd_val-0.8' v(pon)='vdd_val-0.8'

.param ib=10u

vsup vdd 0 dc {vdd_val}

* ONE preamp instance, swept in two dimensions.
*
* This is the whole point of the deck's structure. The code-correlated
* offset term is how ONE physical comparator's offset changes when its
* input common mode moves -- so it must be measured on ONE instance,
* under ONE mismatch draw, at several common modes. Three separate
* instances would carry three INDEPENDENT draws, and their differences
* would report sqrt(2) x the offset sigma (~1.7 mV here) no matter how
* common-mode-insensitive the circuit actually is. That is a plausible,
* alarming, entirely fictitious number, and it is what an earlier
* revision of this deck produced.
*
* The manifest sweeps `dc vd 0 2m 2m vcm 1.60 1.70 0.05`: vd is the inner
* loop, vcm the outer, so one plot carries six operating points in the
* order (vd, vcm) = (0,1.60) (2m,1.60) (0,1.65) (2m,1.65) (0,1.70)
* (2m,1.70) -- offset and gain at each of the three common modes, all
* from a single draw.
vcm  cm 0 dc 1.65
vd   vd 0 dc 0
Eap  ap cm vd 0 0.5
Ean  an cm vd 0 -0.5
ib   vdd ibn dc {ib}
Xa   ap an ibn pop pon vdd 0 preamp

* --- NULL CONTROL: resistor local mismatch is NOT modelled in this PDK -
* Two ppolyf_u_1k identical to the preamp loads (issue #118 -- `_1k`/150u,
* not the `_2k`/75u an earlier revision assumed; see the preamp's own
* Xrlp/Xrln comment below), each carrying a forced 1 uA, so v(rpa) - v(rpb)
* is 1 uA times their resistance MISMATCH. gf180mcu wires a mismatch term
* into every resistor subckt -- `*(1+mis_r*sw_stat_mismatch)` -- but then
* hard-sets `mis_r = 0` and leaves the area-scaled agauss expression
* commented out (sm141064.ngspice, ppolyf_u / ppolyf_u_1k / ppolyf_u_2k /
* nplus_u / ... alike). So the mechanism is present and the COEFFICIENT IS
* ZERO, and this deck's MOS mismatch sigma above therefore contains no
* load-mismatch contribution at all.
*
* That is exactly the class of negative finding this repo records rather
* than papers over (compare sim/device-cdac-cap/ for capacitors). Two
* consequences, both carried in spec/comparator-budget-memo.md S3.4:
* the load-mismatch offset term must be budgeted BY HAND from a stated
* assumption, and if a future PDK revision switches mis_r on, this check
* fails loudly instead of silently changing every offset record.
irpa   0 rpa dc 1u
Xrpa   rpa 0 0 ppolyf_u_1k r_width=1u r_length=150u
irpb   0 rpb dc 1u
Xrpb   rpb 0 0 ppolyf_u_1k r_width=1u r_length=150u

* --- COMPARATOR-NETLIST-BEGIN (verbatim-copied into every testbench) ---
.subckt preamp vinp vinn ibias pop pon vdd vss
* 1:1 NMOS current mirror; ibias is forced into the diode branch.
Xmb  ibias ibias vss vss nfet_03v3 w=20u l=2u
Xmt  ptail ibias vss vss nfet_03v3 w=20u l=2u
* Input pair. The device whose gate is vinp drives the INVERTING node
* pon, so v(pop) - v(pon) = +A_v * (v(vinp) - v(vinn)).
Xmip pon vinp ptail vss nfet_03v3 w=40u l=1u
Xmin pop vinn ptail vss nfet_03v3 w=40u l=1u
* Unsalicided 1 kohm/sq p+ poly loads, 150 squares = 150 kohm nominal.
* Third terminal is the substrate/body contact. `ppolyf_u_1k`, not the
* 2 kohm/sq `ppolyf_u_2k` an earlier revision assumed: issue #118 drew
* SAB(49/0)+RES_MK(110/5)+Resistor(62/0) markers over the load-resistor
* bodies so `klt extract`'s gf180mcu deck recognises them as real devices
* instead of a Poly2 short, and at this repo's pinned klt commit that
* marker geometry can only select `ppolyf_u_1k` (1000 ohm/sq) -- the
* `_2k`/`_3k` flavours share the identical drawn geometry and are chosen by
* a build-time deck option this curated deck does not implement
* (`2AMLogic/klayout-tools#595`, open). `r_length` is doubled (75u -> 150u)
* at the same `r_width=1u` to preserve the 150 kohm target at the new
* sheet-rho -- see layout/adc-top/README.md "Resistors".
Xrlp vdd pop vss ppolyf_u_1k r_width=1u r_length=150u
Xrln vdd pon vss ppolyf_u_1k r_width=1u r_length=150u
.ends preamp

.subckt sarlatch inp inn clk outp outn vdd vss
* clk low  -> tail off; outp/outn/dip/din precharged to vdd
* clk high -> tail on; the input pair discharges dip/din at rates set by
*             v(inp)/v(inn), then the cross-coupled pairs regenerate.
Xmlt ltail clk   vss   vss nfet_03v3 w=16u l=0.35u
Xmlp dip   inp   ltail vss nfet_03v3 w=8u  l=0.5u
Xmln din   inn   ltail vss nfet_03v3 w=8u  l=0.5u
Xmnp outn  outp  dip   vss nfet_03v3 w=6u  l=0.35u
Xmnn outp  outn  din   vss nfet_03v3 w=6u  l=0.35u
Xmpp outn  outp  vdd   vdd pfet_03v3 w=8u  l=0.35u
Xmpn outp  outn  vdd   vdd pfet_03v3 w=8u  l=0.35u
Xmrp outn  clk   vdd   vdd pfet_03v3 w=4u  l=0.35u
Xmrn outp  clk   vdd   vdd pfet_03v3 w=4u  l=0.35u
Xmrd dip   clk   vdd   vdd pfet_03v3 w=2u  l=0.35u
Xmre din   clk   vdd   vdd pfet_03v3 w=2u  l=0.35u
.ends sarlatch

* Minimum-ish isolation inverter. Deliberately small: it is the only
* thing the regeneration nodes drive, so its gate capacitance is added
* directly to the latch's own output nodes and shows up as regeneration
* time.
.subckt inv a y vdd vss
Xp y a vdd vdd pfet_03v3 w=2u   l=0.35u
Xn y a vss vss nfet_03v3 w=1u   l=0.35u
.ends inv

.subckt nor2 a b y vdd vss
Xp1 ps a vdd vdd pfet_03v3 w=8u l=0.35u
Xp2 y  b ps  vdd pfet_03v3 w=8u l=0.35u
Xn1 y  a vss vss nfet_03v3 w=4u l=0.35u
Xn2 y  b vss vss nfet_03v3 w=4u l=0.35u
.ends nor2

.subckt comparator vinp vinn clk ibias dout doutb vdd vss
Xpre preamp_in1 preamp_in2 ibias pop pon vdd vss preamp
Xlat pop pon clk outp outn vdd vss sarlatch
* THE ISOLATION INVERTERS ARE NOT OPTIONAL -- they fix a measured
* hysteresis defect. Both StrongARM outputs precharge HIGH, so the
* decision arrives as an active-low pulse on exactly one of them, and
* the obvious way to hold it is a NAND SR latch wired straight to
* outp/outn. That circuit was built first and MEASURED: after deciding
* one way it would not flip back until the input reached ~10 mV of the
* opposite polarity -- about 3 LSB of hysteresis, which in a SAR (where
* the same comparator makes ten successive decisions on a shrinking
* residue) is a code-dependent error, not an offset.
*
* The cause is that a NAND SR latch's HELD STATE loads the two
* regeneration nodes asymmetrically. Wired directly, the node driving
* the NAND whose output is LOW sees that output swing when it falls
* (Miller-multiplied C_gd, ~26 fF against a regeneration node of a few
* tens of fF), while its twin drives a NAND whose output is already
* HIGH and stays there. The latch is therefore biased toward keeping
* the answer it already holds.
*
* Interposing one small inverter per side removes the coupling: the
* inverters are identical, both of their inputs precharge to V_DD, and
* neither loading depends on what the SR latch is holding. The SR latch
* becomes NOR-type because the inverters make the decision pulses
* active-HIGH. dout goes HIGH when outn falls, i.e. when
* v(vinp) > v(vinn), exactly as before.
Xis outn sset vdd vss inv
Xir outp srst vdd vss inv
Xno1 srst doutb dout  vdd vss nor2
Xno2 sset dout  doutb vdd vss nor2
* Input pass-through (zero-volt sources) so a testbench can probe the
* current the comparator draws from each CDAC top plate directly.
Vpp preamp_in1 vinp dc 0
Vpn preamp_in2 vinn dc 0
.ends comparator
* --- COMPARATOR-NETLIST-END ---
