* Flat LVS reference for the ADC_BLOCK block layout.
*
* GENERATED by layout/adc-top/gen_adc_top.py by flattening
* design/adc-top/adc_top.spice's `adc_cdac_side` and `adc_tp_sw`
* into the same composition the ADC-level testbenches use (DR-0014:
* two array sides + two per-side top-plate V_cm switches) -- do not
* edit. See layout/adc-top/lib/netlist.py for why the layout and this
* reference are derived from the same parsed design netlist, and what
* that does and does not let LVS prove.
*
* Deliberate, documented differences from the schematic, each forced by
* `klt extract`'s gf180mcu ExtractionDeck and restated in
* layout/adc-top/README.md:
*   - NMOS bodies are on the deck's `vsubs` global (no tap layer);
*   - PMOS bodies are on their own Nwell island's net -- one island per
*     placed CDAC cell, one per top-plate switch side, and one per
*     comparator group -- not on `vdd`: the deck never connects `nwell`
*     to `contact`;
*   - the CDAC arrays' capacitors are stated as the layout DRAWS them,
*     not as the schematic writes them: 1024 unit-size
*     `cap_mim_2f0_m4m5_noshield` devices (512 real positions per side
*     -- 511 weighted plus DR-0011's terminating unit), each 4.0000 um
*     square, in parallel per weight. `adc_cdac_side` instead models
*     each weight as ONE lumped capacitor of the whole weight's area
*     (its own comment says why: drawing 1022 unit cells in the
*     simulation deck would multiply cost and change no number). Same
*     capacitance, different device list -- so the reference states the
*     drawn one, which is what `klt extract` reports. Issues #85 (the
*     within-array interconnect) and #86 (the route out to the decode
*     banks, the `vcm` terminating tie and the top-plate mesh's tie to
*     `topp`/`topn`) are what made these capacitors reachable at all;
*     before them they were absent from this reference entirely.
*   - each capacitance is the extraction deck's own MiM model of the
*     drawn plate (35.6528 fF), not the PDK model card's own
*     geometry law for the same plate. See lib/netlist.py's
*     DECK_MIM_AREA_CAP_F_UM2 / DECK_MIM_PERIM_CAP_F_UM: whatever delta
*     the two models carry is a modelling difference no layout change
*     could close, and it is reported in layout/lvs/records/ rather than
*     absorbed by resizing the ratified plate.
*   - the comparator's two 150 kohm p+ poly load resistors are drawn
*     WITH `SAB`/`RES_MK`/`Resistor` markers (issue #118), so
*     `klt extract` recognises each body as a real `ppolyf_u_1k`
*     device (1000 ohm/sq) -- `pop`/`pon` stay distinct nets and
*     each resistor is a genuine `R` device below, not a net merge.
*     The schematic's original `ppolyf_u_2k` (2000 ohm/sq) sheet-rho
*     is not reachable at this repo's pinned klt commit
*     (`2AMLogic/klayout-tools#595`, open); the design is sized for
*     `_1k` instead (see gen_comparator.py / ../README.md
*     'Resistors').
*
* Runnable by hand:
*   klt lvs layout/adc-top/candidates/bank-fold-2x/adc_block.lvs.json --format json
.SUBCKT ADC_BLOCK cmpclk dout doutb hi_128_n hi_128_p hi_16_n hi_16_p hi_1_n hi_1_p hi_256_n hi_256_p hi_2_n hi_2_p hi_32_n hi_32_p hi_4_n hi_4_p hi_64_n hi_64_p hi_8_n hi_8_p ibias lo_128_n lo_128_p lo_16_n lo_16_p lo_1_n lo_1_p lo_256_n lo_256_p lo_2_n lo_2_p lo_32_n lo_32_p lo_4_n lo_4_p lo_64_n lo_64_p lo_8_n lo_8_p pinn pinp rel_128_n rel_128_p rel_16_n rel_16_p rel_1_n rel_1_p rel_256_n rel_256_p rel_2_n rel_2_p rel_32_n rel_32_p rel_4_n rel_4_p rel_64_n rel_64_p rel_8_n rel_8_p sel_in topn topp tp_gn vcm vdd vref vss XCMP.pon XCMP.pop
MXSP_X256_Xdi_Xp XSP.X256.gp_in sel_in vdd vdd pfet L=0.35U W=8U
MXSP_X256_Xdi_Xn XSP.X256.gp_in sel_in vss vss nfet L=0.35U W=4U
MXSP_X256_Xdr_Xp XSP.X256.gp_rel rel_256_p vdd vdd pfet L=0.35U W=8U
MXSP_X256_Xdr_Xn XSP.X256.gp_rel rel_256_p vss vss nfet L=0.35U W=4U
MXSP_X256_Xdh_Xp XSP.X256.gp_hi hi_256_p vdd vdd pfet L=0.35U W=8U
MXSP_X256_Xdh_Xn XSP.X256.gp_hi hi_256_p vss vss nfet L=0.35U W=4U
MXSP_X256_Xdl_Xp XSP.X256.gp_lo lo_256_p vdd vdd pfet L=0.35U W=8U
MXSP_X256_Xdl_Xn XSP.X256.gp_lo lo_256_p vss vss nfet L=0.35U W=4U
MXSP_X256_Xsi_XN pinp sel_in XSP.X256.bp vss nfet L=0.28U W=10U
MXSP_X256_Xsi_XP1 pinp XSP.X256.gp_in XSP.X256.bp vdd pfet L=0.28U W=10U
MXSP_X256_Xsi_XP2 pinp XSP.X256.gp_in XSP.X256.bp vdd pfet L=0.28U W=10U
MXSP_X256_Xsr_XN vcm rel_256_p XSP.X256.bp vss nfet L=0.28U W=10U
MXSP_X256_Xsr_XP1 vcm XSP.X256.gp_rel XSP.X256.bp vdd pfet L=0.28U W=10U
MXSP_X256_Xsr_XP2 vcm XSP.X256.gp_rel XSP.X256.bp vdd pfet L=0.28U W=10U
MXSP_X256_Xsh_XN vref hi_256_p XSP.X256.bp vss nfet L=0.28U W=10U
MXSP_X256_Xsh_XP1 vref XSP.X256.gp_hi XSP.X256.bp vdd pfet L=0.28U W=10U
MXSP_X256_Xsh_XP2 vref XSP.X256.gp_hi XSP.X256.bp vdd pfet L=0.28U W=10U
MXSP_X256_Xsl_XN vss lo_256_p XSP.X256.bp vss nfet L=0.28U W=10U
MXSP_X256_Xsl_XP1 vss XSP.X256.gp_lo XSP.X256.bp vdd pfet L=0.28U W=10U
MXSP_X256_Xsl_XP2 vss XSP.X256.gp_lo XSP.X256.bp vdd pfet L=0.28U W=10U
MXSP_X128_Xdi_Xp XSP.X128.gp_in sel_in vdd vdd pfet L=0.35U W=8U
MXSP_X128_Xdi_Xn XSP.X128.gp_in sel_in vss vss nfet L=0.35U W=4U
MXSP_X128_Xdr_Xp XSP.X128.gp_rel rel_128_p vdd vdd pfet L=0.35U W=8U
MXSP_X128_Xdr_Xn XSP.X128.gp_rel rel_128_p vss vss nfet L=0.35U W=4U
MXSP_X128_Xdh_Xp XSP.X128.gp_hi hi_128_p vdd vdd pfet L=0.35U W=8U
MXSP_X128_Xdh_Xn XSP.X128.gp_hi hi_128_p vss vss nfet L=0.35U W=4U
MXSP_X128_Xdl_Xp XSP.X128.gp_lo lo_128_p vdd vdd pfet L=0.35U W=8U
MXSP_X128_Xdl_Xn XSP.X128.gp_lo lo_128_p vss vss nfet L=0.35U W=4U
MXSP_X128_Xsi_XN pinp sel_in XSP.X128.bp vss nfet L=0.28U W=10U
MXSP_X128_Xsi_XP1 pinp XSP.X128.gp_in XSP.X128.bp vdd pfet L=0.28U W=10U
MXSP_X128_Xsi_XP2 pinp XSP.X128.gp_in XSP.X128.bp vdd pfet L=0.28U W=10U
MXSP_X128_Xsr_XN vcm rel_128_p XSP.X128.bp vss nfet L=0.28U W=10U
MXSP_X128_Xsr_XP1 vcm XSP.X128.gp_rel XSP.X128.bp vdd pfet L=0.28U W=10U
MXSP_X128_Xsr_XP2 vcm XSP.X128.gp_rel XSP.X128.bp vdd pfet L=0.28U W=10U
MXSP_X128_Xsh_XN vref hi_128_p XSP.X128.bp vss nfet L=0.28U W=10U
MXSP_X128_Xsh_XP1 vref XSP.X128.gp_hi XSP.X128.bp vdd pfet L=0.28U W=10U
MXSP_X128_Xsh_XP2 vref XSP.X128.gp_hi XSP.X128.bp vdd pfet L=0.28U W=10U
MXSP_X128_Xsl_XN vss lo_128_p XSP.X128.bp vss nfet L=0.28U W=10U
MXSP_X128_Xsl_XP1 vss XSP.X128.gp_lo XSP.X128.bp vdd pfet L=0.28U W=10U
MXSP_X128_Xsl_XP2 vss XSP.X128.gp_lo XSP.X128.bp vdd pfet L=0.28U W=10U
MXSP_X64_Xdi_Xp XSP.X64.gp_in sel_in vdd vdd pfet L=0.35U W=8U
MXSP_X64_Xdi_Xn XSP.X64.gp_in sel_in vss vss nfet L=0.35U W=4U
MXSP_X64_Xdr_Xp XSP.X64.gp_rel rel_64_p vdd vdd pfet L=0.35U W=8U
MXSP_X64_Xdr_Xn XSP.X64.gp_rel rel_64_p vss vss nfet L=0.35U W=4U
MXSP_X64_Xdh_Xp XSP.X64.gp_hi hi_64_p vdd vdd pfet L=0.35U W=8U
MXSP_X64_Xdh_Xn XSP.X64.gp_hi hi_64_p vss vss nfet L=0.35U W=4U
MXSP_X64_Xdl_Xp XSP.X64.gp_lo lo_64_p vdd vdd pfet L=0.35U W=8U
MXSP_X64_Xdl_Xn XSP.X64.gp_lo lo_64_p vss vss nfet L=0.35U W=4U
MXSP_X64_Xsi_XN pinp sel_in XSP.X64.bp vss nfet L=0.28U W=10U
MXSP_X64_Xsi_XP1 pinp XSP.X64.gp_in XSP.X64.bp vdd pfet L=0.28U W=10U
MXSP_X64_Xsi_XP2 pinp XSP.X64.gp_in XSP.X64.bp vdd pfet L=0.28U W=10U
MXSP_X64_Xsr_XN vcm rel_64_p XSP.X64.bp vss nfet L=0.28U W=10U
MXSP_X64_Xsr_XP1 vcm XSP.X64.gp_rel XSP.X64.bp vdd pfet L=0.28U W=10U
MXSP_X64_Xsr_XP2 vcm XSP.X64.gp_rel XSP.X64.bp vdd pfet L=0.28U W=10U
MXSP_X64_Xsh_XN vref hi_64_p XSP.X64.bp vss nfet L=0.28U W=10U
MXSP_X64_Xsh_XP1 vref XSP.X64.gp_hi XSP.X64.bp vdd pfet L=0.28U W=10U
MXSP_X64_Xsh_XP2 vref XSP.X64.gp_hi XSP.X64.bp vdd pfet L=0.28U W=10U
MXSP_X64_Xsl_XN vss lo_64_p XSP.X64.bp vss nfet L=0.28U W=10U
MXSP_X64_Xsl_XP1 vss XSP.X64.gp_lo XSP.X64.bp vdd pfet L=0.28U W=10U
MXSP_X64_Xsl_XP2 vss XSP.X64.gp_lo XSP.X64.bp vdd pfet L=0.28U W=10U
MXSP_X32_Xdi_Xp XSP.X32.gp_in sel_in vdd vdd pfet L=0.35U W=8U
MXSP_X32_Xdi_Xn XSP.X32.gp_in sel_in vss vss nfet L=0.35U W=4U
MXSP_X32_Xdr_Xp XSP.X32.gp_rel rel_32_p vdd vdd pfet L=0.35U W=8U
MXSP_X32_Xdr_Xn XSP.X32.gp_rel rel_32_p vss vss nfet L=0.35U W=4U
MXSP_X32_Xdh_Xp XSP.X32.gp_hi hi_32_p vdd vdd pfet L=0.35U W=8U
MXSP_X32_Xdh_Xn XSP.X32.gp_hi hi_32_p vss vss nfet L=0.35U W=4U
MXSP_X32_Xdl_Xp XSP.X32.gp_lo lo_32_p vdd vdd pfet L=0.35U W=8U
MXSP_X32_Xdl_Xn XSP.X32.gp_lo lo_32_p vss vss nfet L=0.35U W=4U
MXSP_X32_Xsi_XN pinp sel_in XSP.X32.bp vss nfet L=0.28U W=10U
MXSP_X32_Xsi_XP1 pinp XSP.X32.gp_in XSP.X32.bp vdd pfet L=0.28U W=10U
MXSP_X32_Xsi_XP2 pinp XSP.X32.gp_in XSP.X32.bp vdd pfet L=0.28U W=10U
MXSP_X32_Xsr_XN vcm rel_32_p XSP.X32.bp vss nfet L=0.28U W=10U
MXSP_X32_Xsr_XP1 vcm XSP.X32.gp_rel XSP.X32.bp vdd pfet L=0.28U W=10U
MXSP_X32_Xsr_XP2 vcm XSP.X32.gp_rel XSP.X32.bp vdd pfet L=0.28U W=10U
MXSP_X32_Xsh_XN vref hi_32_p XSP.X32.bp vss nfet L=0.28U W=10U
MXSP_X32_Xsh_XP1 vref XSP.X32.gp_hi XSP.X32.bp vdd pfet L=0.28U W=10U
MXSP_X32_Xsh_XP2 vref XSP.X32.gp_hi XSP.X32.bp vdd pfet L=0.28U W=10U
MXSP_X32_Xsl_XN vss lo_32_p XSP.X32.bp vss nfet L=0.28U W=10U
MXSP_X32_Xsl_XP1 vss XSP.X32.gp_lo XSP.X32.bp vdd pfet L=0.28U W=10U
MXSP_X32_Xsl_XP2 vss XSP.X32.gp_lo XSP.X32.bp vdd pfet L=0.28U W=10U
MXSP_X16_Xdi_Xp XSP.X16.gp_in sel_in vdd vdd pfet L=0.35U W=8U
MXSP_X16_Xdi_Xn XSP.X16.gp_in sel_in vss vss nfet L=0.35U W=4U
MXSP_X16_Xdr_Xp XSP.X16.gp_rel rel_16_p vdd vdd pfet L=0.35U W=8U
MXSP_X16_Xdr_Xn XSP.X16.gp_rel rel_16_p vss vss nfet L=0.35U W=4U
MXSP_X16_Xdh_Xp XSP.X16.gp_hi hi_16_p vdd vdd pfet L=0.35U W=8U
MXSP_X16_Xdh_Xn XSP.X16.gp_hi hi_16_p vss vss nfet L=0.35U W=4U
MXSP_X16_Xdl_Xp XSP.X16.gp_lo lo_16_p vdd vdd pfet L=0.35U W=8U
MXSP_X16_Xdl_Xn XSP.X16.gp_lo lo_16_p vss vss nfet L=0.35U W=4U
MXSP_X16_Xsi_XN pinp sel_in XSP.X16.bp vss nfet L=0.28U W=10U
MXSP_X16_Xsi_XP1 pinp XSP.X16.gp_in XSP.X16.bp vdd pfet L=0.28U W=10U
MXSP_X16_Xsi_XP2 pinp XSP.X16.gp_in XSP.X16.bp vdd pfet L=0.28U W=10U
MXSP_X16_Xsr_XN vcm rel_16_p XSP.X16.bp vss nfet L=0.28U W=10U
MXSP_X16_Xsr_XP1 vcm XSP.X16.gp_rel XSP.X16.bp vdd pfet L=0.28U W=10U
MXSP_X16_Xsr_XP2 vcm XSP.X16.gp_rel XSP.X16.bp vdd pfet L=0.28U W=10U
MXSP_X16_Xsh_XN vref hi_16_p XSP.X16.bp vss nfet L=0.28U W=10U
MXSP_X16_Xsh_XP1 vref XSP.X16.gp_hi XSP.X16.bp vdd pfet L=0.28U W=10U
MXSP_X16_Xsh_XP2 vref XSP.X16.gp_hi XSP.X16.bp vdd pfet L=0.28U W=10U
MXSP_X16_Xsl_XN vss lo_16_p XSP.X16.bp vss nfet L=0.28U W=10U
MXSP_X16_Xsl_XP1 vss XSP.X16.gp_lo XSP.X16.bp vdd pfet L=0.28U W=10U
MXSP_X16_Xsl_XP2 vss XSP.X16.gp_lo XSP.X16.bp vdd pfet L=0.28U W=10U
MXSP_X8_Xdi_Xp XSP.X8.gp_in sel_in vdd vdd pfet L=0.35U W=8U
MXSP_X8_Xdi_Xn XSP.X8.gp_in sel_in vss vss nfet L=0.35U W=4U
MXSP_X8_Xdr_Xp XSP.X8.gp_rel rel_8_p vdd vdd pfet L=0.35U W=8U
MXSP_X8_Xdr_Xn XSP.X8.gp_rel rel_8_p vss vss nfet L=0.35U W=4U
MXSP_X8_Xdh_Xp XSP.X8.gp_hi hi_8_p vdd vdd pfet L=0.35U W=8U
MXSP_X8_Xdh_Xn XSP.X8.gp_hi hi_8_p vss vss nfet L=0.35U W=4U
MXSP_X8_Xdl_Xp XSP.X8.gp_lo lo_8_p vdd vdd pfet L=0.35U W=8U
MXSP_X8_Xdl_Xn XSP.X8.gp_lo lo_8_p vss vss nfet L=0.35U W=4U
MXSP_X8_Xsi_XN pinp sel_in XSP.X8.bp vss nfet L=0.28U W=10U
MXSP_X8_Xsi_XP1 pinp XSP.X8.gp_in XSP.X8.bp vdd pfet L=0.28U W=10U
MXSP_X8_Xsi_XP2 pinp XSP.X8.gp_in XSP.X8.bp vdd pfet L=0.28U W=10U
MXSP_X8_Xsr_XN vcm rel_8_p XSP.X8.bp vss nfet L=0.28U W=10U
MXSP_X8_Xsr_XP1 vcm XSP.X8.gp_rel XSP.X8.bp vdd pfet L=0.28U W=10U
MXSP_X8_Xsr_XP2 vcm XSP.X8.gp_rel XSP.X8.bp vdd pfet L=0.28U W=10U
MXSP_X8_Xsh_XN vref hi_8_p XSP.X8.bp vss nfet L=0.28U W=10U
MXSP_X8_Xsh_XP1 vref XSP.X8.gp_hi XSP.X8.bp vdd pfet L=0.28U W=10U
MXSP_X8_Xsh_XP2 vref XSP.X8.gp_hi XSP.X8.bp vdd pfet L=0.28U W=10U
MXSP_X8_Xsl_XN vss lo_8_p XSP.X8.bp vss nfet L=0.28U W=10U
MXSP_X8_Xsl_XP1 vss XSP.X8.gp_lo XSP.X8.bp vdd pfet L=0.28U W=10U
MXSP_X8_Xsl_XP2 vss XSP.X8.gp_lo XSP.X8.bp vdd pfet L=0.28U W=10U
MXSP_X4_Xdi_Xp XSP.X4.gp_in sel_in vdd vdd pfet L=0.35U W=8U
MXSP_X4_Xdi_Xn XSP.X4.gp_in sel_in vss vss nfet L=0.35U W=4U
MXSP_X4_Xdr_Xp XSP.X4.gp_rel rel_4_p vdd vdd pfet L=0.35U W=8U
MXSP_X4_Xdr_Xn XSP.X4.gp_rel rel_4_p vss vss nfet L=0.35U W=4U
MXSP_X4_Xdh_Xp XSP.X4.gp_hi hi_4_p vdd vdd pfet L=0.35U W=8U
MXSP_X4_Xdh_Xn XSP.X4.gp_hi hi_4_p vss vss nfet L=0.35U W=4U
MXSP_X4_Xdl_Xp XSP.X4.gp_lo lo_4_p vdd vdd pfet L=0.35U W=8U
MXSP_X4_Xdl_Xn XSP.X4.gp_lo lo_4_p vss vss nfet L=0.35U W=4U
MXSP_X4_Xsi_XN pinp sel_in XSP.X4.bp vss nfet L=0.28U W=10U
MXSP_X4_Xsi_XP1 pinp XSP.X4.gp_in XSP.X4.bp vdd pfet L=0.28U W=10U
MXSP_X4_Xsi_XP2 pinp XSP.X4.gp_in XSP.X4.bp vdd pfet L=0.28U W=10U
MXSP_X4_Xsr_XN vcm rel_4_p XSP.X4.bp vss nfet L=0.28U W=10U
MXSP_X4_Xsr_XP1 vcm XSP.X4.gp_rel XSP.X4.bp vdd pfet L=0.28U W=10U
MXSP_X4_Xsr_XP2 vcm XSP.X4.gp_rel XSP.X4.bp vdd pfet L=0.28U W=10U
MXSP_X4_Xsh_XN vref hi_4_p XSP.X4.bp vss nfet L=0.28U W=10U
MXSP_X4_Xsh_XP1 vref XSP.X4.gp_hi XSP.X4.bp vdd pfet L=0.28U W=10U
MXSP_X4_Xsh_XP2 vref XSP.X4.gp_hi XSP.X4.bp vdd pfet L=0.28U W=10U
MXSP_X4_Xsl_XN vss lo_4_p XSP.X4.bp vss nfet L=0.28U W=10U
MXSP_X4_Xsl_XP1 vss XSP.X4.gp_lo XSP.X4.bp vdd pfet L=0.28U W=10U
MXSP_X4_Xsl_XP2 vss XSP.X4.gp_lo XSP.X4.bp vdd pfet L=0.28U W=10U
MXSP_X2_Xdi_Xp XSP.X2.gp_in sel_in vdd vdd pfet L=0.35U W=8U
MXSP_X2_Xdi_Xn XSP.X2.gp_in sel_in vss vss nfet L=0.35U W=4U
MXSP_X2_Xdr_Xp XSP.X2.gp_rel rel_2_p vdd vdd pfet L=0.35U W=8U
MXSP_X2_Xdr_Xn XSP.X2.gp_rel rel_2_p vss vss nfet L=0.35U W=4U
MXSP_X2_Xdh_Xp XSP.X2.gp_hi hi_2_p vdd vdd pfet L=0.35U W=8U
MXSP_X2_Xdh_Xn XSP.X2.gp_hi hi_2_p vss vss nfet L=0.35U W=4U
MXSP_X2_Xdl_Xp XSP.X2.gp_lo lo_2_p vdd vdd pfet L=0.35U W=8U
MXSP_X2_Xdl_Xn XSP.X2.gp_lo lo_2_p vss vss nfet L=0.35U W=4U
MXSP_X2_Xsi_XN pinp sel_in XSP.X2.bp vss nfet L=0.28U W=10U
MXSP_X2_Xsi_XP1 pinp XSP.X2.gp_in XSP.X2.bp vdd pfet L=0.28U W=10U
MXSP_X2_Xsi_XP2 pinp XSP.X2.gp_in XSP.X2.bp vdd pfet L=0.28U W=10U
MXSP_X2_Xsr_XN vcm rel_2_p XSP.X2.bp vss nfet L=0.28U W=10U
MXSP_X2_Xsr_XP1 vcm XSP.X2.gp_rel XSP.X2.bp vdd pfet L=0.28U W=10U
MXSP_X2_Xsr_XP2 vcm XSP.X2.gp_rel XSP.X2.bp vdd pfet L=0.28U W=10U
MXSP_X2_Xsh_XN vref hi_2_p XSP.X2.bp vss nfet L=0.28U W=10U
MXSP_X2_Xsh_XP1 vref XSP.X2.gp_hi XSP.X2.bp vdd pfet L=0.28U W=10U
MXSP_X2_Xsh_XP2 vref XSP.X2.gp_hi XSP.X2.bp vdd pfet L=0.28U W=10U
MXSP_X2_Xsl_XN vss lo_2_p XSP.X2.bp vss nfet L=0.28U W=10U
MXSP_X2_Xsl_XP1 vss XSP.X2.gp_lo XSP.X2.bp vdd pfet L=0.28U W=10U
MXSP_X2_Xsl_XP2 vss XSP.X2.gp_lo XSP.X2.bp vdd pfet L=0.28U W=10U
MXSP_X1_Xdi_Xp XSP.X1.gp_in sel_in vdd vdd pfet L=0.35U W=8U
MXSP_X1_Xdi_Xn XSP.X1.gp_in sel_in vss vss nfet L=0.35U W=4U
MXSP_X1_Xdr_Xp XSP.X1.gp_rel rel_1_p vdd vdd pfet L=0.35U W=8U
MXSP_X1_Xdr_Xn XSP.X1.gp_rel rel_1_p vss vss nfet L=0.35U W=4U
MXSP_X1_Xdh_Xp XSP.X1.gp_hi hi_1_p vdd vdd pfet L=0.35U W=8U
MXSP_X1_Xdh_Xn XSP.X1.gp_hi hi_1_p vss vss nfet L=0.35U W=4U
MXSP_X1_Xdl_Xp XSP.X1.gp_lo lo_1_p vdd vdd pfet L=0.35U W=8U
MXSP_X1_Xdl_Xn XSP.X1.gp_lo lo_1_p vss vss nfet L=0.35U W=4U
MXSP_X1_Xsi_XN pinp sel_in XSP.X1.bp vss nfet L=0.28U W=10U
MXSP_X1_Xsi_XP1 pinp XSP.X1.gp_in XSP.X1.bp vdd pfet L=0.28U W=10U
MXSP_X1_Xsi_XP2 pinp XSP.X1.gp_in XSP.X1.bp vdd pfet L=0.28U W=10U
MXSP_X1_Xsr_XN vcm rel_1_p XSP.X1.bp vss nfet L=0.28U W=10U
MXSP_X1_Xsr_XP1 vcm XSP.X1.gp_rel XSP.X1.bp vdd pfet L=0.28U W=10U
MXSP_X1_Xsr_XP2 vcm XSP.X1.gp_rel XSP.X1.bp vdd pfet L=0.28U W=10U
MXSP_X1_Xsh_XN vref hi_1_p XSP.X1.bp vss nfet L=0.28U W=10U
MXSP_X1_Xsh_XP1 vref XSP.X1.gp_hi XSP.X1.bp vdd pfet L=0.28U W=10U
MXSP_X1_Xsh_XP2 vref XSP.X1.gp_hi XSP.X1.bp vdd pfet L=0.28U W=10U
MXSP_X1_Xsl_XN vss lo_1_p XSP.X1.bp vss nfet L=0.28U W=10U
MXSP_X1_Xsl_XP1 vss XSP.X1.gp_lo XSP.X1.bp vdd pfet L=0.28U W=10U
MXSP_X1_Xsl_XP2 vss XSP.X1.gp_lo XSP.X1.bp vdd pfet L=0.28U W=10U
MXSN_X256_Xdi_Xp XSN.X256.gp_in sel_in vdd vdd pfet L=0.35U W=8U
MXSN_X256_Xdi_Xn XSN.X256.gp_in sel_in vss vss nfet L=0.35U W=4U
MXSN_X256_Xdr_Xp XSN.X256.gp_rel rel_256_n vdd vdd pfet L=0.35U W=8U
MXSN_X256_Xdr_Xn XSN.X256.gp_rel rel_256_n vss vss nfet L=0.35U W=4U
MXSN_X256_Xdh_Xp XSN.X256.gp_hi hi_256_n vdd vdd pfet L=0.35U W=8U
MXSN_X256_Xdh_Xn XSN.X256.gp_hi hi_256_n vss vss nfet L=0.35U W=4U
MXSN_X256_Xdl_Xp XSN.X256.gp_lo lo_256_n vdd vdd pfet L=0.35U W=8U
MXSN_X256_Xdl_Xn XSN.X256.gp_lo lo_256_n vss vss nfet L=0.35U W=4U
MXSN_X256_Xsi_XN pinn sel_in XSN.X256.bp vss nfet L=0.28U W=10U
MXSN_X256_Xsi_XP1 pinn XSN.X256.gp_in XSN.X256.bp vdd pfet L=0.28U W=10U
MXSN_X256_Xsi_XP2 pinn XSN.X256.gp_in XSN.X256.bp vdd pfet L=0.28U W=10U
MXSN_X256_Xsr_XN vcm rel_256_n XSN.X256.bp vss nfet L=0.28U W=10U
MXSN_X256_Xsr_XP1 vcm XSN.X256.gp_rel XSN.X256.bp vdd pfet L=0.28U W=10U
MXSN_X256_Xsr_XP2 vcm XSN.X256.gp_rel XSN.X256.bp vdd pfet L=0.28U W=10U
MXSN_X256_Xsh_XN vref hi_256_n XSN.X256.bp vss nfet L=0.28U W=10U
MXSN_X256_Xsh_XP1 vref XSN.X256.gp_hi XSN.X256.bp vdd pfet L=0.28U W=10U
MXSN_X256_Xsh_XP2 vref XSN.X256.gp_hi XSN.X256.bp vdd pfet L=0.28U W=10U
MXSN_X256_Xsl_XN vss lo_256_n XSN.X256.bp vss nfet L=0.28U W=10U
MXSN_X256_Xsl_XP1 vss XSN.X256.gp_lo XSN.X256.bp vdd pfet L=0.28U W=10U
MXSN_X256_Xsl_XP2 vss XSN.X256.gp_lo XSN.X256.bp vdd pfet L=0.28U W=10U
MXSN_X128_Xdi_Xp XSN.X128.gp_in sel_in vdd vdd pfet L=0.35U W=8U
MXSN_X128_Xdi_Xn XSN.X128.gp_in sel_in vss vss nfet L=0.35U W=4U
MXSN_X128_Xdr_Xp XSN.X128.gp_rel rel_128_n vdd vdd pfet L=0.35U W=8U
MXSN_X128_Xdr_Xn XSN.X128.gp_rel rel_128_n vss vss nfet L=0.35U W=4U
MXSN_X128_Xdh_Xp XSN.X128.gp_hi hi_128_n vdd vdd pfet L=0.35U W=8U
MXSN_X128_Xdh_Xn XSN.X128.gp_hi hi_128_n vss vss nfet L=0.35U W=4U
MXSN_X128_Xdl_Xp XSN.X128.gp_lo lo_128_n vdd vdd pfet L=0.35U W=8U
MXSN_X128_Xdl_Xn XSN.X128.gp_lo lo_128_n vss vss nfet L=0.35U W=4U
MXSN_X128_Xsi_XN pinn sel_in XSN.X128.bp vss nfet L=0.28U W=10U
MXSN_X128_Xsi_XP1 pinn XSN.X128.gp_in XSN.X128.bp vdd pfet L=0.28U W=10U
MXSN_X128_Xsi_XP2 pinn XSN.X128.gp_in XSN.X128.bp vdd pfet L=0.28U W=10U
MXSN_X128_Xsr_XN vcm rel_128_n XSN.X128.bp vss nfet L=0.28U W=10U
MXSN_X128_Xsr_XP1 vcm XSN.X128.gp_rel XSN.X128.bp vdd pfet L=0.28U W=10U
MXSN_X128_Xsr_XP2 vcm XSN.X128.gp_rel XSN.X128.bp vdd pfet L=0.28U W=10U
MXSN_X128_Xsh_XN vref hi_128_n XSN.X128.bp vss nfet L=0.28U W=10U
MXSN_X128_Xsh_XP1 vref XSN.X128.gp_hi XSN.X128.bp vdd pfet L=0.28U W=10U
MXSN_X128_Xsh_XP2 vref XSN.X128.gp_hi XSN.X128.bp vdd pfet L=0.28U W=10U
MXSN_X128_Xsl_XN vss lo_128_n XSN.X128.bp vss nfet L=0.28U W=10U
MXSN_X128_Xsl_XP1 vss XSN.X128.gp_lo XSN.X128.bp vdd pfet L=0.28U W=10U
MXSN_X128_Xsl_XP2 vss XSN.X128.gp_lo XSN.X128.bp vdd pfet L=0.28U W=10U
MXSN_X64_Xdi_Xp XSN.X64.gp_in sel_in vdd vdd pfet L=0.35U W=8U
MXSN_X64_Xdi_Xn XSN.X64.gp_in sel_in vss vss nfet L=0.35U W=4U
MXSN_X64_Xdr_Xp XSN.X64.gp_rel rel_64_n vdd vdd pfet L=0.35U W=8U
MXSN_X64_Xdr_Xn XSN.X64.gp_rel rel_64_n vss vss nfet L=0.35U W=4U
MXSN_X64_Xdh_Xp XSN.X64.gp_hi hi_64_n vdd vdd pfet L=0.35U W=8U
MXSN_X64_Xdh_Xn XSN.X64.gp_hi hi_64_n vss vss nfet L=0.35U W=4U
MXSN_X64_Xdl_Xp XSN.X64.gp_lo lo_64_n vdd vdd pfet L=0.35U W=8U
MXSN_X64_Xdl_Xn XSN.X64.gp_lo lo_64_n vss vss nfet L=0.35U W=4U
MXSN_X64_Xsi_XN pinn sel_in XSN.X64.bp vss nfet L=0.28U W=10U
MXSN_X64_Xsi_XP1 pinn XSN.X64.gp_in XSN.X64.bp vdd pfet L=0.28U W=10U
MXSN_X64_Xsi_XP2 pinn XSN.X64.gp_in XSN.X64.bp vdd pfet L=0.28U W=10U
MXSN_X64_Xsr_XN vcm rel_64_n XSN.X64.bp vss nfet L=0.28U W=10U
MXSN_X64_Xsr_XP1 vcm XSN.X64.gp_rel XSN.X64.bp vdd pfet L=0.28U W=10U
MXSN_X64_Xsr_XP2 vcm XSN.X64.gp_rel XSN.X64.bp vdd pfet L=0.28U W=10U
MXSN_X64_Xsh_XN vref hi_64_n XSN.X64.bp vss nfet L=0.28U W=10U
MXSN_X64_Xsh_XP1 vref XSN.X64.gp_hi XSN.X64.bp vdd pfet L=0.28U W=10U
MXSN_X64_Xsh_XP2 vref XSN.X64.gp_hi XSN.X64.bp vdd pfet L=0.28U W=10U
MXSN_X64_Xsl_XN vss lo_64_n XSN.X64.bp vss nfet L=0.28U W=10U
MXSN_X64_Xsl_XP1 vss XSN.X64.gp_lo XSN.X64.bp vdd pfet L=0.28U W=10U
MXSN_X64_Xsl_XP2 vss XSN.X64.gp_lo XSN.X64.bp vdd pfet L=0.28U W=10U
MXSN_X32_Xdi_Xp XSN.X32.gp_in sel_in vdd vdd pfet L=0.35U W=8U
MXSN_X32_Xdi_Xn XSN.X32.gp_in sel_in vss vss nfet L=0.35U W=4U
MXSN_X32_Xdr_Xp XSN.X32.gp_rel rel_32_n vdd vdd pfet L=0.35U W=8U
MXSN_X32_Xdr_Xn XSN.X32.gp_rel rel_32_n vss vss nfet L=0.35U W=4U
MXSN_X32_Xdh_Xp XSN.X32.gp_hi hi_32_n vdd vdd pfet L=0.35U W=8U
MXSN_X32_Xdh_Xn XSN.X32.gp_hi hi_32_n vss vss nfet L=0.35U W=4U
MXSN_X32_Xdl_Xp XSN.X32.gp_lo lo_32_n vdd vdd pfet L=0.35U W=8U
MXSN_X32_Xdl_Xn XSN.X32.gp_lo lo_32_n vss vss nfet L=0.35U W=4U
MXSN_X32_Xsi_XN pinn sel_in XSN.X32.bp vss nfet L=0.28U W=10U
MXSN_X32_Xsi_XP1 pinn XSN.X32.gp_in XSN.X32.bp vdd pfet L=0.28U W=10U
MXSN_X32_Xsi_XP2 pinn XSN.X32.gp_in XSN.X32.bp vdd pfet L=0.28U W=10U
MXSN_X32_Xsr_XN vcm rel_32_n XSN.X32.bp vss nfet L=0.28U W=10U
MXSN_X32_Xsr_XP1 vcm XSN.X32.gp_rel XSN.X32.bp vdd pfet L=0.28U W=10U
MXSN_X32_Xsr_XP2 vcm XSN.X32.gp_rel XSN.X32.bp vdd pfet L=0.28U W=10U
MXSN_X32_Xsh_XN vref hi_32_n XSN.X32.bp vss nfet L=0.28U W=10U
MXSN_X32_Xsh_XP1 vref XSN.X32.gp_hi XSN.X32.bp vdd pfet L=0.28U W=10U
MXSN_X32_Xsh_XP2 vref XSN.X32.gp_hi XSN.X32.bp vdd pfet L=0.28U W=10U
MXSN_X32_Xsl_XN vss lo_32_n XSN.X32.bp vss nfet L=0.28U W=10U
MXSN_X32_Xsl_XP1 vss XSN.X32.gp_lo XSN.X32.bp vdd pfet L=0.28U W=10U
MXSN_X32_Xsl_XP2 vss XSN.X32.gp_lo XSN.X32.bp vdd pfet L=0.28U W=10U
MXSN_X16_Xdi_Xp XSN.X16.gp_in sel_in vdd vdd pfet L=0.35U W=8U
MXSN_X16_Xdi_Xn XSN.X16.gp_in sel_in vss vss nfet L=0.35U W=4U
MXSN_X16_Xdr_Xp XSN.X16.gp_rel rel_16_n vdd vdd pfet L=0.35U W=8U
MXSN_X16_Xdr_Xn XSN.X16.gp_rel rel_16_n vss vss nfet L=0.35U W=4U
MXSN_X16_Xdh_Xp XSN.X16.gp_hi hi_16_n vdd vdd pfet L=0.35U W=8U
MXSN_X16_Xdh_Xn XSN.X16.gp_hi hi_16_n vss vss nfet L=0.35U W=4U
MXSN_X16_Xdl_Xp XSN.X16.gp_lo lo_16_n vdd vdd pfet L=0.35U W=8U
MXSN_X16_Xdl_Xn XSN.X16.gp_lo lo_16_n vss vss nfet L=0.35U W=4U
MXSN_X16_Xsi_XN pinn sel_in XSN.X16.bp vss nfet L=0.28U W=10U
MXSN_X16_Xsi_XP1 pinn XSN.X16.gp_in XSN.X16.bp vdd pfet L=0.28U W=10U
MXSN_X16_Xsi_XP2 pinn XSN.X16.gp_in XSN.X16.bp vdd pfet L=0.28U W=10U
MXSN_X16_Xsr_XN vcm rel_16_n XSN.X16.bp vss nfet L=0.28U W=10U
MXSN_X16_Xsr_XP1 vcm XSN.X16.gp_rel XSN.X16.bp vdd pfet L=0.28U W=10U
MXSN_X16_Xsr_XP2 vcm XSN.X16.gp_rel XSN.X16.bp vdd pfet L=0.28U W=10U
MXSN_X16_Xsh_XN vref hi_16_n XSN.X16.bp vss nfet L=0.28U W=10U
MXSN_X16_Xsh_XP1 vref XSN.X16.gp_hi XSN.X16.bp vdd pfet L=0.28U W=10U
MXSN_X16_Xsh_XP2 vref XSN.X16.gp_hi XSN.X16.bp vdd pfet L=0.28U W=10U
MXSN_X16_Xsl_XN vss lo_16_n XSN.X16.bp vss nfet L=0.28U W=10U
MXSN_X16_Xsl_XP1 vss XSN.X16.gp_lo XSN.X16.bp vdd pfet L=0.28U W=10U
MXSN_X16_Xsl_XP2 vss XSN.X16.gp_lo XSN.X16.bp vdd pfet L=0.28U W=10U
MXSN_X8_Xdi_Xp XSN.X8.gp_in sel_in vdd vdd pfet L=0.35U W=8U
MXSN_X8_Xdi_Xn XSN.X8.gp_in sel_in vss vss nfet L=0.35U W=4U
MXSN_X8_Xdr_Xp XSN.X8.gp_rel rel_8_n vdd vdd pfet L=0.35U W=8U
MXSN_X8_Xdr_Xn XSN.X8.gp_rel rel_8_n vss vss nfet L=0.35U W=4U
MXSN_X8_Xdh_Xp XSN.X8.gp_hi hi_8_n vdd vdd pfet L=0.35U W=8U
MXSN_X8_Xdh_Xn XSN.X8.gp_hi hi_8_n vss vss nfet L=0.35U W=4U
MXSN_X8_Xdl_Xp XSN.X8.gp_lo lo_8_n vdd vdd pfet L=0.35U W=8U
MXSN_X8_Xdl_Xn XSN.X8.gp_lo lo_8_n vss vss nfet L=0.35U W=4U
MXSN_X8_Xsi_XN pinn sel_in XSN.X8.bp vss nfet L=0.28U W=10U
MXSN_X8_Xsi_XP1 pinn XSN.X8.gp_in XSN.X8.bp vdd pfet L=0.28U W=10U
MXSN_X8_Xsi_XP2 pinn XSN.X8.gp_in XSN.X8.bp vdd pfet L=0.28U W=10U
MXSN_X8_Xsr_XN vcm rel_8_n XSN.X8.bp vss nfet L=0.28U W=10U
MXSN_X8_Xsr_XP1 vcm XSN.X8.gp_rel XSN.X8.bp vdd pfet L=0.28U W=10U
MXSN_X8_Xsr_XP2 vcm XSN.X8.gp_rel XSN.X8.bp vdd pfet L=0.28U W=10U
MXSN_X8_Xsh_XN vref hi_8_n XSN.X8.bp vss nfet L=0.28U W=10U
MXSN_X8_Xsh_XP1 vref XSN.X8.gp_hi XSN.X8.bp vdd pfet L=0.28U W=10U
MXSN_X8_Xsh_XP2 vref XSN.X8.gp_hi XSN.X8.bp vdd pfet L=0.28U W=10U
MXSN_X8_Xsl_XN vss lo_8_n XSN.X8.bp vss nfet L=0.28U W=10U
MXSN_X8_Xsl_XP1 vss XSN.X8.gp_lo XSN.X8.bp vdd pfet L=0.28U W=10U
MXSN_X8_Xsl_XP2 vss XSN.X8.gp_lo XSN.X8.bp vdd pfet L=0.28U W=10U
MXSN_X4_Xdi_Xp XSN.X4.gp_in sel_in vdd vdd pfet L=0.35U W=8U
MXSN_X4_Xdi_Xn XSN.X4.gp_in sel_in vss vss nfet L=0.35U W=4U
MXSN_X4_Xdr_Xp XSN.X4.gp_rel rel_4_n vdd vdd pfet L=0.35U W=8U
MXSN_X4_Xdr_Xn XSN.X4.gp_rel rel_4_n vss vss nfet L=0.35U W=4U
MXSN_X4_Xdh_Xp XSN.X4.gp_hi hi_4_n vdd vdd pfet L=0.35U W=8U
MXSN_X4_Xdh_Xn XSN.X4.gp_hi hi_4_n vss vss nfet L=0.35U W=4U
MXSN_X4_Xdl_Xp XSN.X4.gp_lo lo_4_n vdd vdd pfet L=0.35U W=8U
MXSN_X4_Xdl_Xn XSN.X4.gp_lo lo_4_n vss vss nfet L=0.35U W=4U
MXSN_X4_Xsi_XN pinn sel_in XSN.X4.bp vss nfet L=0.28U W=10U
MXSN_X4_Xsi_XP1 pinn XSN.X4.gp_in XSN.X4.bp vdd pfet L=0.28U W=10U
MXSN_X4_Xsi_XP2 pinn XSN.X4.gp_in XSN.X4.bp vdd pfet L=0.28U W=10U
MXSN_X4_Xsr_XN vcm rel_4_n XSN.X4.bp vss nfet L=0.28U W=10U
MXSN_X4_Xsr_XP1 vcm XSN.X4.gp_rel XSN.X4.bp vdd pfet L=0.28U W=10U
MXSN_X4_Xsr_XP2 vcm XSN.X4.gp_rel XSN.X4.bp vdd pfet L=0.28U W=10U
MXSN_X4_Xsh_XN vref hi_4_n XSN.X4.bp vss nfet L=0.28U W=10U
MXSN_X4_Xsh_XP1 vref XSN.X4.gp_hi XSN.X4.bp vdd pfet L=0.28U W=10U
MXSN_X4_Xsh_XP2 vref XSN.X4.gp_hi XSN.X4.bp vdd pfet L=0.28U W=10U
MXSN_X4_Xsl_XN vss lo_4_n XSN.X4.bp vss nfet L=0.28U W=10U
MXSN_X4_Xsl_XP1 vss XSN.X4.gp_lo XSN.X4.bp vdd pfet L=0.28U W=10U
MXSN_X4_Xsl_XP2 vss XSN.X4.gp_lo XSN.X4.bp vdd pfet L=0.28U W=10U
MXSN_X2_Xdi_Xp XSN.X2.gp_in sel_in vdd vdd pfet L=0.35U W=8U
MXSN_X2_Xdi_Xn XSN.X2.gp_in sel_in vss vss nfet L=0.35U W=4U
MXSN_X2_Xdr_Xp XSN.X2.gp_rel rel_2_n vdd vdd pfet L=0.35U W=8U
MXSN_X2_Xdr_Xn XSN.X2.gp_rel rel_2_n vss vss nfet L=0.35U W=4U
MXSN_X2_Xdh_Xp XSN.X2.gp_hi hi_2_n vdd vdd pfet L=0.35U W=8U
MXSN_X2_Xdh_Xn XSN.X2.gp_hi hi_2_n vss vss nfet L=0.35U W=4U
MXSN_X2_Xdl_Xp XSN.X2.gp_lo lo_2_n vdd vdd pfet L=0.35U W=8U
MXSN_X2_Xdl_Xn XSN.X2.gp_lo lo_2_n vss vss nfet L=0.35U W=4U
MXSN_X2_Xsi_XN pinn sel_in XSN.X2.bp vss nfet L=0.28U W=10U
MXSN_X2_Xsi_XP1 pinn XSN.X2.gp_in XSN.X2.bp vdd pfet L=0.28U W=10U
MXSN_X2_Xsi_XP2 pinn XSN.X2.gp_in XSN.X2.bp vdd pfet L=0.28U W=10U
MXSN_X2_Xsr_XN vcm rel_2_n XSN.X2.bp vss nfet L=0.28U W=10U
MXSN_X2_Xsr_XP1 vcm XSN.X2.gp_rel XSN.X2.bp vdd pfet L=0.28U W=10U
MXSN_X2_Xsr_XP2 vcm XSN.X2.gp_rel XSN.X2.bp vdd pfet L=0.28U W=10U
MXSN_X2_Xsh_XN vref hi_2_n XSN.X2.bp vss nfet L=0.28U W=10U
MXSN_X2_Xsh_XP1 vref XSN.X2.gp_hi XSN.X2.bp vdd pfet L=0.28U W=10U
MXSN_X2_Xsh_XP2 vref XSN.X2.gp_hi XSN.X2.bp vdd pfet L=0.28U W=10U
MXSN_X2_Xsl_XN vss lo_2_n XSN.X2.bp vss nfet L=0.28U W=10U
MXSN_X2_Xsl_XP1 vss XSN.X2.gp_lo XSN.X2.bp vdd pfet L=0.28U W=10U
MXSN_X2_Xsl_XP2 vss XSN.X2.gp_lo XSN.X2.bp vdd pfet L=0.28U W=10U
MXSN_X1_Xdi_Xp XSN.X1.gp_in sel_in vdd vdd pfet L=0.35U W=8U
MXSN_X1_Xdi_Xn XSN.X1.gp_in sel_in vss vss nfet L=0.35U W=4U
MXSN_X1_Xdr_Xp XSN.X1.gp_rel rel_1_n vdd vdd pfet L=0.35U W=8U
MXSN_X1_Xdr_Xn XSN.X1.gp_rel rel_1_n vss vss nfet L=0.35U W=4U
MXSN_X1_Xdh_Xp XSN.X1.gp_hi hi_1_n vdd vdd pfet L=0.35U W=8U
MXSN_X1_Xdh_Xn XSN.X1.gp_hi hi_1_n vss vss nfet L=0.35U W=4U
MXSN_X1_Xdl_Xp XSN.X1.gp_lo lo_1_n vdd vdd pfet L=0.35U W=8U
MXSN_X1_Xdl_Xn XSN.X1.gp_lo lo_1_n vss vss nfet L=0.35U W=4U
MXSN_X1_Xsi_XN pinn sel_in XSN.X1.bp vss nfet L=0.28U W=10U
MXSN_X1_Xsi_XP1 pinn XSN.X1.gp_in XSN.X1.bp vdd pfet L=0.28U W=10U
MXSN_X1_Xsi_XP2 pinn XSN.X1.gp_in XSN.X1.bp vdd pfet L=0.28U W=10U
MXSN_X1_Xsr_XN vcm rel_1_n XSN.X1.bp vss nfet L=0.28U W=10U
MXSN_X1_Xsr_XP1 vcm XSN.X1.gp_rel XSN.X1.bp vdd pfet L=0.28U W=10U
MXSN_X1_Xsr_XP2 vcm XSN.X1.gp_rel XSN.X1.bp vdd pfet L=0.28U W=10U
MXSN_X1_Xsh_XN vref hi_1_n XSN.X1.bp vss nfet L=0.28U W=10U
MXSN_X1_Xsh_XP1 vref XSN.X1.gp_hi XSN.X1.bp vdd pfet L=0.28U W=10U
MXSN_X1_Xsh_XP2 vref XSN.X1.gp_hi XSN.X1.bp vdd pfet L=0.28U W=10U
MXSN_X1_Xsl_XN vss lo_1_n XSN.X1.bp vss nfet L=0.28U W=10U
MXSN_X1_Xsl_XP1 vss XSN.X1.gp_lo XSN.X1.bp vdd pfet L=0.28U W=10U
MXSN_X1_Xsl_XP2 vss XSN.X1.gp_lo XSN.X1.bp vdd pfet L=0.28U W=10U
MXSWP_Xd_Xp XSWP.gp tp_gn vdd vdd pfet L=0.35U W=8U
MXSWP_Xd_Xn XSWP.gp tp_gn vss vss nfet L=0.35U W=4U
MXSWP_Xs_XN vcm tp_gn topp vss nfet L=0.28U W=10U
MXSWP_Xs_XP vcm XSWP.gp topp vdd pfet L=0.28U W=20U
MXSWN_Xd_Xp XSWN.gp tp_gn vdd vdd pfet L=0.35U W=8U
MXSWN_Xd_Xn XSWN.gp tp_gn vss vss nfet L=0.35U W=4U
MXSWN_Xs_XN vcm tp_gn topn vss nfet L=0.28U W=10U
MXSWN_Xs_XP vcm XSWN.gp topn vdd pfet L=0.28U W=20U
MXCMP_Xpre_Xmb ibias ibias vss vss nfet L=2U W=20U
MXCMP_Xpre_Xmt XCMP.Xpre.ptail ibias vss vss nfet L=2U W=20U
MXCMP_Xpre_Xmip XCMP.pon topp XCMP.Xpre.ptail vss nfet L=1U W=40U
MXCMP_Xpre_Xmin XCMP.pop topn XCMP.Xpre.ptail vss nfet L=1U W=40U
MXCMP_Xlat_Xmlt XCMP.Xlat.ltail cmpclk vss vss nfet L=0.35U W=16U
MXCMP_Xlat_Xmlp XCMP.Xlat.dip XCMP.pop XCMP.Xlat.ltail vss nfet L=0.5U W=8U
MXCMP_Xlat_Xmln XCMP.Xlat.din XCMP.pon XCMP.Xlat.ltail vss nfet L=0.5U W=8U
MXCMP_Xlat_Xmnp XCMP.outn XCMP.outp XCMP.Xlat.dip vss nfet L=0.35U W=6U
MXCMP_Xlat_Xmnn XCMP.outp XCMP.outn XCMP.Xlat.din vss nfet L=0.35U W=6U
MXCMP_Xlat_Xmpp XCMP.outn XCMP.outp vdd vdd pfet L=0.35U W=8U
MXCMP_Xlat_Xmpn XCMP.outp XCMP.outn vdd vdd pfet L=0.35U W=8U
MXCMP_Xlat_Xmrp XCMP.outn cmpclk vdd vdd pfet L=0.35U W=4U
MXCMP_Xlat_Xmrn XCMP.outp cmpclk vdd vdd pfet L=0.35U W=4U
MXCMP_Xlat_Xmrd XCMP.Xlat.dip cmpclk vdd vdd pfet L=0.35U W=2U
MXCMP_Xlat_Xmre XCMP.Xlat.din cmpclk vdd vdd pfet L=0.35U W=2U
MXCMP_Xis_Xp XCMP.sset XCMP.outn vdd vdd pfet L=0.35U W=2U
MXCMP_Xis_Xn XCMP.sset XCMP.outn vss vss nfet L=0.35U W=1U
MXCMP_Xir_Xp XCMP.srst XCMP.outp vdd vdd pfet L=0.35U W=2U
MXCMP_Xir_Xn XCMP.srst XCMP.outp vss vss nfet L=0.35U W=1U
MXCMP_Xno1_Xp1 XCMP.Xno1.ps XCMP.srst vdd vdd pfet L=0.35U W=8U
MXCMP_Xno1_Xp2 dout doutb XCMP.Xno1.ps vdd pfet L=0.35U W=8U
MXCMP_Xno1_Xn1 dout XCMP.srst vss vss nfet L=0.35U W=4U
MXCMP_Xno1_Xn2 dout doutb vss vss nfet L=0.35U W=4U
MXCMP_Xno2_Xp1 XCMP.Xno2.ps XCMP.sset vdd vdd pfet L=0.35U W=8U
MXCMP_Xno2_Xp2 doutb dout XCMP.Xno2.ps vdd pfet L=0.35U W=8U
MXCMP_Xno2_Xn1 doutb XCMP.sset vss vss nfet L=0.35U W=4U
MXCMP_Xno2_Xn2 doutb dout vss vss nfet L=0.35U W=4U
RXCMP_Xpre_Xrlp vdd XCMP.pop vss 150000 ppolyf_u_1k
RXCMP_Xpre_Xrln vdd XCMP.pon vss 150000 ppolyf_u_1k
CXSP_CU0_0 XSP.X256.bp topp 3.56528e-14 cap_mim_2f0_m4m5_noshield
CXSP_CU0_1 XSP.X256.bp topp 3.56528e-14 cap_mim_2f0_m4m5_noshield
CXSP_CU0_2 XSP.X256.bp topp 3.56528e-14 cap_mim_2f0_m4m5_noshield
CXSP_CU0_3 XSP.X256.bp topp 3.56528e-14 cap_mim_2f0_m4m5_noshield
CXSP_CU0_4 XSP.X128.bp topp 3.56528e-14 cap_mim_2f0_m4m5_noshield
CXSP_CU0_5 XSP.X128.bp topp 3.56528e-14 cap_mim_2f0_m4m5_noshield
CXSP_CU0_6 XSP.X64.bp topp 3.56528e-14 cap_mim_2f0_m4m5_noshield
CXSP_CU0_7 XSP.X32.bp topp 3.56528e-14 cap_mim_2f0_m4m5_noshield
CXSP_CU0_8 XSP.X256.bp topp 3.56528e-14 cap_mim_2f0_m4m5_noshield
CXSP_CU0_9 XSP.X256.bp topp 3.56528e-14 cap_mim_2f0_m4m5_noshield
CXSP_CU0_10 XSP.X256.bp topp 3.56528e-14 cap_mim_2f0_m4m5_noshield
CXSP_CU0_11 XSP.X256.bp topp 3.56528e-14 cap_mim_2f0_m4m5_noshield
CXSP_CU0_12 XSP.X128.bp topp 3.56528e-14 cap_mim_2f0_m4m5_noshield
CXSP_CU0_13 XSP.X128.bp topp 3.56528e-14 cap_mim_2f0_m4m5_noshield
CXSP_CU0_14 XSP.X64.bp topp 3.56528e-14 cap_mim_2f0_m4m5_noshield
CXSP_CU0_15 XSP.X32.bp topp 3.56528e-14 cap_mim_2f0_m4m5_noshield
CXSP_CU1_0 XSP.X2.bp topp 3.56528e-14 cap_mim_2f0_m4m5_noshield
CXSP_CU1_1 XSP.X64.bp topp 3.56528e-14 cap_mim_2f0_m4m5_noshield
CXSP_CU1_2 XSP.X128.bp topp 3.56528e-14 cap_mim_2f0_m4m5_noshield
CXSP_CU1_3 XSP.X128.bp topp 3.56528e-14 cap_mim_2f0_m4m5_noshield
CXSP_CU1_4 XSP.X256.bp topp 3.56528e-14 cap_mim_2f0_m4m5_noshield
CXSP_CU1_5 XSP.X256.bp topp 3.56528e-14 cap_mim_2f0_m4m5_noshield
CXSP_CU1_6 XSP.X256.bp topp 3.56528e-14 cap_mim_2f0_m4m5_noshield
CXSP_CU1_7 XSP.X256.bp topp 3.56528e-14 cap_mim_2f0_m4m5_noshield
CXSP_CU1_8 vcm topp 3.56528e-14 cap_mim_2f0_m4m5_noshield
CXSP_CU1_9 XSP.X64.bp topp 3.56528e-14 cap_mim_2f0_m4m5_noshield
CXSP_CU1_10 XSP.X128.bp topp 3.56528e-14 cap_mim_2f0_m4m5_noshield
CXSP_CU1_11 XSP.X128.bp topp 3.56528e-14 cap_mim_2f0_m4m5_noshield
CXSP_CU1_12 XSP.X256.bp topp 3.56528e-14 cap_mim_2f0_m4m5_noshield
CXSP_CU1_13 XSP.X256.bp topp 3.56528e-14 cap_mim_2f0_m4m5_noshield
CXSP_CU1_14 XSP.X256.bp topp 3.56528e-14 cap_mim_2f0_m4m5_noshield
CXSP_CU1_15 XSP.X256.bp topp 3.56528e-14 cap_mim_2f0_m4m5_noshield
CXSP_CU2_0 XSP.X256.bp topp 3.56528e-14 cap_mim_2f0_m4m5_noshield
CXSP_CU2_1 XSP.X256.bp topp 3.56528e-14 cap_mim_2f0_m4m5_noshield
CXSP_CU2_2 XSP.X256.bp topp 3.56528e-14 cap_mim_2f0_m4m5_noshield
CXSP_CU2_3 XSP.X256.bp topp 3.56528e-14 cap_mim_2f0_m4m5_noshield
CXSP_CU2_4 XSP.X128.bp topp 3.56528e-14 cap_mim_2f0_m4m5_noshield
CXSP_CU2_5 XSP.X128.bp topp 3.56528e-14 cap_mim_2f0_m4m5_noshield
CXSP_CU2_6 XSP.X64.bp topp 3.56528e-14 cap_mim_2f0_m4m5_noshield
CXSP_CU2_7 XSP.X32.bp topp 3.56528e-14 cap_mim_2f0_m4m5_noshield
CXSP_CU2_8 XSP.X256.bp topp 3.56528e-14 cap_mim_2f0_m4m5_noshield
CXSP_CU2_9 XSP.X256.bp topp 3.56528e-14 cap_mim_2f0_m4m5_noshield
CXSP_CU2_10 XSP.X256.bp topp 3.56528e-14 cap_mim_2f0_m4m5_noshield
CXSP_CU2_11 XSP.X256.bp topp 3.56528e-14 cap_mim_2f0_m4m5_noshield
CXSP_CU2_12 XSP.X128.bp topp 3.56528e-14 cap_mim_2f0_m4m5_noshield
CXSP_CU2_13 XSP.X128.bp topp 3.56528e-14 cap_mim_2f0_m4m5_noshield
CXSP_CU2_14 XSP.X64.bp topp 3.56528e-14 cap_mim_2f0_m4m5_noshield
CXSP_CU2_15 XSP.X32.bp topp 3.56528e-14 cap_mim_2f0_m4m5_noshield
CXSP_CU3_0 XSP.X4.bp topp 3.56528e-14 cap_mim_2f0_m4m5_noshield
CXSP_CU3_1 XSP.X64.bp topp 3.56528e-14 cap_mim_2f0_m4m5_noshield
CXSP_CU3_2 XSP.X128.bp topp 3.56528e-14 cap_mim_2f0_m4m5_noshield
CXSP_CU3_3 XSP.X128.bp topp 3.56528e-14 cap_mim_2f0_m4m5_noshield
CXSP_CU3_4 XSP.X256.bp topp 3.56528e-14 cap_mim_2f0_m4m5_noshield
CXSP_CU3_5 XSP.X256.bp topp 3.56528e-14 cap_mim_2f0_m4m5_noshield
CXSP_CU3_6 XSP.X256.bp topp 3.56528e-14 cap_mim_2f0_m4m5_noshield
CXSP_CU3_7 XSP.X256.bp topp 3.56528e-14 cap_mim_2f0_m4m5_noshield
CXSP_CU3_8 XSP.X4.bp topp 3.56528e-14 cap_mim_2f0_m4m5_noshield
CXSP_CU3_9 XSP.X64.bp topp 3.56528e-14 cap_mim_2f0_m4m5_noshield
CXSP_CU3_10 XSP.X128.bp topp 3.56528e-14 cap_mim_2f0_m4m5_noshield
CXSP_CU3_11 XSP.X128.bp topp 3.56528e-14 cap_mim_2f0_m4m5_noshield
CXSP_CU3_12 XSP.X256.bp topp 3.56528e-14 cap_mim_2f0_m4m5_noshield
CXSP_CU3_13 XSP.X256.bp topp 3.56528e-14 cap_mim_2f0_m4m5_noshield
CXSP_CU3_14 XSP.X256.bp topp 3.56528e-14 cap_mim_2f0_m4m5_noshield
CXSP_CU3_15 XSP.X256.bp topp 3.56528e-14 cap_mim_2f0_m4m5_noshield
CXSP_CU4_0 XSP.X256.bp topp 3.56528e-14 cap_mim_2f0_m4m5_noshield
CXSP_CU4_1 XSP.X256.bp topp 3.56528e-14 cap_mim_2f0_m4m5_noshield
CXSP_CU4_2 XSP.X256.bp topp 3.56528e-14 cap_mim_2f0_m4m5_noshield
CXSP_CU4_3 XSP.X256.bp topp 3.56528e-14 cap_mim_2f0_m4m5_noshield
CXSP_CU4_4 XSP.X128.bp topp 3.56528e-14 cap_mim_2f0_m4m5_noshield
CXSP_CU4_5 XSP.X128.bp topp 3.56528e-14 cap_mim_2f0_m4m5_noshield
CXSP_CU4_6 XSP.X64.bp topp 3.56528e-14 cap_mim_2f0_m4m5_noshield
CXSP_CU4_7 XSP.X32.bp topp 3.56528e-14 cap_mim_2f0_m4m5_noshield
CXSP_CU4_8 XSP.X256.bp topp 3.56528e-14 cap_mim_2f0_m4m5_noshield
CXSP_CU4_9 XSP.X256.bp topp 3.56528e-14 cap_mim_2f0_m4m5_noshield
CXSP_CU4_10 XSP.X256.bp topp 3.56528e-14 cap_mim_2f0_m4m5_noshield
CXSP_CU4_11 XSP.X256.bp topp 3.56528e-14 cap_mim_2f0_m4m5_noshield
CXSP_CU4_12 XSP.X128.bp topp 3.56528e-14 cap_mim_2f0_m4m5_noshield
CXSP_CU4_13 XSP.X128.bp topp 3.56528e-14 cap_mim_2f0_m4m5_noshield
CXSP_CU4_14 XSP.X64.bp topp 3.56528e-14 cap_mim_2f0_m4m5_noshield
CXSP_CU4_15 XSP.X32.bp topp 3.56528e-14 cap_mim_2f0_m4m5_noshield
CXSP_CU5_0 XSP.X8.bp topp 3.56528e-14 cap_mim_2f0_m4m5_noshield
CXSP_CU5_1 XSP.X64.bp topp 3.56528e-14 cap_mim_2f0_m4m5_noshield
CXSP_CU5_2 XSP.X128.bp topp 3.56528e-14 cap_mim_2f0_m4m5_noshield
CXSP_CU5_3 XSP.X128.bp topp 3.56528e-14 cap_mim_2f0_m4m5_noshield
CXSP_CU5_4 XSP.X256.bp topp 3.56528e-14 cap_mim_2f0_m4m5_noshield
CXSP_CU5_5 XSP.X256.bp topp 3.56528e-14 cap_mim_2f0_m4m5_noshield
CXSP_CU5_6 XSP.X256.bp topp 3.56528e-14 cap_mim_2f0_m4m5_noshield
CXSP_CU5_7 XSP.X256.bp topp 3.56528e-14 cap_mim_2f0_m4m5_noshield
CXSP_CU5_8 XSP.X8.bp topp 3.56528e-14 cap_mim_2f0_m4m5_noshield
CXSP_CU5_9 XSP.X64.bp topp 3.56528e-14 cap_mim_2f0_m4m5_noshield
CXSP_CU5_10 XSP.X128.bp topp 3.56528e-14 cap_mim_2f0_m4m5_noshield
CXSP_CU5_11 XSP.X128.bp topp 3.56528e-14 cap_mim_2f0_m4m5_noshield
CXSP_CU5_12 XSP.X256.bp topp 3.56528e-14 cap_mim_2f0_m4m5_noshield
CXSP_CU5_13 XSP.X256.bp topp 3.56528e-14 cap_mim_2f0_m4m5_noshield
CXSP_CU5_14 XSP.X256.bp topp 3.56528e-14 cap_mim_2f0_m4m5_noshield
CXSP_CU5_15 XSP.X256.bp topp 3.56528e-14 cap_mim_2f0_m4m5_noshield
CXSP_CU6_0 XSP.X256.bp topp 3.56528e-14 cap_mim_2f0_m4m5_noshield
CXSP_CU6_1 XSP.X256.bp topp 3.56528e-14 cap_mim_2f0_m4m5_noshield
CXSP_CU6_2 XSP.X256.bp topp 3.56528e-14 cap_mim_2f0_m4m5_noshield
CXSP_CU6_3 XSP.X256.bp topp 3.56528e-14 cap_mim_2f0_m4m5_noshield
CXSP_CU6_4 XSP.X128.bp topp 3.56528e-14 cap_mim_2f0_m4m5_noshield
CXSP_CU6_5 XSP.X128.bp topp 3.56528e-14 cap_mim_2f0_m4m5_noshield
CXSP_CU6_6 XSP.X64.bp topp 3.56528e-14 cap_mim_2f0_m4m5_noshield
CXSP_CU6_7 XSP.X32.bp topp 3.56528e-14 cap_mim_2f0_m4m5_noshield
CXSP_CU6_8 XSP.X256.bp topp 3.56528e-14 cap_mim_2f0_m4m5_noshield
CXSP_CU6_9 XSP.X256.bp topp 3.56528e-14 cap_mim_2f0_m4m5_noshield
CXSP_CU6_10 XSP.X256.bp topp 3.56528e-14 cap_mim_2f0_m4m5_noshield
CXSP_CU6_11 XSP.X256.bp topp 3.56528e-14 cap_mim_2f0_m4m5_noshield
CXSP_CU6_12 XSP.X128.bp topp 3.56528e-14 cap_mim_2f0_m4m5_noshield
CXSP_CU6_13 XSP.X128.bp topp 3.56528e-14 cap_mim_2f0_m4m5_noshield
CXSP_CU6_14 XSP.X64.bp topp 3.56528e-14 cap_mim_2f0_m4m5_noshield
CXSP_CU6_15 XSP.X32.bp topp 3.56528e-14 cap_mim_2f0_m4m5_noshield
CXSP_CU7_0 XSP.X8.bp topp 3.56528e-14 cap_mim_2f0_m4m5_noshield
CXSP_CU7_1 XSP.X64.bp topp 3.56528e-14 cap_mim_2f0_m4m5_noshield
CXSP_CU7_2 XSP.X128.bp topp 3.56528e-14 cap_mim_2f0_m4m5_noshield
CXSP_CU7_3 XSP.X128.bp topp 3.56528e-14 cap_mim_2f0_m4m5_noshield
CXSP_CU7_4 XSP.X256.bp topp 3.56528e-14 cap_mim_2f0_m4m5_noshield
CXSP_CU7_5 XSP.X256.bp topp 3.56528e-14 cap_mim_2f0_m4m5_noshield
CXSP_CU7_6 XSP.X256.bp topp 3.56528e-14 cap_mim_2f0_m4m5_noshield
CXSP_CU7_7 XSP.X256.bp topp 3.56528e-14 cap_mim_2f0_m4m5_noshield
CXSP_CU7_8 XSP.X8.bp topp 3.56528e-14 cap_mim_2f0_m4m5_noshield
CXSP_CU7_9 XSP.X64.bp topp 3.56528e-14 cap_mim_2f0_m4m5_noshield
CXSP_CU7_10 XSP.X128.bp topp 3.56528e-14 cap_mim_2f0_m4m5_noshield
CXSP_CU7_11 XSP.X128.bp topp 3.56528e-14 cap_mim_2f0_m4m5_noshield
CXSP_CU7_12 XSP.X256.bp topp 3.56528e-14 cap_mim_2f0_m4m5_noshield
CXSP_CU7_13 XSP.X256.bp topp 3.56528e-14 cap_mim_2f0_m4m5_noshield
CXSP_CU7_14 XSP.X256.bp topp 3.56528e-14 cap_mim_2f0_m4m5_noshield
CXSP_CU7_15 XSP.X256.bp topp 3.56528e-14 cap_mim_2f0_m4m5_noshield
CXSP_CU8_0 XSP.X256.bp topp 3.56528e-14 cap_mim_2f0_m4m5_noshield
CXSP_CU8_1 XSP.X256.bp topp 3.56528e-14 cap_mim_2f0_m4m5_noshield
CXSP_CU8_2 XSP.X256.bp topp 3.56528e-14 cap_mim_2f0_m4m5_noshield
CXSP_CU8_3 XSP.X256.bp topp 3.56528e-14 cap_mim_2f0_m4m5_noshield
CXSP_CU8_4 XSP.X128.bp topp 3.56528e-14 cap_mim_2f0_m4m5_noshield
CXSP_CU8_5 XSP.X128.bp topp 3.56528e-14 cap_mim_2f0_m4m5_noshield
CXSP_CU8_6 XSP.X64.bp topp 3.56528e-14 cap_mim_2f0_m4m5_noshield
CXSP_CU8_7 XSP.X32.bp topp 3.56528e-14 cap_mim_2f0_m4m5_noshield
CXSP_CU8_8 XSP.X256.bp topp 3.56528e-14 cap_mim_2f0_m4m5_noshield
CXSP_CU8_9 XSP.X256.bp topp 3.56528e-14 cap_mim_2f0_m4m5_noshield
CXSP_CU8_10 XSP.X256.bp topp 3.56528e-14 cap_mim_2f0_m4m5_noshield
CXSP_CU8_11 XSP.X256.bp topp 3.56528e-14 cap_mim_2f0_m4m5_noshield
CXSP_CU8_12 XSP.X128.bp topp 3.56528e-14 cap_mim_2f0_m4m5_noshield
CXSP_CU8_13 XSP.X128.bp topp 3.56528e-14 cap_mim_2f0_m4m5_noshield
CXSP_CU8_14 XSP.X64.bp topp 3.56528e-14 cap_mim_2f0_m4m5_noshield
CXSP_CU8_15 XSP.X32.bp topp 3.56528e-14 cap_mim_2f0_m4m5_noshield
CXSP_CU9_0 XSP.X16.bp topp 3.56528e-14 cap_mim_2f0_m4m5_noshield
CXSP_CU9_1 XSP.X64.bp topp 3.56528e-14 cap_mim_2f0_m4m5_noshield
CXSP_CU9_2 XSP.X128.bp topp 3.56528e-14 cap_mim_2f0_m4m5_noshield
CXSP_CU9_3 XSP.X128.bp topp 3.56528e-14 cap_mim_2f0_m4m5_noshield
CXSP_CU9_4 XSP.X256.bp topp 3.56528e-14 cap_mim_2f0_m4m5_noshield
CXSP_CU9_5 XSP.X256.bp topp 3.56528e-14 cap_mim_2f0_m4m5_noshield
CXSP_CU9_6 XSP.X256.bp topp 3.56528e-14 cap_mim_2f0_m4m5_noshield
CXSP_CU9_7 XSP.X256.bp topp 3.56528e-14 cap_mim_2f0_m4m5_noshield
CXSP_CU9_8 XSP.X16.bp topp 3.56528e-14 cap_mim_2f0_m4m5_noshield
CXSP_CU9_9 XSP.X64.bp topp 3.56528e-14 cap_mim_2f0_m4m5_noshield
CXSP_CU9_10 XSP.X128.bp topp 3.56528e-14 cap_mim_2f0_m4m5_noshield
CXSP_CU9_11 XSP.X128.bp topp 3.56528e-14 cap_mim_2f0_m4m5_noshield
CXSP_CU9_12 XSP.X256.bp topp 3.56528e-14 cap_mim_2f0_m4m5_noshield
CXSP_CU9_13 XSP.X256.bp topp 3.56528e-14 cap_mim_2f0_m4m5_noshield
CXSP_CU9_14 XSP.X256.bp topp 3.56528e-14 cap_mim_2f0_m4m5_noshield
CXSP_CU9_15 XSP.X256.bp topp 3.56528e-14 cap_mim_2f0_m4m5_noshield
CXSP_CU10_0 XSP.X256.bp topp 3.56528e-14 cap_mim_2f0_m4m5_noshield
CXSP_CU10_1 XSP.X256.bp topp 3.56528e-14 cap_mim_2f0_m4m5_noshield
CXSP_CU10_2 XSP.X256.bp topp 3.56528e-14 cap_mim_2f0_m4m5_noshield
CXSP_CU10_3 XSP.X256.bp topp 3.56528e-14 cap_mim_2f0_m4m5_noshield
CXSP_CU10_4 XSP.X128.bp topp 3.56528e-14 cap_mim_2f0_m4m5_noshield
CXSP_CU10_5 XSP.X128.bp topp 3.56528e-14 cap_mim_2f0_m4m5_noshield
CXSP_CU10_6 XSP.X64.bp topp 3.56528e-14 cap_mim_2f0_m4m5_noshield
CXSP_CU10_7 XSP.X32.bp topp 3.56528e-14 cap_mim_2f0_m4m5_noshield
CXSP_CU10_8 XSP.X256.bp topp 3.56528e-14 cap_mim_2f0_m4m5_noshield
CXSP_CU10_9 XSP.X256.bp topp 3.56528e-14 cap_mim_2f0_m4m5_noshield
CXSP_CU10_10 XSP.X256.bp topp 3.56528e-14 cap_mim_2f0_m4m5_noshield
CXSP_CU10_11 XSP.X256.bp topp 3.56528e-14 cap_mim_2f0_m4m5_noshield
CXSP_CU10_12 XSP.X128.bp topp 3.56528e-14 cap_mim_2f0_m4m5_noshield
CXSP_CU10_13 XSP.X128.bp topp 3.56528e-14 cap_mim_2f0_m4m5_noshield
CXSP_CU10_14 XSP.X64.bp topp 3.56528e-14 cap_mim_2f0_m4m5_noshield
CXSP_CU10_15 XSP.X32.bp topp 3.56528e-14 cap_mim_2f0_m4m5_noshield
CXSP_CU11_0 XSP.X16.bp topp 3.56528e-14 cap_mim_2f0_m4m5_noshield
CXSP_CU11_1 XSP.X64.bp topp 3.56528e-14 cap_mim_2f0_m4m5_noshield
CXSP_CU11_2 XSP.X128.bp topp 3.56528e-14 cap_mim_2f0_m4m5_noshield
CXSP_CU11_3 XSP.X128.bp topp 3.56528e-14 cap_mim_2f0_m4m5_noshield
CXSP_CU11_4 XSP.X256.bp topp 3.56528e-14 cap_mim_2f0_m4m5_noshield
CXSP_CU11_5 XSP.X256.bp topp 3.56528e-14 cap_mim_2f0_m4m5_noshield
CXSP_CU11_6 XSP.X256.bp topp 3.56528e-14 cap_mim_2f0_m4m5_noshield
CXSP_CU11_7 XSP.X256.bp topp 3.56528e-14 cap_mim_2f0_m4m5_noshield
CXSP_CU11_8 XSP.X16.bp topp 3.56528e-14 cap_mim_2f0_m4m5_noshield
CXSP_CU11_9 XSP.X64.bp topp 3.56528e-14 cap_mim_2f0_m4m5_noshield
CXSP_CU11_10 XSP.X128.bp topp 3.56528e-14 cap_mim_2f0_m4m5_noshield
CXSP_CU11_11 XSP.X128.bp topp 3.56528e-14 cap_mim_2f0_m4m5_noshield
CXSP_CU11_12 XSP.X256.bp topp 3.56528e-14 cap_mim_2f0_m4m5_noshield
CXSP_CU11_13 XSP.X256.bp topp 3.56528e-14 cap_mim_2f0_m4m5_noshield
CXSP_CU11_14 XSP.X256.bp topp 3.56528e-14 cap_mim_2f0_m4m5_noshield
CXSP_CU11_15 XSP.X256.bp topp 3.56528e-14 cap_mim_2f0_m4m5_noshield
CXSP_CU12_0 XSP.X256.bp topp 3.56528e-14 cap_mim_2f0_m4m5_noshield
CXSP_CU12_1 XSP.X256.bp topp 3.56528e-14 cap_mim_2f0_m4m5_noshield
CXSP_CU12_2 XSP.X256.bp topp 3.56528e-14 cap_mim_2f0_m4m5_noshield
CXSP_CU12_3 XSP.X256.bp topp 3.56528e-14 cap_mim_2f0_m4m5_noshield
CXSP_CU12_4 XSP.X128.bp topp 3.56528e-14 cap_mim_2f0_m4m5_noshield
CXSP_CU12_5 XSP.X128.bp topp 3.56528e-14 cap_mim_2f0_m4m5_noshield
CXSP_CU12_6 XSP.X64.bp topp 3.56528e-14 cap_mim_2f0_m4m5_noshield
CXSP_CU12_7 XSP.X32.bp topp 3.56528e-14 cap_mim_2f0_m4m5_noshield
CXSP_CU12_8 XSP.X256.bp topp 3.56528e-14 cap_mim_2f0_m4m5_noshield
CXSP_CU12_9 XSP.X256.bp topp 3.56528e-14 cap_mim_2f0_m4m5_noshield
CXSP_CU12_10 XSP.X256.bp topp 3.56528e-14 cap_mim_2f0_m4m5_noshield
CXSP_CU12_11 XSP.X256.bp topp 3.56528e-14 cap_mim_2f0_m4m5_noshield
CXSP_CU12_12 XSP.X128.bp topp 3.56528e-14 cap_mim_2f0_m4m5_noshield
CXSP_CU12_13 XSP.X128.bp topp 3.56528e-14 cap_mim_2f0_m4m5_noshield
CXSP_CU12_14 XSP.X64.bp topp 3.56528e-14 cap_mim_2f0_m4m5_noshield
CXSP_CU12_15 XSP.X32.bp topp 3.56528e-14 cap_mim_2f0_m4m5_noshield
CXSP_CU13_0 XSP.X16.bp topp 3.56528e-14 cap_mim_2f0_m4m5_noshield
CXSP_CU13_1 XSP.X64.bp topp 3.56528e-14 cap_mim_2f0_m4m5_noshield
CXSP_CU13_2 XSP.X128.bp topp 3.56528e-14 cap_mim_2f0_m4m5_noshield
CXSP_CU13_3 XSP.X128.bp topp 3.56528e-14 cap_mim_2f0_m4m5_noshield
CXSP_CU13_4 XSP.X256.bp topp 3.56528e-14 cap_mim_2f0_m4m5_noshield
CXSP_CU13_5 XSP.X256.bp topp 3.56528e-14 cap_mim_2f0_m4m5_noshield
CXSP_CU13_6 XSP.X256.bp topp 3.56528e-14 cap_mim_2f0_m4m5_noshield
CXSP_CU13_7 XSP.X256.bp topp 3.56528e-14 cap_mim_2f0_m4m5_noshield
CXSP_CU13_8 XSP.X16.bp topp 3.56528e-14 cap_mim_2f0_m4m5_noshield
CXSP_CU13_9 XSP.X64.bp topp 3.56528e-14 cap_mim_2f0_m4m5_noshield
CXSP_CU13_10 XSP.X128.bp topp 3.56528e-14 cap_mim_2f0_m4m5_noshield
CXSP_CU13_11 XSP.X128.bp topp 3.56528e-14 cap_mim_2f0_m4m5_noshield
CXSP_CU13_12 XSP.X256.bp topp 3.56528e-14 cap_mim_2f0_m4m5_noshield
CXSP_CU13_13 XSP.X256.bp topp 3.56528e-14 cap_mim_2f0_m4m5_noshield
CXSP_CU13_14 XSP.X256.bp topp 3.56528e-14 cap_mim_2f0_m4m5_noshield
CXSP_CU13_15 XSP.X256.bp topp 3.56528e-14 cap_mim_2f0_m4m5_noshield
CXSP_CU14_0 XSP.X256.bp topp 3.56528e-14 cap_mim_2f0_m4m5_noshield
CXSP_CU14_1 XSP.X256.bp topp 3.56528e-14 cap_mim_2f0_m4m5_noshield
CXSP_CU14_2 XSP.X256.bp topp 3.56528e-14 cap_mim_2f0_m4m5_noshield
CXSP_CU14_3 XSP.X256.bp topp 3.56528e-14 cap_mim_2f0_m4m5_noshield
CXSP_CU14_4 XSP.X128.bp topp 3.56528e-14 cap_mim_2f0_m4m5_noshield
CXSP_CU14_5 XSP.X128.bp topp 3.56528e-14 cap_mim_2f0_m4m5_noshield
CXSP_CU14_6 XSP.X64.bp topp 3.56528e-14 cap_mim_2f0_m4m5_noshield
CXSP_CU14_7 XSP.X32.bp topp 3.56528e-14 cap_mim_2f0_m4m5_noshield
CXSP_CU14_8 XSP.X256.bp topp 3.56528e-14 cap_mim_2f0_m4m5_noshield
CXSP_CU14_9 XSP.X256.bp topp 3.56528e-14 cap_mim_2f0_m4m5_noshield
CXSP_CU14_10 XSP.X256.bp topp 3.56528e-14 cap_mim_2f0_m4m5_noshield
CXSP_CU14_11 XSP.X256.bp topp 3.56528e-14 cap_mim_2f0_m4m5_noshield
CXSP_CU14_12 XSP.X128.bp topp 3.56528e-14 cap_mim_2f0_m4m5_noshield
CXSP_CU14_13 XSP.X128.bp topp 3.56528e-14 cap_mim_2f0_m4m5_noshield
CXSP_CU14_14 XSP.X64.bp topp 3.56528e-14 cap_mim_2f0_m4m5_noshield
CXSP_CU14_15 XSP.X32.bp topp 3.56528e-14 cap_mim_2f0_m4m5_noshield
CXSP_CU15_0 XSP.X16.bp topp 3.56528e-14 cap_mim_2f0_m4m5_noshield
CXSP_CU15_1 XSP.X64.bp topp 3.56528e-14 cap_mim_2f0_m4m5_noshield
CXSP_CU15_2 XSP.X128.bp topp 3.56528e-14 cap_mim_2f0_m4m5_noshield
CXSP_CU15_3 XSP.X128.bp topp 3.56528e-14 cap_mim_2f0_m4m5_noshield
CXSP_CU15_4 XSP.X256.bp topp 3.56528e-14 cap_mim_2f0_m4m5_noshield
CXSP_CU15_5 XSP.X256.bp topp 3.56528e-14 cap_mim_2f0_m4m5_noshield
CXSP_CU15_6 XSP.X256.bp topp 3.56528e-14 cap_mim_2f0_m4m5_noshield
CXSP_CU15_7 XSP.X256.bp topp 3.56528e-14 cap_mim_2f0_m4m5_noshield
CXSP_CU15_8 XSP.X16.bp topp 3.56528e-14 cap_mim_2f0_m4m5_noshield
CXSP_CU15_9 XSP.X64.bp topp 3.56528e-14 cap_mim_2f0_m4m5_noshield
CXSP_CU15_10 XSP.X128.bp topp 3.56528e-14 cap_mim_2f0_m4m5_noshield
CXSP_CU15_11 XSP.X128.bp topp 3.56528e-14 cap_mim_2f0_m4m5_noshield
CXSP_CU15_12 XSP.X256.bp topp 3.56528e-14 cap_mim_2f0_m4m5_noshield
CXSP_CU15_13 XSP.X256.bp topp 3.56528e-14 cap_mim_2f0_m4m5_noshield
CXSP_CU15_14 XSP.X256.bp topp 3.56528e-14 cap_mim_2f0_m4m5_noshield
CXSP_CU15_15 XSP.X256.bp topp 3.56528e-14 cap_mim_2f0_m4m5_noshield
CXSP_CU16_0 XSP.X256.bp topp 3.56528e-14 cap_mim_2f0_m4m5_noshield
CXSP_CU16_1 XSP.X256.bp topp 3.56528e-14 cap_mim_2f0_m4m5_noshield
CXSP_CU16_2 XSP.X256.bp topp 3.56528e-14 cap_mim_2f0_m4m5_noshield
CXSP_CU16_3 XSP.X256.bp topp 3.56528e-14 cap_mim_2f0_m4m5_noshield
CXSP_CU16_4 XSP.X128.bp topp 3.56528e-14 cap_mim_2f0_m4m5_noshield
CXSP_CU16_5 XSP.X128.bp topp 3.56528e-14 cap_mim_2f0_m4m5_noshield
CXSP_CU16_6 XSP.X64.bp topp 3.56528e-14 cap_mim_2f0_m4m5_noshield
CXSP_CU16_7 XSP.X16.bp topp 3.56528e-14 cap_mim_2f0_m4m5_noshield
CXSP_CU16_8 XSP.X256.bp topp 3.56528e-14 cap_mim_2f0_m4m5_noshield
CXSP_CU16_9 XSP.X256.bp topp 3.56528e-14 cap_mim_2f0_m4m5_noshield
CXSP_CU16_10 XSP.X256.bp topp 3.56528e-14 cap_mim_2f0_m4m5_noshield
CXSP_CU16_11 XSP.X256.bp topp 3.56528e-14 cap_mim_2f0_m4m5_noshield
CXSP_CU16_12 XSP.X128.bp topp 3.56528e-14 cap_mim_2f0_m4m5_noshield
CXSP_CU16_13 XSP.X128.bp topp 3.56528e-14 cap_mim_2f0_m4m5_noshield
CXSP_CU16_14 XSP.X64.bp topp 3.56528e-14 cap_mim_2f0_m4m5_noshield
CXSP_CU16_15 XSP.X16.bp topp 3.56528e-14 cap_mim_2f0_m4m5_noshield
CXSP_CU17_0 XSP.X32.bp topp 3.56528e-14 cap_mim_2f0_m4m5_noshield
CXSP_CU17_1 XSP.X64.bp topp 3.56528e-14 cap_mim_2f0_m4m5_noshield
CXSP_CU17_2 XSP.X128.bp topp 3.56528e-14 cap_mim_2f0_m4m5_noshield
CXSP_CU17_3 XSP.X128.bp topp 3.56528e-14 cap_mim_2f0_m4m5_noshield
CXSP_CU17_4 XSP.X256.bp topp 3.56528e-14 cap_mim_2f0_m4m5_noshield
CXSP_CU17_5 XSP.X256.bp topp 3.56528e-14 cap_mim_2f0_m4m5_noshield
CXSP_CU17_6 XSP.X256.bp topp 3.56528e-14 cap_mim_2f0_m4m5_noshield
CXSP_CU17_7 XSP.X256.bp topp 3.56528e-14 cap_mim_2f0_m4m5_noshield
CXSP_CU17_8 XSP.X32.bp topp 3.56528e-14 cap_mim_2f0_m4m5_noshield
CXSP_CU17_9 XSP.X64.bp topp 3.56528e-14 cap_mim_2f0_m4m5_noshield
CXSP_CU17_10 XSP.X128.bp topp 3.56528e-14 cap_mim_2f0_m4m5_noshield
CXSP_CU17_11 XSP.X128.bp topp 3.56528e-14 cap_mim_2f0_m4m5_noshield
CXSP_CU17_12 XSP.X256.bp topp 3.56528e-14 cap_mim_2f0_m4m5_noshield
CXSP_CU17_13 XSP.X256.bp topp 3.56528e-14 cap_mim_2f0_m4m5_noshield
CXSP_CU17_14 XSP.X256.bp topp 3.56528e-14 cap_mim_2f0_m4m5_noshield
CXSP_CU17_15 XSP.X256.bp topp 3.56528e-14 cap_mim_2f0_m4m5_noshield
CXSP_CU18_0 XSP.X256.bp topp 3.56528e-14 cap_mim_2f0_m4m5_noshield
CXSP_CU18_1 XSP.X256.bp topp 3.56528e-14 cap_mim_2f0_m4m5_noshield
CXSP_CU18_2 XSP.X256.bp topp 3.56528e-14 cap_mim_2f0_m4m5_noshield
CXSP_CU18_3 XSP.X256.bp topp 3.56528e-14 cap_mim_2f0_m4m5_noshield
CXSP_CU18_4 XSP.X128.bp topp 3.56528e-14 cap_mim_2f0_m4m5_noshield
CXSP_CU18_5 XSP.X128.bp topp 3.56528e-14 cap_mim_2f0_m4m5_noshield
CXSP_CU18_6 XSP.X64.bp topp 3.56528e-14 cap_mim_2f0_m4m5_noshield
CXSP_CU18_7 XSP.X16.bp topp 3.56528e-14 cap_mim_2f0_m4m5_noshield
CXSP_CU18_8 XSP.X256.bp topp 3.56528e-14 cap_mim_2f0_m4m5_noshield
CXSP_CU18_9 XSP.X256.bp topp 3.56528e-14 cap_mim_2f0_m4m5_noshield
CXSP_CU18_10 XSP.X256.bp topp 3.56528e-14 cap_mim_2f0_m4m5_noshield
CXSP_CU18_11 XSP.X256.bp topp 3.56528e-14 cap_mim_2f0_m4m5_noshield
CXSP_CU18_12 XSP.X128.bp topp 3.56528e-14 cap_mim_2f0_m4m5_noshield
CXSP_CU18_13 XSP.X128.bp topp 3.56528e-14 cap_mim_2f0_m4m5_noshield
CXSP_CU18_14 XSP.X64.bp topp 3.56528e-14 cap_mim_2f0_m4m5_noshield
CXSP_CU18_15 XSP.X16.bp topp 3.56528e-14 cap_mim_2f0_m4m5_noshield
CXSP_CU19_0 XSP.X32.bp topp 3.56528e-14 cap_mim_2f0_m4m5_noshield
CXSP_CU19_1 XSP.X64.bp topp 3.56528e-14 cap_mim_2f0_m4m5_noshield
CXSP_CU19_2 XSP.X128.bp topp 3.56528e-14 cap_mim_2f0_m4m5_noshield
CXSP_CU19_3 XSP.X128.bp topp 3.56528e-14 cap_mim_2f0_m4m5_noshield
CXSP_CU19_4 XSP.X256.bp topp 3.56528e-14 cap_mim_2f0_m4m5_noshield
CXSP_CU19_5 XSP.X256.bp topp 3.56528e-14 cap_mim_2f0_m4m5_noshield
CXSP_CU19_6 XSP.X256.bp topp 3.56528e-14 cap_mim_2f0_m4m5_noshield
CXSP_CU19_7 XSP.X256.bp topp 3.56528e-14 cap_mim_2f0_m4m5_noshield
CXSP_CU19_8 XSP.X32.bp topp 3.56528e-14 cap_mim_2f0_m4m5_noshield
CXSP_CU19_9 XSP.X64.bp topp 3.56528e-14 cap_mim_2f0_m4m5_noshield
CXSP_CU19_10 XSP.X128.bp topp 3.56528e-14 cap_mim_2f0_m4m5_noshield
CXSP_CU19_11 XSP.X128.bp topp 3.56528e-14 cap_mim_2f0_m4m5_noshield
CXSP_CU19_12 XSP.X256.bp topp 3.56528e-14 cap_mim_2f0_m4m5_noshield
CXSP_CU19_13 XSP.X256.bp topp 3.56528e-14 cap_mim_2f0_m4m5_noshield
CXSP_CU19_14 XSP.X256.bp topp 3.56528e-14 cap_mim_2f0_m4m5_noshield
CXSP_CU19_15 XSP.X256.bp topp 3.56528e-14 cap_mim_2f0_m4m5_noshield
CXSP_CU20_0 XSP.X256.bp topp 3.56528e-14 cap_mim_2f0_m4m5_noshield
CXSP_CU20_1 XSP.X256.bp topp 3.56528e-14 cap_mim_2f0_m4m5_noshield
CXSP_CU20_2 XSP.X256.bp topp 3.56528e-14 cap_mim_2f0_m4m5_noshield
CXSP_CU20_3 XSP.X256.bp topp 3.56528e-14 cap_mim_2f0_m4m5_noshield
CXSP_CU20_4 XSP.X128.bp topp 3.56528e-14 cap_mim_2f0_m4m5_noshield
CXSP_CU20_5 XSP.X128.bp topp 3.56528e-14 cap_mim_2f0_m4m5_noshield
CXSP_CU20_6 XSP.X64.bp topp 3.56528e-14 cap_mim_2f0_m4m5_noshield
CXSP_CU20_7 XSP.X16.bp topp 3.56528e-14 cap_mim_2f0_m4m5_noshield
CXSP_CU20_8 XSP.X256.bp topp 3.56528e-14 cap_mim_2f0_m4m5_noshield
CXSP_CU20_9 XSP.X256.bp topp 3.56528e-14 cap_mim_2f0_m4m5_noshield
CXSP_CU20_10 XSP.X256.bp topp 3.56528e-14 cap_mim_2f0_m4m5_noshield
CXSP_CU20_11 XSP.X256.bp topp 3.56528e-14 cap_mim_2f0_m4m5_noshield
CXSP_CU20_12 XSP.X128.bp topp 3.56528e-14 cap_mim_2f0_m4m5_noshield
CXSP_CU20_13 XSP.X128.bp topp 3.56528e-14 cap_mim_2f0_m4m5_noshield
CXSP_CU20_14 XSP.X64.bp topp 3.56528e-14 cap_mim_2f0_m4m5_noshield
CXSP_CU20_15 XSP.X16.bp topp 3.56528e-14 cap_mim_2f0_m4m5_noshield
CXSP_CU21_0 XSP.X32.bp topp 3.56528e-14 cap_mim_2f0_m4m5_noshield
CXSP_CU21_1 XSP.X64.bp topp 3.56528e-14 cap_mim_2f0_m4m5_noshield
CXSP_CU21_2 XSP.X128.bp topp 3.56528e-14 cap_mim_2f0_m4m5_noshield
CXSP_CU21_3 XSP.X128.bp topp 3.56528e-14 cap_mim_2f0_m4m5_noshield
CXSP_CU21_4 XSP.X256.bp topp 3.56528e-14 cap_mim_2f0_m4m5_noshield
CXSP_CU21_5 XSP.X256.bp topp 3.56528e-14 cap_mim_2f0_m4m5_noshield
CXSP_CU21_6 XSP.X256.bp topp 3.56528e-14 cap_mim_2f0_m4m5_noshield
CXSP_CU21_7 XSP.X256.bp topp 3.56528e-14 cap_mim_2f0_m4m5_noshield
CXSP_CU21_8 XSP.X32.bp topp 3.56528e-14 cap_mim_2f0_m4m5_noshield
CXSP_CU21_9 XSP.X64.bp topp 3.56528e-14 cap_mim_2f0_m4m5_noshield
CXSP_CU21_10 XSP.X128.bp topp 3.56528e-14 cap_mim_2f0_m4m5_noshield
CXSP_CU21_11 XSP.X128.bp topp 3.56528e-14 cap_mim_2f0_m4m5_noshield
CXSP_CU21_12 XSP.X256.bp topp 3.56528e-14 cap_mim_2f0_m4m5_noshield
CXSP_CU21_13 XSP.X256.bp topp 3.56528e-14 cap_mim_2f0_m4m5_noshield
CXSP_CU21_14 XSP.X256.bp topp 3.56528e-14 cap_mim_2f0_m4m5_noshield
CXSP_CU21_15 XSP.X256.bp topp 3.56528e-14 cap_mim_2f0_m4m5_noshield
CXSP_CU22_0 XSP.X256.bp topp 3.56528e-14 cap_mim_2f0_m4m5_noshield
CXSP_CU22_1 XSP.X256.bp topp 3.56528e-14 cap_mim_2f0_m4m5_noshield
CXSP_CU22_2 XSP.X256.bp topp 3.56528e-14 cap_mim_2f0_m4m5_noshield
CXSP_CU22_3 XSP.X256.bp topp 3.56528e-14 cap_mim_2f0_m4m5_noshield
CXSP_CU22_4 XSP.X128.bp topp 3.56528e-14 cap_mim_2f0_m4m5_noshield
CXSP_CU22_5 XSP.X128.bp topp 3.56528e-14 cap_mim_2f0_m4m5_noshield
CXSP_CU22_6 XSP.X64.bp topp 3.56528e-14 cap_mim_2f0_m4m5_noshield
CXSP_CU22_7 XSP.X16.bp topp 3.56528e-14 cap_mim_2f0_m4m5_noshield
CXSP_CU22_8 XSP.X256.bp topp 3.56528e-14 cap_mim_2f0_m4m5_noshield
CXSP_CU22_9 XSP.X256.bp topp 3.56528e-14 cap_mim_2f0_m4m5_noshield
CXSP_CU22_10 XSP.X256.bp topp 3.56528e-14 cap_mim_2f0_m4m5_noshield
CXSP_CU22_11 XSP.X256.bp topp 3.56528e-14 cap_mim_2f0_m4m5_noshield
CXSP_CU22_12 XSP.X128.bp topp 3.56528e-14 cap_mim_2f0_m4m5_noshield
CXSP_CU22_13 XSP.X128.bp topp 3.56528e-14 cap_mim_2f0_m4m5_noshield
CXSP_CU22_14 XSP.X64.bp topp 3.56528e-14 cap_mim_2f0_m4m5_noshield
CXSP_CU22_15 XSP.X16.bp topp 3.56528e-14 cap_mim_2f0_m4m5_noshield
CXSP_CU23_0 XSP.X32.bp topp 3.56528e-14 cap_mim_2f0_m4m5_noshield
CXSP_CU23_1 XSP.X64.bp topp 3.56528e-14 cap_mim_2f0_m4m5_noshield
CXSP_CU23_2 XSP.X128.bp topp 3.56528e-14 cap_mim_2f0_m4m5_noshield
CXSP_CU23_3 XSP.X128.bp topp 3.56528e-14 cap_mim_2f0_m4m5_noshield
CXSP_CU23_4 XSP.X256.bp topp 3.56528e-14 cap_mim_2f0_m4m5_noshield
CXSP_CU23_5 XSP.X256.bp topp 3.56528e-14 cap_mim_2f0_m4m5_noshield
CXSP_CU23_6 XSP.X256.bp topp 3.56528e-14 cap_mim_2f0_m4m5_noshield
CXSP_CU23_7 XSP.X256.bp topp 3.56528e-14 cap_mim_2f0_m4m5_noshield
CXSP_CU23_8 XSP.X32.bp topp 3.56528e-14 cap_mim_2f0_m4m5_noshield
CXSP_CU23_9 XSP.X64.bp topp 3.56528e-14 cap_mim_2f0_m4m5_noshield
CXSP_CU23_10 XSP.X128.bp topp 3.56528e-14 cap_mim_2f0_m4m5_noshield
CXSP_CU23_11 XSP.X128.bp topp 3.56528e-14 cap_mim_2f0_m4m5_noshield
CXSP_CU23_12 XSP.X256.bp topp 3.56528e-14 cap_mim_2f0_m4m5_noshield
CXSP_CU23_13 XSP.X256.bp topp 3.56528e-14 cap_mim_2f0_m4m5_noshield
CXSP_CU23_14 XSP.X256.bp topp 3.56528e-14 cap_mim_2f0_m4m5_noshield
CXSP_CU23_15 XSP.X256.bp topp 3.56528e-14 cap_mim_2f0_m4m5_noshield
CXSP_CU24_0 XSP.X256.bp topp 3.56528e-14 cap_mim_2f0_m4m5_noshield
CXSP_CU24_1 XSP.X256.bp topp 3.56528e-14 cap_mim_2f0_m4m5_noshield
CXSP_CU24_2 XSP.X256.bp topp 3.56528e-14 cap_mim_2f0_m4m5_noshield
CXSP_CU24_3 XSP.X256.bp topp 3.56528e-14 cap_mim_2f0_m4m5_noshield
CXSP_CU24_4 XSP.X128.bp topp 3.56528e-14 cap_mim_2f0_m4m5_noshield
CXSP_CU24_5 XSP.X128.bp topp 3.56528e-14 cap_mim_2f0_m4m5_noshield
CXSP_CU24_6 XSP.X64.bp topp 3.56528e-14 cap_mim_2f0_m4m5_noshield
CXSP_CU24_7 XSP.X8.bp topp 3.56528e-14 cap_mim_2f0_m4m5_noshield
CXSP_CU24_8 XSP.X256.bp topp 3.56528e-14 cap_mim_2f0_m4m5_noshield
CXSP_CU24_9 XSP.X256.bp topp 3.56528e-14 cap_mim_2f0_m4m5_noshield
CXSP_CU24_10 XSP.X256.bp topp 3.56528e-14 cap_mim_2f0_m4m5_noshield
CXSP_CU24_11 XSP.X256.bp topp 3.56528e-14 cap_mim_2f0_m4m5_noshield
CXSP_CU24_12 XSP.X128.bp topp 3.56528e-14 cap_mim_2f0_m4m5_noshield
CXSP_CU24_13 XSP.X128.bp topp 3.56528e-14 cap_mim_2f0_m4m5_noshield
CXSP_CU24_14 XSP.X64.bp topp 3.56528e-14 cap_mim_2f0_m4m5_noshield
CXSP_CU24_15 XSP.X8.bp topp 3.56528e-14 cap_mim_2f0_m4m5_noshield
CXSP_CU25_0 XSP.X32.bp topp 3.56528e-14 cap_mim_2f0_m4m5_noshield
CXSP_CU25_1 XSP.X64.bp topp 3.56528e-14 cap_mim_2f0_m4m5_noshield
CXSP_CU25_2 XSP.X128.bp topp 3.56528e-14 cap_mim_2f0_m4m5_noshield
CXSP_CU25_3 XSP.X128.bp topp 3.56528e-14 cap_mim_2f0_m4m5_noshield
CXSP_CU25_4 XSP.X256.bp topp 3.56528e-14 cap_mim_2f0_m4m5_noshield
CXSP_CU25_5 XSP.X256.bp topp 3.56528e-14 cap_mim_2f0_m4m5_noshield
CXSP_CU25_6 XSP.X256.bp topp 3.56528e-14 cap_mim_2f0_m4m5_noshield
CXSP_CU25_7 XSP.X256.bp topp 3.56528e-14 cap_mim_2f0_m4m5_noshield
CXSP_CU25_8 XSP.X32.bp topp 3.56528e-14 cap_mim_2f0_m4m5_noshield
CXSP_CU25_9 XSP.X64.bp topp 3.56528e-14 cap_mim_2f0_m4m5_noshield
CXSP_CU25_10 XSP.X128.bp topp 3.56528e-14 cap_mim_2f0_m4m5_noshield
CXSP_CU25_11 XSP.X128.bp topp 3.56528e-14 cap_mim_2f0_m4m5_noshield
CXSP_CU25_12 XSP.X256.bp topp 3.56528e-14 cap_mim_2f0_m4m5_noshield
CXSP_CU25_13 XSP.X256.bp topp 3.56528e-14 cap_mim_2f0_m4m5_noshield
CXSP_CU25_14 XSP.X256.bp topp 3.56528e-14 cap_mim_2f0_m4m5_noshield
CXSP_CU25_15 XSP.X256.bp topp 3.56528e-14 cap_mim_2f0_m4m5_noshield
CXSP_CU26_0 XSP.X256.bp topp 3.56528e-14 cap_mim_2f0_m4m5_noshield
CXSP_CU26_1 XSP.X256.bp topp 3.56528e-14 cap_mim_2f0_m4m5_noshield
CXSP_CU26_2 XSP.X256.bp topp 3.56528e-14 cap_mim_2f0_m4m5_noshield
CXSP_CU26_3 XSP.X256.bp topp 3.56528e-14 cap_mim_2f0_m4m5_noshield
CXSP_CU26_4 XSP.X128.bp topp 3.56528e-14 cap_mim_2f0_m4m5_noshield
CXSP_CU26_5 XSP.X128.bp topp 3.56528e-14 cap_mim_2f0_m4m5_noshield
CXSP_CU26_6 XSP.X64.bp topp 3.56528e-14 cap_mim_2f0_m4m5_noshield
CXSP_CU26_7 XSP.X8.bp topp 3.56528e-14 cap_mim_2f0_m4m5_noshield
CXSP_CU26_8 XSP.X256.bp topp 3.56528e-14 cap_mim_2f0_m4m5_noshield
CXSP_CU26_9 XSP.X256.bp topp 3.56528e-14 cap_mim_2f0_m4m5_noshield
CXSP_CU26_10 XSP.X256.bp topp 3.56528e-14 cap_mim_2f0_m4m5_noshield
CXSP_CU26_11 XSP.X256.bp topp 3.56528e-14 cap_mim_2f0_m4m5_noshield
CXSP_CU26_12 XSP.X128.bp topp 3.56528e-14 cap_mim_2f0_m4m5_noshield
CXSP_CU26_13 XSP.X128.bp topp 3.56528e-14 cap_mim_2f0_m4m5_noshield
CXSP_CU26_14 XSP.X64.bp topp 3.56528e-14 cap_mim_2f0_m4m5_noshield
CXSP_CU26_15 XSP.X8.bp topp 3.56528e-14 cap_mim_2f0_m4m5_noshield
CXSP_CU27_0 XSP.X32.bp topp 3.56528e-14 cap_mim_2f0_m4m5_noshield
CXSP_CU27_1 XSP.X64.bp topp 3.56528e-14 cap_mim_2f0_m4m5_noshield
CXSP_CU27_2 XSP.X128.bp topp 3.56528e-14 cap_mim_2f0_m4m5_noshield
CXSP_CU27_3 XSP.X128.bp topp 3.56528e-14 cap_mim_2f0_m4m5_noshield
CXSP_CU27_4 XSP.X256.bp topp 3.56528e-14 cap_mim_2f0_m4m5_noshield
CXSP_CU27_5 XSP.X256.bp topp 3.56528e-14 cap_mim_2f0_m4m5_noshield
CXSP_CU27_6 XSP.X256.bp topp 3.56528e-14 cap_mim_2f0_m4m5_noshield
CXSP_CU27_7 XSP.X256.bp topp 3.56528e-14 cap_mim_2f0_m4m5_noshield
CXSP_CU27_8 XSP.X32.bp topp 3.56528e-14 cap_mim_2f0_m4m5_noshield
CXSP_CU27_9 XSP.X64.bp topp 3.56528e-14 cap_mim_2f0_m4m5_noshield
CXSP_CU27_10 XSP.X128.bp topp 3.56528e-14 cap_mim_2f0_m4m5_noshield
CXSP_CU27_11 XSP.X128.bp topp 3.56528e-14 cap_mim_2f0_m4m5_noshield
CXSP_CU27_12 XSP.X256.bp topp 3.56528e-14 cap_mim_2f0_m4m5_noshield
CXSP_CU27_13 XSP.X256.bp topp 3.56528e-14 cap_mim_2f0_m4m5_noshield
CXSP_CU27_14 XSP.X256.bp topp 3.56528e-14 cap_mim_2f0_m4m5_noshield
CXSP_CU27_15 XSP.X256.bp topp 3.56528e-14 cap_mim_2f0_m4m5_noshield
CXSP_CU28_0 XSP.X256.bp topp 3.56528e-14 cap_mim_2f0_m4m5_noshield
CXSP_CU28_1 XSP.X256.bp topp 3.56528e-14 cap_mim_2f0_m4m5_noshield
CXSP_CU28_2 XSP.X256.bp topp 3.56528e-14 cap_mim_2f0_m4m5_noshield
CXSP_CU28_3 XSP.X256.bp topp 3.56528e-14 cap_mim_2f0_m4m5_noshield
CXSP_CU28_4 XSP.X128.bp topp 3.56528e-14 cap_mim_2f0_m4m5_noshield
CXSP_CU28_5 XSP.X128.bp topp 3.56528e-14 cap_mim_2f0_m4m5_noshield
CXSP_CU28_6 XSP.X64.bp topp 3.56528e-14 cap_mim_2f0_m4m5_noshield
CXSP_CU28_7 XSP.X4.bp topp 3.56528e-14 cap_mim_2f0_m4m5_noshield
CXSP_CU28_8 XSP.X256.bp topp 3.56528e-14 cap_mim_2f0_m4m5_noshield
CXSP_CU28_9 XSP.X256.bp topp 3.56528e-14 cap_mim_2f0_m4m5_noshield
CXSP_CU28_10 XSP.X256.bp topp 3.56528e-14 cap_mim_2f0_m4m5_noshield
CXSP_CU28_11 XSP.X256.bp topp 3.56528e-14 cap_mim_2f0_m4m5_noshield
CXSP_CU28_12 XSP.X128.bp topp 3.56528e-14 cap_mim_2f0_m4m5_noshield
CXSP_CU28_13 XSP.X128.bp topp 3.56528e-14 cap_mim_2f0_m4m5_noshield
CXSP_CU28_14 XSP.X64.bp topp 3.56528e-14 cap_mim_2f0_m4m5_noshield
CXSP_CU28_15 XSP.X4.bp topp 3.56528e-14 cap_mim_2f0_m4m5_noshield
CXSP_CU29_0 XSP.X32.bp topp 3.56528e-14 cap_mim_2f0_m4m5_noshield
CXSP_CU29_1 XSP.X64.bp topp 3.56528e-14 cap_mim_2f0_m4m5_noshield
CXSP_CU29_2 XSP.X128.bp topp 3.56528e-14 cap_mim_2f0_m4m5_noshield
CXSP_CU29_3 XSP.X128.bp topp 3.56528e-14 cap_mim_2f0_m4m5_noshield
CXSP_CU29_4 XSP.X256.bp topp 3.56528e-14 cap_mim_2f0_m4m5_noshield
CXSP_CU29_5 XSP.X256.bp topp 3.56528e-14 cap_mim_2f0_m4m5_noshield
CXSP_CU29_6 XSP.X256.bp topp 3.56528e-14 cap_mim_2f0_m4m5_noshield
CXSP_CU29_7 XSP.X256.bp topp 3.56528e-14 cap_mim_2f0_m4m5_noshield
CXSP_CU29_8 XSP.X32.bp topp 3.56528e-14 cap_mim_2f0_m4m5_noshield
CXSP_CU29_9 XSP.X64.bp topp 3.56528e-14 cap_mim_2f0_m4m5_noshield
CXSP_CU29_10 XSP.X128.bp topp 3.56528e-14 cap_mim_2f0_m4m5_noshield
CXSP_CU29_11 XSP.X128.bp topp 3.56528e-14 cap_mim_2f0_m4m5_noshield
CXSP_CU29_12 XSP.X256.bp topp 3.56528e-14 cap_mim_2f0_m4m5_noshield
CXSP_CU29_13 XSP.X256.bp topp 3.56528e-14 cap_mim_2f0_m4m5_noshield
CXSP_CU29_14 XSP.X256.bp topp 3.56528e-14 cap_mim_2f0_m4m5_noshield
CXSP_CU29_15 XSP.X256.bp topp 3.56528e-14 cap_mim_2f0_m4m5_noshield
CXSP_CU30_0 XSP.X256.bp topp 3.56528e-14 cap_mim_2f0_m4m5_noshield
CXSP_CU30_1 XSP.X256.bp topp 3.56528e-14 cap_mim_2f0_m4m5_noshield
CXSP_CU30_2 XSP.X256.bp topp 3.56528e-14 cap_mim_2f0_m4m5_noshield
CXSP_CU30_3 XSP.X256.bp topp 3.56528e-14 cap_mim_2f0_m4m5_noshield
CXSP_CU30_4 XSP.X128.bp topp 3.56528e-14 cap_mim_2f0_m4m5_noshield
CXSP_CU30_5 XSP.X128.bp topp 3.56528e-14 cap_mim_2f0_m4m5_noshield
CXSP_CU30_6 XSP.X64.bp topp 3.56528e-14 cap_mim_2f0_m4m5_noshield
CXSP_CU30_7 XSP.X1.bp topp 3.56528e-14 cap_mim_2f0_m4m5_noshield
CXSP_CU30_8 XSP.X256.bp topp 3.56528e-14 cap_mim_2f0_m4m5_noshield
CXSP_CU30_9 XSP.X256.bp topp 3.56528e-14 cap_mim_2f0_m4m5_noshield
CXSP_CU30_10 XSP.X256.bp topp 3.56528e-14 cap_mim_2f0_m4m5_noshield
CXSP_CU30_11 XSP.X256.bp topp 3.56528e-14 cap_mim_2f0_m4m5_noshield
CXSP_CU30_12 XSP.X128.bp topp 3.56528e-14 cap_mim_2f0_m4m5_noshield
CXSP_CU30_13 XSP.X128.bp topp 3.56528e-14 cap_mim_2f0_m4m5_noshield
CXSP_CU30_14 XSP.X64.bp topp 3.56528e-14 cap_mim_2f0_m4m5_noshield
CXSP_CU30_15 XSP.X2.bp topp 3.56528e-14 cap_mim_2f0_m4m5_noshield
CXSP_CU31_0 XSP.X32.bp topp 3.56528e-14 cap_mim_2f0_m4m5_noshield
CXSP_CU31_1 XSP.X64.bp topp 3.56528e-14 cap_mim_2f0_m4m5_noshield
CXSP_CU31_2 XSP.X128.bp topp 3.56528e-14 cap_mim_2f0_m4m5_noshield
CXSP_CU31_3 XSP.X128.bp topp 3.56528e-14 cap_mim_2f0_m4m5_noshield
CXSP_CU31_4 XSP.X256.bp topp 3.56528e-14 cap_mim_2f0_m4m5_noshield
CXSP_CU31_5 XSP.X256.bp topp 3.56528e-14 cap_mim_2f0_m4m5_noshield
CXSP_CU31_6 XSP.X256.bp topp 3.56528e-14 cap_mim_2f0_m4m5_noshield
CXSP_CU31_7 XSP.X256.bp topp 3.56528e-14 cap_mim_2f0_m4m5_noshield
CXSP_CU31_8 XSP.X32.bp topp 3.56528e-14 cap_mim_2f0_m4m5_noshield
CXSP_CU31_9 XSP.X64.bp topp 3.56528e-14 cap_mim_2f0_m4m5_noshield
CXSP_CU31_10 XSP.X128.bp topp 3.56528e-14 cap_mim_2f0_m4m5_noshield
CXSP_CU31_11 XSP.X128.bp topp 3.56528e-14 cap_mim_2f0_m4m5_noshield
CXSP_CU31_12 XSP.X256.bp topp 3.56528e-14 cap_mim_2f0_m4m5_noshield
CXSP_CU31_13 XSP.X256.bp topp 3.56528e-14 cap_mim_2f0_m4m5_noshield
CXSP_CU31_14 XSP.X256.bp topp 3.56528e-14 cap_mim_2f0_m4m5_noshield
CXSP_CU31_15 XSP.X256.bp topp 3.56528e-14 cap_mim_2f0_m4m5_noshield
CXSN_CU0_0 XSN.X256.bp topn 3.56528e-14 cap_mim_2f0_m4m5_noshield
CXSN_CU0_1 XSN.X256.bp topn 3.56528e-14 cap_mim_2f0_m4m5_noshield
CXSN_CU0_2 XSN.X256.bp topn 3.56528e-14 cap_mim_2f0_m4m5_noshield
CXSN_CU0_3 XSN.X256.bp topn 3.56528e-14 cap_mim_2f0_m4m5_noshield
CXSN_CU0_4 XSN.X128.bp topn 3.56528e-14 cap_mim_2f0_m4m5_noshield
CXSN_CU0_5 XSN.X128.bp topn 3.56528e-14 cap_mim_2f0_m4m5_noshield
CXSN_CU0_6 XSN.X64.bp topn 3.56528e-14 cap_mim_2f0_m4m5_noshield
CXSN_CU0_7 XSN.X32.bp topn 3.56528e-14 cap_mim_2f0_m4m5_noshield
CXSN_CU0_8 XSN.X256.bp topn 3.56528e-14 cap_mim_2f0_m4m5_noshield
CXSN_CU0_9 XSN.X256.bp topn 3.56528e-14 cap_mim_2f0_m4m5_noshield
CXSN_CU0_10 XSN.X256.bp topn 3.56528e-14 cap_mim_2f0_m4m5_noshield
CXSN_CU0_11 XSN.X256.bp topn 3.56528e-14 cap_mim_2f0_m4m5_noshield
CXSN_CU0_12 XSN.X128.bp topn 3.56528e-14 cap_mim_2f0_m4m5_noshield
CXSN_CU0_13 XSN.X128.bp topn 3.56528e-14 cap_mim_2f0_m4m5_noshield
CXSN_CU0_14 XSN.X64.bp topn 3.56528e-14 cap_mim_2f0_m4m5_noshield
CXSN_CU0_15 XSN.X32.bp topn 3.56528e-14 cap_mim_2f0_m4m5_noshield
CXSN_CU1_0 XSN.X2.bp topn 3.56528e-14 cap_mim_2f0_m4m5_noshield
CXSN_CU1_1 XSN.X64.bp topn 3.56528e-14 cap_mim_2f0_m4m5_noshield
CXSN_CU1_2 XSN.X128.bp topn 3.56528e-14 cap_mim_2f0_m4m5_noshield
CXSN_CU1_3 XSN.X128.bp topn 3.56528e-14 cap_mim_2f0_m4m5_noshield
CXSN_CU1_4 XSN.X256.bp topn 3.56528e-14 cap_mim_2f0_m4m5_noshield
CXSN_CU1_5 XSN.X256.bp topn 3.56528e-14 cap_mim_2f0_m4m5_noshield
CXSN_CU1_6 XSN.X256.bp topn 3.56528e-14 cap_mim_2f0_m4m5_noshield
CXSN_CU1_7 XSN.X256.bp topn 3.56528e-14 cap_mim_2f0_m4m5_noshield
CXSN_CU1_8 vcm topn 3.56528e-14 cap_mim_2f0_m4m5_noshield
CXSN_CU1_9 XSN.X64.bp topn 3.56528e-14 cap_mim_2f0_m4m5_noshield
CXSN_CU1_10 XSN.X128.bp topn 3.56528e-14 cap_mim_2f0_m4m5_noshield
CXSN_CU1_11 XSN.X128.bp topn 3.56528e-14 cap_mim_2f0_m4m5_noshield
CXSN_CU1_12 XSN.X256.bp topn 3.56528e-14 cap_mim_2f0_m4m5_noshield
CXSN_CU1_13 XSN.X256.bp topn 3.56528e-14 cap_mim_2f0_m4m5_noshield
CXSN_CU1_14 XSN.X256.bp topn 3.56528e-14 cap_mim_2f0_m4m5_noshield
CXSN_CU1_15 XSN.X256.bp topn 3.56528e-14 cap_mim_2f0_m4m5_noshield
CXSN_CU2_0 XSN.X256.bp topn 3.56528e-14 cap_mim_2f0_m4m5_noshield
CXSN_CU2_1 XSN.X256.bp topn 3.56528e-14 cap_mim_2f0_m4m5_noshield
CXSN_CU2_2 XSN.X256.bp topn 3.56528e-14 cap_mim_2f0_m4m5_noshield
CXSN_CU2_3 XSN.X256.bp topn 3.56528e-14 cap_mim_2f0_m4m5_noshield
CXSN_CU2_4 XSN.X128.bp topn 3.56528e-14 cap_mim_2f0_m4m5_noshield
CXSN_CU2_5 XSN.X128.bp topn 3.56528e-14 cap_mim_2f0_m4m5_noshield
CXSN_CU2_6 XSN.X64.bp topn 3.56528e-14 cap_mim_2f0_m4m5_noshield
CXSN_CU2_7 XSN.X32.bp topn 3.56528e-14 cap_mim_2f0_m4m5_noshield
CXSN_CU2_8 XSN.X256.bp topn 3.56528e-14 cap_mim_2f0_m4m5_noshield
CXSN_CU2_9 XSN.X256.bp topn 3.56528e-14 cap_mim_2f0_m4m5_noshield
CXSN_CU2_10 XSN.X256.bp topn 3.56528e-14 cap_mim_2f0_m4m5_noshield
CXSN_CU2_11 XSN.X256.bp topn 3.56528e-14 cap_mim_2f0_m4m5_noshield
CXSN_CU2_12 XSN.X128.bp topn 3.56528e-14 cap_mim_2f0_m4m5_noshield
CXSN_CU2_13 XSN.X128.bp topn 3.56528e-14 cap_mim_2f0_m4m5_noshield
CXSN_CU2_14 XSN.X64.bp topn 3.56528e-14 cap_mim_2f0_m4m5_noshield
CXSN_CU2_15 XSN.X32.bp topn 3.56528e-14 cap_mim_2f0_m4m5_noshield
CXSN_CU3_0 XSN.X4.bp topn 3.56528e-14 cap_mim_2f0_m4m5_noshield
CXSN_CU3_1 XSN.X64.bp topn 3.56528e-14 cap_mim_2f0_m4m5_noshield
CXSN_CU3_2 XSN.X128.bp topn 3.56528e-14 cap_mim_2f0_m4m5_noshield
CXSN_CU3_3 XSN.X128.bp topn 3.56528e-14 cap_mim_2f0_m4m5_noshield
CXSN_CU3_4 XSN.X256.bp topn 3.56528e-14 cap_mim_2f0_m4m5_noshield
CXSN_CU3_5 XSN.X256.bp topn 3.56528e-14 cap_mim_2f0_m4m5_noshield
CXSN_CU3_6 XSN.X256.bp topn 3.56528e-14 cap_mim_2f0_m4m5_noshield
CXSN_CU3_7 XSN.X256.bp topn 3.56528e-14 cap_mim_2f0_m4m5_noshield
CXSN_CU3_8 XSN.X4.bp topn 3.56528e-14 cap_mim_2f0_m4m5_noshield
CXSN_CU3_9 XSN.X64.bp topn 3.56528e-14 cap_mim_2f0_m4m5_noshield
CXSN_CU3_10 XSN.X128.bp topn 3.56528e-14 cap_mim_2f0_m4m5_noshield
CXSN_CU3_11 XSN.X128.bp topn 3.56528e-14 cap_mim_2f0_m4m5_noshield
CXSN_CU3_12 XSN.X256.bp topn 3.56528e-14 cap_mim_2f0_m4m5_noshield
CXSN_CU3_13 XSN.X256.bp topn 3.56528e-14 cap_mim_2f0_m4m5_noshield
CXSN_CU3_14 XSN.X256.bp topn 3.56528e-14 cap_mim_2f0_m4m5_noshield
CXSN_CU3_15 XSN.X256.bp topn 3.56528e-14 cap_mim_2f0_m4m5_noshield
CXSN_CU4_0 XSN.X256.bp topn 3.56528e-14 cap_mim_2f0_m4m5_noshield
CXSN_CU4_1 XSN.X256.bp topn 3.56528e-14 cap_mim_2f0_m4m5_noshield
CXSN_CU4_2 XSN.X256.bp topn 3.56528e-14 cap_mim_2f0_m4m5_noshield
CXSN_CU4_3 XSN.X256.bp topn 3.56528e-14 cap_mim_2f0_m4m5_noshield
CXSN_CU4_4 XSN.X128.bp topn 3.56528e-14 cap_mim_2f0_m4m5_noshield
CXSN_CU4_5 XSN.X128.bp topn 3.56528e-14 cap_mim_2f0_m4m5_noshield
CXSN_CU4_6 XSN.X64.bp topn 3.56528e-14 cap_mim_2f0_m4m5_noshield
CXSN_CU4_7 XSN.X32.bp topn 3.56528e-14 cap_mim_2f0_m4m5_noshield
CXSN_CU4_8 XSN.X256.bp topn 3.56528e-14 cap_mim_2f0_m4m5_noshield
CXSN_CU4_9 XSN.X256.bp topn 3.56528e-14 cap_mim_2f0_m4m5_noshield
CXSN_CU4_10 XSN.X256.bp topn 3.56528e-14 cap_mim_2f0_m4m5_noshield
CXSN_CU4_11 XSN.X256.bp topn 3.56528e-14 cap_mim_2f0_m4m5_noshield
CXSN_CU4_12 XSN.X128.bp topn 3.56528e-14 cap_mim_2f0_m4m5_noshield
CXSN_CU4_13 XSN.X128.bp topn 3.56528e-14 cap_mim_2f0_m4m5_noshield
CXSN_CU4_14 XSN.X64.bp topn 3.56528e-14 cap_mim_2f0_m4m5_noshield
CXSN_CU4_15 XSN.X32.bp topn 3.56528e-14 cap_mim_2f0_m4m5_noshield
CXSN_CU5_0 XSN.X8.bp topn 3.56528e-14 cap_mim_2f0_m4m5_noshield
CXSN_CU5_1 XSN.X64.bp topn 3.56528e-14 cap_mim_2f0_m4m5_noshield
CXSN_CU5_2 XSN.X128.bp topn 3.56528e-14 cap_mim_2f0_m4m5_noshield
CXSN_CU5_3 XSN.X128.bp topn 3.56528e-14 cap_mim_2f0_m4m5_noshield
CXSN_CU5_4 XSN.X256.bp topn 3.56528e-14 cap_mim_2f0_m4m5_noshield
CXSN_CU5_5 XSN.X256.bp topn 3.56528e-14 cap_mim_2f0_m4m5_noshield
CXSN_CU5_6 XSN.X256.bp topn 3.56528e-14 cap_mim_2f0_m4m5_noshield
CXSN_CU5_7 XSN.X256.bp topn 3.56528e-14 cap_mim_2f0_m4m5_noshield
CXSN_CU5_8 XSN.X8.bp topn 3.56528e-14 cap_mim_2f0_m4m5_noshield
CXSN_CU5_9 XSN.X64.bp topn 3.56528e-14 cap_mim_2f0_m4m5_noshield
CXSN_CU5_10 XSN.X128.bp topn 3.56528e-14 cap_mim_2f0_m4m5_noshield
CXSN_CU5_11 XSN.X128.bp topn 3.56528e-14 cap_mim_2f0_m4m5_noshield
CXSN_CU5_12 XSN.X256.bp topn 3.56528e-14 cap_mim_2f0_m4m5_noshield
CXSN_CU5_13 XSN.X256.bp topn 3.56528e-14 cap_mim_2f0_m4m5_noshield
CXSN_CU5_14 XSN.X256.bp topn 3.56528e-14 cap_mim_2f0_m4m5_noshield
CXSN_CU5_15 XSN.X256.bp topn 3.56528e-14 cap_mim_2f0_m4m5_noshield
CXSN_CU6_0 XSN.X256.bp topn 3.56528e-14 cap_mim_2f0_m4m5_noshield
CXSN_CU6_1 XSN.X256.bp topn 3.56528e-14 cap_mim_2f0_m4m5_noshield
CXSN_CU6_2 XSN.X256.bp topn 3.56528e-14 cap_mim_2f0_m4m5_noshield
CXSN_CU6_3 XSN.X256.bp topn 3.56528e-14 cap_mim_2f0_m4m5_noshield
CXSN_CU6_4 XSN.X128.bp topn 3.56528e-14 cap_mim_2f0_m4m5_noshield
CXSN_CU6_5 XSN.X128.bp topn 3.56528e-14 cap_mim_2f0_m4m5_noshield
CXSN_CU6_6 XSN.X64.bp topn 3.56528e-14 cap_mim_2f0_m4m5_noshield
CXSN_CU6_7 XSN.X32.bp topn 3.56528e-14 cap_mim_2f0_m4m5_noshield
CXSN_CU6_8 XSN.X256.bp topn 3.56528e-14 cap_mim_2f0_m4m5_noshield
CXSN_CU6_9 XSN.X256.bp topn 3.56528e-14 cap_mim_2f0_m4m5_noshield
CXSN_CU6_10 XSN.X256.bp topn 3.56528e-14 cap_mim_2f0_m4m5_noshield
CXSN_CU6_11 XSN.X256.bp topn 3.56528e-14 cap_mim_2f0_m4m5_noshield
CXSN_CU6_12 XSN.X128.bp topn 3.56528e-14 cap_mim_2f0_m4m5_noshield
CXSN_CU6_13 XSN.X128.bp topn 3.56528e-14 cap_mim_2f0_m4m5_noshield
CXSN_CU6_14 XSN.X64.bp topn 3.56528e-14 cap_mim_2f0_m4m5_noshield
CXSN_CU6_15 XSN.X32.bp topn 3.56528e-14 cap_mim_2f0_m4m5_noshield
CXSN_CU7_0 XSN.X8.bp topn 3.56528e-14 cap_mim_2f0_m4m5_noshield
CXSN_CU7_1 XSN.X64.bp topn 3.56528e-14 cap_mim_2f0_m4m5_noshield
CXSN_CU7_2 XSN.X128.bp topn 3.56528e-14 cap_mim_2f0_m4m5_noshield
CXSN_CU7_3 XSN.X128.bp topn 3.56528e-14 cap_mim_2f0_m4m5_noshield
CXSN_CU7_4 XSN.X256.bp topn 3.56528e-14 cap_mim_2f0_m4m5_noshield
CXSN_CU7_5 XSN.X256.bp topn 3.56528e-14 cap_mim_2f0_m4m5_noshield
CXSN_CU7_6 XSN.X256.bp topn 3.56528e-14 cap_mim_2f0_m4m5_noshield
CXSN_CU7_7 XSN.X256.bp topn 3.56528e-14 cap_mim_2f0_m4m5_noshield
CXSN_CU7_8 XSN.X8.bp topn 3.56528e-14 cap_mim_2f0_m4m5_noshield
CXSN_CU7_9 XSN.X64.bp topn 3.56528e-14 cap_mim_2f0_m4m5_noshield
CXSN_CU7_10 XSN.X128.bp topn 3.56528e-14 cap_mim_2f0_m4m5_noshield
CXSN_CU7_11 XSN.X128.bp topn 3.56528e-14 cap_mim_2f0_m4m5_noshield
CXSN_CU7_12 XSN.X256.bp topn 3.56528e-14 cap_mim_2f0_m4m5_noshield
CXSN_CU7_13 XSN.X256.bp topn 3.56528e-14 cap_mim_2f0_m4m5_noshield
CXSN_CU7_14 XSN.X256.bp topn 3.56528e-14 cap_mim_2f0_m4m5_noshield
CXSN_CU7_15 XSN.X256.bp topn 3.56528e-14 cap_mim_2f0_m4m5_noshield
CXSN_CU8_0 XSN.X256.bp topn 3.56528e-14 cap_mim_2f0_m4m5_noshield
CXSN_CU8_1 XSN.X256.bp topn 3.56528e-14 cap_mim_2f0_m4m5_noshield
CXSN_CU8_2 XSN.X256.bp topn 3.56528e-14 cap_mim_2f0_m4m5_noshield
CXSN_CU8_3 XSN.X256.bp topn 3.56528e-14 cap_mim_2f0_m4m5_noshield
CXSN_CU8_4 XSN.X128.bp topn 3.56528e-14 cap_mim_2f0_m4m5_noshield
CXSN_CU8_5 XSN.X128.bp topn 3.56528e-14 cap_mim_2f0_m4m5_noshield
CXSN_CU8_6 XSN.X64.bp topn 3.56528e-14 cap_mim_2f0_m4m5_noshield
CXSN_CU8_7 XSN.X32.bp topn 3.56528e-14 cap_mim_2f0_m4m5_noshield
CXSN_CU8_8 XSN.X256.bp topn 3.56528e-14 cap_mim_2f0_m4m5_noshield
CXSN_CU8_9 XSN.X256.bp topn 3.56528e-14 cap_mim_2f0_m4m5_noshield
CXSN_CU8_10 XSN.X256.bp topn 3.56528e-14 cap_mim_2f0_m4m5_noshield
CXSN_CU8_11 XSN.X256.bp topn 3.56528e-14 cap_mim_2f0_m4m5_noshield
CXSN_CU8_12 XSN.X128.bp topn 3.56528e-14 cap_mim_2f0_m4m5_noshield
CXSN_CU8_13 XSN.X128.bp topn 3.56528e-14 cap_mim_2f0_m4m5_noshield
CXSN_CU8_14 XSN.X64.bp topn 3.56528e-14 cap_mim_2f0_m4m5_noshield
CXSN_CU8_15 XSN.X32.bp topn 3.56528e-14 cap_mim_2f0_m4m5_noshield
CXSN_CU9_0 XSN.X16.bp topn 3.56528e-14 cap_mim_2f0_m4m5_noshield
CXSN_CU9_1 XSN.X64.bp topn 3.56528e-14 cap_mim_2f0_m4m5_noshield
CXSN_CU9_2 XSN.X128.bp topn 3.56528e-14 cap_mim_2f0_m4m5_noshield
CXSN_CU9_3 XSN.X128.bp topn 3.56528e-14 cap_mim_2f0_m4m5_noshield
CXSN_CU9_4 XSN.X256.bp topn 3.56528e-14 cap_mim_2f0_m4m5_noshield
CXSN_CU9_5 XSN.X256.bp topn 3.56528e-14 cap_mim_2f0_m4m5_noshield
CXSN_CU9_6 XSN.X256.bp topn 3.56528e-14 cap_mim_2f0_m4m5_noshield
CXSN_CU9_7 XSN.X256.bp topn 3.56528e-14 cap_mim_2f0_m4m5_noshield
CXSN_CU9_8 XSN.X16.bp topn 3.56528e-14 cap_mim_2f0_m4m5_noshield
CXSN_CU9_9 XSN.X64.bp topn 3.56528e-14 cap_mim_2f0_m4m5_noshield
CXSN_CU9_10 XSN.X128.bp topn 3.56528e-14 cap_mim_2f0_m4m5_noshield
CXSN_CU9_11 XSN.X128.bp topn 3.56528e-14 cap_mim_2f0_m4m5_noshield
CXSN_CU9_12 XSN.X256.bp topn 3.56528e-14 cap_mim_2f0_m4m5_noshield
CXSN_CU9_13 XSN.X256.bp topn 3.56528e-14 cap_mim_2f0_m4m5_noshield
CXSN_CU9_14 XSN.X256.bp topn 3.56528e-14 cap_mim_2f0_m4m5_noshield
CXSN_CU9_15 XSN.X256.bp topn 3.56528e-14 cap_mim_2f0_m4m5_noshield
CXSN_CU10_0 XSN.X256.bp topn 3.56528e-14 cap_mim_2f0_m4m5_noshield
CXSN_CU10_1 XSN.X256.bp topn 3.56528e-14 cap_mim_2f0_m4m5_noshield
CXSN_CU10_2 XSN.X256.bp topn 3.56528e-14 cap_mim_2f0_m4m5_noshield
CXSN_CU10_3 XSN.X256.bp topn 3.56528e-14 cap_mim_2f0_m4m5_noshield
CXSN_CU10_4 XSN.X128.bp topn 3.56528e-14 cap_mim_2f0_m4m5_noshield
CXSN_CU10_5 XSN.X128.bp topn 3.56528e-14 cap_mim_2f0_m4m5_noshield
CXSN_CU10_6 XSN.X64.bp topn 3.56528e-14 cap_mim_2f0_m4m5_noshield
CXSN_CU10_7 XSN.X32.bp topn 3.56528e-14 cap_mim_2f0_m4m5_noshield
CXSN_CU10_8 XSN.X256.bp topn 3.56528e-14 cap_mim_2f0_m4m5_noshield
CXSN_CU10_9 XSN.X256.bp topn 3.56528e-14 cap_mim_2f0_m4m5_noshield
CXSN_CU10_10 XSN.X256.bp topn 3.56528e-14 cap_mim_2f0_m4m5_noshield
CXSN_CU10_11 XSN.X256.bp topn 3.56528e-14 cap_mim_2f0_m4m5_noshield
CXSN_CU10_12 XSN.X128.bp topn 3.56528e-14 cap_mim_2f0_m4m5_noshield
CXSN_CU10_13 XSN.X128.bp topn 3.56528e-14 cap_mim_2f0_m4m5_noshield
CXSN_CU10_14 XSN.X64.bp topn 3.56528e-14 cap_mim_2f0_m4m5_noshield
CXSN_CU10_15 XSN.X32.bp topn 3.56528e-14 cap_mim_2f0_m4m5_noshield
CXSN_CU11_0 XSN.X16.bp topn 3.56528e-14 cap_mim_2f0_m4m5_noshield
CXSN_CU11_1 XSN.X64.bp topn 3.56528e-14 cap_mim_2f0_m4m5_noshield
CXSN_CU11_2 XSN.X128.bp topn 3.56528e-14 cap_mim_2f0_m4m5_noshield
CXSN_CU11_3 XSN.X128.bp topn 3.56528e-14 cap_mim_2f0_m4m5_noshield
CXSN_CU11_4 XSN.X256.bp topn 3.56528e-14 cap_mim_2f0_m4m5_noshield
CXSN_CU11_5 XSN.X256.bp topn 3.56528e-14 cap_mim_2f0_m4m5_noshield
CXSN_CU11_6 XSN.X256.bp topn 3.56528e-14 cap_mim_2f0_m4m5_noshield
CXSN_CU11_7 XSN.X256.bp topn 3.56528e-14 cap_mim_2f0_m4m5_noshield
CXSN_CU11_8 XSN.X16.bp topn 3.56528e-14 cap_mim_2f0_m4m5_noshield
CXSN_CU11_9 XSN.X64.bp topn 3.56528e-14 cap_mim_2f0_m4m5_noshield
CXSN_CU11_10 XSN.X128.bp topn 3.56528e-14 cap_mim_2f0_m4m5_noshield
CXSN_CU11_11 XSN.X128.bp topn 3.56528e-14 cap_mim_2f0_m4m5_noshield
CXSN_CU11_12 XSN.X256.bp topn 3.56528e-14 cap_mim_2f0_m4m5_noshield
CXSN_CU11_13 XSN.X256.bp topn 3.56528e-14 cap_mim_2f0_m4m5_noshield
CXSN_CU11_14 XSN.X256.bp topn 3.56528e-14 cap_mim_2f0_m4m5_noshield
CXSN_CU11_15 XSN.X256.bp topn 3.56528e-14 cap_mim_2f0_m4m5_noshield
CXSN_CU12_0 XSN.X256.bp topn 3.56528e-14 cap_mim_2f0_m4m5_noshield
CXSN_CU12_1 XSN.X256.bp topn 3.56528e-14 cap_mim_2f0_m4m5_noshield
CXSN_CU12_2 XSN.X256.bp topn 3.56528e-14 cap_mim_2f0_m4m5_noshield
CXSN_CU12_3 XSN.X256.bp topn 3.56528e-14 cap_mim_2f0_m4m5_noshield
CXSN_CU12_4 XSN.X128.bp topn 3.56528e-14 cap_mim_2f0_m4m5_noshield
CXSN_CU12_5 XSN.X128.bp topn 3.56528e-14 cap_mim_2f0_m4m5_noshield
CXSN_CU12_6 XSN.X64.bp topn 3.56528e-14 cap_mim_2f0_m4m5_noshield
CXSN_CU12_7 XSN.X32.bp topn 3.56528e-14 cap_mim_2f0_m4m5_noshield
CXSN_CU12_8 XSN.X256.bp topn 3.56528e-14 cap_mim_2f0_m4m5_noshield
CXSN_CU12_9 XSN.X256.bp topn 3.56528e-14 cap_mim_2f0_m4m5_noshield
CXSN_CU12_10 XSN.X256.bp topn 3.56528e-14 cap_mim_2f0_m4m5_noshield
CXSN_CU12_11 XSN.X256.bp topn 3.56528e-14 cap_mim_2f0_m4m5_noshield
CXSN_CU12_12 XSN.X128.bp topn 3.56528e-14 cap_mim_2f0_m4m5_noshield
CXSN_CU12_13 XSN.X128.bp topn 3.56528e-14 cap_mim_2f0_m4m5_noshield
CXSN_CU12_14 XSN.X64.bp topn 3.56528e-14 cap_mim_2f0_m4m5_noshield
CXSN_CU12_15 XSN.X32.bp topn 3.56528e-14 cap_mim_2f0_m4m5_noshield
CXSN_CU13_0 XSN.X16.bp topn 3.56528e-14 cap_mim_2f0_m4m5_noshield
CXSN_CU13_1 XSN.X64.bp topn 3.56528e-14 cap_mim_2f0_m4m5_noshield
CXSN_CU13_2 XSN.X128.bp topn 3.56528e-14 cap_mim_2f0_m4m5_noshield
CXSN_CU13_3 XSN.X128.bp topn 3.56528e-14 cap_mim_2f0_m4m5_noshield
CXSN_CU13_4 XSN.X256.bp topn 3.56528e-14 cap_mim_2f0_m4m5_noshield
CXSN_CU13_5 XSN.X256.bp topn 3.56528e-14 cap_mim_2f0_m4m5_noshield
CXSN_CU13_6 XSN.X256.bp topn 3.56528e-14 cap_mim_2f0_m4m5_noshield
CXSN_CU13_7 XSN.X256.bp topn 3.56528e-14 cap_mim_2f0_m4m5_noshield
CXSN_CU13_8 XSN.X16.bp topn 3.56528e-14 cap_mim_2f0_m4m5_noshield
CXSN_CU13_9 XSN.X64.bp topn 3.56528e-14 cap_mim_2f0_m4m5_noshield
CXSN_CU13_10 XSN.X128.bp topn 3.56528e-14 cap_mim_2f0_m4m5_noshield
CXSN_CU13_11 XSN.X128.bp topn 3.56528e-14 cap_mim_2f0_m4m5_noshield
CXSN_CU13_12 XSN.X256.bp topn 3.56528e-14 cap_mim_2f0_m4m5_noshield
CXSN_CU13_13 XSN.X256.bp topn 3.56528e-14 cap_mim_2f0_m4m5_noshield
CXSN_CU13_14 XSN.X256.bp topn 3.56528e-14 cap_mim_2f0_m4m5_noshield
CXSN_CU13_15 XSN.X256.bp topn 3.56528e-14 cap_mim_2f0_m4m5_noshield
CXSN_CU14_0 XSN.X256.bp topn 3.56528e-14 cap_mim_2f0_m4m5_noshield
CXSN_CU14_1 XSN.X256.bp topn 3.56528e-14 cap_mim_2f0_m4m5_noshield
CXSN_CU14_2 XSN.X256.bp topn 3.56528e-14 cap_mim_2f0_m4m5_noshield
CXSN_CU14_3 XSN.X256.bp topn 3.56528e-14 cap_mim_2f0_m4m5_noshield
CXSN_CU14_4 XSN.X128.bp topn 3.56528e-14 cap_mim_2f0_m4m5_noshield
CXSN_CU14_5 XSN.X128.bp topn 3.56528e-14 cap_mim_2f0_m4m5_noshield
CXSN_CU14_6 XSN.X64.bp topn 3.56528e-14 cap_mim_2f0_m4m5_noshield
CXSN_CU14_7 XSN.X32.bp topn 3.56528e-14 cap_mim_2f0_m4m5_noshield
CXSN_CU14_8 XSN.X256.bp topn 3.56528e-14 cap_mim_2f0_m4m5_noshield
CXSN_CU14_9 XSN.X256.bp topn 3.56528e-14 cap_mim_2f0_m4m5_noshield
CXSN_CU14_10 XSN.X256.bp topn 3.56528e-14 cap_mim_2f0_m4m5_noshield
CXSN_CU14_11 XSN.X256.bp topn 3.56528e-14 cap_mim_2f0_m4m5_noshield
CXSN_CU14_12 XSN.X128.bp topn 3.56528e-14 cap_mim_2f0_m4m5_noshield
CXSN_CU14_13 XSN.X128.bp topn 3.56528e-14 cap_mim_2f0_m4m5_noshield
CXSN_CU14_14 XSN.X64.bp topn 3.56528e-14 cap_mim_2f0_m4m5_noshield
CXSN_CU14_15 XSN.X32.bp topn 3.56528e-14 cap_mim_2f0_m4m5_noshield
CXSN_CU15_0 XSN.X16.bp topn 3.56528e-14 cap_mim_2f0_m4m5_noshield
CXSN_CU15_1 XSN.X64.bp topn 3.56528e-14 cap_mim_2f0_m4m5_noshield
CXSN_CU15_2 XSN.X128.bp topn 3.56528e-14 cap_mim_2f0_m4m5_noshield
CXSN_CU15_3 XSN.X128.bp topn 3.56528e-14 cap_mim_2f0_m4m5_noshield
CXSN_CU15_4 XSN.X256.bp topn 3.56528e-14 cap_mim_2f0_m4m5_noshield
CXSN_CU15_5 XSN.X256.bp topn 3.56528e-14 cap_mim_2f0_m4m5_noshield
CXSN_CU15_6 XSN.X256.bp topn 3.56528e-14 cap_mim_2f0_m4m5_noshield
CXSN_CU15_7 XSN.X256.bp topn 3.56528e-14 cap_mim_2f0_m4m5_noshield
CXSN_CU15_8 XSN.X16.bp topn 3.56528e-14 cap_mim_2f0_m4m5_noshield
CXSN_CU15_9 XSN.X64.bp topn 3.56528e-14 cap_mim_2f0_m4m5_noshield
CXSN_CU15_10 XSN.X128.bp topn 3.56528e-14 cap_mim_2f0_m4m5_noshield
CXSN_CU15_11 XSN.X128.bp topn 3.56528e-14 cap_mim_2f0_m4m5_noshield
CXSN_CU15_12 XSN.X256.bp topn 3.56528e-14 cap_mim_2f0_m4m5_noshield
CXSN_CU15_13 XSN.X256.bp topn 3.56528e-14 cap_mim_2f0_m4m5_noshield
CXSN_CU15_14 XSN.X256.bp topn 3.56528e-14 cap_mim_2f0_m4m5_noshield
CXSN_CU15_15 XSN.X256.bp topn 3.56528e-14 cap_mim_2f0_m4m5_noshield
CXSN_CU16_0 XSN.X256.bp topn 3.56528e-14 cap_mim_2f0_m4m5_noshield
CXSN_CU16_1 XSN.X256.bp topn 3.56528e-14 cap_mim_2f0_m4m5_noshield
CXSN_CU16_2 XSN.X256.bp topn 3.56528e-14 cap_mim_2f0_m4m5_noshield
CXSN_CU16_3 XSN.X256.bp topn 3.56528e-14 cap_mim_2f0_m4m5_noshield
CXSN_CU16_4 XSN.X128.bp topn 3.56528e-14 cap_mim_2f0_m4m5_noshield
CXSN_CU16_5 XSN.X128.bp topn 3.56528e-14 cap_mim_2f0_m4m5_noshield
CXSN_CU16_6 XSN.X64.bp topn 3.56528e-14 cap_mim_2f0_m4m5_noshield
CXSN_CU16_7 XSN.X16.bp topn 3.56528e-14 cap_mim_2f0_m4m5_noshield
CXSN_CU16_8 XSN.X256.bp topn 3.56528e-14 cap_mim_2f0_m4m5_noshield
CXSN_CU16_9 XSN.X256.bp topn 3.56528e-14 cap_mim_2f0_m4m5_noshield
CXSN_CU16_10 XSN.X256.bp topn 3.56528e-14 cap_mim_2f0_m4m5_noshield
CXSN_CU16_11 XSN.X256.bp topn 3.56528e-14 cap_mim_2f0_m4m5_noshield
CXSN_CU16_12 XSN.X128.bp topn 3.56528e-14 cap_mim_2f0_m4m5_noshield
CXSN_CU16_13 XSN.X128.bp topn 3.56528e-14 cap_mim_2f0_m4m5_noshield
CXSN_CU16_14 XSN.X64.bp topn 3.56528e-14 cap_mim_2f0_m4m5_noshield
CXSN_CU16_15 XSN.X16.bp topn 3.56528e-14 cap_mim_2f0_m4m5_noshield
CXSN_CU17_0 XSN.X32.bp topn 3.56528e-14 cap_mim_2f0_m4m5_noshield
CXSN_CU17_1 XSN.X64.bp topn 3.56528e-14 cap_mim_2f0_m4m5_noshield
CXSN_CU17_2 XSN.X128.bp topn 3.56528e-14 cap_mim_2f0_m4m5_noshield
CXSN_CU17_3 XSN.X128.bp topn 3.56528e-14 cap_mim_2f0_m4m5_noshield
CXSN_CU17_4 XSN.X256.bp topn 3.56528e-14 cap_mim_2f0_m4m5_noshield
CXSN_CU17_5 XSN.X256.bp topn 3.56528e-14 cap_mim_2f0_m4m5_noshield
CXSN_CU17_6 XSN.X256.bp topn 3.56528e-14 cap_mim_2f0_m4m5_noshield
CXSN_CU17_7 XSN.X256.bp topn 3.56528e-14 cap_mim_2f0_m4m5_noshield
CXSN_CU17_8 XSN.X32.bp topn 3.56528e-14 cap_mim_2f0_m4m5_noshield
CXSN_CU17_9 XSN.X64.bp topn 3.56528e-14 cap_mim_2f0_m4m5_noshield
CXSN_CU17_10 XSN.X128.bp topn 3.56528e-14 cap_mim_2f0_m4m5_noshield
CXSN_CU17_11 XSN.X128.bp topn 3.56528e-14 cap_mim_2f0_m4m5_noshield
CXSN_CU17_12 XSN.X256.bp topn 3.56528e-14 cap_mim_2f0_m4m5_noshield
CXSN_CU17_13 XSN.X256.bp topn 3.56528e-14 cap_mim_2f0_m4m5_noshield
CXSN_CU17_14 XSN.X256.bp topn 3.56528e-14 cap_mim_2f0_m4m5_noshield
CXSN_CU17_15 XSN.X256.bp topn 3.56528e-14 cap_mim_2f0_m4m5_noshield
CXSN_CU18_0 XSN.X256.bp topn 3.56528e-14 cap_mim_2f0_m4m5_noshield
CXSN_CU18_1 XSN.X256.bp topn 3.56528e-14 cap_mim_2f0_m4m5_noshield
CXSN_CU18_2 XSN.X256.bp topn 3.56528e-14 cap_mim_2f0_m4m5_noshield
CXSN_CU18_3 XSN.X256.bp topn 3.56528e-14 cap_mim_2f0_m4m5_noshield
CXSN_CU18_4 XSN.X128.bp topn 3.56528e-14 cap_mim_2f0_m4m5_noshield
CXSN_CU18_5 XSN.X128.bp topn 3.56528e-14 cap_mim_2f0_m4m5_noshield
CXSN_CU18_6 XSN.X64.bp topn 3.56528e-14 cap_mim_2f0_m4m5_noshield
CXSN_CU18_7 XSN.X16.bp topn 3.56528e-14 cap_mim_2f0_m4m5_noshield
CXSN_CU18_8 XSN.X256.bp topn 3.56528e-14 cap_mim_2f0_m4m5_noshield
CXSN_CU18_9 XSN.X256.bp topn 3.56528e-14 cap_mim_2f0_m4m5_noshield
CXSN_CU18_10 XSN.X256.bp topn 3.56528e-14 cap_mim_2f0_m4m5_noshield
CXSN_CU18_11 XSN.X256.bp topn 3.56528e-14 cap_mim_2f0_m4m5_noshield
CXSN_CU18_12 XSN.X128.bp topn 3.56528e-14 cap_mim_2f0_m4m5_noshield
CXSN_CU18_13 XSN.X128.bp topn 3.56528e-14 cap_mim_2f0_m4m5_noshield
CXSN_CU18_14 XSN.X64.bp topn 3.56528e-14 cap_mim_2f0_m4m5_noshield
CXSN_CU18_15 XSN.X16.bp topn 3.56528e-14 cap_mim_2f0_m4m5_noshield
CXSN_CU19_0 XSN.X32.bp topn 3.56528e-14 cap_mim_2f0_m4m5_noshield
CXSN_CU19_1 XSN.X64.bp topn 3.56528e-14 cap_mim_2f0_m4m5_noshield
CXSN_CU19_2 XSN.X128.bp topn 3.56528e-14 cap_mim_2f0_m4m5_noshield
CXSN_CU19_3 XSN.X128.bp topn 3.56528e-14 cap_mim_2f0_m4m5_noshield
CXSN_CU19_4 XSN.X256.bp topn 3.56528e-14 cap_mim_2f0_m4m5_noshield
CXSN_CU19_5 XSN.X256.bp topn 3.56528e-14 cap_mim_2f0_m4m5_noshield
CXSN_CU19_6 XSN.X256.bp topn 3.56528e-14 cap_mim_2f0_m4m5_noshield
CXSN_CU19_7 XSN.X256.bp topn 3.56528e-14 cap_mim_2f0_m4m5_noshield
CXSN_CU19_8 XSN.X32.bp topn 3.56528e-14 cap_mim_2f0_m4m5_noshield
CXSN_CU19_9 XSN.X64.bp topn 3.56528e-14 cap_mim_2f0_m4m5_noshield
CXSN_CU19_10 XSN.X128.bp topn 3.56528e-14 cap_mim_2f0_m4m5_noshield
CXSN_CU19_11 XSN.X128.bp topn 3.56528e-14 cap_mim_2f0_m4m5_noshield
CXSN_CU19_12 XSN.X256.bp topn 3.56528e-14 cap_mim_2f0_m4m5_noshield
CXSN_CU19_13 XSN.X256.bp topn 3.56528e-14 cap_mim_2f0_m4m5_noshield
CXSN_CU19_14 XSN.X256.bp topn 3.56528e-14 cap_mim_2f0_m4m5_noshield
CXSN_CU19_15 XSN.X256.bp topn 3.56528e-14 cap_mim_2f0_m4m5_noshield
CXSN_CU20_0 XSN.X256.bp topn 3.56528e-14 cap_mim_2f0_m4m5_noshield
CXSN_CU20_1 XSN.X256.bp topn 3.56528e-14 cap_mim_2f0_m4m5_noshield
CXSN_CU20_2 XSN.X256.bp topn 3.56528e-14 cap_mim_2f0_m4m5_noshield
CXSN_CU20_3 XSN.X256.bp topn 3.56528e-14 cap_mim_2f0_m4m5_noshield
CXSN_CU20_4 XSN.X128.bp topn 3.56528e-14 cap_mim_2f0_m4m5_noshield
CXSN_CU20_5 XSN.X128.bp topn 3.56528e-14 cap_mim_2f0_m4m5_noshield
CXSN_CU20_6 XSN.X64.bp topn 3.56528e-14 cap_mim_2f0_m4m5_noshield
CXSN_CU20_7 XSN.X16.bp topn 3.56528e-14 cap_mim_2f0_m4m5_noshield
CXSN_CU20_8 XSN.X256.bp topn 3.56528e-14 cap_mim_2f0_m4m5_noshield
CXSN_CU20_9 XSN.X256.bp topn 3.56528e-14 cap_mim_2f0_m4m5_noshield
CXSN_CU20_10 XSN.X256.bp topn 3.56528e-14 cap_mim_2f0_m4m5_noshield
CXSN_CU20_11 XSN.X256.bp topn 3.56528e-14 cap_mim_2f0_m4m5_noshield
CXSN_CU20_12 XSN.X128.bp topn 3.56528e-14 cap_mim_2f0_m4m5_noshield
CXSN_CU20_13 XSN.X128.bp topn 3.56528e-14 cap_mim_2f0_m4m5_noshield
CXSN_CU20_14 XSN.X64.bp topn 3.56528e-14 cap_mim_2f0_m4m5_noshield
CXSN_CU20_15 XSN.X16.bp topn 3.56528e-14 cap_mim_2f0_m4m5_noshield
CXSN_CU21_0 XSN.X32.bp topn 3.56528e-14 cap_mim_2f0_m4m5_noshield
CXSN_CU21_1 XSN.X64.bp topn 3.56528e-14 cap_mim_2f0_m4m5_noshield
CXSN_CU21_2 XSN.X128.bp topn 3.56528e-14 cap_mim_2f0_m4m5_noshield
CXSN_CU21_3 XSN.X128.bp topn 3.56528e-14 cap_mim_2f0_m4m5_noshield
CXSN_CU21_4 XSN.X256.bp topn 3.56528e-14 cap_mim_2f0_m4m5_noshield
CXSN_CU21_5 XSN.X256.bp topn 3.56528e-14 cap_mim_2f0_m4m5_noshield
CXSN_CU21_6 XSN.X256.bp topn 3.56528e-14 cap_mim_2f0_m4m5_noshield
CXSN_CU21_7 XSN.X256.bp topn 3.56528e-14 cap_mim_2f0_m4m5_noshield
CXSN_CU21_8 XSN.X32.bp topn 3.56528e-14 cap_mim_2f0_m4m5_noshield
CXSN_CU21_9 XSN.X64.bp topn 3.56528e-14 cap_mim_2f0_m4m5_noshield
CXSN_CU21_10 XSN.X128.bp topn 3.56528e-14 cap_mim_2f0_m4m5_noshield
CXSN_CU21_11 XSN.X128.bp topn 3.56528e-14 cap_mim_2f0_m4m5_noshield
CXSN_CU21_12 XSN.X256.bp topn 3.56528e-14 cap_mim_2f0_m4m5_noshield
CXSN_CU21_13 XSN.X256.bp topn 3.56528e-14 cap_mim_2f0_m4m5_noshield
CXSN_CU21_14 XSN.X256.bp topn 3.56528e-14 cap_mim_2f0_m4m5_noshield
CXSN_CU21_15 XSN.X256.bp topn 3.56528e-14 cap_mim_2f0_m4m5_noshield
CXSN_CU22_0 XSN.X256.bp topn 3.56528e-14 cap_mim_2f0_m4m5_noshield
CXSN_CU22_1 XSN.X256.bp topn 3.56528e-14 cap_mim_2f0_m4m5_noshield
CXSN_CU22_2 XSN.X256.bp topn 3.56528e-14 cap_mim_2f0_m4m5_noshield
CXSN_CU22_3 XSN.X256.bp topn 3.56528e-14 cap_mim_2f0_m4m5_noshield
CXSN_CU22_4 XSN.X128.bp topn 3.56528e-14 cap_mim_2f0_m4m5_noshield
CXSN_CU22_5 XSN.X128.bp topn 3.56528e-14 cap_mim_2f0_m4m5_noshield
CXSN_CU22_6 XSN.X64.bp topn 3.56528e-14 cap_mim_2f0_m4m5_noshield
CXSN_CU22_7 XSN.X16.bp topn 3.56528e-14 cap_mim_2f0_m4m5_noshield
CXSN_CU22_8 XSN.X256.bp topn 3.56528e-14 cap_mim_2f0_m4m5_noshield
CXSN_CU22_9 XSN.X256.bp topn 3.56528e-14 cap_mim_2f0_m4m5_noshield
CXSN_CU22_10 XSN.X256.bp topn 3.56528e-14 cap_mim_2f0_m4m5_noshield
CXSN_CU22_11 XSN.X256.bp topn 3.56528e-14 cap_mim_2f0_m4m5_noshield
CXSN_CU22_12 XSN.X128.bp topn 3.56528e-14 cap_mim_2f0_m4m5_noshield
CXSN_CU22_13 XSN.X128.bp topn 3.56528e-14 cap_mim_2f0_m4m5_noshield
CXSN_CU22_14 XSN.X64.bp topn 3.56528e-14 cap_mim_2f0_m4m5_noshield
CXSN_CU22_15 XSN.X16.bp topn 3.56528e-14 cap_mim_2f0_m4m5_noshield
CXSN_CU23_0 XSN.X32.bp topn 3.56528e-14 cap_mim_2f0_m4m5_noshield
CXSN_CU23_1 XSN.X64.bp topn 3.56528e-14 cap_mim_2f0_m4m5_noshield
CXSN_CU23_2 XSN.X128.bp topn 3.56528e-14 cap_mim_2f0_m4m5_noshield
CXSN_CU23_3 XSN.X128.bp topn 3.56528e-14 cap_mim_2f0_m4m5_noshield
CXSN_CU23_4 XSN.X256.bp topn 3.56528e-14 cap_mim_2f0_m4m5_noshield
CXSN_CU23_5 XSN.X256.bp topn 3.56528e-14 cap_mim_2f0_m4m5_noshield
CXSN_CU23_6 XSN.X256.bp topn 3.56528e-14 cap_mim_2f0_m4m5_noshield
CXSN_CU23_7 XSN.X256.bp topn 3.56528e-14 cap_mim_2f0_m4m5_noshield
CXSN_CU23_8 XSN.X32.bp topn 3.56528e-14 cap_mim_2f0_m4m5_noshield
CXSN_CU23_9 XSN.X64.bp topn 3.56528e-14 cap_mim_2f0_m4m5_noshield
CXSN_CU23_10 XSN.X128.bp topn 3.56528e-14 cap_mim_2f0_m4m5_noshield
CXSN_CU23_11 XSN.X128.bp topn 3.56528e-14 cap_mim_2f0_m4m5_noshield
CXSN_CU23_12 XSN.X256.bp topn 3.56528e-14 cap_mim_2f0_m4m5_noshield
CXSN_CU23_13 XSN.X256.bp topn 3.56528e-14 cap_mim_2f0_m4m5_noshield
CXSN_CU23_14 XSN.X256.bp topn 3.56528e-14 cap_mim_2f0_m4m5_noshield
CXSN_CU23_15 XSN.X256.bp topn 3.56528e-14 cap_mim_2f0_m4m5_noshield
CXSN_CU24_0 XSN.X256.bp topn 3.56528e-14 cap_mim_2f0_m4m5_noshield
CXSN_CU24_1 XSN.X256.bp topn 3.56528e-14 cap_mim_2f0_m4m5_noshield
CXSN_CU24_2 XSN.X256.bp topn 3.56528e-14 cap_mim_2f0_m4m5_noshield
CXSN_CU24_3 XSN.X256.bp topn 3.56528e-14 cap_mim_2f0_m4m5_noshield
CXSN_CU24_4 XSN.X128.bp topn 3.56528e-14 cap_mim_2f0_m4m5_noshield
CXSN_CU24_5 XSN.X128.bp topn 3.56528e-14 cap_mim_2f0_m4m5_noshield
CXSN_CU24_6 XSN.X64.bp topn 3.56528e-14 cap_mim_2f0_m4m5_noshield
CXSN_CU24_7 XSN.X8.bp topn 3.56528e-14 cap_mim_2f0_m4m5_noshield
CXSN_CU24_8 XSN.X256.bp topn 3.56528e-14 cap_mim_2f0_m4m5_noshield
CXSN_CU24_9 XSN.X256.bp topn 3.56528e-14 cap_mim_2f0_m4m5_noshield
CXSN_CU24_10 XSN.X256.bp topn 3.56528e-14 cap_mim_2f0_m4m5_noshield
CXSN_CU24_11 XSN.X256.bp topn 3.56528e-14 cap_mim_2f0_m4m5_noshield
CXSN_CU24_12 XSN.X128.bp topn 3.56528e-14 cap_mim_2f0_m4m5_noshield
CXSN_CU24_13 XSN.X128.bp topn 3.56528e-14 cap_mim_2f0_m4m5_noshield
CXSN_CU24_14 XSN.X64.bp topn 3.56528e-14 cap_mim_2f0_m4m5_noshield
CXSN_CU24_15 XSN.X8.bp topn 3.56528e-14 cap_mim_2f0_m4m5_noshield
CXSN_CU25_0 XSN.X32.bp topn 3.56528e-14 cap_mim_2f0_m4m5_noshield
CXSN_CU25_1 XSN.X64.bp topn 3.56528e-14 cap_mim_2f0_m4m5_noshield
CXSN_CU25_2 XSN.X128.bp topn 3.56528e-14 cap_mim_2f0_m4m5_noshield
CXSN_CU25_3 XSN.X128.bp topn 3.56528e-14 cap_mim_2f0_m4m5_noshield
CXSN_CU25_4 XSN.X256.bp topn 3.56528e-14 cap_mim_2f0_m4m5_noshield
CXSN_CU25_5 XSN.X256.bp topn 3.56528e-14 cap_mim_2f0_m4m5_noshield
CXSN_CU25_6 XSN.X256.bp topn 3.56528e-14 cap_mim_2f0_m4m5_noshield
CXSN_CU25_7 XSN.X256.bp topn 3.56528e-14 cap_mim_2f0_m4m5_noshield
CXSN_CU25_8 XSN.X32.bp topn 3.56528e-14 cap_mim_2f0_m4m5_noshield
CXSN_CU25_9 XSN.X64.bp topn 3.56528e-14 cap_mim_2f0_m4m5_noshield
CXSN_CU25_10 XSN.X128.bp topn 3.56528e-14 cap_mim_2f0_m4m5_noshield
CXSN_CU25_11 XSN.X128.bp topn 3.56528e-14 cap_mim_2f0_m4m5_noshield
CXSN_CU25_12 XSN.X256.bp topn 3.56528e-14 cap_mim_2f0_m4m5_noshield
CXSN_CU25_13 XSN.X256.bp topn 3.56528e-14 cap_mim_2f0_m4m5_noshield
CXSN_CU25_14 XSN.X256.bp topn 3.56528e-14 cap_mim_2f0_m4m5_noshield
CXSN_CU25_15 XSN.X256.bp topn 3.56528e-14 cap_mim_2f0_m4m5_noshield
CXSN_CU26_0 XSN.X256.bp topn 3.56528e-14 cap_mim_2f0_m4m5_noshield
CXSN_CU26_1 XSN.X256.bp topn 3.56528e-14 cap_mim_2f0_m4m5_noshield
CXSN_CU26_2 XSN.X256.bp topn 3.56528e-14 cap_mim_2f0_m4m5_noshield
CXSN_CU26_3 XSN.X256.bp topn 3.56528e-14 cap_mim_2f0_m4m5_noshield
CXSN_CU26_4 XSN.X128.bp topn 3.56528e-14 cap_mim_2f0_m4m5_noshield
CXSN_CU26_5 XSN.X128.bp topn 3.56528e-14 cap_mim_2f0_m4m5_noshield
CXSN_CU26_6 XSN.X64.bp topn 3.56528e-14 cap_mim_2f0_m4m5_noshield
CXSN_CU26_7 XSN.X8.bp topn 3.56528e-14 cap_mim_2f0_m4m5_noshield
CXSN_CU26_8 XSN.X256.bp topn 3.56528e-14 cap_mim_2f0_m4m5_noshield
CXSN_CU26_9 XSN.X256.bp topn 3.56528e-14 cap_mim_2f0_m4m5_noshield
CXSN_CU26_10 XSN.X256.bp topn 3.56528e-14 cap_mim_2f0_m4m5_noshield
CXSN_CU26_11 XSN.X256.bp topn 3.56528e-14 cap_mim_2f0_m4m5_noshield
CXSN_CU26_12 XSN.X128.bp topn 3.56528e-14 cap_mim_2f0_m4m5_noshield
CXSN_CU26_13 XSN.X128.bp topn 3.56528e-14 cap_mim_2f0_m4m5_noshield
CXSN_CU26_14 XSN.X64.bp topn 3.56528e-14 cap_mim_2f0_m4m5_noshield
CXSN_CU26_15 XSN.X8.bp topn 3.56528e-14 cap_mim_2f0_m4m5_noshield
CXSN_CU27_0 XSN.X32.bp topn 3.56528e-14 cap_mim_2f0_m4m5_noshield
CXSN_CU27_1 XSN.X64.bp topn 3.56528e-14 cap_mim_2f0_m4m5_noshield
CXSN_CU27_2 XSN.X128.bp topn 3.56528e-14 cap_mim_2f0_m4m5_noshield
CXSN_CU27_3 XSN.X128.bp topn 3.56528e-14 cap_mim_2f0_m4m5_noshield
CXSN_CU27_4 XSN.X256.bp topn 3.56528e-14 cap_mim_2f0_m4m5_noshield
CXSN_CU27_5 XSN.X256.bp topn 3.56528e-14 cap_mim_2f0_m4m5_noshield
CXSN_CU27_6 XSN.X256.bp topn 3.56528e-14 cap_mim_2f0_m4m5_noshield
CXSN_CU27_7 XSN.X256.bp topn 3.56528e-14 cap_mim_2f0_m4m5_noshield
CXSN_CU27_8 XSN.X32.bp topn 3.56528e-14 cap_mim_2f0_m4m5_noshield
CXSN_CU27_9 XSN.X64.bp topn 3.56528e-14 cap_mim_2f0_m4m5_noshield
CXSN_CU27_10 XSN.X128.bp topn 3.56528e-14 cap_mim_2f0_m4m5_noshield
CXSN_CU27_11 XSN.X128.bp topn 3.56528e-14 cap_mim_2f0_m4m5_noshield
CXSN_CU27_12 XSN.X256.bp topn 3.56528e-14 cap_mim_2f0_m4m5_noshield
CXSN_CU27_13 XSN.X256.bp topn 3.56528e-14 cap_mim_2f0_m4m5_noshield
CXSN_CU27_14 XSN.X256.bp topn 3.56528e-14 cap_mim_2f0_m4m5_noshield
CXSN_CU27_15 XSN.X256.bp topn 3.56528e-14 cap_mim_2f0_m4m5_noshield
CXSN_CU28_0 XSN.X256.bp topn 3.56528e-14 cap_mim_2f0_m4m5_noshield
CXSN_CU28_1 XSN.X256.bp topn 3.56528e-14 cap_mim_2f0_m4m5_noshield
CXSN_CU28_2 XSN.X256.bp topn 3.56528e-14 cap_mim_2f0_m4m5_noshield
CXSN_CU28_3 XSN.X256.bp topn 3.56528e-14 cap_mim_2f0_m4m5_noshield
CXSN_CU28_4 XSN.X128.bp topn 3.56528e-14 cap_mim_2f0_m4m5_noshield
CXSN_CU28_5 XSN.X128.bp topn 3.56528e-14 cap_mim_2f0_m4m5_noshield
CXSN_CU28_6 XSN.X64.bp topn 3.56528e-14 cap_mim_2f0_m4m5_noshield
CXSN_CU28_7 XSN.X4.bp topn 3.56528e-14 cap_mim_2f0_m4m5_noshield
CXSN_CU28_8 XSN.X256.bp topn 3.56528e-14 cap_mim_2f0_m4m5_noshield
CXSN_CU28_9 XSN.X256.bp topn 3.56528e-14 cap_mim_2f0_m4m5_noshield
CXSN_CU28_10 XSN.X256.bp topn 3.56528e-14 cap_mim_2f0_m4m5_noshield
CXSN_CU28_11 XSN.X256.bp topn 3.56528e-14 cap_mim_2f0_m4m5_noshield
CXSN_CU28_12 XSN.X128.bp topn 3.56528e-14 cap_mim_2f0_m4m5_noshield
CXSN_CU28_13 XSN.X128.bp topn 3.56528e-14 cap_mim_2f0_m4m5_noshield
CXSN_CU28_14 XSN.X64.bp topn 3.56528e-14 cap_mim_2f0_m4m5_noshield
CXSN_CU28_15 XSN.X4.bp topn 3.56528e-14 cap_mim_2f0_m4m5_noshield
CXSN_CU29_0 XSN.X32.bp topn 3.56528e-14 cap_mim_2f0_m4m5_noshield
CXSN_CU29_1 XSN.X64.bp topn 3.56528e-14 cap_mim_2f0_m4m5_noshield
CXSN_CU29_2 XSN.X128.bp topn 3.56528e-14 cap_mim_2f0_m4m5_noshield
CXSN_CU29_3 XSN.X128.bp topn 3.56528e-14 cap_mim_2f0_m4m5_noshield
CXSN_CU29_4 XSN.X256.bp topn 3.56528e-14 cap_mim_2f0_m4m5_noshield
CXSN_CU29_5 XSN.X256.bp topn 3.56528e-14 cap_mim_2f0_m4m5_noshield
CXSN_CU29_6 XSN.X256.bp topn 3.56528e-14 cap_mim_2f0_m4m5_noshield
CXSN_CU29_7 XSN.X256.bp topn 3.56528e-14 cap_mim_2f0_m4m5_noshield
CXSN_CU29_8 XSN.X32.bp topn 3.56528e-14 cap_mim_2f0_m4m5_noshield
CXSN_CU29_9 XSN.X64.bp topn 3.56528e-14 cap_mim_2f0_m4m5_noshield
CXSN_CU29_10 XSN.X128.bp topn 3.56528e-14 cap_mim_2f0_m4m5_noshield
CXSN_CU29_11 XSN.X128.bp topn 3.56528e-14 cap_mim_2f0_m4m5_noshield
CXSN_CU29_12 XSN.X256.bp topn 3.56528e-14 cap_mim_2f0_m4m5_noshield
CXSN_CU29_13 XSN.X256.bp topn 3.56528e-14 cap_mim_2f0_m4m5_noshield
CXSN_CU29_14 XSN.X256.bp topn 3.56528e-14 cap_mim_2f0_m4m5_noshield
CXSN_CU29_15 XSN.X256.bp topn 3.56528e-14 cap_mim_2f0_m4m5_noshield
CXSN_CU30_0 XSN.X256.bp topn 3.56528e-14 cap_mim_2f0_m4m5_noshield
CXSN_CU30_1 XSN.X256.bp topn 3.56528e-14 cap_mim_2f0_m4m5_noshield
CXSN_CU30_2 XSN.X256.bp topn 3.56528e-14 cap_mim_2f0_m4m5_noshield
CXSN_CU30_3 XSN.X256.bp topn 3.56528e-14 cap_mim_2f0_m4m5_noshield
CXSN_CU30_4 XSN.X128.bp topn 3.56528e-14 cap_mim_2f0_m4m5_noshield
CXSN_CU30_5 XSN.X128.bp topn 3.56528e-14 cap_mim_2f0_m4m5_noshield
CXSN_CU30_6 XSN.X64.bp topn 3.56528e-14 cap_mim_2f0_m4m5_noshield
CXSN_CU30_7 XSN.X1.bp topn 3.56528e-14 cap_mim_2f0_m4m5_noshield
CXSN_CU30_8 XSN.X256.bp topn 3.56528e-14 cap_mim_2f0_m4m5_noshield
CXSN_CU30_9 XSN.X256.bp topn 3.56528e-14 cap_mim_2f0_m4m5_noshield
CXSN_CU30_10 XSN.X256.bp topn 3.56528e-14 cap_mim_2f0_m4m5_noshield
CXSN_CU30_11 XSN.X256.bp topn 3.56528e-14 cap_mim_2f0_m4m5_noshield
CXSN_CU30_12 XSN.X128.bp topn 3.56528e-14 cap_mim_2f0_m4m5_noshield
CXSN_CU30_13 XSN.X128.bp topn 3.56528e-14 cap_mim_2f0_m4m5_noshield
CXSN_CU30_14 XSN.X64.bp topn 3.56528e-14 cap_mim_2f0_m4m5_noshield
CXSN_CU30_15 XSN.X2.bp topn 3.56528e-14 cap_mim_2f0_m4m5_noshield
CXSN_CU31_0 XSN.X32.bp topn 3.56528e-14 cap_mim_2f0_m4m5_noshield
CXSN_CU31_1 XSN.X64.bp topn 3.56528e-14 cap_mim_2f0_m4m5_noshield
CXSN_CU31_2 XSN.X128.bp topn 3.56528e-14 cap_mim_2f0_m4m5_noshield
CXSN_CU31_3 XSN.X128.bp topn 3.56528e-14 cap_mim_2f0_m4m5_noshield
CXSN_CU31_4 XSN.X256.bp topn 3.56528e-14 cap_mim_2f0_m4m5_noshield
CXSN_CU31_5 XSN.X256.bp topn 3.56528e-14 cap_mim_2f0_m4m5_noshield
CXSN_CU31_6 XSN.X256.bp topn 3.56528e-14 cap_mim_2f0_m4m5_noshield
CXSN_CU31_7 XSN.X256.bp topn 3.56528e-14 cap_mim_2f0_m4m5_noshield
CXSN_CU31_8 XSN.X32.bp topn 3.56528e-14 cap_mim_2f0_m4m5_noshield
CXSN_CU31_9 XSN.X64.bp topn 3.56528e-14 cap_mim_2f0_m4m5_noshield
CXSN_CU31_10 XSN.X128.bp topn 3.56528e-14 cap_mim_2f0_m4m5_noshield
CXSN_CU31_11 XSN.X128.bp topn 3.56528e-14 cap_mim_2f0_m4m5_noshield
CXSN_CU31_12 XSN.X256.bp topn 3.56528e-14 cap_mim_2f0_m4m5_noshield
CXSN_CU31_13 XSN.X256.bp topn 3.56528e-14 cap_mim_2f0_m4m5_noshield
CXSN_CU31_14 XSN.X256.bp topn 3.56528e-14 cap_mim_2f0_m4m5_noshield
CXSN_CU31_15 XSN.X256.bp topn 3.56528e-14 cap_mim_2f0_m4m5_noshield
.ENDS ADC_BLOCK
