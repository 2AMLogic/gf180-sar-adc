* extracted by klt extract --deck gf180mcu

* cell LVS_UNIT
* pin D
* pin G
* pin S
* pin vsubs
.SUBCKT LVS_UNIT D G S vsubs
* device instance $1 r0 *1 1.54,0.6 nfet
M$1 D G S vsubs nfet L=0.28U W=1.2U AS=1.68P AD=1.584P PS=5.2U PD=5.04U
.ENDS LVS_UNIT
