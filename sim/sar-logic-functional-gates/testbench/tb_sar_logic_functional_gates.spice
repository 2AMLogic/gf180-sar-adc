* ==================================================================
* tb_sar_logic_functional -- exhaustive functional verification of
* the synchronous SAR controller (issue #11).
*
* GENERATED by design/sar-logic/flow/gen_sar_ctrl_gates_tb.py -- do not edit.
*
* Two independent closed loops run in the same deck: `se` in
* single-ended mode and `df` in differential mode (DR-0011's two
* input modes, which switch a DIFFERENT NUMBER OF SIDES per trial and
* therefore need separate coverage, not one run with a flag flipped).
*
* Each loop converts 64 times. The input ramps by exactly one
* LSB of its own mode per conversion, offset half an LSB so every
* sample lands mid-code, so the run exercises every one of the 1024
* output codes exactly once -- i.e. every possible bit-trial decision
* sequence, since a plain-binary SAR with no redundancy (DR-0009) has
* exactly one decision sequence per code.
*
* All 1024 conversions are checked with two scalars per mode, not
* 1024 assertions: an error signal (converted code minus the
* closed-form ideal code of the held sample) is evaluated during every
* SETTLED drdy window -- drdy high AND at least one settling guard past
* its own rise, so the comparison never reads the output register
* mid-update (DR-0031 part 2b, issue #327) -- and its MAX and MIN over
* the whole run are measured. A single wrong conversion anywhere moves
* one of them by >= 1 LSB.
*
* DR-0014 (bottom-plate sampling) changes three things in this deck
* and they are stated here rather than left to be inferred from the
* netlist: (1) the behavioural top plate is now
* 2*V_cm - V_sampled + DAC, i.e. the sampled input enters INVERTED,
* (2) the ideal sample-and-hold is clocked by the TOP-PLATE switch
* control `samp_tp_n`, which is the sampling instant, not by the
* bottom-plate control that falls one clock later, and (3) the
* one-hot invariant is over FOUR legs per cell. The two-phase sample
* itself is measured as `iso_gap_ns` in tb.json, from the `_iso` duty-
* cycle node below: the behavioural loop cannot catch an ordering bug
* on its own, because its sample-and-hold is clocked by the top-plate
* control by construction, so the ordering is asserted on the
* controller's own two output controls instead. The TIGHT bound on
* that number is sim/sar-logic-timing/'s, not this deck's -- see the
* note on the `_iso` node for why a 20 ns maximum timestep cannot
* carry a sub-nanosecond timing claim.
* ==================================================================

* V_REF is ratiometric to the supply here: the ratified spec (README
* note [c]) makes V_REF <= V_DD a hard condition, so a fixed 3.3 V
* reference is not legal at the 2.97 V corner. Taking V_REF = V_DD
* keeps the deck legal at every point of the supply axis; the code
* check is ratiometric too, so it is unaffected.
.param vref={vdd_val}
.param vcm={vdd_val/2}
.param vth={vdd_val/2}
.param lsbse={vdd_val/1024}
.param lsbdf={vdd_val/512}
.model sarl_sw sw(vt={vdd_val/2} vh=0 ron=1 roff=1e12)

vclk clk 0 pulse(0 {vdd_val} 0 100p 100p 31.25n 62.5n)

* ---- loop se ----
vsestart se_start 0 pwl(0 {vdd_val} 125n {vdd_val} 125.1n 0)
vsemode se_mode 0 dc 0
xse clk se_start se_mode se_cmpo se_samp_tp_n se_sel_in_n se_drdy se_c9
+ se_c8 se_c7 se_c6 se_c5 se_c4 se_c3 se_c2 se_c1 se_c0 se_rel_n_256p
+ se_sel_hi_n_256p se_sel_lo_n_256p se_rel_n_128p se_sel_hi_n_128p
+ se_sel_lo_n_128p se_rel_n_64p se_sel_hi_n_64p se_sel_lo_n_64p
+ se_rel_n_32p se_sel_hi_n_32p se_sel_lo_n_32p se_rel_n_16p
+ se_sel_hi_n_16p se_sel_lo_n_16p se_rel_n_8p se_sel_hi_n_8p
+ se_sel_lo_n_8p se_rel_n_4p se_sel_hi_n_4p se_sel_lo_n_4p se_rel_n_2p
+ se_sel_hi_n_2p se_sel_lo_n_2p se_rel_n_1p se_sel_hi_n_1p se_sel_lo_n_1p
+ se_rel_n_256n se_sel_hi_n_256n se_sel_lo_n_256n se_rel_n_128n
+ se_sel_hi_n_128n se_sel_lo_n_128n se_rel_n_64n se_sel_hi_n_64n
+ se_sel_lo_n_64n se_rel_n_32n se_sel_hi_n_32n se_sel_lo_n_32n
+ se_rel_n_16n se_sel_hi_n_16n se_sel_lo_n_16n se_rel_n_8n se_sel_hi_n_8n
+ se_sel_lo_n_8n se_rel_n_4n se_sel_hi_n_4n se_sel_lo_n_4n se_rel_n_2n
+ se_sel_hi_n_2n se_sel_lo_n_2n se_rel_n_1n se_sel_hi_n_1n se_sel_lo_n_1n
+ sar_ctrl_a
ssep se_vinp se_shp se_samp_tp_n 0 sarl_sw
ssen se_vinn se_shn se_samp_tp_n 0 sarl_sw
csep se_shp 0 1p
csen se_shn 0 1p
rsesd se_samp_tp_n se_sampd 10k
csesd se_sampd 0 1p
ssexp se_vinp se_shxp se_sampd 0 sarl_sw
ssexn se_vinn se_shxn se_sampd 0 sarl_sw
csexp se_shxp 0 1p
csexn se_shxn 0 1p
bsetopp se_topip 0 V = 2*vcm-v(se_shp)+(1.0/512)*(
+ 256*((v(se_rel_n_256p)*vcm+v(se_sel_hi_n_256p)*vref+v(se_sel_in_n)*v(se_vinp))/vdd_val-vcm) + 128*((v(se_rel_n_128p)*vcm+v(se_sel_hi_n_128p)*vref+v(se_sel_in_n)*v(se_vinp))/vdd_val-vcm) + 64*((v(se_rel_n_64p)*vcm+v(se_sel_hi_n_64p)*vref+v(se_sel_in_n)*v(se_vinp))/vdd_val-vcm) + 32*((v(se_rel_n_32p)*vcm+v(se_sel_hi_n_32p)*vref+v(se_sel_in_n)*v(se_vinp))/vdd_val-vcm) + 16*((v(se_rel_n_16p)*vcm+v(se_sel_hi_n_16p)*vref+v(se_sel_in_n)*v(se_vinp))/vdd_val-vcm) + 8*((v(se_rel_n_8p)*vcm+v(se_sel_hi_n_8p)*vref+v(se_sel_in_n)*v(se_vinp))/vdd_val-vcm) + 4*((v(se_rel_n_4p)*vcm+v(se_sel_hi_n_4p)*vref+v(se_sel_in_n)*v(se_vinp))/vdd_val-vcm) + 2*((v(se_rel_n_2p)*vcm+v(se_sel_hi_n_2p)*vref+v(se_sel_in_n)*v(se_vinp))/vdd_val-vcm) + 1*((v(se_rel_n_1p)*vcm+v(se_sel_hi_n_1p)*vref+v(se_sel_in_n)*v(se_vinp))/vdd_val-vcm) )
bsetopn se_topin 0 V = 2*vcm-v(se_shn)+(1.0/512)*(
+ 256*((v(se_rel_n_256n)*vcm+v(se_sel_hi_n_256n)*vref+v(se_sel_in_n)*v(se_vinn))/vdd_val-vcm) + 128*((v(se_rel_n_128n)*vcm+v(se_sel_hi_n_128n)*vref+v(se_sel_in_n)*v(se_vinn))/vdd_val-vcm) + 64*((v(se_rel_n_64n)*vcm+v(se_sel_hi_n_64n)*vref+v(se_sel_in_n)*v(se_vinn))/vdd_val-vcm) + 32*((v(se_rel_n_32n)*vcm+v(se_sel_hi_n_32n)*vref+v(se_sel_in_n)*v(se_vinn))/vdd_val-vcm) + 16*((v(se_rel_n_16n)*vcm+v(se_sel_hi_n_16n)*vref+v(se_sel_in_n)*v(se_vinn))/vdd_val-vcm) + 8*((v(se_rel_n_8n)*vcm+v(se_sel_hi_n_8n)*vref+v(se_sel_in_n)*v(se_vinn))/vdd_val-vcm) + 4*((v(se_rel_n_4n)*vcm+v(se_sel_hi_n_4n)*vref+v(se_sel_in_n)*v(se_vinn))/vdd_val-vcm) + 2*((v(se_rel_n_2n)*vcm+v(se_sel_hi_n_2n)*vref+v(se_sel_in_n)*v(se_vinn))/vdd_val-vcm) + 1*((v(se_rel_n_1n)*vcm+v(se_sel_hi_n_1n)*vref+v(se_sel_in_n)*v(se_vinn))/vdd_val-vcm) )
rsep se_topip se_topp 1k
rsen se_topin se_topn 1k
csetp se_topp 0 2.56p
csetn se_topn 0 2.56p
bsecmp se_cmpd 0 V = v(se_topp) > v(se_topn) ? vdd_val : 0
rsecmps se_cmpd se_cmpo 1k
csecmpl se_cmpo 0 100f
bsecode se_code 0 V =
+ (512)*(v(se_c9)>vth ? 1 : 0) + (256)*(v(se_c8)>vth ? 1 : 0) + (128)*(v(se_c7)>vth ? 1 : 0) + (64)*(v(se_c6)>vth ? 1 : 0) + (32)*(v(se_c5)>vth ? 1 : 0) + (16)*(v(se_c4)>vth ? 1 : 0) + (8)*(v(se_c3)>vth ? 1 : 0) + (4)*(v(se_c2)>vth ? 1 : 0) + (2)*(v(se_c1)>vth ? 1 : 0) + (1)*(v(se_c0)>vth ? 1 : 0)
bsedrdyb se_drdyb 0 V = v(se_drdy)>vth ? vdd_val : 0
rsedrdyg se_drdyb se_drdyg 1k
csedrdyg se_drdyg 0 721.348f
bseconf se_conf 0 V = (
+ abs(v(se_sel_in_n)+v(se_rel_n_256p)+v(se_sel_hi_n_256p)+v(se_sel_lo_n_256p)-vdd_val) + abs(v(se_sel_in_n)+v(se_rel_n_128p)+v(se_sel_hi_n_128p)+v(se_sel_lo_n_128p)-vdd_val) + abs(v(se_sel_in_n)+v(se_rel_n_64p)+v(se_sel_hi_n_64p)+v(se_sel_lo_n_64p)-vdd_val) + abs(v(se_sel_in_n)+v(se_rel_n_32p)+v(se_sel_hi_n_32p)+v(se_sel_lo_n_32p)-vdd_val) + abs(v(se_sel_in_n)+v(se_rel_n_16p)+v(se_sel_hi_n_16p)+v(se_sel_lo_n_16p)-vdd_val) + abs(v(se_sel_in_n)+v(se_rel_n_8p)+v(se_sel_hi_n_8p)+v(se_sel_lo_n_8p)-vdd_val) + abs(v(se_sel_in_n)+v(se_rel_n_4p)+v(se_sel_hi_n_4p)+v(se_sel_lo_n_4p)-vdd_val) + abs(v(se_sel_in_n)+v(se_rel_n_2p)+v(se_sel_hi_n_2p)+v(se_sel_lo_n_2p)-vdd_val) + abs(v(se_sel_in_n)+v(se_rel_n_1p)+v(se_sel_hi_n_1p)+v(se_sel_lo_n_1p)-vdd_val) + abs(v(se_sel_in_n)+v(se_rel_n_256n)+v(se_sel_hi_n_256n)+v(se_sel_lo_n_256n)-vdd_val) + abs(v(se_sel_in_n)+v(se_rel_n_128n)+v(se_sel_hi_n_128n)+v(se_sel_lo_n_128n)-vdd_val) + abs(v(se_sel_in_n)+v(se_rel_n_64n)+v(se_sel_hi_n_64n)+v(se_sel_lo_n_64n)-vdd_val) + abs(v(se_sel_in_n)+v(se_rel_n_32n)+v(se_sel_hi_n_32n)+v(se_sel_lo_n_32n)-vdd_val) + abs(v(se_sel_in_n)+v(se_rel_n_16n)+v(se_sel_hi_n_16n)+v(se_sel_lo_n_16n)-vdd_val) + abs(v(se_sel_in_n)+v(se_rel_n_8n)+v(se_sel_hi_n_8n)+v(se_sel_lo_n_8n)-vdd_val) + abs(v(se_sel_in_n)+v(se_rel_n_4n)+v(se_sel_hi_n_4n)+v(se_sel_lo_n_4n)-vdd_val) + abs(v(se_sel_in_n)+v(se_rel_n_2n)+v(se_sel_hi_n_2n)+v(se_sel_lo_n_2n)-vdd_val) + abs(v(se_sel_in_n)+v(se_rel_n_1n)+v(se_sel_hi_n_1n)+v(se_sel_lo_n_1n)-vdd_val))/vdd_val
bsenside se_nside 0 V = (
+ v(se_sel_hi_n_256n)+v(se_sel_lo_n_256n) + v(se_sel_hi_n_128n)+v(se_sel_lo_n_128n) + v(se_sel_hi_n_64n)+v(se_sel_lo_n_64n) + v(se_sel_hi_n_32n)+v(se_sel_lo_n_32n) + v(se_sel_hi_n_16n)+v(se_sel_lo_n_16n) + v(se_sel_hi_n_8n)+v(se_sel_lo_n_8n) + v(se_sel_hi_n_4n)+v(se_sel_lo_n_4n) + v(se_sel_hi_n_2n)+v(se_sel_lo_n_2n) + v(se_sel_hi_n_1n)+v(se_sel_lo_n_1n))/vdd_val
bseacq se_acq 0 V = v(se_samp_tp_n)/vdd_val
bseiso se_iso 0 V = (v(se_sel_in_n)-v(se_samp_tp_n))/vdd_val
* single-ended: the p side samples V_in over 0..V_REF, the n side is
* pinned at V_cm (DR-0011). Full scale = V_REF, LSB = V_REF/1024.
vsein se_vinp 0 pwl(0 {lsbse/2} 64000.0n {vref+lsbse/2})
vsecm se_vinn 0 dc {vcm}
bseexp se_exp 0 V = min(max(floor(v(se_shxp)/lsbse),0),1023)
bseerr se_err 0 V = min(v(se_drdy),v(se_drdyg))>vth ? v(se_code)-v(se_exp) : 0

* ---- loop df ----
vdfstart df_start 0 pwl(0 {vdd_val} 125n {vdd_val} 125.1n 0)
vdfmode df_mode 0 dc {vdd_val}
xdf clk df_start df_mode df_cmpo df_samp_tp_n df_sel_in_n df_drdy df_c9
+ df_c8 df_c7 df_c6 df_c5 df_c4 df_c3 df_c2 df_c1 df_c0 df_rel_n_256p
+ df_sel_hi_n_256p df_sel_lo_n_256p df_rel_n_128p df_sel_hi_n_128p
+ df_sel_lo_n_128p df_rel_n_64p df_sel_hi_n_64p df_sel_lo_n_64p
+ df_rel_n_32p df_sel_hi_n_32p df_sel_lo_n_32p df_rel_n_16p
+ df_sel_hi_n_16p df_sel_lo_n_16p df_rel_n_8p df_sel_hi_n_8p
+ df_sel_lo_n_8p df_rel_n_4p df_sel_hi_n_4p df_sel_lo_n_4p df_rel_n_2p
+ df_sel_hi_n_2p df_sel_lo_n_2p df_rel_n_1p df_sel_hi_n_1p df_sel_lo_n_1p
+ df_rel_n_256n df_sel_hi_n_256n df_sel_lo_n_256n df_rel_n_128n
+ df_sel_hi_n_128n df_sel_lo_n_128n df_rel_n_64n df_sel_hi_n_64n
+ df_sel_lo_n_64n df_rel_n_32n df_sel_hi_n_32n df_sel_lo_n_32n
+ df_rel_n_16n df_sel_hi_n_16n df_sel_lo_n_16n df_rel_n_8n df_sel_hi_n_8n
+ df_sel_lo_n_8n df_rel_n_4n df_sel_hi_n_4n df_sel_lo_n_4n df_rel_n_2n
+ df_sel_hi_n_2n df_sel_lo_n_2n df_rel_n_1n df_sel_hi_n_1n df_sel_lo_n_1n
+ sar_ctrl_a
sdfp df_vinp df_shp df_samp_tp_n 0 sarl_sw
sdfn df_vinn df_shn df_samp_tp_n 0 sarl_sw
cdfp df_shp 0 1p
cdfn df_shn 0 1p
rdfsd df_samp_tp_n df_sampd 10k
cdfsd df_sampd 0 1p
sdfxp df_vinp df_shxp df_sampd 0 sarl_sw
sdfxn df_vinn df_shxn df_sampd 0 sarl_sw
cdfxp df_shxp 0 1p
cdfxn df_shxn 0 1p
bdftopp df_topip 0 V = 2*vcm-v(df_shp)+(1.0/512)*(
+ 256*((v(df_rel_n_256p)*vcm+v(df_sel_hi_n_256p)*vref+v(df_sel_in_n)*v(df_vinp))/vdd_val-vcm) + 128*((v(df_rel_n_128p)*vcm+v(df_sel_hi_n_128p)*vref+v(df_sel_in_n)*v(df_vinp))/vdd_val-vcm) + 64*((v(df_rel_n_64p)*vcm+v(df_sel_hi_n_64p)*vref+v(df_sel_in_n)*v(df_vinp))/vdd_val-vcm) + 32*((v(df_rel_n_32p)*vcm+v(df_sel_hi_n_32p)*vref+v(df_sel_in_n)*v(df_vinp))/vdd_val-vcm) + 16*((v(df_rel_n_16p)*vcm+v(df_sel_hi_n_16p)*vref+v(df_sel_in_n)*v(df_vinp))/vdd_val-vcm) + 8*((v(df_rel_n_8p)*vcm+v(df_sel_hi_n_8p)*vref+v(df_sel_in_n)*v(df_vinp))/vdd_val-vcm) + 4*((v(df_rel_n_4p)*vcm+v(df_sel_hi_n_4p)*vref+v(df_sel_in_n)*v(df_vinp))/vdd_val-vcm) + 2*((v(df_rel_n_2p)*vcm+v(df_sel_hi_n_2p)*vref+v(df_sel_in_n)*v(df_vinp))/vdd_val-vcm) + 1*((v(df_rel_n_1p)*vcm+v(df_sel_hi_n_1p)*vref+v(df_sel_in_n)*v(df_vinp))/vdd_val-vcm) )
bdftopn df_topin 0 V = 2*vcm-v(df_shn)+(1.0/512)*(
+ 256*((v(df_rel_n_256n)*vcm+v(df_sel_hi_n_256n)*vref+v(df_sel_in_n)*v(df_vinn))/vdd_val-vcm) + 128*((v(df_rel_n_128n)*vcm+v(df_sel_hi_n_128n)*vref+v(df_sel_in_n)*v(df_vinn))/vdd_val-vcm) + 64*((v(df_rel_n_64n)*vcm+v(df_sel_hi_n_64n)*vref+v(df_sel_in_n)*v(df_vinn))/vdd_val-vcm) + 32*((v(df_rel_n_32n)*vcm+v(df_sel_hi_n_32n)*vref+v(df_sel_in_n)*v(df_vinn))/vdd_val-vcm) + 16*((v(df_rel_n_16n)*vcm+v(df_sel_hi_n_16n)*vref+v(df_sel_in_n)*v(df_vinn))/vdd_val-vcm) + 8*((v(df_rel_n_8n)*vcm+v(df_sel_hi_n_8n)*vref+v(df_sel_in_n)*v(df_vinn))/vdd_val-vcm) + 4*((v(df_rel_n_4n)*vcm+v(df_sel_hi_n_4n)*vref+v(df_sel_in_n)*v(df_vinn))/vdd_val-vcm) + 2*((v(df_rel_n_2n)*vcm+v(df_sel_hi_n_2n)*vref+v(df_sel_in_n)*v(df_vinn))/vdd_val-vcm) + 1*((v(df_rel_n_1n)*vcm+v(df_sel_hi_n_1n)*vref+v(df_sel_in_n)*v(df_vinn))/vdd_val-vcm) )
rdfp df_topip df_topp 1k
rdfn df_topin df_topn 1k
cdftp df_topp 0 2.56p
cdftn df_topn 0 2.56p
bdfcmp df_cmpd 0 V = v(df_topp) > v(df_topn) ? vdd_val : 0
rdfcmps df_cmpd df_cmpo 1k
cdfcmpl df_cmpo 0 100f
bdfcode df_code 0 V =
+ (512)*(v(df_c9)>vth ? 1 : 0) + (256)*(v(df_c8)>vth ? 1 : 0) + (128)*(v(df_c7)>vth ? 1 : 0) + (64)*(v(df_c6)>vth ? 1 : 0) + (32)*(v(df_c5)>vth ? 1 : 0) + (16)*(v(df_c4)>vth ? 1 : 0) + (8)*(v(df_c3)>vth ? 1 : 0) + (4)*(v(df_c2)>vth ? 1 : 0) + (2)*(v(df_c1)>vth ? 1 : 0) + (1)*(v(df_c0)>vth ? 1 : 0)
bdfdrdyb df_drdyb 0 V = v(df_drdy)>vth ? vdd_val : 0
rdfdrdyg df_drdyb df_drdyg 1k
cdfdrdyg df_drdyg 0 721.348f
bdfconf df_conf 0 V = (
+ abs(v(df_sel_in_n)+v(df_rel_n_256p)+v(df_sel_hi_n_256p)+v(df_sel_lo_n_256p)-vdd_val) + abs(v(df_sel_in_n)+v(df_rel_n_128p)+v(df_sel_hi_n_128p)+v(df_sel_lo_n_128p)-vdd_val) + abs(v(df_sel_in_n)+v(df_rel_n_64p)+v(df_sel_hi_n_64p)+v(df_sel_lo_n_64p)-vdd_val) + abs(v(df_sel_in_n)+v(df_rel_n_32p)+v(df_sel_hi_n_32p)+v(df_sel_lo_n_32p)-vdd_val) + abs(v(df_sel_in_n)+v(df_rel_n_16p)+v(df_sel_hi_n_16p)+v(df_sel_lo_n_16p)-vdd_val) + abs(v(df_sel_in_n)+v(df_rel_n_8p)+v(df_sel_hi_n_8p)+v(df_sel_lo_n_8p)-vdd_val) + abs(v(df_sel_in_n)+v(df_rel_n_4p)+v(df_sel_hi_n_4p)+v(df_sel_lo_n_4p)-vdd_val) + abs(v(df_sel_in_n)+v(df_rel_n_2p)+v(df_sel_hi_n_2p)+v(df_sel_lo_n_2p)-vdd_val) + abs(v(df_sel_in_n)+v(df_rel_n_1p)+v(df_sel_hi_n_1p)+v(df_sel_lo_n_1p)-vdd_val) + abs(v(df_sel_in_n)+v(df_rel_n_256n)+v(df_sel_hi_n_256n)+v(df_sel_lo_n_256n)-vdd_val) + abs(v(df_sel_in_n)+v(df_rel_n_128n)+v(df_sel_hi_n_128n)+v(df_sel_lo_n_128n)-vdd_val) + abs(v(df_sel_in_n)+v(df_rel_n_64n)+v(df_sel_hi_n_64n)+v(df_sel_lo_n_64n)-vdd_val) + abs(v(df_sel_in_n)+v(df_rel_n_32n)+v(df_sel_hi_n_32n)+v(df_sel_lo_n_32n)-vdd_val) + abs(v(df_sel_in_n)+v(df_rel_n_16n)+v(df_sel_hi_n_16n)+v(df_sel_lo_n_16n)-vdd_val) + abs(v(df_sel_in_n)+v(df_rel_n_8n)+v(df_sel_hi_n_8n)+v(df_sel_lo_n_8n)-vdd_val) + abs(v(df_sel_in_n)+v(df_rel_n_4n)+v(df_sel_hi_n_4n)+v(df_sel_lo_n_4n)-vdd_val) + abs(v(df_sel_in_n)+v(df_rel_n_2n)+v(df_sel_hi_n_2n)+v(df_sel_lo_n_2n)-vdd_val) + abs(v(df_sel_in_n)+v(df_rel_n_1n)+v(df_sel_hi_n_1n)+v(df_sel_lo_n_1n)-vdd_val))/vdd_val
bdfnside df_nside 0 V = (
+ v(df_sel_hi_n_256n)+v(df_sel_lo_n_256n) + v(df_sel_hi_n_128n)+v(df_sel_lo_n_128n) + v(df_sel_hi_n_64n)+v(df_sel_lo_n_64n) + v(df_sel_hi_n_32n)+v(df_sel_lo_n_32n) + v(df_sel_hi_n_16n)+v(df_sel_lo_n_16n) + v(df_sel_hi_n_8n)+v(df_sel_lo_n_8n) + v(df_sel_hi_n_4n)+v(df_sel_lo_n_4n) + v(df_sel_hi_n_2n)+v(df_sel_lo_n_2n) + v(df_sel_hi_n_1n)+v(df_sel_lo_n_1n))/vdd_val
bdfacq df_acq 0 V = v(df_samp_tp_n)/vdd_val
bdfiso df_iso 0 V = (v(df_sel_in_n)-v(df_samp_tp_n))/vdd_val
* differential: both pins swing +-V_REF/2 about V_cm, so the
* differential input covers +-V_REF. Full scale = 2*V_REF,
* LSB = V_REF/512, mid-scale code 512 at zero differential input.
vdfp df_vinp 0 pwl(0 {vcm-vref/2+lsbdf/4} 64000.0n {vcm+vref/2+lsbdf/4})
vdfn df_vinn 0 pwl(0 {vcm+vref/2-lsbdf/4} 64000.0n {vcm-vref/2-lsbdf/4})
bdfexp df_exp 0 V = min(max(512+floor((v(df_shxp)-v(df_shxn))/lsbdf),0),1023)
bdferr df_err 0 V = min(v(df_drdy),v(df_drdyg))>vth ? v(df_code)-v(df_exp) : 0

* Externally-supplied net(s) this subckt's cells bind but nothing
* inside it drives. Without .global, SPICE scopes these LOCALLY to
* each instance -- the DUT would sit unpowered at ~0 V and every
* symptom would read as a solver/power-up problem (issue #282).
.global vdd_gate

.subckt sar_ctrl_a clk start mode cmp samp_tp_n sel_in_n drdy c9 c8 c7 c6 c5 c4 c3 c2 c1 c0 rel_n_256p sel_hi_n_256p sel_lo_n_256p rel_n_128p sel_hi_n_128p sel_lo_n_128p rel_n_64p sel_hi_n_64p sel_lo_n_64p rel_n_32p sel_hi_n_32p sel_lo_n_32p rel_n_16p sel_hi_n_16p sel_lo_n_16p rel_n_8p sel_hi_n_8p sel_lo_n_8p rel_n_4p sel_hi_n_4p sel_lo_n_4p rel_n_2p sel_hi_n_2p sel_lo_n_2p rel_n_1p sel_hi_n_1p sel_lo_n_1p rel_n_256n sel_hi_n_256n sel_lo_n_256n rel_n_128n sel_hi_n_128n sel_lo_n_128n rel_n_64n sel_hi_n_64n sel_lo_n_64n rel_n_32n sel_hi_n_32n sel_lo_n_32n rel_n_16n sel_hi_n_16n sel_lo_n_16n rel_n_8n sel_hi_n_8n sel_lo_n_8n rel_n_4n sel_hi_n_4n sel_lo_n_4n rel_n_2n sel_hi_n_2n sel_lo_n_2n rel_n_1n sel_hi_n_1n sel_lo_n_1n
X_065_ eng3 _030_ vdd_gate vdd_gate 0 0 gf180mcu_fd_sc_mcu7t5v0__clkinv_1
X_066_ mode _031_ vdd_gate vdd_gate 0 0 gf180mcu_fd_sc_mcu7t5v0__clkinv_1
X_067_ ph_2 _032_ vdd_gate vdd_gate 0 0 gf180mcu_fd_sc_mcu7t5v0__clkinv_1
X_068_ ph_0 _033_ vdd_gate vdd_gate 0 0 gf180mcu_fd_sc_mcu7t5v0__clkinv_1
X_069_ ph_1 _034_ vdd_gate vdd_gate 0 0 gf180mcu_fd_sc_mcu7t5v0__clkinv_1
X_070_ ph_3 _035_ vdd_gate vdd_gate 0 0 gf180mcu_fd_sc_mcu7t5v0__clkinv_1
X_071_ eng4 _036_ vdd_gate vdd_gate 0 0 gf180mcu_fd_sc_mcu7t5v0__clkinv_1
X_072_ eng5 _037_ vdd_gate vdd_gate 0 0 gf180mcu_fd_sc_mcu7t5v0__clkinv_1
X_073_ eng6 _038_ vdd_gate vdd_gate 0 0 gf180mcu_fd_sc_mcu7t5v0__clkinv_1
X_074_ eng7 _039_ vdd_gate vdd_gate 0 0 gf180mcu_fd_sc_mcu7t5v0__clkinv_1
X_075_ eng8 _040_ vdd_gate vdd_gate 0 0 gf180mcu_fd_sc_mcu7t5v0__clkinv_1
X_076_ eng9 _041_ vdd_gate vdd_gate 0 0 gf180mcu_fd_sc_mcu7t5v0__clkinv_1
X_077_ eng2 _042_ vdd_gate vdd_gate 0 0 gf180mcu_fd_sc_mcu7t5v0__clkinv_1
X_078_ ph_12 _043_ vdd_gate vdd_gate 0 0 gf180mcu_fd_sc_mcu7t5v0__clkinv_1
X_079_ eng1 _044_ vdd_gate vdd_gate 0 0 gf180mcu_fd_sc_mcu7t5v0__clkinv_1
X_080_ ph_13 _045_ vdd_gate vdd_gate 0 0 gf180mcu_fd_sc_mcu7t5v0__clkinv_1
X_081_ ph_11 _046_ vdd_gate vdd_gate 0 0 gf180mcu_fd_sc_mcu7t5v0__clkinv_1
X_082_ ph_10 _047_ vdd_gate vdd_gate 0 0 gf180mcu_fd_sc_mcu7t5v0__clkinv_1
X_083_ ph_9 _048_ vdd_gate vdd_gate 0 0 gf180mcu_fd_sc_mcu7t5v0__clkinv_1
X_084_ ph_8 _049_ vdd_gate vdd_gate 0 0 gf180mcu_fd_sc_mcu7t5v0__clkinv_1
X_085_ ph_7 _050_ vdd_gate vdd_gate 0 0 gf180mcu_fd_sc_mcu7t5v0__clkinv_1
X_086_ ph_6 _051_ vdd_gate vdd_gate 0 0 gf180mcu_fd_sc_mcu7t5v0__clkinv_1
X_087_ ph_5 _052_ vdd_gate vdd_gate 0 0 gf180mcu_fd_sc_mcu7t5v0__clkinv_1
X_088_ ph_4 _053_ vdd_gate vdd_gate 0 0 gf180mcu_fd_sc_mcu7t5v0__clkinv_1
X_089_ ph_14 _054_ vdd_gate vdd_gate 0 0 gf180mcu_fd_sc_mcu7t5v0__clkinv_1
X_090_ _030_ q3 sel_lo_n_4p vdd_gate vdd_gate 0 0 gf180mcu_fd_sc_mcu7t5v0__nor2_1
X_091_ _030_ _031_ q3 sel_hi_n_4n vdd_gate vdd_gate 0 0 gf180mcu_fd_sc_mcu7t5v0__nor3_1
X_092_ _032_ _033_ _034_ samp_tp_n vdd_gate vdd_gate 0 0 gf180mcu_fd_sc_mcu7t5v0__nand3_1
X_093_ ph_2 ph_0 ph_1 ph_3 sel_in_n vdd_gate vdd_gate 0 0 gf180mcu_fd_sc_mcu7t5v0__or4_1
X_094_ eng3 sel_in_n rel_n_4p vdd_gate vdd_gate 0 0 gf180mcu_fd_sc_mcu7t5v0__nor2_1
X_095_ eng3 mode sel_in_n rel_n_4n vdd_gate vdd_gate 0 0 gf180mcu_fd_sc_mcu7t5v0__aoi21_1
X_096_ eng3 q3 sel_hi_n_4p vdd_gate vdd_gate 0 0 gf180mcu_fd_sc_mcu7t5v0__and2_1
X_097_ q4 eng4 sel_hi_n_8p vdd_gate vdd_gate 0 0 gf180mcu_fd_sc_mcu7t5v0__and2_1
X_098_ mode sel_hi_n_8p sel_lo_n_8n vdd_gate vdd_gate 0 0 gf180mcu_fd_sc_mcu7t5v0__and2_1
X_099_ q4 _036_ sel_lo_n_8p vdd_gate vdd_gate 0 0 gf180mcu_fd_sc_mcu7t5v0__nor2_1
X_100_ _031_ q4 _036_ sel_hi_n_8n vdd_gate vdd_gate 0 0 gf180mcu_fd_sc_mcu7t5v0__nor3_1
X_101_ eng4 sel_in_n rel_n_8p vdd_gate vdd_gate 0 0 gf180mcu_fd_sc_mcu7t5v0__nor2_1
X_102_ mode eng4 sel_in_n rel_n_8n vdd_gate vdd_gate 0 0 gf180mcu_fd_sc_mcu7t5v0__aoi21_1
X_103_ q5 eng5 sel_hi_n_16p vdd_gate vdd_gate 0 0 gf180mcu_fd_sc_mcu7t5v0__and2_1
X_104_ mode sel_hi_n_16p sel_lo_n_16n vdd_gate vdd_gate 0 0 gf180mcu_fd_sc_mcu7t5v0__and2_1
X_105_ q5 _037_ sel_lo_n_16p vdd_gate vdd_gate 0 0 gf180mcu_fd_sc_mcu7t5v0__nor2_1
X_106_ _031_ q5 _037_ sel_hi_n_16n vdd_gate vdd_gate 0 0 gf180mcu_fd_sc_mcu7t5v0__nor3_1
X_107_ eng5 sel_in_n rel_n_16p vdd_gate vdd_gate 0 0 gf180mcu_fd_sc_mcu7t5v0__nor2_1
X_108_ mode eng5 sel_in_n rel_n_16n vdd_gate vdd_gate 0 0 gf180mcu_fd_sc_mcu7t5v0__aoi21_1
X_109_ q6 eng6 sel_hi_n_32p vdd_gate vdd_gate 0 0 gf180mcu_fd_sc_mcu7t5v0__and2_1
X_110_ mode sel_hi_n_32p sel_lo_n_32n vdd_gate vdd_gate 0 0 gf180mcu_fd_sc_mcu7t5v0__and2_1
X_111_ q6 _038_ sel_lo_n_32p vdd_gate vdd_gate 0 0 gf180mcu_fd_sc_mcu7t5v0__nor2_1
X_112_ _031_ q6 _038_ sel_hi_n_32n vdd_gate vdd_gate 0 0 gf180mcu_fd_sc_mcu7t5v0__nor3_1
X_113_ eng6 sel_in_n rel_n_32p vdd_gate vdd_gate 0 0 gf180mcu_fd_sc_mcu7t5v0__nor2_1
X_114_ mode eng6 sel_in_n rel_n_32n vdd_gate vdd_gate 0 0 gf180mcu_fd_sc_mcu7t5v0__aoi21_1
X_115_ q7 eng7 sel_hi_n_64p vdd_gate vdd_gate 0 0 gf180mcu_fd_sc_mcu7t5v0__and2_1
X_116_ mode sel_hi_n_64p sel_lo_n_64n vdd_gate vdd_gate 0 0 gf180mcu_fd_sc_mcu7t5v0__and2_1
X_117_ q7 _039_ sel_lo_n_64p vdd_gate vdd_gate 0 0 gf180mcu_fd_sc_mcu7t5v0__nor2_1
X_118_ _031_ q7 _039_ sel_hi_n_64n vdd_gate vdd_gate 0 0 gf180mcu_fd_sc_mcu7t5v0__nor3_1
X_119_ eng7 sel_in_n rel_n_64p vdd_gate vdd_gate 0 0 gf180mcu_fd_sc_mcu7t5v0__nor2_1
X_120_ mode eng7 sel_in_n rel_n_64n vdd_gate vdd_gate 0 0 gf180mcu_fd_sc_mcu7t5v0__aoi21_1
X_121_ q8 eng8 sel_hi_n_128p vdd_gate vdd_gate 0 0 gf180mcu_fd_sc_mcu7t5v0__and2_1
X_122_ mode sel_hi_n_128p sel_lo_n_128n vdd_gate vdd_gate 0 0 gf180mcu_fd_sc_mcu7t5v0__and2_1
X_123_ q8 _040_ sel_lo_n_128p vdd_gate vdd_gate 0 0 gf180mcu_fd_sc_mcu7t5v0__nor2_1
X_124_ _031_ q8 _040_ sel_hi_n_128n vdd_gate vdd_gate 0 0 gf180mcu_fd_sc_mcu7t5v0__nor3_1
X_125_ eng8 sel_in_n rel_n_128p vdd_gate vdd_gate 0 0 gf180mcu_fd_sc_mcu7t5v0__nor2_1
X_126_ mode eng8 sel_in_n rel_n_128n vdd_gate vdd_gate 0 0 gf180mcu_fd_sc_mcu7t5v0__aoi21_1
X_127_ mode sel_hi_n_4p sel_lo_n_4n vdd_gate vdd_gate 0 0 gf180mcu_fd_sc_mcu7t5v0__and2_1
X_128_ q9 eng9 sel_hi_n_256p vdd_gate vdd_gate 0 0 gf180mcu_fd_sc_mcu7t5v0__and2_1
X_129_ mode sel_hi_n_256p sel_lo_n_256n vdd_gate vdd_gate 0 0 gf180mcu_fd_sc_mcu7t5v0__and2_1
X_130_ q9 _041_ sel_lo_n_256p vdd_gate vdd_gate 0 0 gf180mcu_fd_sc_mcu7t5v0__nor2_1
X_131_ _031_ q9 _041_ sel_hi_n_256n vdd_gate vdd_gate 0 0 gf180mcu_fd_sc_mcu7t5v0__nor3_1
X_132_ eng9 sel_in_n rel_n_256p vdd_gate vdd_gate 0 0 gf180mcu_fd_sc_mcu7t5v0__nor2_1
X_133_ mode eng9 sel_in_n rel_n_256n vdd_gate vdd_gate 0 0 gf180mcu_fd_sc_mcu7t5v0__aoi21_1
X_134_ eng2 sel_in_n rel_n_2p vdd_gate vdd_gate 0 0 gf180mcu_fd_sc_mcu7t5v0__nor2_1
X_135_ eng2 q2 sel_hi_n_2p vdd_gate vdd_gate 0 0 gf180mcu_fd_sc_mcu7t5v0__and2_1
X_136_ _043_ _044_ ph_13 _000_ vdd_gate vdd_gate 0 0 gf180mcu_fd_sc_mcu7t5v0__aoi21_1
X_137_ _042_ _046_ ph_13 _001_ vdd_gate vdd_gate 0 0 gf180mcu_fd_sc_mcu7t5v0__aoi21_1
X_138_ _042_ q2 sel_lo_n_2p vdd_gate vdd_gate 0 0 gf180mcu_fd_sc_mcu7t5v0__nor2_1
X_139_ _030_ _047_ ph_13 _002_ vdd_gate vdd_gate 0 0 gf180mcu_fd_sc_mcu7t5v0__aoi21_1
X_140_ _036_ _048_ ph_13 _003_ vdd_gate vdd_gate 0 0 gf180mcu_fd_sc_mcu7t5v0__aoi21_1
X_141_ _037_ _049_ ph_13 _004_ vdd_gate vdd_gate 0 0 gf180mcu_fd_sc_mcu7t5v0__aoi21_1
X_142_ _038_ _050_ ph_13 _005_ vdd_gate vdd_gate 0 0 gf180mcu_fd_sc_mcu7t5v0__aoi21_1
X_143_ mode eng2 sel_in_n rel_n_2n vdd_gate vdd_gate 0 0 gf180mcu_fd_sc_mcu7t5v0__aoi21_1
X_144_ _039_ _051_ ph_13 _006_ vdd_gate vdd_gate 0 0 gf180mcu_fd_sc_mcu7t5v0__aoi21_1
X_145_ _040_ _052_ ph_13 _007_ vdd_gate vdd_gate 0 0 gf180mcu_fd_sc_mcu7t5v0__aoi21_1
X_146_ _041_ _053_ ph_13 _008_ vdd_gate vdd_gate 0 0 gf180mcu_fd_sc_mcu7t5v0__aoi21_1
X_147_ _031_ _042_ q2 sel_hi_n_2n vdd_gate vdd_gate 0 0 gf180mcu_fd_sc_mcu7t5v0__nor3_1
X_148_ _054_ start _009__15 vdd_gate vdd_gate 0 0 gf180mcu_fd_sc_mcu7t5v0__nor2_1
X_149_ _045_ start _009__14 vdd_gate vdd_gate 0 0 gf180mcu_fd_sc_mcu7t5v0__nor2_1
X_150_ mode sel_hi_n_2p sel_lo_n_2n vdd_gate vdd_gate 0 0 gf180mcu_fd_sc_mcu7t5v0__and2_1
X_151_ _043_ start _009__13 vdd_gate vdd_gate 0 0 gf180mcu_fd_sc_mcu7t5v0__nor2_1
X_152_ _046_ start _009__12 vdd_gate vdd_gate 0 0 gf180mcu_fd_sc_mcu7t5v0__nor2_1
X_153_ eng1 sel_in_n rel_n_1p vdd_gate vdd_gate 0 0 gf180mcu_fd_sc_mcu7t5v0__nor2_1
X_154_ _047_ start _009__11 vdd_gate vdd_gate 0 0 gf180mcu_fd_sc_mcu7t5v0__nor2_1
X_155_ eng1 q1 sel_hi_n_1p vdd_gate vdd_gate 0 0 gf180mcu_fd_sc_mcu7t5v0__and2_1
X_156_ _048_ start _009__10 vdd_gate vdd_gate 0 0 gf180mcu_fd_sc_mcu7t5v0__nor2_1
X_157_ _049_ start _009__9 vdd_gate vdd_gate 0 0 gf180mcu_fd_sc_mcu7t5v0__nor2_1
X_158_ _044_ q1 sel_lo_n_1p vdd_gate vdd_gate 0 0 gf180mcu_fd_sc_mcu7t5v0__nor2_1
X_159_ _050_ start _009__8 vdd_gate vdd_gate 0 0 gf180mcu_fd_sc_mcu7t5v0__nor2_1
X_160_ mode sel_hi_n_1p sel_lo_n_1n vdd_gate vdd_gate 0 0 gf180mcu_fd_sc_mcu7t5v0__and2_1
X_161_ _051_ start _009__7 vdd_gate vdd_gate 0 0 gf180mcu_fd_sc_mcu7t5v0__nor2_1
X_162_ _052_ start _009__6 vdd_gate vdd_gate 0 0 gf180mcu_fd_sc_mcu7t5v0__nor2_1
X_163_ _031_ _044_ q1 sel_hi_n_1n vdd_gate vdd_gate 0 0 gf180mcu_fd_sc_mcu7t5v0__nor3_1
X_164_ _053_ start _009__5 vdd_gate vdd_gate 0 0 gf180mcu_fd_sc_mcu7t5v0__nor2_1
X_165_ _035_ start _009__4 vdd_gate vdd_gate 0 0 gf180mcu_fd_sc_mcu7t5v0__nor2_1
X_166_ _032_ start _009__3 vdd_gate vdd_gate 0 0 gf180mcu_fd_sc_mcu7t5v0__nor2_1
X_167_ mode eng1 sel_in_n rel_n_1n vdd_gate vdd_gate 0 0 gf180mcu_fd_sc_mcu7t5v0__aoi21_1
X_168_ _034_ start _009__2 vdd_gate vdd_gate 0 0 gf180mcu_fd_sc_mcu7t5v0__nor2_1
X_169_ _033_ start _009__1 vdd_gate vdd_gate 0 0 gf180mcu_fd_sc_mcu7t5v0__nor2_1
X_170_ start drdy _009__0 vdd_gate vdd_gate 0 0 gf180mcu_fd_sc_mcu7t5v0__or2_1
X_171_ c8 q8 ph_14 _010_ vdd_gate vdd_gate 0 0 gf180mcu_fd_sc_mcu7t5v0__mux2_1
X_172_ c9 q9 ph_14 _011_ vdd_gate vdd_gate 0 0 gf180mcu_fd_sc_mcu7t5v0__mux2_1
X_173_ ph_13 q0 _055_ vdd_gate vdd_gate 0 0 gf180mcu_fd_sc_mcu7t5v0__nor2_1
X_174_ ph_13 cmp _055_ _012_ vdd_gate vdd_gate 0 0 gf180mcu_fd_sc_mcu7t5v0__aoi21_1
X_175_ c0 q0 ph_14 _013_ vdd_gate vdd_gate 0 0 gf180mcu_fd_sc_mcu7t5v0__mux2_1
X_176_ q6 ph_7 _056_ vdd_gate vdd_gate 0 0 gf180mcu_fd_sc_mcu7t5v0__nor2_1
X_177_ ph_7 cmp _056_ _014_ vdd_gate vdd_gate 0 0 gf180mcu_fd_sc_mcu7t5v0__aoi21_1
X_178_ c1 q1 ph_14 _015_ vdd_gate vdd_gate 0 0 gf180mcu_fd_sc_mcu7t5v0__mux2_1
X_179_ c2 q2 ph_14 _016_ vdd_gate vdd_gate 0 0 gf180mcu_fd_sc_mcu7t5v0__mux2_1
X_180_ q2 ph_11 _057_ vdd_gate vdd_gate 0 0 gf180mcu_fd_sc_mcu7t5v0__nor2_1
X_181_ ph_11 cmp _057_ _017_ vdd_gate vdd_gate 0 0 gf180mcu_fd_sc_mcu7t5v0__aoi21_1
X_182_ q7 ph_6 _058_ vdd_gate vdd_gate 0 0 gf180mcu_fd_sc_mcu7t5v0__nor2_1
X_183_ ph_6 cmp _058_ _018_ vdd_gate vdd_gate 0 0 gf180mcu_fd_sc_mcu7t5v0__aoi21_1
X_184_ q5 ph_8 _059_ vdd_gate vdd_gate 0 0 gf180mcu_fd_sc_mcu7t5v0__nor2_1
X_185_ ph_8 cmp _059_ _019_ vdd_gate vdd_gate 0 0 gf180mcu_fd_sc_mcu7t5v0__aoi21_1
X_186_ ph_12 q1 _060_ vdd_gate vdd_gate 0 0 gf180mcu_fd_sc_mcu7t5v0__nor2_1
X_187_ ph_12 cmp _060_ _020_ vdd_gate vdd_gate 0 0 gf180mcu_fd_sc_mcu7t5v0__aoi21_1
X_188_ c3 q3 ph_14 _021_ vdd_gate vdd_gate 0 0 gf180mcu_fd_sc_mcu7t5v0__mux2_1
X_189_ q8 ph_5 _061_ vdd_gate vdd_gate 0 0 gf180mcu_fd_sc_mcu7t5v0__nor2_1
X_190_ ph_5 cmp _061_ _022_ vdd_gate vdd_gate 0 0 gf180mcu_fd_sc_mcu7t5v0__aoi21_1
X_191_ c4 q4 ph_14 _023_ vdd_gate vdd_gate 0 0 gf180mcu_fd_sc_mcu7t5v0__mux2_1
X_192_ c5 q5 ph_14 _024_ vdd_gate vdd_gate 0 0 gf180mcu_fd_sc_mcu7t5v0__mux2_1
X_193_ q4 ph_9 _062_ vdd_gate vdd_gate 0 0 gf180mcu_fd_sc_mcu7t5v0__nor2_1
X_194_ ph_9 cmp _062_ _025_ vdd_gate vdd_gate 0 0 gf180mcu_fd_sc_mcu7t5v0__aoi21_1
X_195_ q9 ph_4 _063_ vdd_gate vdd_gate 0 0 gf180mcu_fd_sc_mcu7t5v0__nor2_1
X_196_ ph_4 cmp _063_ _026_ vdd_gate vdd_gate 0 0 gf180mcu_fd_sc_mcu7t5v0__aoi21_1
X_197_ c6 q6 ph_14 _027_ vdd_gate vdd_gate 0 0 gf180mcu_fd_sc_mcu7t5v0__mux2_1
X_198_ c7 q7 ph_14 _028_ vdd_gate vdd_gate 0 0 gf180mcu_fd_sc_mcu7t5v0__mux2_1
X_199_ q3 ph_10 _064_ vdd_gate vdd_gate 0 0 gf180mcu_fd_sc_mcu7t5v0__nor2_1
X_200_ ph_10 cmp _064_ _029_ vdd_gate vdd_gate 0 0 gf180mcu_fd_sc_mcu7t5v0__aoi21_1
X_201_ _020_ clk q1 vdd_gate vdd_gate 0 0 gf180mcu_fd_sc_mcu7t5v0__dffq_1
X_202_ _017_ clk q2 vdd_gate vdd_gate 0 0 gf180mcu_fd_sc_mcu7t5v0__dffq_1
X_203_ _029_ clk q3 vdd_gate vdd_gate 0 0 gf180mcu_fd_sc_mcu7t5v0__dffq_1
X_204_ _025_ clk q4 vdd_gate vdd_gate 0 0 gf180mcu_fd_sc_mcu7t5v0__dffq_1
X_205_ _019_ clk q5 vdd_gate vdd_gate 0 0 gf180mcu_fd_sc_mcu7t5v0__dffq_1
X_206_ _014_ clk q6 vdd_gate vdd_gate 0 0 gf180mcu_fd_sc_mcu7t5v0__dffq_1
X_207_ _018_ clk q7 vdd_gate vdd_gate 0 0 gf180mcu_fd_sc_mcu7t5v0__dffq_1
X_208_ _022_ clk q8 vdd_gate vdd_gate 0 0 gf180mcu_fd_sc_mcu7t5v0__dffq_1
X_209_ _026_ clk q9 vdd_gate vdd_gate 0 0 gf180mcu_fd_sc_mcu7t5v0__dffq_1
X_210_ _012_ clk q0 vdd_gate vdd_gate 0 0 gf180mcu_fd_sc_mcu7t5v0__dffq_1
X_211_ _013_ clk c0 vdd_gate vdd_gate 0 0 gf180mcu_fd_sc_mcu7t5v0__dffq_1
X_212_ _015_ clk c1 vdd_gate vdd_gate 0 0 gf180mcu_fd_sc_mcu7t5v0__dffq_1
X_213_ _016_ clk c2 vdd_gate vdd_gate 0 0 gf180mcu_fd_sc_mcu7t5v0__dffq_1
X_214_ _021_ clk c3 vdd_gate vdd_gate 0 0 gf180mcu_fd_sc_mcu7t5v0__dffq_1
X_215_ _023_ clk c4 vdd_gate vdd_gate 0 0 gf180mcu_fd_sc_mcu7t5v0__dffq_1
X_216_ _024_ clk c5 vdd_gate vdd_gate 0 0 gf180mcu_fd_sc_mcu7t5v0__dffq_1
X_217_ _027_ clk c6 vdd_gate vdd_gate 0 0 gf180mcu_fd_sc_mcu7t5v0__dffq_1
X_218_ _028_ clk c7 vdd_gate vdd_gate 0 0 gf180mcu_fd_sc_mcu7t5v0__dffq_1
X_219_ _010_ clk c8 vdd_gate vdd_gate 0 0 gf180mcu_fd_sc_mcu7t5v0__dffq_1
X_220_ _011_ clk c9 vdd_gate vdd_gate 0 0 gf180mcu_fd_sc_mcu7t5v0__dffq_1
X_221_ _008_ clk eng9 vdd_gate vdd_gate 0 0 gf180mcu_fd_sc_mcu7t5v0__dffq_1
X_222_ _007_ clk eng8 vdd_gate vdd_gate 0 0 gf180mcu_fd_sc_mcu7t5v0__dffq_1
X_223_ _006_ clk eng7 vdd_gate vdd_gate 0 0 gf180mcu_fd_sc_mcu7t5v0__dffq_1
X_224_ _005_ clk eng6 vdd_gate vdd_gate 0 0 gf180mcu_fd_sc_mcu7t5v0__dffq_1
X_225_ _004_ clk eng5 vdd_gate vdd_gate 0 0 gf180mcu_fd_sc_mcu7t5v0__dffq_1
X_226_ _003_ clk eng4 vdd_gate vdd_gate 0 0 gf180mcu_fd_sc_mcu7t5v0__dffq_1
X_227_ _002_ clk eng3 vdd_gate vdd_gate 0 0 gf180mcu_fd_sc_mcu7t5v0__dffq_1
X_228_ _001_ clk eng2 vdd_gate vdd_gate 0 0 gf180mcu_fd_sc_mcu7t5v0__dffq_1
X_229_ _000_ clk eng1 vdd_gate vdd_gate 0 0 gf180mcu_fd_sc_mcu7t5v0__dffq_1
X_230_ _009__0 clk ph_0 vdd_gate vdd_gate 0 0 gf180mcu_fd_sc_mcu7t5v0__dffq_1
X_231_ _009__1 clk ph_1 vdd_gate vdd_gate 0 0 gf180mcu_fd_sc_mcu7t5v0__dffq_1
X_232_ _009__2 clk ph_2 vdd_gate vdd_gate 0 0 gf180mcu_fd_sc_mcu7t5v0__dffq_1
X_233_ _009__3 clk ph_3 vdd_gate vdd_gate 0 0 gf180mcu_fd_sc_mcu7t5v0__dffq_1
X_234_ _009__4 clk ph_4 vdd_gate vdd_gate 0 0 gf180mcu_fd_sc_mcu7t5v0__dffq_1
X_235_ _009__5 clk ph_5 vdd_gate vdd_gate 0 0 gf180mcu_fd_sc_mcu7t5v0__dffq_1
X_236_ _009__6 clk ph_6 vdd_gate vdd_gate 0 0 gf180mcu_fd_sc_mcu7t5v0__dffq_1
X_237_ _009__7 clk ph_7 vdd_gate vdd_gate 0 0 gf180mcu_fd_sc_mcu7t5v0__dffq_1
X_238_ _009__8 clk ph_8 vdd_gate vdd_gate 0 0 gf180mcu_fd_sc_mcu7t5v0__dffq_1
X_239_ _009__9 clk ph_9 vdd_gate vdd_gate 0 0 gf180mcu_fd_sc_mcu7t5v0__dffq_1
X_240_ _009__10 clk ph_10 vdd_gate vdd_gate 0 0 gf180mcu_fd_sc_mcu7t5v0__dffq_1
X_241_ _009__11 clk ph_11 vdd_gate vdd_gate 0 0 gf180mcu_fd_sc_mcu7t5v0__dffq_1
X_242_ _009__12 clk ph_12 vdd_gate vdd_gate 0 0 gf180mcu_fd_sc_mcu7t5v0__dffq_1
X_243_ _009__13 clk ph_13 vdd_gate vdd_gate 0 0 gf180mcu_fd_sc_mcu7t5v0__dffq_1
X_244_ _009__14 clk ph_14 vdd_gate vdd_gate 0 0 gf180mcu_fd_sc_mcu7t5v0__dffq_1
X_245_ _009__15 clk drdy vdd_gate vdd_gate 0 0 gf180mcu_fd_sc_mcu7t5v0__dffq_1
.ends

.SUBCKT gf180mcu_fd_sc_mcu7t5v0__and2_1 A1 A2 Z VDD VNW VPW VSS
X_i_2 net_0 A1 Z_neg VPW nfet_06v0 W=3.65e-07 L=6e-07
X_i_3 VSS A2 net_0 VPW nfet_06v0 W=3.65e-07 L=6e-07
X_i_0 Z Z_neg VSS VPW nfet_06v0 W=8.15e-07 L=6e-07
X_i_4 Z_neg A1 VDD VNW pfet_06v0 W=6e-07 L=5e-07
X_i_5 VDD A2 Z_neg VNW pfet_06v0 W=6e-07 L=5e-07
X_i_1 Z Z_neg VDD VNW pfet_06v0 W=1.215e-06 L=5e-07
.ENDS

.SUBCKT gf180mcu_fd_sc_mcu7t5v0__aoi21_1 A1 A2 B ZN VDD VNW VPW VSS
X_i_1 net_0 A2 VSS VPW nfet_06v0 W=8.2e-07 L=6e-07
X_i_0 ZN A1 net_0 VPW nfet_06v0 W=8.2e-07 L=6e-07
X_i_2 VSS B ZN VPW nfet_06v0 W=5.1e-07 L=6e-07
X_i_4 ZN A2 net_1 VNW pfet_06v0 W=1.215e-06 L=5e-07
X_i_3 net_1 A1 ZN VNW pfet_06v0 W=1.215e-06 L=5e-07
X_i_5 VDD B net_1 VNW pfet_06v0 W=1.215e-06 L=5e-07
.ENDS

.SUBCKT gf180mcu_fd_sc_mcu7t5v0__clkinv_1 I ZN VDD VNW VPW VSS
X_i_0 ZN I VSS VPW nfet_06v0 W=4.8e-07 L=6e-07
X_i_1 ZN I VDD VNW pfet_06v0 W=1.22e-06 L=5e-07
.ENDS

.SUBCKT gf180mcu_fd_sc_mcu7t5v0__dffq_1 D CLK Q VDD VNW VPW VSS
X_tn3 VSS CLK ncki VPW nfet_06v0 W=4.05e-07 L=6e-07
X_tn4 cki ncki VSS VPW nfet_06v0 W=4.05e-07 L=6e-07
X_tn5 net5 ncki VSS VPW nfet_06v0 W=3.6e-07 L=6e-07
X_tn8 net4 D net5 VPW nfet_06v0 W=3.6e-07 L=6e-07
X_tn6 net6 cki net4 VPW nfet_06v0 W=3.6e-07 L=6e-07
X_tn7 VSS net0 net6 VPW nfet_06v0 W=3.6e-07 L=6e-07
X_tn0 net0 net4 VSS VPW nfet_06v0 W=3.6e-07 L=6e-07
X_tn9 net2 cki net0 VPW nfet_06v0 W=3.6e-07 L=6e-07
X_tn11 net1 ncki net2 VPW nfet_06v0 W=3.6e-07 L=6e-07
X_tn12 VSS net3 net1 VPW nfet_06v0 W=3.6e-07 L=6e-07
X_tn10 net3 net2 VSS VPW nfet_06v0 W=4e-07 L=6e-07
X_tn1 Q net3 VSS VPW nfet_06v0 W=8.2e-07 L=6e-07
X_tp3 VDD CLK ncki VNW pfet_06v0 W=8.65e-07 L=5e-07
X_tp4 cki ncki VDD VNW pfet_06v0 W=8.65e-07 L=5e-07
X_tp12 net7 cki VDD VNW pfet_06v0 W=3.6e-07 L=5e-07
X_tp11 net4 D net7 VNW pfet_06v0 W=3.6e-07 L=5e-07
X_tp6 net8 ncki net4 VNW pfet_06v0 W=3.6e-07 L=5e-07
X_tp5 VDD net0 net8 VNW pfet_06v0 W=3.6e-07 L=5e-07
X_tp0 net0 net4 VDD VNW pfet_06v0 W=3.6e-07 L=5e-07
X_tp7 net2 ncki net0 VNW pfet_06v0 W=3.6e-07 L=5e-07
X_tp9 net1x cki net2 VNW pfet_06v0 W=3.6e-07 L=5e-07
X_tp10 VDD net3 net1x VNW pfet_06v0 W=3.6e-07 L=5e-07
X_tp8 net3 net2 VDD VNW pfet_06v0 W=8e-07 L=5e-07
X_tp1 Q net3 VDD VNW pfet_06v0 W=1.22e-06 L=5e-07
.ENDS

.SUBCKT gf180mcu_fd_sc_mcu7t5v0__mux2_1 I0 I1 S Z VDD VNW VPW VSS
X_MN2 VSS int04 Z VPW nfet_06v0 W=8.2e-07 L=6e-07
X_MN4 net_1 I1 VSS VPW nfet_06v0 W=3.6e-07 L=6e-07
X_MN8 int04 S net_1 VPW nfet_06v0 W=3.6e-07 L=6e-07
X_MN7 net_3 sel1_n int04 VPW nfet_06v0 W=3.6e-07 L=6e-07
X_MN3 VSS I0 net_3 VPW nfet_06v0 W=3.6e-07 L=6e-07
X_MN1 sel1_n S VSS VPW nfet_06v0 W=3.6e-07 L=6e-07
X_MP5 VDD int04 Z VNW pfet_06v0 W=1.22e-06 L=5e-07
X_MP4 net_0 I1 VDD VNW pfet_06v0 W=6.15e-07 L=5e-07
X_MP8 int04 sel1_n net_0 VNW pfet_06v0 W=6.15e-07 L=5e-07
X_MP7 net_2 S int04 VNW pfet_06v0 W=6.15e-07 L=5e-07
X_MP3 VDD I0 net_2 VNW pfet_06v0 W=6.15e-07 L=5e-07
X_MP1 sel1_n S VDD VNW pfet_06v0 W=6.15e-07 L=5e-07
.ENDS

.SUBCKT gf180mcu_fd_sc_mcu7t5v0__nand3_1 A1 A2 A3 ZN VDD VNW VPW VSS
X_i_2 net_1 A3 VSS VPW nfet_06v0 W=8.2e-07 L=6e-07
X_i_1 net_0 A2 net_1 VPW nfet_06v0 W=8.2e-07 L=6e-07
X_i_0 ZN A1 net_0 VPW nfet_06v0 W=8.2e-07 L=6e-07
X_i_5 ZN A3 VDD VNW pfet_06v0 W=9.85e-07 L=5e-07
X_i_4 VDD A2 ZN VNW pfet_06v0 W=9.85e-07 L=5e-07
X_i_3 ZN A1 VDD VNW pfet_06v0 W=9.85e-07 L=5e-07
.ENDS

.SUBCKT gf180mcu_fd_sc_mcu7t5v0__nor2_1 A1 A2 ZN VDD VNW VPW VSS
X_i_1 ZN A2 VSS VPW nfet_06v0 W=5.65e-07 L=6e-07
X_i_0 VSS A1 ZN VPW nfet_06v0 W=5.65e-07 L=6e-07
X_i_3 net_0 A2 VDD VNW pfet_06v0 W=1.22e-06 L=5e-07
X_i_2 ZN A1 net_0 VNW pfet_06v0 W=1.22e-06 L=5e-07
.ENDS

.SUBCKT gf180mcu_fd_sc_mcu7t5v0__nor3_1 A1 A2 A3 ZN VDD VNW VPW VSS
X_i_2 ZN A3 VSS VPW nfet_06v0 W=4.65e-07 L=6e-07
X_i_1 VSS A2 ZN VPW nfet_06v0 W=4.65e-07 L=6e-07
X_i_0 ZN A1 VSS VPW nfet_06v0 W=4.65e-07 L=6e-07
X_i_5 net_1 A3 VDD VNW pfet_06v0 W=1.22e-06 L=5e-07
X_i_4 net_0 A2 net_1 VNW pfet_06v0 W=1.22e-06 L=5e-07
X_i_3 ZN A1 net_0 VNW pfet_06v0 W=1.22e-06 L=5e-07
.ENDS

.SUBCKT gf180mcu_fd_sc_mcu7t5v0__or2_1 A1 A2 Z VDD VNW VPW VSS
X_i_2 Z_neg A1 VSS VPW nfet_06v0 W=3.6e-07 L=6e-07
X_i_3 VSS A2 Z_neg VPW nfet_06v0 W=3.6e-07 L=6e-07
X_i_0 Z Z_neg VSS VPW nfet_06v0 W=8.2e-07 L=6e-07
X_i_4 net_0 A1 Z_neg VNW pfet_06v0 W=5.65e-07 L=5e-07
X_i_5 VDD A2 net_0 VNW pfet_06v0 W=5.65e-07 L=5e-07
X_i_1 Z Z_neg VDD VNW pfet_06v0 W=1.22e-06 L=5e-07
.ENDS

.SUBCKT gf180mcu_fd_sc_mcu7t5v0__or4_1 A1 A2 A3 A4 Z VDD VNW VPW VSS
X_i_2 Z_neg A1 VSS VPW nfet_06v0 W=3.6e-07 L=6e-07
X_i_3 VSS A2 Z_neg VPW nfet_06v0 W=3.6e-07 L=6e-07
X_i_4 Z_neg A3 VSS VPW nfet_06v0 W=3.6e-07 L=6e-07
X_i_5 VSS A4 Z_neg VPW nfet_06v0 W=3.6e-07 L=6e-07
X_i_0 Z Z_neg VSS VPW nfet_06v0 W=8.2e-07 L=6e-07
X_i_6 net_0 A1 Z_neg VNW pfet_06v0 W=5.6e-07 L=5e-07
X_i_7 net_1 A2 net_0 VNW pfet_06v0 W=5.6e-07 L=5e-07
X_i_8 net_2 A3 net_1 VNW pfet_06v0 W=5.6e-07 L=5e-07
X_i_9 VDD A4 net_2 VNW pfet_06v0 W=5.6e-07 L=5e-07
X_i_1 Z Z_neg VDD VNW pfet_06v0 W=1.22e-06 L=5e-07
.ENDS

vvdd_gate vdd_gate 0 dc {vdd_val}
