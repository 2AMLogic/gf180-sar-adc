* extracted by klt extract --deck gf180mcu

* cell ADC_DRV
* pin a
* pin vdd
* pin vss
* pin vsubs
* pin y
.SUBCKT ADC_DRV a vdd vss vsubs y
* device instance $1 r0 *1 1.275,2 nfet
M$1 y a vss vsubs nfet L=0.35U W=4U AS=4.4P AD=4.4P PS=10.2U PD=10.2U
* device instance $2 r0 *1 5.125,4 pfet
M$2 y a vdd \$5 pfet L=0.35U W=8U AS=8.8P AD=8.8P PS=18.2U PD=18.2U
.ENDS ADC_DRV
