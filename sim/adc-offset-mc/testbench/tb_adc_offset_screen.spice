* tb_adc_offset_screen -- GENERATED by gen_pilot.py, do not edit.
* Comparator-inclusive ADC_BLOCK input-offset measurement, issue #454 (screening, up+down staircase).
* One transient = one mismatch draw = 82 back-to-back DR-0014 conversions of a
* differential-input staircase (-6.0 mV start, 0.50 mV step; ascending then descending, section 6.6). See sim/adc-offset-mc/README.md.
*
* Mismatch switch: sw_stat_mismatch=1 (ON: per-instance MOS mismatch). sw_stat_global=0 in both, so the
* population is mismatch-only (no global process spread).
.include "../../adc-block-pex/netlist-snapshots/20261008-185501-c618a90d.spice"

.param sw_stat_global=0 sw_stat_mismatch=1 mc_skew=3 res_mc_skew=3
+ cap_mc_skew=3 fnoicor=0

Vdd   vdd  0 dc 3.3
Vref  vref 0 dc 3.3
Vcm   vcm  0 dc 1.65
* parasitic caps in the extracted deck reference the global substrate net `vsubs`;
* tied to ground (the bodies are already tied inside the extracted netlist, DR-0035).
Vsubs vsubs 0 dc 0
Ibias vdd  ibias dc 10u

* inputs are stacked on the vcm node, so V_cm (and the +/-d/2 about it) follow the
* per-corner supply_v override of Vcm; the differential stimulus is supply-independent.
Vinp  pinp vcm pwl(0.0000n -0.003 192.0000n -0.003 192.2000n -0.00275 392.0000n -0.00275 392.2000n
+ -0.0025 592.0000n -0.0025 592.2000n -0.00225 792.0000n -0.00225 792.2000n -0.002 992.0000n -0.002
+ 992.2000n -0.00175 1192.0000n -0.00175 1192.2000n -0.0015 1392.0000n -0.0015 1392.2000n -0.00125
+ 1592.0000n -0.00125 1592.2000n -0.001 1792.0000n -0.001 1792.2000n -0.00075 1992.0000n -0.00075
+ 1992.2000n -0.0005 2192.0000n -0.0005 2192.2000n -0.00025 2392.0000n -0.00025 2392.2000n 0
+ 2592.0000n 0 2592.2000n 0.00025 2792.0000n 0.00025 2792.2000n 0.0005 2992.0000n 0.0005 2992.2000n
+ 0.00075 3192.0000n 0.00075 3192.2000n 0.001 3392.0000n 0.001 3392.2000n 0.00125 3592.0000n 0.00125
+ 3592.2000n 0.0015 3792.0000n 0.0015 3792.2000n 0.00175 3992.0000n 0.00175 3992.2000n 0.002
+ 4192.0000n 0.002 4192.2000n 0.00225 4392.0000n 0.00225 4392.2000n 0.0025 4592.0000n 0.0025
+ 4592.2000n 0.00275 4792.0000n 0.00275 4792.2000n 0.003 4992.0000n 0.003 4992.2000n 0.00325
+ 5192.0000n 0.00325 5192.2000n 0.0035 5392.0000n 0.0035 5392.2000n 0.00375 5592.0000n 0.00375
+ 5592.2000n 0.004 5792.0000n 0.004 5792.2000n 0.00425 5992.0000n 0.00425 5992.2000n 0.0045
+ 6192.0000n 0.0045 6192.2000n 0.00475 6392.0000n 0.00475 6392.2000n 0.005 6592.0000n 0.005
+ 6592.2000n 0.00525 6792.0000n 0.00525 6792.2000n 0.0055 6992.0000n 0.0055 6992.2000n 0.00575
+ 7192.0000n 0.00575 7192.2000n 0.006 7392.0000n 0.006 7392.2000n 0.00625 7592.0000n 0.00625
+ 7592.2000n 0.0065 7792.0000n 0.0065 7792.2000n 0.00675 7992.0000n 0.00675 7992.2000n 0.007
+ 8192.0000n 0.007 8192.2000n 0.007 8392.0000n 0.007 8392.2000n 0.00675 8592.0000n 0.00675
+ 8592.2000n 0.0065 8792.0000n 0.0065 8792.2000n 0.00625 8992.0000n 0.00625 8992.2000n 0.006
+ 9192.0000n 0.006 9192.2000n 0.00575 9392.0000n 0.00575 9392.2000n 0.0055 9592.0000n 0.0055
+ 9592.2000n 0.00525 9792.0000n 0.00525 9792.2000n 0.005 9992.0000n 0.005 9992.2000n 0.00475
+ 10192.0000n 0.00475 10192.2000n 0.0045 10392.0000n 0.0045 10392.2000n 0.00425 10592.0000n 0.00425
+ 10592.2000n 0.004 10792.0000n 0.004 10792.2000n 0.00375 10992.0000n 0.00375 10992.2000n 0.0035
+ 11192.0000n 0.0035 11192.2000n 0.00325 11392.0000n 0.00325 11392.2000n 0.003 11592.0000n 0.003
+ 11592.2000n 0.00275 11792.0000n 0.00275 11792.2000n 0.0025 11992.0000n 0.0025 11992.2000n 0.00225
+ 12192.0000n 0.00225 12192.2000n 0.002 12392.0000n 0.002 12392.2000n 0.00175 12592.0000n 0.00175
+ 12592.2000n 0.0015 12792.0000n 0.0015 12792.2000n 0.00125 12992.0000n 0.00125 12992.2000n 0.001
+ 13192.0000n 0.001 13192.2000n 0.00075 13392.0000n 0.00075 13392.2000n 0.0005 13592.0000n 0.0005
+ 13592.2000n 0.00025 13792.0000n 0.00025 13792.2000n 0 13992.0000n 0 13992.2000n -0.00025
+ 14192.0000n -0.00025 14192.2000n -0.0005 14392.0000n -0.0005 14392.2000n -0.00075 14592.0000n
+ -0.00075 14592.2000n -0.001 14792.0000n -0.001 14792.2000n -0.00125 14992.0000n -0.00125
+ 14992.2000n -0.0015 15192.0000n -0.0015 15192.2000n -0.00175 15392.0000n -0.00175 15392.2000n
+ -0.002 15592.0000n -0.002 15592.2000n -0.00225 15792.0000n -0.00225 15792.2000n -0.0025
+ 15992.0000n -0.0025 15992.2000n -0.00275 16192.0000n -0.00275 16192.2000n -0.003)
Vinn  pinn vcm pwl(0.0000n 0.003 192.0000n 0.003 192.2000n 0.00275 392.0000n 0.00275 392.2000n
+ 0.0025 592.0000n 0.0025 592.2000n 0.00225 792.0000n 0.00225 792.2000n 0.002 992.0000n 0.002
+ 992.2000n 0.00175 1192.0000n 0.00175 1192.2000n 0.0015 1392.0000n 0.0015 1392.2000n 0.00125
+ 1592.0000n 0.00125 1592.2000n 0.001 1792.0000n 0.001 1792.2000n 0.00075 1992.0000n 0.00075
+ 1992.2000n 0.0005 2192.0000n 0.0005 2192.2000n 0.00025 2392.0000n 0.00025 2392.2000n 0 2592.0000n
+ 0 2592.2000n -0.00025 2792.0000n -0.00025 2792.2000n -0.0005 2992.0000n -0.0005 2992.2000n
+ -0.00075 3192.0000n -0.00075 3192.2000n -0.001 3392.0000n -0.001 3392.2000n -0.00125 3592.0000n
+ -0.00125 3592.2000n -0.0015 3792.0000n -0.0015 3792.2000n -0.00175 3992.0000n -0.00175 3992.2000n
+ -0.002 4192.0000n -0.002 4192.2000n -0.00225 4392.0000n -0.00225 4392.2000n -0.0025 4592.0000n
+ -0.0025 4592.2000n -0.00275 4792.0000n -0.00275 4792.2000n -0.003 4992.0000n -0.003 4992.2000n
+ -0.00325 5192.0000n -0.00325 5192.2000n -0.0035 5392.0000n -0.0035 5392.2000n -0.00375 5592.0000n
+ -0.00375 5592.2000n -0.004 5792.0000n -0.004 5792.2000n -0.00425 5992.0000n -0.00425 5992.2000n
+ -0.0045 6192.0000n -0.0045 6192.2000n -0.00475 6392.0000n -0.00475 6392.2000n -0.005 6592.0000n
+ -0.005 6592.2000n -0.00525 6792.0000n -0.00525 6792.2000n -0.0055 6992.0000n -0.0055 6992.2000n
+ -0.00575 7192.0000n -0.00575 7192.2000n -0.006 7392.0000n -0.006 7392.2000n -0.00625 7592.0000n
+ -0.00625 7592.2000n -0.0065 7792.0000n -0.0065 7792.2000n -0.00675 7992.0000n -0.00675 7992.2000n
+ -0.007 8192.0000n -0.007 8192.2000n -0.007 8392.0000n -0.007 8392.2000n -0.00675 8592.0000n
+ -0.00675 8592.2000n -0.0065 8792.0000n -0.0065 8792.2000n -0.00625 8992.0000n -0.00625 8992.2000n
+ -0.006 9192.0000n -0.006 9192.2000n -0.00575 9392.0000n -0.00575 9392.2000n -0.0055 9592.0000n
+ -0.0055 9592.2000n -0.00525 9792.0000n -0.00525 9792.2000n -0.005 9992.0000n -0.005 9992.2000n
+ -0.00475 10192.0000n -0.00475 10192.2000n -0.0045 10392.0000n -0.0045 10392.2000n -0.00425
+ 10592.0000n -0.00425 10592.2000n -0.004 10792.0000n -0.004 10792.2000n -0.00375 10992.0000n
+ -0.00375 10992.2000n -0.0035 11192.0000n -0.0035 11192.2000n -0.00325 11392.0000n -0.00325
+ 11392.2000n -0.003 11592.0000n -0.003 11592.2000n -0.00275 11792.0000n -0.00275 11792.2000n
+ -0.0025 11992.0000n -0.0025 11992.2000n -0.00225 12192.0000n -0.00225 12192.2000n -0.002
+ 12392.0000n -0.002 12392.2000n -0.00175 12592.0000n -0.00175 12592.2000n -0.0015 12792.0000n
+ -0.0015 12792.2000n -0.00125 12992.0000n -0.00125 12992.2000n -0.001 13192.0000n -0.001
+ 13192.2000n -0.00075 13392.0000n -0.00075 13392.2000n -0.0005 13592.0000n -0.0005 13592.2000n
+ -0.00025 13792.0000n -0.00025 13792.2000n 0 13992.0000n 0 13992.2000n 0.00025 14192.0000n 0.00025
+ 14192.2000n 0.0005 14392.0000n 0.0005 14392.2000n 0.00075 14592.0000n 0.00075 14592.2000n 0.001
+ 14792.0000n 0.001 14792.2000n 0.00125 14992.0000n 0.00125 14992.2000n 0.0015 15192.0000n 0.0015
+ 15192.2000n 0.00175 15392.0000n 0.00175 15392.2000n 0.002 15592.0000n 0.002 15592.2000n 0.00225
+ 15792.0000n 0.00225 15792.2000n 0.0025 15992.0000n 0.0025 15992.2000n 0.00275 16192.0000n 0.00275
+ 16192.2000n 0.003)
Vtpl   tp_l   0 pwl(0.0000n 1 100.0000n 1 100.2000n 0 185.0000n 0 185.2000n 1 300.0000n 1 300.2000n
+ 0 385.0000n 0 385.2000n 1 500.0000n 1 500.2000n 0 585.0000n 0 585.2000n 1 700.0000n 1 700.2000n 0
+ 785.0000n 0 785.2000n 1 900.0000n 1 900.2000n 0 985.0000n 0 985.2000n 1 1100.0000n 1 1100.2000n 0
+ 1185.0000n 0 1185.2000n 1 1300.0000n 1 1300.2000n 0 1385.0000n 0 1385.2000n 1 1500.0000n 1
+ 1500.2000n 0 1585.0000n 0 1585.2000n 1 1700.0000n 1 1700.2000n 0 1785.0000n 0 1785.2000n 1
+ 1900.0000n 1 1900.2000n 0 1985.0000n 0 1985.2000n 1 2100.0000n 1 2100.2000n 0 2185.0000n 0
+ 2185.2000n 1 2300.0000n 1 2300.2000n 0 2385.0000n 0 2385.2000n 1 2500.0000n 1 2500.2000n 0
+ 2585.0000n 0 2585.2000n 1 2700.0000n 1 2700.2000n 0 2785.0000n 0 2785.2000n 1 2900.0000n 1
+ 2900.2000n 0 2985.0000n 0 2985.2000n 1 3100.0000n 1 3100.2000n 0 3185.0000n 0 3185.2000n 1
+ 3300.0000n 1 3300.2000n 0 3385.0000n 0 3385.2000n 1 3500.0000n 1 3500.2000n 0 3585.0000n 0
+ 3585.2000n 1 3700.0000n 1 3700.2000n 0 3785.0000n 0 3785.2000n 1 3900.0000n 1 3900.2000n 0
+ 3985.0000n 0 3985.2000n 1 4100.0000n 1 4100.2000n 0 4185.0000n 0 4185.2000n 1 4300.0000n 1
+ 4300.2000n 0 4385.0000n 0 4385.2000n 1 4500.0000n 1 4500.2000n 0 4585.0000n 0 4585.2000n 1
+ 4700.0000n 1 4700.2000n 0 4785.0000n 0 4785.2000n 1 4900.0000n 1 4900.2000n 0 4985.0000n 0
+ 4985.2000n 1 5100.0000n 1 5100.2000n 0 5185.0000n 0 5185.2000n 1 5300.0000n 1 5300.2000n 0
+ 5385.0000n 0 5385.2000n 1 5500.0000n 1 5500.2000n 0 5585.0000n 0 5585.2000n 1 5700.0000n 1
+ 5700.2000n 0 5785.0000n 0 5785.2000n 1 5900.0000n 1 5900.2000n 0 5985.0000n 0 5985.2000n 1
+ 6100.0000n 1 6100.2000n 0 6185.0000n 0 6185.2000n 1 6300.0000n 1 6300.2000n 0 6385.0000n 0
+ 6385.2000n 1 6500.0000n 1 6500.2000n 0 6585.0000n 0 6585.2000n 1 6700.0000n 1 6700.2000n 0
+ 6785.0000n 0 6785.2000n 1 6900.0000n 1 6900.2000n 0 6985.0000n 0 6985.2000n 1 7100.0000n 1
+ 7100.2000n 0 7185.0000n 0 7185.2000n 1 7300.0000n 1 7300.2000n 0 7385.0000n 0 7385.2000n 1
+ 7500.0000n 1 7500.2000n 0 7585.0000n 0 7585.2000n 1 7700.0000n 1 7700.2000n 0 7785.0000n 0
+ 7785.2000n 1 7900.0000n 1 7900.2000n 0 7985.0000n 0 7985.2000n 1 8100.0000n 1 8100.2000n 0
+ 8185.0000n 0 8185.2000n 1 8300.0000n 1 8300.2000n 0 8385.0000n 0 8385.2000n 1 8500.0000n 1
+ 8500.2000n 0 8585.0000n 0 8585.2000n 1 8700.0000n 1 8700.2000n 0 8785.0000n 0 8785.2000n 1
+ 8900.0000n 1 8900.2000n 0 8985.0000n 0 8985.2000n 1 9100.0000n 1 9100.2000n 0 9185.0000n 0
+ 9185.2000n 1 9300.0000n 1 9300.2000n 0 9385.0000n 0 9385.2000n 1 9500.0000n 1 9500.2000n 0
+ 9585.0000n 0 9585.2000n 1 9700.0000n 1 9700.2000n 0 9785.0000n 0 9785.2000n 1 9900.0000n 1
+ 9900.2000n 0 9985.0000n 0 9985.2000n 1 10100.0000n 1 10100.2000n 0 10185.0000n 0 10185.2000n 1
+ 10300.0000n 1 10300.2000n 0 10385.0000n 0 10385.2000n 1 10500.0000n 1 10500.2000n 0 10585.0000n 0
+ 10585.2000n 1 10700.0000n 1 10700.2000n 0 10785.0000n 0 10785.2000n 1 10900.0000n 1 10900.2000n 0
+ 10985.0000n 0 10985.2000n 1 11100.0000n 1 11100.2000n 0 11185.0000n 0 11185.2000n 1 11300.0000n 1
+ 11300.2000n 0 11385.0000n 0 11385.2000n 1 11500.0000n 1 11500.2000n 0 11585.0000n 0 11585.2000n 1
+ 11700.0000n 1 11700.2000n 0 11785.0000n 0 11785.2000n 1 11900.0000n 1 11900.2000n 0 11985.0000n 0
+ 11985.2000n 1 12100.0000n 1 12100.2000n 0 12185.0000n 0 12185.2000n 1 12300.0000n 1 12300.2000n 0
+ 12385.0000n 0 12385.2000n 1 12500.0000n 1 12500.2000n 0 12585.0000n 0 12585.2000n 1 12700.0000n 1
+ 12700.2000n 0 12785.0000n 0 12785.2000n 1 12900.0000n 1 12900.2000n 0 12985.0000n 0 12985.2000n 1
+ 13100.0000n 1 13100.2000n 0 13185.0000n 0 13185.2000n 1 13300.0000n 1 13300.2000n 0 13385.0000n 0
+ 13385.2000n 1 13500.0000n 1 13500.2000n 0 13585.0000n 0 13585.2000n 1 13700.0000n 1 13700.2000n 0
+ 13785.0000n 0 13785.2000n 1 13900.0000n 1 13900.2000n 0 13985.0000n 0 13985.2000n 1 14100.0000n 1
+ 14100.2000n 0 14185.0000n 0 14185.2000n 1 14300.0000n 1 14300.2000n 0 14385.0000n 0 14385.2000n 1
+ 14500.0000n 1 14500.2000n 0 14585.0000n 0 14585.2000n 1 14700.0000n 1 14700.2000n 0 14785.0000n 0
+ 14785.2000n 1 14900.0000n 1 14900.2000n 0 14985.0000n 0 14985.2000n 1 15100.0000n 1 15100.2000n 0
+ 15185.0000n 0 15185.2000n 1 15300.0000n 1 15300.2000n 0 15385.0000n 0 15385.2000n 1 15500.0000n 1
+ 15500.2000n 0 15585.0000n 0 15585.2000n 1 15700.0000n 1 15700.2000n 0 15785.0000n 0 15785.2000n 1
+ 15900.0000n 1 15900.2000n 0 15985.0000n 0 15985.2000n 1 16100.0000n 1 16100.2000n 0 16185.0000n 0
+ 16185.2000n 1 16300.0000n 1 16300.2000n 0 16385.0000n 0 16385.2000n 1)
Vsell  sel_l  0 pwl(0.0000n 1 110.0000n 1 110.2000n 0 188.0000n 0 188.2000n 1 310.0000n 1 310.2000n
+ 0 388.0000n 0 388.2000n 1 510.0000n 1 510.2000n 0 588.0000n 0 588.2000n 1 710.0000n 1 710.2000n 0
+ 788.0000n 0 788.2000n 1 910.0000n 1 910.2000n 0 988.0000n 0 988.2000n 1 1110.0000n 1 1110.2000n 0
+ 1188.0000n 0 1188.2000n 1 1310.0000n 1 1310.2000n 0 1388.0000n 0 1388.2000n 1 1510.0000n 1
+ 1510.2000n 0 1588.0000n 0 1588.2000n 1 1710.0000n 1 1710.2000n 0 1788.0000n 0 1788.2000n 1
+ 1910.0000n 1 1910.2000n 0 1988.0000n 0 1988.2000n 1 2110.0000n 1 2110.2000n 0 2188.0000n 0
+ 2188.2000n 1 2310.0000n 1 2310.2000n 0 2388.0000n 0 2388.2000n 1 2510.0000n 1 2510.2000n 0
+ 2588.0000n 0 2588.2000n 1 2710.0000n 1 2710.2000n 0 2788.0000n 0 2788.2000n 1 2910.0000n 1
+ 2910.2000n 0 2988.0000n 0 2988.2000n 1 3110.0000n 1 3110.2000n 0 3188.0000n 0 3188.2000n 1
+ 3310.0000n 1 3310.2000n 0 3388.0000n 0 3388.2000n 1 3510.0000n 1 3510.2000n 0 3588.0000n 0
+ 3588.2000n 1 3710.0000n 1 3710.2000n 0 3788.0000n 0 3788.2000n 1 3910.0000n 1 3910.2000n 0
+ 3988.0000n 0 3988.2000n 1 4110.0000n 1 4110.2000n 0 4188.0000n 0 4188.2000n 1 4310.0000n 1
+ 4310.2000n 0 4388.0000n 0 4388.2000n 1 4510.0000n 1 4510.2000n 0 4588.0000n 0 4588.2000n 1
+ 4710.0000n 1 4710.2000n 0 4788.0000n 0 4788.2000n 1 4910.0000n 1 4910.2000n 0 4988.0000n 0
+ 4988.2000n 1 5110.0000n 1 5110.2000n 0 5188.0000n 0 5188.2000n 1 5310.0000n 1 5310.2000n 0
+ 5388.0000n 0 5388.2000n 1 5510.0000n 1 5510.2000n 0 5588.0000n 0 5588.2000n 1 5710.0000n 1
+ 5710.2000n 0 5788.0000n 0 5788.2000n 1 5910.0000n 1 5910.2000n 0 5988.0000n 0 5988.2000n 1
+ 6110.0000n 1 6110.2000n 0 6188.0000n 0 6188.2000n 1 6310.0000n 1 6310.2000n 0 6388.0000n 0
+ 6388.2000n 1 6510.0000n 1 6510.2000n 0 6588.0000n 0 6588.2000n 1 6710.0000n 1 6710.2000n 0
+ 6788.0000n 0 6788.2000n 1 6910.0000n 1 6910.2000n 0 6988.0000n 0 6988.2000n 1 7110.0000n 1
+ 7110.2000n 0 7188.0000n 0 7188.2000n 1 7310.0000n 1 7310.2000n 0 7388.0000n 0 7388.2000n 1
+ 7510.0000n 1 7510.2000n 0 7588.0000n 0 7588.2000n 1 7710.0000n 1 7710.2000n 0 7788.0000n 0
+ 7788.2000n 1 7910.0000n 1 7910.2000n 0 7988.0000n 0 7988.2000n 1 8110.0000n 1 8110.2000n 0
+ 8188.0000n 0 8188.2000n 1 8310.0000n 1 8310.2000n 0 8388.0000n 0 8388.2000n 1 8510.0000n 1
+ 8510.2000n 0 8588.0000n 0 8588.2000n 1 8710.0000n 1 8710.2000n 0 8788.0000n 0 8788.2000n 1
+ 8910.0000n 1 8910.2000n 0 8988.0000n 0 8988.2000n 1 9110.0000n 1 9110.2000n 0 9188.0000n 0
+ 9188.2000n 1 9310.0000n 1 9310.2000n 0 9388.0000n 0 9388.2000n 1 9510.0000n 1 9510.2000n 0
+ 9588.0000n 0 9588.2000n 1 9710.0000n 1 9710.2000n 0 9788.0000n 0 9788.2000n 1 9910.0000n 1
+ 9910.2000n 0 9988.0000n 0 9988.2000n 1 10110.0000n 1 10110.2000n 0 10188.0000n 0 10188.2000n 1
+ 10310.0000n 1 10310.2000n 0 10388.0000n 0 10388.2000n 1 10510.0000n 1 10510.2000n 0 10588.0000n 0
+ 10588.2000n 1 10710.0000n 1 10710.2000n 0 10788.0000n 0 10788.2000n 1 10910.0000n 1 10910.2000n 0
+ 10988.0000n 0 10988.2000n 1 11110.0000n 1 11110.2000n 0 11188.0000n 0 11188.2000n 1 11310.0000n 1
+ 11310.2000n 0 11388.0000n 0 11388.2000n 1 11510.0000n 1 11510.2000n 0 11588.0000n 0 11588.2000n 1
+ 11710.0000n 1 11710.2000n 0 11788.0000n 0 11788.2000n 1 11910.0000n 1 11910.2000n 0 11988.0000n 0
+ 11988.2000n 1 12110.0000n 1 12110.2000n 0 12188.0000n 0 12188.2000n 1 12310.0000n 1 12310.2000n 0
+ 12388.0000n 0 12388.2000n 1 12510.0000n 1 12510.2000n 0 12588.0000n 0 12588.2000n 1 12710.0000n 1
+ 12710.2000n 0 12788.0000n 0 12788.2000n 1 12910.0000n 1 12910.2000n 0 12988.0000n 0 12988.2000n 1
+ 13110.0000n 1 13110.2000n 0 13188.0000n 0 13188.2000n 1 13310.0000n 1 13310.2000n 0 13388.0000n 0
+ 13388.2000n 1 13510.0000n 1 13510.2000n 0 13588.0000n 0 13588.2000n 1 13710.0000n 1 13710.2000n 0
+ 13788.0000n 0 13788.2000n 1 13910.0000n 1 13910.2000n 0 13988.0000n 0 13988.2000n 1 14110.0000n 1
+ 14110.2000n 0 14188.0000n 0 14188.2000n 1 14310.0000n 1 14310.2000n 0 14388.0000n 0 14388.2000n 1
+ 14510.0000n 1 14510.2000n 0 14588.0000n 0 14588.2000n 1 14710.0000n 1 14710.2000n 0 14788.0000n 0
+ 14788.2000n 1 14910.0000n 1 14910.2000n 0 14988.0000n 0 14988.2000n 1 15110.0000n 1 15110.2000n 0
+ 15188.0000n 0 15188.2000n 1 15310.0000n 1 15310.2000n 0 15388.0000n 0 15388.2000n 1 15510.0000n 1
+ 15510.2000n 0 15588.0000n 0 15588.2000n 1 15710.0000n 1 15710.2000n 0 15788.0000n 0 15788.2000n 1
+ 15910.0000n 1 15910.2000n 0 15988.0000n 0 15988.2000n 1 16110.0000n 1 16110.2000n 0 16188.0000n 0
+ 16188.2000n 1 16310.0000n 1 16310.2000n 0 16388.0000n 0 16388.2000n 1)
Vrell  rel_l  0 pwl(0.0000n 0 115.0000n 0 115.2000n 1 182.0000n 1 182.2000n 0 315.0000n 0 315.2000n
+ 1 382.0000n 1 382.2000n 0 515.0000n 0 515.2000n 1 582.0000n 1 582.2000n 0 715.0000n 0 715.2000n 1
+ 782.0000n 1 782.2000n 0 915.0000n 0 915.2000n 1 982.0000n 1 982.2000n 0 1115.0000n 0 1115.2000n 1
+ 1182.0000n 1 1182.2000n 0 1315.0000n 0 1315.2000n 1 1382.0000n 1 1382.2000n 0 1515.0000n 0
+ 1515.2000n 1 1582.0000n 1 1582.2000n 0 1715.0000n 0 1715.2000n 1 1782.0000n 1 1782.2000n 0
+ 1915.0000n 0 1915.2000n 1 1982.0000n 1 1982.2000n 0 2115.0000n 0 2115.2000n 1 2182.0000n 1
+ 2182.2000n 0 2315.0000n 0 2315.2000n 1 2382.0000n 1 2382.2000n 0 2515.0000n 0 2515.2000n 1
+ 2582.0000n 1 2582.2000n 0 2715.0000n 0 2715.2000n 1 2782.0000n 1 2782.2000n 0 2915.0000n 0
+ 2915.2000n 1 2982.0000n 1 2982.2000n 0 3115.0000n 0 3115.2000n 1 3182.0000n 1 3182.2000n 0
+ 3315.0000n 0 3315.2000n 1 3382.0000n 1 3382.2000n 0 3515.0000n 0 3515.2000n 1 3582.0000n 1
+ 3582.2000n 0 3715.0000n 0 3715.2000n 1 3782.0000n 1 3782.2000n 0 3915.0000n 0 3915.2000n 1
+ 3982.0000n 1 3982.2000n 0 4115.0000n 0 4115.2000n 1 4182.0000n 1 4182.2000n 0 4315.0000n 0
+ 4315.2000n 1 4382.0000n 1 4382.2000n 0 4515.0000n 0 4515.2000n 1 4582.0000n 1 4582.2000n 0
+ 4715.0000n 0 4715.2000n 1 4782.0000n 1 4782.2000n 0 4915.0000n 0 4915.2000n 1 4982.0000n 1
+ 4982.2000n 0 5115.0000n 0 5115.2000n 1 5182.0000n 1 5182.2000n 0 5315.0000n 0 5315.2000n 1
+ 5382.0000n 1 5382.2000n 0 5515.0000n 0 5515.2000n 1 5582.0000n 1 5582.2000n 0 5715.0000n 0
+ 5715.2000n 1 5782.0000n 1 5782.2000n 0 5915.0000n 0 5915.2000n 1 5982.0000n 1 5982.2000n 0
+ 6115.0000n 0 6115.2000n 1 6182.0000n 1 6182.2000n 0 6315.0000n 0 6315.2000n 1 6382.0000n 1
+ 6382.2000n 0 6515.0000n 0 6515.2000n 1 6582.0000n 1 6582.2000n 0 6715.0000n 0 6715.2000n 1
+ 6782.0000n 1 6782.2000n 0 6915.0000n 0 6915.2000n 1 6982.0000n 1 6982.2000n 0 7115.0000n 0
+ 7115.2000n 1 7182.0000n 1 7182.2000n 0 7315.0000n 0 7315.2000n 1 7382.0000n 1 7382.2000n 0
+ 7515.0000n 0 7515.2000n 1 7582.0000n 1 7582.2000n 0 7715.0000n 0 7715.2000n 1 7782.0000n 1
+ 7782.2000n 0 7915.0000n 0 7915.2000n 1 7982.0000n 1 7982.2000n 0 8115.0000n 0 8115.2000n 1
+ 8182.0000n 1 8182.2000n 0 8315.0000n 0 8315.2000n 1 8382.0000n 1 8382.2000n 0 8515.0000n 0
+ 8515.2000n 1 8582.0000n 1 8582.2000n 0 8715.0000n 0 8715.2000n 1 8782.0000n 1 8782.2000n 0
+ 8915.0000n 0 8915.2000n 1 8982.0000n 1 8982.2000n 0 9115.0000n 0 9115.2000n 1 9182.0000n 1
+ 9182.2000n 0 9315.0000n 0 9315.2000n 1 9382.0000n 1 9382.2000n 0 9515.0000n 0 9515.2000n 1
+ 9582.0000n 1 9582.2000n 0 9715.0000n 0 9715.2000n 1 9782.0000n 1 9782.2000n 0 9915.0000n 0
+ 9915.2000n 1 9982.0000n 1 9982.2000n 0 10115.0000n 0 10115.2000n 1 10182.0000n 1 10182.2000n 0
+ 10315.0000n 0 10315.2000n 1 10382.0000n 1 10382.2000n 0 10515.0000n 0 10515.2000n 1 10582.0000n 1
+ 10582.2000n 0 10715.0000n 0 10715.2000n 1 10782.0000n 1 10782.2000n 0 10915.0000n 0 10915.2000n 1
+ 10982.0000n 1 10982.2000n 0 11115.0000n 0 11115.2000n 1 11182.0000n 1 11182.2000n 0 11315.0000n 0
+ 11315.2000n 1 11382.0000n 1 11382.2000n 0 11515.0000n 0 11515.2000n 1 11582.0000n 1 11582.2000n 0
+ 11715.0000n 0 11715.2000n 1 11782.0000n 1 11782.2000n 0 11915.0000n 0 11915.2000n 1 11982.0000n 1
+ 11982.2000n 0 12115.0000n 0 12115.2000n 1 12182.0000n 1 12182.2000n 0 12315.0000n 0 12315.2000n 1
+ 12382.0000n 1 12382.2000n 0 12515.0000n 0 12515.2000n 1 12582.0000n 1 12582.2000n 0 12715.0000n 0
+ 12715.2000n 1 12782.0000n 1 12782.2000n 0 12915.0000n 0 12915.2000n 1 12982.0000n 1 12982.2000n 0
+ 13115.0000n 0 13115.2000n 1 13182.0000n 1 13182.2000n 0 13315.0000n 0 13315.2000n 1 13382.0000n 1
+ 13382.2000n 0 13515.0000n 0 13515.2000n 1 13582.0000n 1 13582.2000n 0 13715.0000n 0 13715.2000n 1
+ 13782.0000n 1 13782.2000n 0 13915.0000n 0 13915.2000n 1 13982.0000n 1 13982.2000n 0 14115.0000n 0
+ 14115.2000n 1 14182.0000n 1 14182.2000n 0 14315.0000n 0 14315.2000n 1 14382.0000n 1 14382.2000n 0
+ 14515.0000n 0 14515.2000n 1 14582.0000n 1 14582.2000n 0 14715.0000n 0 14715.2000n 1 14782.0000n 1
+ 14782.2000n 0 14915.0000n 0 14915.2000n 1 14982.0000n 1 14982.2000n 0 15115.0000n 0 15115.2000n 1
+ 15182.0000n 1 15182.2000n 0 15315.0000n 0 15315.2000n 1 15382.0000n 1 15382.2000n 0 15515.0000n 0
+ 15515.2000n 1 15582.0000n 1 15582.2000n 0 15715.0000n 0 15715.2000n 1 15782.0000n 1 15782.2000n 0
+ 15915.0000n 0 15915.2000n 1 15982.0000n 1 15982.2000n 0 16115.0000n 0 16115.2000n 1 16182.0000n 1
+ 16182.2000n 0 16315.0000n 0 16315.2000n 1 16382.0000n 1 16382.2000n 0)
Vclkl  clk_l  0 pwl(0.0000n 0 150.0000n 0 150.1000n 1 180.0000n 1 180.1000n 0 350.0000n 0 350.1000n
+ 1 380.0000n 1 380.1000n 0 550.0000n 0 550.1000n 1 580.0000n 1 580.1000n 0 750.0000n 0 750.1000n 1
+ 780.0000n 1 780.1000n 0 950.0000n 0 950.1000n 1 980.0000n 1 980.1000n 0 1150.0000n 0 1150.1000n 1
+ 1180.0000n 1 1180.1000n 0 1350.0000n 0 1350.1000n 1 1380.0000n 1 1380.1000n 0 1550.0000n 0
+ 1550.1000n 1 1580.0000n 1 1580.1000n 0 1750.0000n 0 1750.1000n 1 1780.0000n 1 1780.1000n 0
+ 1950.0000n 0 1950.1000n 1 1980.0000n 1 1980.1000n 0 2150.0000n 0 2150.1000n 1 2180.0000n 1
+ 2180.1000n 0 2350.0000n 0 2350.1000n 1 2380.0000n 1 2380.1000n 0 2550.0000n 0 2550.1000n 1
+ 2580.0000n 1 2580.1000n 0 2750.0000n 0 2750.1000n 1 2780.0000n 1 2780.1000n 0 2950.0000n 0
+ 2950.1000n 1 2980.0000n 1 2980.1000n 0 3150.0000n 0 3150.1000n 1 3180.0000n 1 3180.1000n 0
+ 3350.0000n 0 3350.1000n 1 3380.0000n 1 3380.1000n 0 3550.0000n 0 3550.1000n 1 3580.0000n 1
+ 3580.1000n 0 3750.0000n 0 3750.1000n 1 3780.0000n 1 3780.1000n 0 3950.0000n 0 3950.1000n 1
+ 3980.0000n 1 3980.1000n 0 4150.0000n 0 4150.1000n 1 4180.0000n 1 4180.1000n 0 4350.0000n 0
+ 4350.1000n 1 4380.0000n 1 4380.1000n 0 4550.0000n 0 4550.1000n 1 4580.0000n 1 4580.1000n 0
+ 4750.0000n 0 4750.1000n 1 4780.0000n 1 4780.1000n 0 4950.0000n 0 4950.1000n 1 4980.0000n 1
+ 4980.1000n 0 5150.0000n 0 5150.1000n 1 5180.0000n 1 5180.1000n 0 5350.0000n 0 5350.1000n 1
+ 5380.0000n 1 5380.1000n 0 5550.0000n 0 5550.1000n 1 5580.0000n 1 5580.1000n 0 5750.0000n 0
+ 5750.1000n 1 5780.0000n 1 5780.1000n 0 5950.0000n 0 5950.1000n 1 5980.0000n 1 5980.1000n 0
+ 6150.0000n 0 6150.1000n 1 6180.0000n 1 6180.1000n 0 6350.0000n 0 6350.1000n 1 6380.0000n 1
+ 6380.1000n 0 6550.0000n 0 6550.1000n 1 6580.0000n 1 6580.1000n 0 6750.0000n 0 6750.1000n 1
+ 6780.0000n 1 6780.1000n 0 6950.0000n 0 6950.1000n 1 6980.0000n 1 6980.1000n 0 7150.0000n 0
+ 7150.1000n 1 7180.0000n 1 7180.1000n 0 7350.0000n 0 7350.1000n 1 7380.0000n 1 7380.1000n 0
+ 7550.0000n 0 7550.1000n 1 7580.0000n 1 7580.1000n 0 7750.0000n 0 7750.1000n 1 7780.0000n 1
+ 7780.1000n 0 7950.0000n 0 7950.1000n 1 7980.0000n 1 7980.1000n 0 8150.0000n 0 8150.1000n 1
+ 8180.0000n 1 8180.1000n 0 8350.0000n 0 8350.1000n 1 8380.0000n 1 8380.1000n 0 8550.0000n 0
+ 8550.1000n 1 8580.0000n 1 8580.1000n 0 8750.0000n 0 8750.1000n 1 8780.0000n 1 8780.1000n 0
+ 8950.0000n 0 8950.1000n 1 8980.0000n 1 8980.1000n 0 9150.0000n 0 9150.1000n 1 9180.0000n 1
+ 9180.1000n 0 9350.0000n 0 9350.1000n 1 9380.0000n 1 9380.1000n 0 9550.0000n 0 9550.1000n 1
+ 9580.0000n 1 9580.1000n 0 9750.0000n 0 9750.1000n 1 9780.0000n 1 9780.1000n 0 9950.0000n 0
+ 9950.1000n 1 9980.0000n 1 9980.1000n 0 10150.0000n 0 10150.1000n 1 10180.0000n 1 10180.1000n 0
+ 10350.0000n 0 10350.1000n 1 10380.0000n 1 10380.1000n 0 10550.0000n 0 10550.1000n 1 10580.0000n 1
+ 10580.1000n 0 10750.0000n 0 10750.1000n 1 10780.0000n 1 10780.1000n 0 10950.0000n 0 10950.1000n 1
+ 10980.0000n 1 10980.1000n 0 11150.0000n 0 11150.1000n 1 11180.0000n 1 11180.1000n 0 11350.0000n 0
+ 11350.1000n 1 11380.0000n 1 11380.1000n 0 11550.0000n 0 11550.1000n 1 11580.0000n 1 11580.1000n 0
+ 11750.0000n 0 11750.1000n 1 11780.0000n 1 11780.1000n 0 11950.0000n 0 11950.1000n 1 11980.0000n 1
+ 11980.1000n 0 12150.0000n 0 12150.1000n 1 12180.0000n 1 12180.1000n 0 12350.0000n 0 12350.1000n 1
+ 12380.0000n 1 12380.1000n 0 12550.0000n 0 12550.1000n 1 12580.0000n 1 12580.1000n 0 12750.0000n 0
+ 12750.1000n 1 12780.0000n 1 12780.1000n 0 12950.0000n 0 12950.1000n 1 12980.0000n 1 12980.1000n 0
+ 13150.0000n 0 13150.1000n 1 13180.0000n 1 13180.1000n 0 13350.0000n 0 13350.1000n 1 13380.0000n 1
+ 13380.1000n 0 13550.0000n 0 13550.1000n 1 13580.0000n 1 13580.1000n 0 13750.0000n 0 13750.1000n 1
+ 13780.0000n 1 13780.1000n 0 13950.0000n 0 13950.1000n 1 13980.0000n 1 13980.1000n 0 14150.0000n 0
+ 14150.1000n 1 14180.0000n 1 14180.1000n 0 14350.0000n 0 14350.1000n 1 14380.0000n 1 14380.1000n 0
+ 14550.0000n 0 14550.1000n 1 14580.0000n 1 14580.1000n 0 14750.0000n 0 14750.1000n 1 14780.0000n 1
+ 14780.1000n 0 14950.0000n 0 14950.1000n 1 14980.0000n 1 14980.1000n 0 15150.0000n 0 15150.1000n 1
+ 15180.0000n 1 15180.1000n 0 15350.0000n 0 15350.1000n 1 15380.0000n 1 15380.1000n 0 15550.0000n 0
+ 15550.1000n 1 15580.0000n 1 15580.1000n 0 15750.0000n 0 15750.1000n 1 15780.0000n 1 15780.1000n 0
+ 15950.0000n 0 15950.1000n 1 15980.0000n 1 15980.1000n 0 16150.0000n 0 16150.1000n 1 16180.0000n 1
+ 16180.1000n 0 16350.0000n 0 16350.1000n 1 16380.0000n 1 16380.1000n 0)
Btp    tp_gn  0 v = v(vdd)*v(tp_l)
Bsel   sel_in 0 v = v(vdd)*v(sel_l)
Brel   relall 0 v = v(vdd)*v(rel_l)
Bclk   cmpclk 0 v = v(vdd)*v(clk_l)

Xdut cmpclk dout doutb
+ 0 0 0 0 0 0 0 0 0 0 0 0 0 0 0 0 0 0
+ ibias
+ 0 0 0 0 0 0 0 0 0 0 0 0 0 0 0 0 0 0
+ pinn pinp
+ relall relall relall relall relall relall relall relall relall
+ relall relall relall relall relall relall relall relall relall
+ sel_in topn topp tp_gn vcm vdd vref 0
+ ADC_BLOCK
