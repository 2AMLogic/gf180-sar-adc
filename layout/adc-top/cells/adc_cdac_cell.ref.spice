* Flat LVS reference for ADC_CDAC_CELL.
*
* GENERATED by layout/adc-top/cells/gen_adc_cells.py from
* design/adc-top/adc_top.spice's `.subckt adc_cdac_cell` -- do not
* edit. See layout/adc-top/lib/netlist.py for why the layout and this
* reference are derived from the same parsed design netlist, and what
* that does and does not let LVS prove.
*
* Deliberate, documented differences from the schematic, each forced by
* `klt extract`'s gf180mcu ExtractionDeck and restated in
* layout/adc-top/README.md:
*   - every NMOS body is on the deck's `vsubs` global, not on the
*     schematic's `0`/`vss`: the curated deck has no tap layer, so a
*     drawn substrate tie cannot name that net;
*   - every PMOS body is on the Nwell island's own (unnamed) net, not
*     on `vdd`: the deck never connects `nwell` to `contact`;
*   - the MiM capacitor is absent: the deck reads none of the MiM
*     layers and has no capacitor device class at all.
*
* Runnable by hand:  klt lvs layout/adc-top/cells/adc_cdac_cell.lvs.json --format json
.SUBCKT ADC_CDAC_CELL bp gn_hi gn_in gn_lo gn_rel vcm vdd vin vref vss vsubs
MXdi_Xp gp_in gn_in vdd nw pfet L=0.35U W=8U
MXdi_Xn gp_in gn_in vss vsubs nfet L=0.35U W=4U
MXdr_Xp gp_rel gn_rel vdd nw pfet L=0.35U W=8U
MXdr_Xn gp_rel gn_rel vss vsubs nfet L=0.35U W=4U
MXdh_Xp gp_hi gn_hi vdd nw pfet L=0.35U W=8U
MXdh_Xn gp_hi gn_hi vss vsubs nfet L=0.35U W=4U
MXdl_Xp gp_lo gn_lo vdd nw pfet L=0.35U W=8U
MXdl_Xn gp_lo gn_lo vss vsubs nfet L=0.35U W=4U
MXsi_XN vin gn_in bp vsubs nfet L=0.28U W=10U
MXsi_XP vin gp_in bp nw pfet L=0.28U W=20U
MXsr_XN vcm gn_rel bp vsubs nfet L=0.28U W=10U
MXsr_XP vcm gp_rel bp nw pfet L=0.28U W=20U
MXsh_XN vref gn_hi bp vsubs nfet L=0.28U W=10U
MXsh_XP vref gp_hi bp nw pfet L=0.28U W=20U
MXsl_XN vss gn_lo bp vsubs nfet L=0.28U W=10U
MXsl_XP vss gp_lo bp nw pfet L=0.28U W=20U
.ENDS ADC_CDAC_CELL
